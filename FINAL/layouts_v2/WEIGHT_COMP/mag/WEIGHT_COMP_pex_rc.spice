* Nodos de bulk atados: 11 de pozo n -> VDD, 23 de sustrato -> VSS.
*   magic no extrae los taps de este layout y los dejaba flotando;
*   la conexion si existe (el LVS de KLayout da 'match uniquely').
*   Quien detecta un tap que falte de verdad es el LVS, no esto.
* NGSPICE file created from WEIGHT_COMP.ext - technology: gf180mcuD

.subckt WEIGHT_COMP VSS VDD VD WE VA VB OUT OUT_N VC
X0 OUT.t0 a_3260_3416.t2 VSS.t7 VSS nfet_05v0 ad=0.5808p pd=3.52u as=0.5808p ps=3.52u w=1.32u l=0.6u
X1 a_1376_n116.t1 a_1376_n116.t0 VDD.t4 VDD pfet_06v0 ad=0.88p pd=4.88u as=0.88p ps=4.88u w=2u l=1u
X2 a_3260_3416.t0 WE.t27 VDD.t2 VDD pfet_05v0 ad=0.8052p pd=4.54u as=0.8052p ps=4.54u w=1.83u l=0.5u
X3 WE.t23 VA.t1 a_5026_1208.t1 VSS nfet_06v0 ad=0.6448p pd=3u as=1.0912p ps=5.84u w=2.48u l=1u
X4 a_1038_1208.t2 VB.t0 WE.t17 VSS nfet_06v0 ad=1.0912p pd=5.84u as=0.6448p ps=3u w=2.48u l=1u
X5 a_2882_1208.t1 WE.t14 WE.t15 VSS nfet_06v0 ad=0.88p pd=4.88u as=0.52p ps=2.52u w=2u l=1u
X6 a_4282_1138.t1 WE.t26 VSS.t3 VSS nfet_06v0 ad=0.5p pd=2.5u as=0.88p ps=4.88u w=2u l=1u
X7 a_3040_0.t1 a_1376_n116.t6 VSS.t4 VSS nfet_06v0 ad=0.175p pd=1.2u as=0.308p ps=2.28u w=0.7u l=1u
X8 a_3260_3416.t1 WE.t24 VSS.t8 VSS nfet_05v0 ad=0.5808p pd=3.52u as=0.5808p ps=3.52u w=1.32u l=0.6u
X9 a_3640_0.t1 a_1376_n116.t4 a_3340_0.t1 VSS nfet_06v0 ad=0.175p pd=1.2u as=0.175p ps=1.2u w=0.7u l=1u
X10 OUT_N.t0 OUT.t2 VSS.t0 VSS nfet_05v0 ad=0.5808p pd=3.52u as=0.5808p ps=3.52u w=1.32u l=0.6u
X11 a_5026_1208.t2 VA.t0 WE.t22 VSS nfet_06v0 ad=1.0912p pd=5.84u as=0.6448p ps=3u w=2.48u l=1u
X12 a_5026_1208.t0 a_1376_n116.t9 VSS.t5 VSS nfet_06v0 ad=0.5456p pd=3.36u as=0.5456p ps=3.36u w=1.24u l=1u
X13 OUT_N.t1 OUT.t3 VDD.t7 VDD pfet_05v0 ad=0.8052p pd=4.54u as=0.8052p ps=4.54u w=1.83u l=0.5u
X14 a_n74_1208.t2 VD.t0 WE.t19 VSS nfet_06v0 ad=1.0912p pd=5.84u as=0.6448p ps=3u w=2.48u l=1u
X15 VDD.t9 WE.t2 WE.t3 VDD pfet_06v0 ad=0.52p pd=2.52u as=0.52p ps=2.52u w=2u l=1u
X16 WE.t9 WE.t8 VDD.t1 VDD pfet_06v0 ad=0.52p pd=2.52u as=0.52p ps=2.52u w=2u l=1u
X17 a_2882_1208.t2 WE.t25 a_4282_1138.t0 VSS nfet_06v0 ad=0.88p pd=4.88u as=0.5p ps=2.5u w=2u l=1u
X18 WE.t1 WE.t0 VDD.t0 VDD pfet_06v0 ad=0.52p pd=2.52u as=0.88p ps=4.88u w=2u l=1u
X19 OUT.t1 a_3260_3416.t3 VDD.t6 VDD pfet_05v0 ad=0.8052p pd=4.54u as=0.8052p ps=4.54u w=1.83u l=0.5u
X20 WE.t16 VB.t1 a_1038_1208.t1 VSS nfet_06v0 ad=0.6448p pd=3u as=1.0912p ps=5.84u w=2.48u l=1u
X21 VDD.t3 WE.t10 WE.t11 VDD pfet_06v0 ad=0.88p pd=4.88u as=0.52p ps=2.52u w=2u l=1u
X22 WE.t13 WE.t12 a_2882_1208.t0 VSS nfet_06v0 ad=0.52p pd=2.52u as=0.88p ps=4.88u w=2u l=1u
X23 WE.t5 WE.t4 VDD.t8 VDD pfet_06v0 ad=0.52p pd=2.52u as=0.52p ps=2.52u w=2u l=1u
X24 a_n74_0.t0 a_1376_n116.t8 VSS.t2 VSS nfet_06v0 ad=0.5456p pd=3.36u as=0.5456p ps=3.36u w=1.24u l=1u
X25 a_n74_1208.t0 a_1376_n116.t7 VSS.t1 VSS nfet_06v0 ad=0.5456p pd=3.36u as=0.5456p ps=3.36u w=1.24u l=1u
X26 a_3340_0.t0 a_1376_n116.t5 a_3040_0.t0 VSS nfet_06v0 ad=0.175p pd=1.2u as=0.175p ps=1.2u w=0.7u l=1u
X27 WE.t18 VD.t1 a_n74_1208.t1 VSS nfet_06v0 ad=0.6448p pd=3u as=1.0912p ps=5.84u w=2.48u l=1u
X28 a_n74_0.t2 VC.t0 WE.t21 VSS nfet_06v0 ad=1.0912p pd=5.84u as=0.6448p ps=3u w=2.48u l=1u
X29 a_1376_n116.t3 a_1376_n116.t2 a_3640_0.t0 VSS nfet_06v0 ad=0.308p pd=2.28u as=0.175p ps=1.2u w=0.7u l=1u
X30 a_1038_1208.t0 a_1376_n116.t10 VSS.t6 VSS nfet_06v0 ad=0.5456p pd=3.36u as=0.5456p ps=3.36u w=1.24u l=1u
X31 VDD.t5 WE.t6 WE.t7 VDD pfet_06v0 ad=0.52p pd=2.52u as=0.52p ps=2.52u w=2u l=1u
X32 WE.t20 VC.t1 a_n74_0.t1 VSS nfet_06v0 ad=0.6448p pd=3u as=1.0912p ps=5.84u w=2.48u l=1u
R0 VC.n0 VC.t0 17.3073
R1 VC.n0 VC.t1 15.9725
R2 VC VC.n0 1.083
R3 VSS.n15 VSS.t4 9.93823
R4 VSS.n19 VSS.n14 9.0005
R5 VSS.n21 VSS.n20 9.0005
R6 VSS.n22 VSS.n1 9.0005
R7 VSS.n24 VSS.n23 9.0005
R8 VSS.n13 VSS.n0 9.0005
R9 VSS.n12 VSS.n11 9.0005
R10 VSS.n7 VSS.n2 9.0005
R11 VSS.n6 VSS.n5 9.0005
R12 VSS.n16 VSS.t2 5.69436
R13 VSS.n17 VSS.t1 5.6202
R14 VSS.n10 VSS.t8 5.51806
R15 VSS.n8 VSS.t7 5.51806
R16 VSS.n3 VSS.t0 5.51806
R17 VSS.n4 VSS.t5 5.07216
R18 VSS.n18 VSS.t6 4.99947
R19 VSS.n5 VSS.n4 4.72864
R20 VSS.n9 VSS.t3 3.00965
R21 VSS.n16 VSS.n14 2.03917
R22 VSS.n13 VSS.n12 0.4005
R23 VSS.n17 VSS.n16 0.287892
R24 VSS.n5 VSS.n2 0.2005
R25 VSS.n12 VSS.n2 0.2005
R26 VSS.n23 VSS.n13 0.2005
R27 VSS.n23 VSS.n22 0.2005
R28 VSS.n22 VSS.n21 0.2005
R29 VSS.n21 VSS.n14 0.2005
R30 VSS.n7 VSS.n6 0.2005
R31 VSS.n24 VSS.n1 0.2005
R32 VSS.n20 VSS.n19 0.2005
R33 VSS VSS.n0 0.1995
R34 VSS.n10 VSS.n9 0.1955
R35 VSS.n11 VSS.n8 0.193
R36 VSS.n4 VSS.n3 0.15269
R37 VSS.n15 VSS.n1 0.15
R38 VSS.n11 VSS.n10 0.134
R39 VSS.n6 VSS.n3 0.119
R40 VSS.n9 VSS.n0 0.072
R41 VSS.n18 VSS.n17 0.0655
R42 VSS.n20 VSS.n15 0.051
R43 VSS.n19 VSS.n18 0.051
R44 VSS.n8 VSS.n7 0.008
R45 VSS VSS.n24 0.0015
R46 VA.n0 VA.t1 17.1173
R47 VA.n0 VA.t0 16.1625
R48 VA VA.n0 1.0668
R49 VB.n0 VB.t1 17.1173
R50 VB.n0 VB.t0 16.1625
R51 VB VB.n0 1.32507
R52 VD.n0 VD.t1 17.1173
R53 VD.n0 VD.t0 16.1625
R54 VD VD.n0 0.808543
R55 OUT_N OUT_N.t0 5.32182
R56 OUT_N OUT_N.t1 3.92072
R57 VDD.n11 VDD.n3 9.0005
R58 VDD.n13 VDD.n12 9.0005
R59 VDD.n15 VDD.n14 9.0005
R60 VDD.n5 VDD.t3 7.70006
R61 VDD.n8 VDD.t0 6.898
R62 VDD.n9 VDD.n8 6.26061
R63 VDD.n7 VDD.n6 6.0255
R64 VDD.n5 VDD.n4 6.0255
R65 VDD.n2 VDD.t7 3.40193
R66 VDD.n1 VDD.t2 3.323
R67 VDD.n0 VDD.t6 3.323
R68 VDD.n10 VDD.t4 2.82475
R69 VDD.n14 VDD.n2 1.81072
R70 VDD.n9 VDD.n3 1.62272
R71 VDD.n6 VDD.t8 0.9105
R72 VDD.n6 VDD.t9 0.9105
R73 VDD.n4 VDD.t1 0.9105
R74 VDD.n4 VDD.t5 0.9105
R75 VDD.n7 VDD.n5 0.805206
R76 VDD.n8 VDD.n7 0.802559
R77 VDD.n10 VDD.n9 0.504638
R78 VDD.n2 VDD.n0 0.270477
R79 VDD.n14 VDD.n13 0.2005
R80 VDD.n13 VDD.n3 0.2005
R81 VDD.n12 VDD.n11 0.2005
R82 VDD.n11 VDD.n10 0.196
R83 VDD.n15 VDD.n1 0.19
R84 VDD VDD.n0 0.166
R85 VDD.n12 VDD.n1 0.011
R86 VDD VDD.n15 0.0015
R87 OUT.n1 OUT.t3 32.7434
R88 OUT.n1 OUT.n0 27.0301
R89 OUT.n0 OUT.t2 26.4905
R90 OUT OUT.t0 5.83834
R91 OUT OUT.n1 5.42139
R92 OUT.n0 OUT 5.30889
R93 OUT OUT.t1 4.17898
R94 WE.n6 WE.t24 30.4248
R95 WE.n22 WE.t27 29.3188
R96 WE.n7 WE.n6 21.4537
R97 WE.n17 WE.t26 19.8695
R98 WE.n16 WE.t25 19.8695
R99 WE.n16 WE.n15 19.0431
R100 WE.n14 WE.n8 17.1628
R101 WE.n20 WE.n19 17.0986
R102 WE.n28 WE.n27 16.9828
R103 WE.n21 WE.t12 15.3272
R104 WE.n9 WE.t10 14.9805
R105 WE.n13 WE.t8 14.8655
R106 WE.n21 WE.t14 14.2942
R107 WE.n11 WE.t0 14.2205
R108 WE.n10 WE.t2 14.2205
R109 WE.n9 WE.t6 14.2205
R110 WE.n12 WE.t4 14.2205
R111 WE WE.n5 13.335
R112 WE WE.n4 7.47982
R113 WE.n2 WE.n0 6.83021
R114 WE.n6 WE 6.68621
R115 WE.n26 WE.n25 6.3905
R116 WE.n14 WE.n13 6.34159
R117 WE.n2 WE.n1 6.0255
R118 WE.n4 WE.n3 6.0255
R119 WE.n25 WE.n18 5.1305
R120 WE WE.n29 4.5005
R121 WE.n25 WE.n24 4.5005
R122 WE.n23 WE.n22 4.5005
R123 WE.n23 WE.n7 1.87282
R124 WE.n26 WE.n14 1.26371
R125 WE.n11 WE.n10 1.16479
R126 WE.n22 WE.n21 1.03872
R127 WE.n0 WE.t3 0.9105
R128 WE.n0 WE.t1 0.9105
R129 WE.n1 WE.t7 0.9105
R130 WE.n1 WE.t5 0.9105
R131 WE.n3 WE.t11 0.9105
R132 WE.n3 WE.t9 0.9105
R133 WE.n19 WE.t15 0.8195
R134 WE.n19 WE.t13 0.8195
R135 WE.n4 WE.n2 0.805206
R136 WE.n10 WE.n9 0.7605
R137 WE.n12 WE.n11 0.7605
R138 WE.n8 WE.t19 0.660984
R139 WE.n8 WE.t18 0.660984
R140 WE.n27 WE.t17 0.660984
R141 WE.n27 WE.t16 0.660984
R142 WE.n15 WE.t22 0.660984
R143 WE.n15 WE.t23 0.660984
R144 WE.n5 WE.t21 0.660984
R145 WE.n5 WE.t20 0.660984
R146 WE.n24 WE.n20 0.505143
R147 WE.n18 WE.n17 0.476214
R148 WE.n17 WE.n16 0.4505
R149 WE.n20 WE.n18 0.325143
R150 WE.n28 WE.n26 0.241571
R151 WE.n29 WE.n7 0.186929
R152 WE.n29 WE.n28 0.1805
R153 WE.n13 WE.n12 0.1155
R154 WE.n24 WE.n23 0.0632632
R155 a_3640_0.t0 a_3640_0.t1 4.5005
R156 a_3340_0.t0 a_3340_0.t1 4.5005
R157 a_3040_0.t0 a_3040_0.t1 4.5005
R158 a_n74_0.t0 a_n74_0.n0 24.2505
R159 a_n74_0.n0 a_n74_0.t2 7.7829
R160 a_n74_0.n0 a_n74_0.t1 6.98348
R161 a_4282_1138.t0 a_4282_1138.t1 1.5755
R162 a_5026_1208.t0 a_5026_1208.n0 23.5139
R163 a_5026_1208.n0 a_5026_1208.t2 7.7829
R164 a_5026_1208.n0 a_5026_1208.t1 6.98348
R165 a_2882_1208.t1 a_2882_1208.n0 7.88141
R166 a_2882_1208.n0 a_2882_1208.t2 22.7862
R167 a_2882_1208.n0 a_2882_1208.t0 7.082
R168 a_1038_1208.t0 a_1038_1208.n0 24.5469
R169 a_1038_1208.n0 a_1038_1208.t2 7.7829
R170 a_1038_1208.n0 a_1038_1208.t1 6.98348
R171 a_n74_1208.t0 a_n74_1208.n0 52.9511
R172 a_n74_1208.n0 a_n74_1208.t2 7.7829
R173 a_n74_1208.n0 a_n74_1208.t1 6.98348
R174 a_3260_3416.t1 a_3260_3416.n0 11.405
R175 a_3260_3416.n0 a_3260_3416.n1 28.7679
R176 a_3260_3416.n1 a_3260_3416.t0 9.85814
R177 a_3260_3416.n1 a_3260_3416.t3 33.0017
R178 a_3260_3416.n0 a_3260_3416.t2 26.7487
R179 a_1376_n116.t3 a_1376_n116.n8 14.2588
R180 a_1376_n116.n8 a_1376_n116.n7 24.9705
R181 a_1376_n116.n7 a_1376_n116.t9 18.2084
R182 a_1376_n116.n7 a_1376_n116.n5 5.59818
R183 a_1376_n116.n5 a_1376_n116.n6 0.239964
R184 a_1376_n116.n6 a_1376_n116.t10 18.0894
R185 a_1376_n116.n6 a_1376_n116.t0 20.1982
R186 a_1376_n116.n5 a_1376_n116.t1 8.63065
R187 a_1376_n116.n8 a_1376_n116.n0 0.239964
R188 a_1376_n116.n0 a_1376_n116.n1 0.4505
R189 a_1376_n116.n1 a_1376_n116.n2 0.4505
R190 a_1376_n116.n2 a_1376_n116.n3 0.4505
R191 a_1376_n116.n3 a_1376_n116.n4 1.14479
R192 a_1376_n116.n4 a_1376_n116.t8 17.915
R193 a_1376_n116.n4 a_1376_n116.t7 16.7707
R194 a_1376_n116.n3 a_1376_n116.t6 14.7997
R195 a_1376_n116.n2 a_1376_n116.t5 14.7997
R196 a_1376_n116.n1 a_1376_n116.t4 14.7997
R197 a_1376_n116.n0 a_1376_n116.t2 14.7997
R198 VDD VDD 355.517
R199 VDD VDD 266.2
R200 VDD VDD 266.2
R201 VDD VDD 266.2
R202 VDD VDD 266.2
R203 VDD VDD 266.2
R204 VDD VDD 711.034
R205 VDD VDD 667.25
R206 VDD VDD 623.468
R207 VDD VDD 623.468
R208 VSS VSS 340.332
R209 VSS VSS 256.091
R210 VSS VSS 680.664
R211 VSS VSS 210.601
R212 VSS VSS 45.4904
R213 VSS VSS 571.152
R214 VSS VSS 109.513
R215 VSS VSS 507.128
R216 VSS VSS 109.513
R217 VSS VSS 143.209
R218 VSS VSS 112.882
R219 VSS VSS 139.839
R220 VSS VSS 252.722
R221 VSS VSS 288.103
R222 VSS VSS 252.722
R223 VSS VSS 42.1208
R224 VSS VSS 549.249
R225 VSS VSS 25.2727
R226 VSS VSS 256.091
R227 VSS VSS 267.885
R228 VSS VSS 412.779
C0 VC WE 0.56577f
C1 VSS VC 0.18688f
C2 VSS WE 1.28037f
C3 VSS OUT_N 0.27572f
C4 VDD WE 3.20075f
C5 OUT OUT_N 2.86376f
C6 VDD OUT_N 0.19846f
C7 VD WE 0.60265f
C8 VSS OUT 0.32988f
C9 VA WE 1.00936f
C10 VDD OUT 0.33105f
C11 VSS VD 0.12009f
C12 VB WE 0.78284f
C13 VDD VD 0.02903f
C14 VSS VA 0.1602f
C15 VA OUT 0.1556f
C16 VSS VB 0.14225f
C17 VDD VB 0.09192f
C18 VC 0 0.90942f
C19 VSS 0 6.35505f
C20 VA 0 1.6999f
C21 VB 0 1.47411f
C22 VD 0 0.7875f
C23 OUT_N 0 5.52431f
C24 VDD 0 4.68127f
C25 OUT 0 2.62065f
C26 WE 0 7.63612f
C27 VDD 0 0.23143f
C28 VDD 0 0.40472f
C29 VDD 0 0.34657f
C30 VDD 0 0.34657f
C31 VDD 0 0.34657f
C32 VDD 0 0.34657f
C33 VDD 0 0.63615f
C34 VDD 0 0.89722f
C35 VDD 0 0.84021f
C36 VDD 0 0.81171f
C37 VDD 0 0.81171f
C38 a_1376_n116.t3 0 0.12872f
C39 a_1376_n116.t2 0 0.24355f
C40 a_1376_n116.n0 0 0.24628f
C41 a_1376_n116.t4 0 0.24355f
C42 a_1376_n116.n1 0 0.26539f
C43 a_1376_n116.t5 0 0.24355f
C44 a_1376_n116.n2 0 0.26539f
C45 a_1376_n116.t6 0 0.24355f
C46 a_1376_n116.n3 0 0.32842f
C47 a_1376_n116.t7 0 0.32734f
C48 a_1376_n116.n4 0 0.72394f
C49 a_1376_n116.t8 0 0.34806f
C50 a_1376_n116.t1 0 0.42273f
C51 a_1376_n116.n5 0 0.68597f
C52 a_1376_n116.t0 0 0.47173f
C53 a_1376_n116.n6 0 0.66682f
C54 a_1376_n116.t10 0 0.38151f
C55 a_1376_n116.t9 0 0.38379f
C56 a_1376_n116.n7 0 1.67116f
C57 a_1376_n116.n8 0 1.29649f
C58 a_3260_3416.t1 0 0.45474f
C59 a_3260_3416.t2 0 0.32985f
C60 a_3260_3416.n0 0 2.80809f
C61 a_3260_3416.t3 0 0.32862f
C62 a_3260_3416.n1 0 3.11567f
C63 a_3260_3416.t0 0 0.61331f
C64 a_n74_1208.t0 0 2.40747f
C65 a_n74_1208.t1 0 0.42205f
C66 a_n74_1208.n0 0 3.02542f
C67 a_n74_1208.t2 0 0.44742f
C68 a_1038_1208.t0 0 1.05976f
C69 a_1038_1208.t1 0 0.56127f
C70 a_1038_1208.n0 0 1.69366f
C71 a_1038_1208.t2 0 0.59503f
C72 a_2882_1208.t1 0 0.47935f
C73 a_2882_1208.t0 0 0.44745f
C74 a_2882_1208.n0 0 1.63788f
C75 a_2882_1208.t2 0 1.29983f
C76 a_5026_1208.t0 0 0.75704f
C77 a_5026_1208.t1 0 0.44462f
C78 a_5026_1208.n0 0 1.25707f
C79 a_5026_1208.t2 0 0.47136f
C80 a_4282_1138.t0 0 0.02368f
C81 a_4282_1138.t1 0 0.02368f
C82 a_n74_0.t0 0 0.76398f
C83 a_n74_0.t1 0 0.35839f
C84 a_n74_0.n0 0 1.15703f
C85 a_n74_0.t2 0 0.37995f
C86 WE.t3 0 0.06342f
C87 WE.t1 0 0.06342f
C88 WE.n0 0 0.25823f
C89 WE.t7 0 0.06342f
C90 WE.t5 0 0.06342f
C91 WE.n1 0 0.23768f
C92 WE.n2 0 0.4386f
C93 WE.t11 0 0.06342f
C94 WE.t9 0 0.06342f
C95 WE.n3 0 0.23768f
C96 WE.n4 0 0.45052f
C97 WE.t24 0 0.32679f
C98 WE.t21 0 0.07864f
C99 WE.t20 0 0.07864f
C100 WE.n5 0 0.45405f
C101 WE.n6 0 2.16393f
C102 WE.n7 0 0.94359f
C103 WE.t19 0 0.07864f
C104 WE.t18 0 0.07864f
C105 WE.n8 0 0.57337f
C106 WE.t8 0 0.38125f
C107 WE.t10 0 0.43823f
C108 WE.t6 0 0.4214f
C109 WE.n9 0 0.73607f
C110 WE.t2 0 0.4214f
C111 WE.n10 0 0.48516f
C112 WE.t0 0 0.36774f
C113 WE.n11 0 0.4783f
C114 WE.t4 0 0.36774f
C115 WE.n12 0 0.30795f
C116 WE.n13 0 0.67254f
C117 WE.n14 0 0.63017f
C118 WE.t22 0 0.07864f
C119 WE.t23 0 0.07864f
C120 WE.n15 0 0.63607f
C121 WE.t25 0 0.53656f
C122 WE.n16 0 1.14708f
C123 WE.t26 0 0.53656f
C124 WE.n17 0 0.42564f
C125 WE.n18 0 0.12389f
C126 WE.t15 0 0.06342f
C127 WE.t13 0 0.06342f
C128 WE.n19 0 0.50727f
C129 WE.n20 0 0.46807f
C130 WE.t14 0 0.42249f
C131 WE.t12 0 0.44841f
C132 WE.n21 0 0.83208f
C133 WE.t27 0 0.21408f
C134 WE.n22 0 0.51792f
C135 WE.n23 0 0.21994f
C136 WE.n24 0 0.07699f
C137 WE.n25 0 0.98569f
C138 WE.n26 0 0.3065f
C139 WE.t17 0 0.07864f
C140 WE.t16 0 0.07864f
C141 WE.n27 0 0.56896f
C142 WE.n28 0 0.43673f
C143 WE.n29 0 0.05503f
C144 OUT.t1 0 0.34915f
C145 OUT.t0 0 0.24172f
C146 OUT.t2 0 0.33982f
C147 OUT.n0 0 2.40421f
C148 OUT.t3 0 0.34074f
C149 OUT.n1 0 3.70281f
C150 VDD.t6 0 0.04954f
C151 VDD.n0 0 0.2104f
C152 VDD.t2 0 0.04954f
C153 VDD.n1 0 0.10157f
C154 VDD.t7 0 0.07744f
C155 VDD.n2 0 1.37023f
C156 VDD.n3 0 0.82914f
C157 VDD.t4 0 0.05295f
C158 VDD.t3 0 0.10611f
C159 VDD.t1 0 0.02007f
C160 VDD.t5 0 0.02007f
C161 VDD.n4 0 0.0752f
C162 VDD.n5 0 0.15206f
C163 VDD.t8 0 0.02007f
C164 VDD.t9 0 0.02007f
C165 VDD.n6 0 0.0752f
C166 VDD.n7 0 0.08995f
C167 VDD.t0 0 0.09889f
C168 VDD.n8 0 0.14329f
C169 VDD.n9 0 0.94784f
C170 VDD.n10 0 0.40061f
C171 VDD.n11 0 0.14353f
C172 VDD.n12 0 0.07928f
C173 VDD.n13 0 0.14509f
C174 VDD.n14 0 1.12282f
C175 VDD.n15 0 0.07233f
C176 OUT_N.t1 0 0.22135f
C177 OUT_N.t0 0 0.14281f
C178 VD.t0 0 0.45491f
C179 VD.t1 0 0.4758f
C180 VD.n0 0 0.8005f
C181 VB.t0 0 0.44718f
C182 VB.t1 0 0.46772f
C183 VB.n0 0 0.81911f
C184 VA.t0 0 0.58828f
C185 VA.t1 0 0.6153f
C186 VA.n0 0 1.05637f
C187 VSS.n0 0 0.08135f
C188 VSS.n1 0 0.10364f
C189 VSS.n2 0 0.11789f
C190 VSS.t7 0 0.03385f
C191 VSS.t0 0 0.03385f
C192 VSS.n3 0 0.12798f
C193 VSS.t5 0 0.03662f
C194 VSS.n4 0 0.42442f
C195 VSS.n5 0 0.52103f
C196 VSS.n6 0 0.09489f
C197 VSS.n7 0 0.06357f
C198 VSS.n8 0 0.09616f
C199 VSS.t8 0 0.03385f
C200 VSS.t3 0 0.05417f
C201 VSS.n9 0 0.13738f
C202 VSS.n10 0 0.13242f
C203 VSS.n11 0 0.09701f
C204 VSS.n12 0 0.17432f
C205 VSS.n13 0 0.17432f
C206 VSS.n14 0 0.68743f
C207 VSS.t4 0 0.01891f
C208 VSS.n15 0 0.10236f
C209 VSS.t6 0 0.03124f
C210 VSS.t1 0 0.03191f
C211 VSS.t2 0 0.03982f
C212 VSS.n16 0 0.7229f
C213 VSS.n17 0 0.157f
C214 VSS.n18 0 0.07886f
C215 VSS.n19 0 0.0757f
C216 VSS.n20 0 0.0757f
C217 VSS.n21 0 0.11789f
C218 VSS.n22 0 0.11789f
C219 VSS.n23 0 0.11789f
C220 VSS.n24 0 0.06173f
C221 VC.t0 0 0.46836f
C222 VC.t1 0 0.4388f
C223 VC.n0 0 0.78738f
.ends
