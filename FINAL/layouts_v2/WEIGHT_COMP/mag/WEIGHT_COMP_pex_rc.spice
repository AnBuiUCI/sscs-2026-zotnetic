* Nodos de bulk atados: 11 de pozo n -> VDD, 28 de sustrato -> VSS.
*   magic no extrae los taps de este layout y los dejaba flotando;
*   la conexion si existe (el LVS de KLayout da 'match uniquely').
*   Quien detecta un tap que falte de verdad es el LVS, no esto.
* NGSPICE file created from WEIGHT_COMP.ext - technology: gf180mcuD

.subckt WEIGHT_COMP VSS VDD VC VD WE VB OUT OUT_N VA
X0 OUT.t0 a_3260_3548.t3 VDD.t5 VDD pfet_05v0 ad=0.8052p pd=4.54u as=0.8052p ps=4.54u w=1.83u l=0.5u
X1 WE.t11 WE.t10 VDD.t6 VDD pfet_06v0 ad=0.52p pd=2.52u as=0.88p ps=4.88u w=2u l=1u
X2 WE.t3 VA.t1 a_5026_1208.t0 VSS nfet_06v0 ad=0.6448p pd=3u as=1.0912p ps=5.84u w=2.48u l=1u
X3 VDD.t9 WE.t20 WE.t21 VDD pfet_06v0 ad=0.88p pd=4.88u as=0.52p ps=2.52u w=2u l=1u
X4 a_2984_0.t0 a_n24_n116.t4 VSS.t0 VSS nfet_06v0 ad=0.5456p pd=3.36u as=0.5456p ps=3.36u w=1.24u l=1u
X5 a_3260_3548.t1 WE.t26 VSS.t3 VSS nfet_05v0 ad=0.5808p pd=3.52u as=0.5808p ps=3.52u w=1.32u l=0.6u
X6 WE.t15 WE.t14 VDD.t3 VDD pfet_06v0 ad=0.52p pd=2.52u as=0.52p ps=2.52u w=2u l=1u
X7 a_1038_1208.t1 VB.t0 WE.t0 VSS nfet_06v0 ad=1.0912p pd=5.84u as=0.6448p ps=3u w=2.48u l=1u
X8 a_2984_0.t2 VDD.t10 WE.t5 VSS nfet_06v0 ad=1.0912p pd=5.84u as=0.6448p ps=3u w=2.48u l=1u
X9 OUT_N.t1 OUT.t2 VSS.t2 VSS nfet_05v0 ad=0.5808p pd=3.52u as=0.5808p ps=3.52u w=1.32u l=0.6u
X10 a_2882_1208.t2 WE.t22 WE.t23 VSS nfet_06v0 ad=0.88p pd=4.88u as=0.52p ps=2.52u w=2u l=1u
X11 a_4282_1138.t0 WE.t28 VSS.t1 VSS nfet_06v0 ad=0.5p pd=2.5u as=0.88p ps=4.88u w=2u l=1u
X12 a_176_0.t0 a_n24_n116.t9 VSS.t4 VSS nfet_06v0 ad=0.5456p pd=3.36u as=0.5456p ps=3.36u w=1.24u l=1u
X13 a_n24_n116.t3 a_n24_n116.t2 VDD.t7 VDD pfet_06v0 ad=0.88p pd=4.88u as=0.88p ps=4.88u w=2u l=1u
X14 a_5026_1208.t1 VA.t0 WE.t2 VSS nfet_06v0 ad=1.0912p pd=5.84u as=0.6448p ps=3u w=2.48u l=1u
X15 a_5026_1208.t2 a_n24_n116.t10 VSS.t5 VSS nfet_06v0 ad=0.5456p pd=3.36u as=0.5456p ps=3.36u w=1.24u l=1u
X16 a_1940_0.t1 a_n24_n116.t6 a_1640_0.t0 VSS nfet_06v0 ad=0.175p pd=1.2u as=0.175p ps=1.2u w=0.7u l=1u
X17 a_n24_n116.t1 a_n24_n116.t0 a_2240_0.t1 VSS nfet_06v0 ad=0.308p pd=2.28u as=0.175p ps=1.2u w=0.7u l=1u
X18 OUT.t1 a_3260_3548.t2 VSS.t6 VSS nfet_05v0 ad=0.5808p pd=3.52u as=0.5808p ps=3.52u w=1.32u l=0.6u
X19 VDD.t8 WE.t16 WE.t17 VDD pfet_06v0 ad=0.52p pd=2.52u as=0.52p ps=2.52u w=2u l=1u
X20 a_n74_1208.t1 VD.t0 WE.t7 VSS nfet_06v0 ad=1.0912p pd=5.84u as=0.6448p ps=3u w=2.48u l=1u
X21 a_2882_1208.t0 WE.t27 a_4282_1138.t1 VSS nfet_06v0 ad=0.88p pd=4.88u as=0.5p ps=2.5u w=2u l=1u
X22 a_3260_3548.t0 WE.t29 VDD.t0 VDD pfet_05v0 ad=0.8052p pd=4.54u as=0.8052p ps=4.54u w=1.83u l=0.5u
X23 a_908_0.t0 a_n24_n116.t8 VSS.t9 VSS nfet_06v0 ad=0.5456p pd=3.36u as=0.5456p ps=3.36u w=1.24u l=1u
X24 WE.t1 VB.t1 a_1038_1208.t0 VSS nfet_06v0 ad=0.6448p pd=3u as=1.0912p ps=5.84u w=2.48u l=1u
X25 WE.t9 WE.t8 a_2882_1208.t1 VSS nfet_06v0 ad=0.52p pd=2.52u as=0.88p ps=4.88u w=2u l=1u
X26 a_176_0.t2 VC.t0 WE.t24 VSS nfet_06v0 ad=1.0912p pd=5.84u as=0.6448p ps=3u w=2.48u l=1u
X27 WE.t6 VD.t1 a_n74_1208.t0 VSS nfet_06v0 ad=0.6448p pd=3u as=1.0912p ps=5.84u w=2.48u l=1u
X28 a_1640_0.t1 a_n24_n116.t7 VSS.t8 VSS nfet_06v0 ad=0.175p pd=1.2u as=0.308p ps=2.28u w=0.7u l=1u
X29 OUT_N.t0 OUT.t3 VDD.t1 VDD pfet_05v0 ad=0.8052p pd=4.54u as=0.8052p ps=4.54u w=1.83u l=0.5u
X30 WE.t25 VC.t1 a_176_0.t1 VSS nfet_06v0 ad=0.6448p pd=3u as=1.0912p ps=5.84u w=2.48u l=1u
X31 a_2240_0.t0 a_n24_n116.t5 a_1940_0.t0 VSS nfet_06v0 ad=0.175p pd=1.2u as=0.175p ps=1.2u w=0.7u l=1u
X32 WE.t19 WE.t18 VDD.t2 VDD pfet_06v0 ad=0.52p pd=2.52u as=0.52p ps=2.52u w=2u l=1u
X33 a_1038_1208.t2 a_n24_n116.t11 VSS.t7 VSS nfet_06v0 ad=0.5456p pd=3.36u as=0.5456p ps=3.36u w=1.24u l=1u
X34 WE.t4 VDD.t11 a_2984_0.t1 VSS nfet_06v0 ad=0.6448p pd=3u as=1.0912p ps=5.84u w=2.48u l=1u
X35 VDD.t4 WE.t12 WE.t13 VDD pfet_06v0 ad=0.52p pd=2.52u as=0.52p ps=2.52u w=2u l=1u
R0 VSS.n23 VSS.t8 9.93823
R1 VSS.n22 VSS.n21 9.0005
R2 VSS.n23 VSS.n18 9.0005
R3 VSS.n25 VSS.n24 9.0005
R4 VSS.n27 VSS.n26 9.0005
R5 VSS.n28 VSS.n16 9.0005
R6 VSS.n30 VSS.n29 9.0005
R7 VSS.n31 VSS.n1 9.0005
R8 VSS.n33 VSS.n32 9.0005
R9 VSS.n15 VSS.n14 9.0005
R10 VSS.n13 VSS.n2 9.0005
R11 VSS.n11 VSS.n10 9.0005
R12 VSS.n9 VSS.n3 9.0005
R13 VSS.n8 VSS.n7 9.0005
R14 VSS.n20 VSS.t4 5.8527
R15 VSS.n19 VSS.t9 5.6202
R16 VSS.n0 VSS.t0 5.6202
R17 VSS.n12 VSS.t3 5.51806
R18 VSS.n6 VSS.t6 5.51806
R19 VSS.n5 VSS.t2 5.51806
R20 VSS.n4 VSS.t5 4.99947
R21 VSS.n17 VSS.t7 4.99947
R22 VSS.n21 VSS.n20 4.701
R23 VSS.n34 VSS.t1 3.00965
R24 VSS.n8 VSS.n4 2.78747
R25 VSS.n9 VSS.n8 0.2005
R26 VSS.n10 VSS.n9 0.2005
R27 VSS.n10 VSS.n2 0.2005
R28 VSS.n15 VSS.n2 0.2005
R29 VSS.n32 VSS.n15 0.2005
R30 VSS.n32 VSS.n31 0.2005
R31 VSS.n31 VSS.n30 0.2005
R32 VSS.n30 VSS.n16 0.2005
R33 VSS.n26 VSS.n16 0.2005
R34 VSS.n26 VSS.n25 0.2005
R35 VSS.n25 VSS.n18 0.2005
R36 VSS.n21 VSS.n18 0.2005
R37 VSS.n11 VSS.n3 0.2005
R38 VSS.n14 VSS.n13 0.2005
R39 VSS.n33 VSS.n1 0.2005
R40 VSS.n29 VSS.n1 0.2005
R41 VSS.n29 VSS.n28 0.2005
R42 VSS.n28 VSS.n27 0.2005
R43 VSS.n24 VSS.n23 0.2005
R44 VSS.n23 VSS.n22 0.2005
R45 VSS.n24 VSS.n17 0.1995
R46 VSS.n7 VSS.n5 0.1905
R47 VSS.n22 VSS.n19 0.1665
R48 VSS.n13 VSS.n12 0.1385
R49 VSS.n7 VSS.n6 0.1365
R50 VSS.n20 VSS.n19 0.132826
R51 VSS.n34 VSS.n33 0.1215
R52 VSS.n6 VSS.n3 0.0645
R53 VSS.n12 VSS.n11 0.0625
R54 VSS VSS.n0 0.044
R55 VSS.n14 VSS.n0 0.0285
R56 VSS VSS.n34 0.008
R57 VSS.n5 VSS.n4 0.0035
R58 VSS.n27 VSS.n17 0.0015
R59 VC.n0 VC.t1 17.1173
R60 VC.n0 VC.t0 16.1625
R61 VC VC.n0 0.550283
R62 VA.n0 VA.t1 17.1173
R63 VA.n0 VA.t0 16.1625
R64 VA VA.n0 2.35811
R65 VB.n0 VB.t1 17.1173
R66 VB.n0 VB.t0 16.1625
R67 VB VB.n0 1.58333
R68 VD.n0 VD.t1 17.1173
R69 VD.n0 VD.t0 16.1625
R70 VD VD.n0 0.808543
R71 OUT_N OUT_N.t1 5.32182
R72 OUT_N OUT_N.t0 4.17898
R73 VDD.n11 VDD.n10 23.4658
R74 VDD.n10 VDD.t11 17.1173
R75 VDD.n10 VDD.t10 16.1625
R76 VDD.n13 VDD.n12 9.0005
R77 VDD.n15 VDD.n2 9.0005
R78 VDD.n17 VDD.n16 9.0005
R79 VDD.n18 VDD.n1 9.0005
R80 VDD.n20 VDD.n19 9.0005
R81 VDD.n5 VDD.t9 7.70006
R82 VDD.n8 VDD.t6 6.898
R83 VDD.n9 VDD.n8 6.20962
R84 VDD.n7 VDD.n6 6.0255
R85 VDD.n5 VDD.n4 6.0255
R86 VDD.n0 VDD.t1 3.35463
R87 VDD.n3 VDD.t0 3.323
R88 VDD.n21 VDD.t5 3.323
R89 VDD.n14 VDD.t7 2.82475
R90 VDD.n11 VDD.n9 1.97332
R91 VDD.n19 VDD.n0 1.82991
R92 VDD.n6 VDD.t3 0.9105
R93 VDD.n6 VDD.t4 0.9105
R94 VDD.n4 VDD.t2 0.9105
R95 VDD.n4 VDD.t8 0.9105
R96 VDD.n7 VDD.n5 0.805206
R97 VDD.n8 VDD.n7 0.802559
R98 VDD.n13 VDD.n9 0.56189
R99 VDD VDD.n0 0.210728
R100 VDD.n19 VDD.n18 0.2005
R101 VDD.n18 VDD.n17 0.2005
R102 VDD.n17 VDD.n2 0.2005
R103 VDD.n12 VDD.n2 0.2005
R104 VDD.n20 VDD.n1 0.2005
R105 VDD.n16 VDD.n15 0.2005
R106 VDD.n15 VDD.n14 0.1465
R107 VDD.n3 VDD.n1 0.1405
R108 VDD VDD.n21 0.113
R109 VDD.n12 VDD.n11 0.106
R110 VDD.n16 VDD.n3 0.0605
R111 VDD.n14 VDD.n13 0.0545
R112 VDD.n21 VDD.n20 0.0165
R113 OUT.n1 OUT.t3 33.0017
R114 OUT.n1 OUT.n0 29.4876
R115 OUT.n0 OUT.t2 26.2322
R116 OUT OUT.t1 5.58008
R117 OUT OUT.n1 5.42139
R118 OUT.n0 OUT 5.30889
R119 OUT OUT.t0 4.43725
R120 WE.n7 WE.t29 29.5665
R121 WE.n11 WE.t26 25.9739
R122 WE.n12 WE.n11 22.7321
R123 WE.n16 WE.t27 19.8695
R124 WE.n17 WE.t28 19.8695
R125 WE.n12 WE.n9 19.5896
R126 WE.n19 WE.n18 17.0986
R127 WE.n14 WE.n13 16.9828
R128 WE.n6 WE.t8 15.3072
R129 WE.n23 WE.t20 14.9805
R130 WE.n27 WE.t18 14.8842
R131 WE.n6 WE.t22 14.3143
R132 WE.n25 WE.t10 14.2205
R133 WE.n24 WE.t12 14.2205
R134 WE.n23 WE.t16 14.2205
R135 WE.n26 WE.t14 14.2205
R136 WE WE.n10 12.8185
R137 WE.n31 WE.n5 12.5212
R138 WE.n29 WE.n28 12.5145
R139 WE WE.n4 7.72267
R140 WE.n2 WE.n0 6.83021
R141 WE.n11 WE 6.45157
R142 WE.n30 WE.n29 6.26354
R143 WE.n2 WE.n1 6.0255
R144 WE.n4 WE.n3 6.0255
R145 WE.n21 WE.n15 5.64595
R146 WE.n22 WE.n21 5.64595
R147 WE.n31 WE.n30 4.5005
R148 WE.n8 WE.n7 4.5005
R149 WE.n21 WE.n20 4.5005
R150 WE.n29 WE.n27 2.13294
R151 WE.n16 WE.n15 1.67193
R152 WE.n22 WE.n8 1.66389
R153 WE.n25 WE.n24 1.16479
R154 WE.n7 WE.n6 1.02813
R155 WE.n0 WE.t13 0.9105
R156 WE.n0 WE.t11 0.9105
R157 WE.n1 WE.t17 0.9105
R158 WE.n1 WE.t15 0.9105
R159 WE.n3 WE.t21 0.9105
R160 WE.n3 WE.t19 0.9105
R161 WE.n18 WE.t23 0.8195
R162 WE.n18 WE.t9 0.8195
R163 WE.n4 WE.n2 0.805206
R164 WE.n24 WE.n23 0.7605
R165 WE.n26 WE.n25 0.7605
R166 WE.n13 WE.t2 0.660984
R167 WE.n13 WE.t3 0.660984
R168 WE.n5 WE.t0 0.660984
R169 WE.n5 WE.t1 0.660984
R170 WE.n28 WE.t7 0.660984
R171 WE.n28 WE.t6 0.660984
R172 WE.n9 WE.t24 0.660984
R173 WE.n9 WE.t25 0.660984
R174 WE.n10 WE.t5 0.660984
R175 WE.n10 WE.t4 0.660984
R176 WE.n19 WE.n8 0.609607
R177 WE.n30 WE.n22 0.487464
R178 WE.n20 WE.n17 0.476214
R179 WE.n17 WE.n16 0.4505
R180 WE.n15 WE.n14 0.350857
R181 WE.n20 WE.n19 0.325143
R182 WE.n14 WE.n12 0.293
R183 WE.n27 WE.n26 0.09675
R184 WE WE.n31 0.0838824
R185 a_2240_0.t0 a_2240_0.t1 4.5005
R186 a_1940_0.t0 a_1940_0.t1 4.5005
R187 a_1640_0.t0 a_1640_0.t1 4.5005
R188 a_2984_0.t0 a_2984_0.n0 23.3322
R189 a_2984_0.n0 a_2984_0.t2 7.7829
R190 a_2984_0.n0 a_2984_0.t1 6.98348
R191 a_176_0.t0 a_176_0.n0 55.9115
R192 a_176_0.n0 a_176_0.t2 7.7829
R193 a_176_0.n0 a_176_0.t1 6.98348
R194 a_4282_1138.t0 a_4282_1138.t1 1.5755
R195 a_5026_1208.t1 a_5026_1208.n0 7.7829
R196 a_5026_1208.n0 a_5026_1208.t2 24.5469
R197 a_5026_1208.n0 a_5026_1208.t0 6.98348
R198 a_2882_1208.t1 a_2882_1208.n0 7.082
R199 a_2882_1208.n0 a_2882_1208.t0 22.7862
R200 a_2882_1208.n0 a_2882_1208.t2 7.88141
R201 a_1038_1208.t1 a_1038_1208.n0 7.7829
R202 a_1038_1208.n0 a_1038_1208.t2 24.5469
R203 a_1038_1208.n0 a_1038_1208.t0 6.98348
R204 a_n74_1208.t0 a_n74_1208.t1 14.7659
R205 a_3260_3548.t1 a_3260_3548.n0 11.1467
R206 a_3260_3548.n0 a_3260_3548.n1 31.7615
R207 a_3260_3548.n1 a_3260_3548.t0 10.1164
R208 a_3260_3548.n1 a_3260_3548.t3 33.2599
R209 a_3260_3548.n0 a_3260_3548.t2 26.4905
R210 a_n24_n116.t1 a_n24_n116.n9 14.2588
R211 a_n24_n116.n9 a_n24_n116.t4 19.4306
R212 a_n24_n116.n9 a_n24_n116.n0 0.239964
R213 a_n24_n116.n0 a_n24_n116.n1 0.4505
R214 a_n24_n116.n1 a_n24_n116.n2 0.4505
R215 a_n24_n116.n2 a_n24_n116.n3 0.4505
R216 a_n24_n116.n3 a_n24_n116.n4 1.14479
R217 a_n24_n116.n4 a_n24_n116.n5 1.14479
R218 a_n24_n116.n5 a_n24_n116.n6 27.1707
R219 a_n24_n116.n6 a_n24_n116.n7 0.1805
R220 a_n24_n116.n7 a_n24_n116.n8 0.239964
R221 a_n24_n116.n8 a_n24_n116.t10 23.8382
R222 a_n24_n116.n8 a_n24_n116.t3 8.88891
R223 a_n24_n116.n7 a_n24_n116.t2 20.4565
R224 a_n24_n116.n6 a_n24_n116.t11 17.9094
R225 a_n24_n116.n5 a_n24_n116.t9 16.7707
R226 a_n24_n116.n4 a_n24_n116.t8 16.7707
R227 a_n24_n116.n3 a_n24_n116.t7 14.7997
R228 a_n24_n116.n2 a_n24_n116.t6 14.7997
R229 a_n24_n116.n1 a_n24_n116.t5 14.7997
R230 a_n24_n116.n0 a_n24_n116.t0 14.7997
R231 VDD VDD 355.517
R232 VDD VDD 266.2
R233 VDD VDD 266.2
R234 VDD VDD 266.2
R235 VDD VDD 266.2
R236 VDD VDD 266.2
R237 VDD VDD 711.034
R238 VDD VDD 667.25
R239 VDD VDD 623.468
R240 VDD VDD 623.468
R241 VSS VSS 728.682
R242 VSS VSS 32.0119
R243 VSS VSS 256.091
R244 VSS VSS 328.538
R245 VSS VSS 352.125
R246 VSS VSS 256.091
R247 VSS VSS 8.42455
R248 VSS VSS 252.722
R249 VSS VSS 252.722
R250 VSS VSS 166.797
R251 VSS VSS 85.9259
R252 VSS VSS 530.716
R253 VSS VSS 85.9259
R254 VSS VSS 170.167
R255 VSS VSS 85.9259
R256 VSS VSS 594.739
R257 VSS VSS 85.9259
R258 VSS VSS 166.797
R259 VSS VSS 416.149
R260 VSS VSS 200.493
R261 VSS VSS 256.091
R262 VSS VSS 92.6651
R263 VSS VSS 549.249
R264 VSS VSS 38.7511
R265 VSS VSS 616.641
R266 VSS VSS 256.091
C0 OUT_N WE 0.03539f
C1 VSS VB 0.11576f
C2 VC OUT 0.08034f
C3 VB VDD 0.16099f
C4 VSS OUT 0.33536f
C5 OUT_N VC 0.01339f
C6 WE VC 0.95717f
C7 VA OUT 0.2105f
C8 VSS OUT_N 0.24046f
C9 VSS WE 1.40185f
C10 OUT_N VA 0.54872f
C11 VA WE 0.62238f
C12 VDD OUT 0.32316f
C13 OUT_N VDD 0.19152f
C14 WE VD 0.5885f
C15 VDD WE 3.94771f
C16 VSS VC 0.15643f
C17 VSS VA 0.11644f
C18 m2_n100_2216# VD 0.03053f
C19 VB WE 0.71909f
C20 VSS VD 0.1224f
C21 VSS VDD 0.88903f
C22 VDD VA 0.06304f
C23 OUT_N OUT 3.91953f
C24 WE OUT 0.38974f
C25 VSS 0 7.24487f
C26 VC 0 1.45629f
C27 VA 0 2.01184f
C28 VB 0 1.59487f
C29 VD 0 0.88007f
C30 OUT_N 0 6.92069f
C31 VDD 0 7.5863f
C32 OUT 0 2.79509f
C33 WE 0 8.20821f
C34 m2_n100_2216# 0 0.01778f $ **FLOATING
C35 VDD 0 0.23589f
C36 VDD 0 0.41252f
C37 VDD 0 0.35325f
C38 VDD 0 0.35325f
C39 VDD 0 0.35325f
C40 VDD 0 0.35325f
C41 VDD 0 0.64841f
C42 VDD 0 0.91451f
C43 VDD 0 0.85641f
C44 VDD 0 0.82735f
C45 VDD 0 0.82735f
C46 a_n24_n116.t1 0 0.13804f
C47 a_n24_n116.t0 0 0.26118f
C48 a_n24_n116.n0 0 0.26412f
C49 a_n24_n116.t5 0 0.26118f
C50 a_n24_n116.n1 0 0.28461f
C51 a_n24_n116.t6 0 0.26118f
C52 a_n24_n116.n2 0 0.28461f
C53 a_n24_n116.t7 0 0.26118f
C54 a_n24_n116.n3 0 0.35219f
C55 a_n24_n116.t8 0 0.35104f
C56 a_n24_n116.n4 0 0.45061f
C57 a_n24_n116.t9 0 0.35104f
C58 a_n24_n116.n5 0 1.39042f
C59 a_n24_n116.t11 0 0.40566f
C60 a_n24_n116.n6 0 1.79661f
C61 a_n24_n116.t2 0 0.51728f
C62 a_n24_n116.n7 0 0.39204f
C63 a_n24_n116.t3 0 0.47487f
C64 a_n24_n116.n8 0 1.46294f
C65 a_n24_n116.t10 0 0.63166f
C66 a_n24_n116.t4 0 0.41887f
C67 a_n24_n116.n9 0 0.87f
C68 a_3260_3548.t1 0 0.41786f
C69 a_3260_3548.t2 0 0.31148f
C70 a_3260_3548.n0 0 3.04092f
C71 a_3260_3548.t3 0 0.3305f
C72 a_3260_3548.n1 0 3.54106f
C73 a_3260_3548.t0 0 0.63002f
C74 a_n74_1208.t0 0 0.89028f
C75 a_n74_1208.t1 0 0.8665f
C76 a_1038_1208.t1 0 0.6078f
C77 a_1038_1208.t0 0 0.57332f
C78 a_1038_1208.n0 0 1.73003f
C79 a_1038_1208.t2 0 1.08252f
C80 a_2882_1208.t1 0 0.46693f
C81 a_2882_1208.t2 0 0.50022f
C82 a_2882_1208.t0 0 1.35642f
C83 a_2882_1208.n0 0 1.7092f
C84 a_5026_1208.t1 0 0.58767f
C85 a_5026_1208.t0 0 0.55434f
C86 a_5026_1208.n0 0 1.67273f
C87 a_5026_1208.t2 0 1.04666f
C88 a_4282_1138.t0 0 0.01937f
C89 a_4282_1138.t1 0 0.01937f
C90 a_176_0.t0 0 2.71599f
C91 a_176_0.t1 0 0.45092f
C92 a_176_0.n0 0 3.79659f
C93 a_176_0.t2 0 0.47803f
C94 a_2984_0.t0 0 0.72358f
C95 a_2984_0.t1 0 0.37472f
C96 a_2984_0.n0 0 1.1334f
C97 a_2984_0.t2 0 0.39726f
C98 a_908_0.t0 0 2.39044f
C99 WE.t13 0 0.0595f
C100 WE.t11 0 0.0595f
C101 WE.n0 0 0.24226f
C102 WE.t17 0 0.0595f
C103 WE.t15 0 0.0595f
C104 WE.n1 0 0.22298f
C105 WE.n2 0 0.41148f
C106 WE.t21 0 0.0595f
C107 WE.t19 0 0.0595f
C108 WE.n3 0 0.22298f
C109 WE.n4 0 0.43131f
C110 WE.t0 0 0.07378f
C111 WE.t1 0 0.07378f
C112 WE.n5 0 0.40821f
C113 WE.t22 0 0.39666f
C114 WE.t8 0 0.42003f
C115 WE.n6 0 0.78005f
C116 WE.t29 0 0.20408f
C117 WE.n7 0 0.51209f
C118 WE.n8 0 0.24164f
C119 WE.t24 0 0.07378f
C120 WE.t25 0 0.07378f
C121 WE.n9 0 0.61846f
C122 WE.t5 0 0.07378f
C123 WE.t4 0 0.07378f
C124 WE.n10 0 0.40825f
C125 WE.t26 0 0.20906f
C126 WE.n11 0 1.42075f
C127 WE.n12 0 1.54244f
C128 WE.t2 0 0.07378f
C129 WE.t3 0 0.07378f
C130 WE.n13 0 0.53377f
C131 WE.n14 0 0.43178f
C132 WE.n15 0 0.3549f
C133 WE.t27 0 0.50338f
C134 WE.n16 0 0.51844f
C135 WE.t28 0 0.50338f
C136 WE.n17 0 0.39932f
C137 WE.t23 0 0.0595f
C138 WE.t9 0 0.0595f
C139 WE.n18 0 0.4759f
C140 WE.n19 0 0.44945f
C141 WE.n20 0 0.09824f
C142 WE.n21 0 2.32819f
C143 WE.n22 0 0.36775f
C144 WE.t18 0 0.35816f
C145 WE.t20 0 0.41113f
C146 WE.t16 0 0.39534f
C147 WE.n23 0 0.69056f
C148 WE.t12 0 0.39534f
C149 WE.n24 0 0.45516f
C150 WE.t10 0 0.345f
C151 WE.n25 0 0.44872f
C152 WE.t14 0 0.345f
C153 WE.n26 0 0.28582f
C154 WE.n27 0 0.55133f
C155 WE.t7 0 0.07378f
C156 WE.t6 0 0.07378f
C157 WE.n28 0 0.40795f
C158 WE.n29 0 0.70207f
C159 WE.n30 0 0.37841f
C160 WE.n31 0 0.49731f
C161 OUT.t0 0 0.3775f
C162 OUT.t1 0 0.22609f
C163 OUT.t2 0 0.33015f
C164 OUT.n0 0 2.85435f
C165 OUT.t3 0 0.35274f
C166 OUT.n1 0 5.12472f
C167 VDD.t1 0 0.06673f
C168 VDD.n0 0 1.80692f
C169 VDD.t5 0 0.05138f
C170 VDD.n1 0 0.12687f
C171 VDD.n2 0 0.15047f
C172 VDD.t0 0 0.05138f
C173 VDD.n3 0 0.10533f
C174 VDD.t7 0 0.05491f
C175 VDD.t9 0 0.11005f
C176 VDD.t2 0 0.02081f
C177 VDD.t8 0 0.02081f
C178 VDD.n4 0 0.07798f
C179 VDD.n5 0 0.15769f
C180 VDD.t3 0 0.02081f
C181 VDD.t4 0 0.02081f
C182 VDD.n6 0 0.07798f
C183 VDD.n7 0 0.09329f
C184 VDD.t6 0 0.10256f
C185 VDD.n8 0 0.1347f
C186 VDD.n9 0 0.8501f
C187 VDD.t10 0 0.16831f
C188 VDD.t11 0 0.17605f
C189 VDD.n10 0 0.48812f
C190 VDD.n11 0 1.49571f
C191 VDD.n12 0 0.11643f
C192 VDD.n13 0 0.28473f
C193 VDD.n14 0 0.10799f
C194 VDD.n15 0 0.13102f
C195 VDD.n16 0 0.10005f
C196 VDD.n17 0 0.15047f
C197 VDD.n18 0 0.15047f
C198 VDD.n19 0 1.47605f
C199 VDD.n20 0 0.08234f
C200 VDD.n21 0 0.07958f
C201 OUT_N.t0 0 0.28835f
C202 OUT_N.t1 0 0.17221f
C203 VD.t0 0 0.40882f
C204 VD.t1 0 0.4276f
C205 VD.n0 0 0.71941f
C206 VB.t0 0 0.44778f
C207 VB.t1 0 0.46834f
C208 VB.n0 0 0.83634f
C209 VA.t0 0 0.42083f
C210 VA.t1 0 0.44015f
C211 VA.n0 0 0.83154f
C212 VC.t0 0 0.40158f
C213 VC.t1 0 0.42002f
C214 VC.n0 0 0.69225f
C215 VSS.t0 0 0.03141f
C216 VSS.n0 0 0.05976f
C217 VSS.t1 0 0.05331f
C218 VSS.n1 0 0.11603f
C219 VSS.n2 0 0.11603f
C220 VSS.t3 0 0.03332f
C221 VSS.n3 0 0.07826f
C222 VSS.t5 0 0.03075f
C223 VSS.n4 0 0.6955f
C224 VSS.t2 0 0.03332f
C225 VSS.n5 0 0.0927f
C226 VSS.t6 0 0.03332f
C227 VSS.n6 0 0.09465f
C228 VSS.n7 0 0.09548f
C229 VSS.n8 0 0.7304f
C230 VSS.n9 0 0.11603f
C231 VSS.n10 0 0.11603f
C232 VSS.n11 0 0.07771f
C233 VSS.n12 0 0.09465f
C234 VSS.n13 0 0.09881f
C235 VSS.n14 0 0.06826f
C236 VSS.n15 0 0.11603f
C237 VSS.n16 0 0.11603f
C238 VSS.t7 0 0.03075f
C239 VSS.n17 0 0.10108f
C240 VSS.n18 0 0.11603f
C241 VSS.t8 0 0.01861f
C242 VSS.t9 0 0.03141f
C243 VSS.n19 0 0.14741f
C244 VSS.t4 0 0.03742f
C245 VSS.n20 0 0.24104f
C246 VSS.n21 0 0.53352f
C247 VSS.n22 0 0.10659f
C248 VSS.n23 0 0.16123f
C249 VSS.n24 0 0.11576f
C250 VSS.n25 0 0.11603f
C251 VSS.n26 0 0.11603f
C252 VSS.n27 0 0.06076f
C253 VSS.n28 0 0.11603f
C254 VSS.n29 0 0.11603f
C255 VSS.n30 0 0.11603f
C256 VSS.n31 0 0.11603f
C257 VSS.n32 0 0.11603f
C258 VSS.n33 0 0.09409f
C259 VSS.n34 0 0.09689f
.ends
