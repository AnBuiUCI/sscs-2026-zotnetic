* Nodos de bulk atados: 11 de pozo n -> VDD, 28 de sustrato -> VSS.
*   magic no extrae los taps de este layout y los dejaba flotando;
*   la conexion si existe (el LVS de KLayout da 'match uniquely').
*   Quien detecta un tap que falte de verdad es el LVS, no esto.
* NGSPICE file created from WEIGHT_COMP.ext - technology: gf180mcuD

.subckt WEIGHT_COMP VSS VDD VC VD WE VB OUT OUT_N VA
X0 OUT.t0 a_3260_3548.t3 VDD.t1 VDD pfet_05v0 ad=0.8052p pd=4.54u as=0.8052p ps=4.54u w=1.83u l=0.5u
X1 WE.t9 WE.t8 VDD.t3 VDD pfet_06v0 ad=0.52p pd=2.52u as=0.88p ps=4.88u w=2u l=1u
X2 WE.t24 VA.t1 a_5026_1208.t1 VSS nfet_06v0 ad=0.6448p pd=3u as=1.0912p ps=5.84u w=2.48u l=1u
X3 VDD.t9 WE.t18 WE.t19 VDD pfet_06v0 ad=0.88p pd=4.88u as=0.52p ps=2.52u w=2u l=1u
X4 a_2984_0.t0 a_n24_n116.t4 VSS.t4 VSS nfet_06v0 ad=0.5456p pd=3.36u as=0.5456p ps=3.36u w=1.24u l=1u
X5 a_3260_3548.t0 WE.t26 VSS.t8 VSS nfet_05v0 ad=0.5808p pd=3.52u as=0.5808p ps=3.52u w=1.32u l=0.6u
X6 WE.t13 WE.t12 VDD.t4 VDD pfet_06v0 ad=0.52p pd=2.52u as=0.52p ps=2.52u w=2u l=1u
X7 a_1038_1208.t2 VB.t0 WE.t2 VSS nfet_06v0 ad=1.0912p pd=5.84u as=0.6448p ps=3u w=2.48u l=1u
X8 a_2984_0.t2 VDD.t10 WE.t5 VSS nfet_06v0 ad=1.0912p pd=5.84u as=0.6448p ps=3u w=2.48u l=1u
X9 OUT_N.t0 OUT.t2 VSS.t0 VSS nfet_05v0 ad=0.5808p pd=3.52u as=0.5808p ps=3.52u w=1.32u l=0.6u
X10 a_2882_1208.t2 WE.t22 WE.t23 VSS nfet_06v0 ad=0.88p pd=4.88u as=0.52p ps=2.52u w=2u l=1u
X11 a_4282_1138.t0 WE.t28 VSS.t9 VSS nfet_06v0 ad=0.5p pd=2.5u as=0.88p ps=4.88u w=2u l=1u
X12 a_176_0.t0 a_n24_n116.t9 VSS.t1 VSS nfet_06v0 ad=0.5456p pd=3.36u as=0.5456p ps=3.36u w=1.24u l=1u
X13 a_n24_n116.t1 a_n24_n116.t0 VDD.t8 VDD pfet_06v0 ad=0.88p pd=4.88u as=0.88p ps=4.88u w=2u l=1u
X14 a_5026_1208.t2 VA.t0 WE.t25 VSS nfet_06v0 ad=1.0912p pd=5.84u as=0.6448p ps=3u w=2.48u l=1u
X15 a_5026_1208.t0 a_n24_n116.t10 VSS.t2 VSS nfet_06v0 ad=0.5456p pd=3.36u as=0.5456p ps=3.36u w=1.24u l=1u
X16 a_1940_0.t1 a_n24_n116.t6 a_1640_0.t1 VSS nfet_06v0 ad=0.175p pd=1.2u as=0.175p ps=1.2u w=0.7u l=1u
X17 a_n24_n116.t3 a_n24_n116.t2 a_2240_0.t1 VSS nfet_06v0 ad=0.308p pd=2.28u as=0.175p ps=1.2u w=0.7u l=1u
X18 OUT.t1 a_3260_3548.t2 VSS.t7 VSS nfet_05v0 ad=0.5808p pd=3.52u as=0.5808p ps=3.52u w=1.32u l=0.6u
X19 VDD.t6 WE.t14 WE.t15 VDD pfet_06v0 ad=0.52p pd=2.52u as=0.52p ps=2.52u w=2u l=1u
X20 a_n74_1208.t2 VD.t0 WE.t7 VSS nfet_06v0 ad=1.0912p pd=5.84u as=0.6448p ps=3u w=2.48u l=1u
X21 a_2882_1208.t0 WE.t27 a_4282_1138.t1 VSS nfet_06v0 ad=0.88p pd=4.88u as=0.5p ps=2.5u w=2u l=1u
X22 a_3260_3548.t1 WE.t29 VDD.t2 VDD pfet_05v0 ad=0.8052p pd=4.54u as=0.8052p ps=4.54u w=1.83u l=0.5u
X23 a_n74_1208.t0 a_n24_n116.t8 VSS.t6 VSS nfet_06v0 ad=0.5456p pd=3.36u as=0.5456p ps=3.36u w=1.24u l=1u
X24 WE.t3 VB.t1 a_1038_1208.t1 VSS nfet_06v0 ad=0.6448p pd=3u as=1.0912p ps=5.84u w=2.48u l=1u
X25 WE.t21 WE.t20 a_2882_1208.t1 VSS nfet_06v0 ad=0.52p pd=2.52u as=0.88p ps=4.88u w=2u l=1u
X26 a_176_0.t2 VC.t0 WE.t0 VSS nfet_06v0 ad=1.0912p pd=5.84u as=0.6448p ps=3u w=2.48u l=1u
X27 WE.t6 VD.t1 a_n74_1208.t1 VSS nfet_06v0 ad=0.6448p pd=3u as=1.0912p ps=5.84u w=2.48u l=1u
X28 a_1640_0.t0 a_n24_n116.t7 VSS.t5 VSS nfet_06v0 ad=0.175p pd=1.2u as=0.308p ps=2.28u w=0.7u l=1u
X29 OUT_N.t1 OUT.t3 VDD.t7 VDD pfet_05v0 ad=0.8052p pd=4.54u as=0.8052p ps=4.54u w=1.83u l=0.5u
X30 WE.t1 VC.t1 a_176_0.t1 VSS nfet_06v0 ad=0.6448p pd=3u as=1.0912p ps=5.84u w=2.48u l=1u
X31 a_2240_0.t0 a_n24_n116.t5 a_1940_0.t0 VSS nfet_06v0 ad=0.175p pd=1.2u as=0.175p ps=1.2u w=0.7u l=1u
X32 WE.t17 WE.t16 VDD.t0 VDD pfet_06v0 ad=0.52p pd=2.52u as=0.52p ps=2.52u w=2u l=1u
X33 a_1038_1208.t0 a_n24_n116.t11 VSS.t3 VSS nfet_06v0 ad=0.5456p pd=3.36u as=0.5456p ps=3.36u w=1.24u l=1u
X34 WE.t4 VDD.t11 a_2984_0.t1 VSS nfet_06v0 ad=0.6448p pd=3u as=1.0912p ps=5.84u w=2.48u l=1u
X35 VDD.t5 WE.t10 WE.t11 VDD pfet_06v0 ad=0.52p pd=2.52u as=0.52p ps=2.52u w=2u l=1u
R0 VSS.n23 VSS.t5 9.93823
R1 VSS.n22 VSS.n21 9.0005
R2 VSS.n23 VSS.n18 9.0005
R3 VSS.n25 VSS.n24 9.0005
R4 VSS.n27 VSS.n26 9.0005
R5 VSS.n28 VSS.n16 9.0005
R6 VSS.n30 VSS.n29 9.0005
R7 VSS.n31 VSS.n1 9.0005
R8 VSS.n33 VSS.n32 9.0005
R9 VSS.n15 VSS.n14 9.0005
R10 VSS.n13 VSS.n2 9.0005
R11 VSS.n11 VSS.n10 9.0005
R12 VSS.n9 VSS.n3 9.0005
R13 VSS.n8 VSS.n7 9.0005
R14 VSS.n20 VSS.t1 5.8527
R15 VSS.n19 VSS.t6 5.6202
R16 VSS.n0 VSS.t4 5.6202
R17 VSS.n12 VSS.t8 5.51806
R18 VSS.n6 VSS.t7 5.51806
R19 VSS.n5 VSS.t0 5.51806
R20 VSS.n4 VSS.t2 4.99947
R21 VSS.n17 VSS.t3 4.99947
R22 VSS.n21 VSS.n20 4.701
R23 VSS.n34 VSS.t9 3.00965
R24 VSS.n8 VSS.n4 2.78747
R25 VSS.n9 VSS.n8 0.2005
R26 VSS.n10 VSS.n9 0.2005
R27 VSS.n10 VSS.n2 0.2005
R28 VSS.n15 VSS.n2 0.2005
R29 VSS.n32 VSS.n15 0.2005
R30 VSS.n32 VSS.n31 0.2005
R31 VSS.n31 VSS.n30 0.2005
R32 VSS.n30 VSS.n16 0.2005
R33 VSS.n26 VSS.n16 0.2005
R34 VSS.n26 VSS.n25 0.2005
R35 VSS.n25 VSS.n18 0.2005
R36 VSS.n21 VSS.n18 0.2005
R37 VSS.n11 VSS.n3 0.2005
R38 VSS.n14 VSS.n13 0.2005
R39 VSS.n33 VSS.n1 0.2005
R40 VSS.n29 VSS.n1 0.2005
R41 VSS.n29 VSS.n28 0.2005
R42 VSS.n28 VSS.n27 0.2005
R43 VSS.n24 VSS.n23 0.2005
R44 VSS.n23 VSS.n22 0.2005
R45 VSS.n24 VSS.n17 0.1995
R46 VSS.n7 VSS.n5 0.1905
R47 VSS.n22 VSS.n19 0.1665
R48 VSS.n13 VSS.n12 0.1385
R49 VSS.n7 VSS.n6 0.1365
R50 VSS.n20 VSS.n19 0.132826
R51 VSS.n34 VSS.n33 0.1215
R52 VSS.n6 VSS.n3 0.0645
R53 VSS.n12 VSS.n11 0.0625
R54 VSS VSS.n0 0.044
R55 VSS.n14 VSS.n0 0.0285
R56 VSS VSS.n34 0.008
R57 VSS.n5 VSS.n4 0.0035
R58 VSS.n27 VSS.n17 0.0015
R59 VC.n0 VC.t1 17.1173
R60 VC.n0 VC.t0 16.1625
R61 VC VC.n0 0.550283
R62 VA.n0 VA.t1 17.1173
R63 VA.n0 VA.t0 16.1625
R64 VA VA.n0 2.35811
R65 VB.n0 VB.t1 17.1173
R66 VB.n0 VB.t0 16.1625
R67 VB VB.n0 1.58333
R68 VD.n0 VD.t1 17.1173
R69 VD.n0 VD.t0 16.1625
R70 VD VD.n0 0.808543
R71 OUT_N OUT_N.t0 5.32182
R72 OUT_N OUT_N.t1 4.17898
R73 VDD.n11 VDD.n10 23.4658
R74 VDD.n10 VDD.t11 17.1173
R75 VDD.n10 VDD.t10 16.1625
R76 VDD.n13 VDD.n12 9.0005
R77 VDD.n15 VDD.n2 9.0005
R78 VDD.n17 VDD.n16 9.0005
R79 VDD.n18 VDD.n1 9.0005
R80 VDD.n20 VDD.n19 9.0005
R81 VDD.n5 VDD.t9 7.70006
R82 VDD.n8 VDD.t3 6.898
R83 VDD.n9 VDD.n8 6.20962
R84 VDD.n7 VDD.n6 6.0255
R85 VDD.n5 VDD.n4 6.0255
R86 VDD.n0 VDD.t7 3.35463
R87 VDD.n3 VDD.t2 3.323
R88 VDD.n21 VDD.t1 3.323
R89 VDD.n14 VDD.t8 2.82475
R90 VDD.n11 VDD.n9 1.97332
R91 VDD.n19 VDD.n0 1.82991
R92 VDD.n6 VDD.t4 0.9105
R93 VDD.n6 VDD.t5 0.9105
R94 VDD.n4 VDD.t0 0.9105
R95 VDD.n4 VDD.t6 0.9105
R96 VDD.n7 VDD.n5 0.805206
R97 VDD.n8 VDD.n7 0.802559
R98 VDD.n13 VDD.n9 0.56189
R99 VDD VDD.n0 0.210728
R100 VDD.n19 VDD.n18 0.2005
R101 VDD.n18 VDD.n17 0.2005
R102 VDD.n17 VDD.n2 0.2005
R103 VDD.n12 VDD.n2 0.2005
R104 VDD.n20 VDD.n1 0.2005
R105 VDD.n16 VDD.n15 0.2005
R106 VDD.n15 VDD.n14 0.1465
R107 VDD.n3 VDD.n1 0.1405
R108 VDD VDD.n21 0.113
R109 VDD.n12 VDD.n11 0.106
R110 VDD.n16 VDD.n3 0.0605
R111 VDD.n14 VDD.n13 0.0545
R112 VDD.n21 VDD.n20 0.0165
R113 OUT.n1 OUT.t3 33.0017
R114 OUT.n1 OUT.n0 30.0708
R115 OUT.n0 OUT.t2 26.2322
R116 OUT OUT.t1 5.58008
R117 OUT OUT.n1 5.42139
R118 OUT.n0 OUT 5.30889
R119 OUT OUT.t0 4.43725
R120 WE.n7 WE.t29 29.5665
R121 WE.n11 WE.t26 25.9739
R122 WE.n12 WE.n11 22.7321
R123 WE.n16 WE.t27 19.8695
R124 WE.n17 WE.t28 19.8695
R125 WE.n12 WE.n9 19.5896
R126 WE.n19 WE.n18 17.0986
R127 WE.n14 WE.n13 16.9828
R128 WE.n6 WE.t20 15.3072
R129 WE.n23 WE.t18 14.9805
R130 WE.n27 WE.t16 14.8842
R131 WE.n6 WE.t22 14.3143
R132 WE.n25 WE.t8 14.2205
R133 WE.n24 WE.t10 14.2205
R134 WE.n23 WE.t14 14.2205
R135 WE.n26 WE.t12 14.2205
R136 WE WE.n10 12.8185
R137 WE.n31 WE.n5 12.5212
R138 WE.n29 WE.n28 12.5145
R139 WE WE.n4 7.72267
R140 WE.n2 WE.n0 6.83021
R141 WE.n11 WE 6.45157
R142 WE.n30 WE.n29 6.26354
R143 WE.n2 WE.n1 6.0255
R144 WE.n4 WE.n3 6.0255
R145 WE.n21 WE.n15 5.64595
R146 WE.n22 WE.n21 5.64595
R147 WE.n31 WE.n30 4.5005
R148 WE.n8 WE.n7 4.5005
R149 WE.n21 WE.n20 4.5005
R150 WE.n29 WE.n27 2.13294
R151 WE.n16 WE.n15 1.67193
R152 WE.n22 WE.n8 1.66389
R153 WE.n25 WE.n24 1.16479
R154 WE.n7 WE.n6 1.02813
R155 WE.n0 WE.t11 0.9105
R156 WE.n0 WE.t9 0.9105
R157 WE.n1 WE.t15 0.9105
R158 WE.n1 WE.t13 0.9105
R159 WE.n3 WE.t19 0.9105
R160 WE.n3 WE.t17 0.9105
R161 WE.n18 WE.t23 0.8195
R162 WE.n18 WE.t21 0.8195
R163 WE.n4 WE.n2 0.805206
R164 WE.n24 WE.n23 0.7605
R165 WE.n26 WE.n25 0.7605
R166 WE.n13 WE.t25 0.660984
R167 WE.n13 WE.t24 0.660984
R168 WE.n5 WE.t2 0.660984
R169 WE.n5 WE.t3 0.660984
R170 WE.n28 WE.t7 0.660984
R171 WE.n28 WE.t6 0.660984
R172 WE.n9 WE.t0 0.660984
R173 WE.n9 WE.t1 0.660984
R174 WE.n10 WE.t5 0.660984
R175 WE.n10 WE.t4 0.660984
R176 WE.n19 WE.n8 0.609607
R177 WE.n30 WE.n22 0.487464
R178 WE.n20 WE.n17 0.476214
R179 WE.n17 WE.n16 0.4505
R180 WE.n15 WE.n14 0.350857
R181 WE.n20 WE.n19 0.325143
R182 WE.n14 WE.n12 0.293
R183 WE.n27 WE.n26 0.09675
R184 WE WE.n31 0.0838824
R185 a_2240_0.t0 a_2240_0.t1 4.5005
R186 a_1940_0.t0 a_1940_0.t1 4.5005
R187 a_1640_0.t0 a_1640_0.t1 4.5005
R188 a_2984_0.t0 a_2984_0.n0 23.3322
R189 a_2984_0.n0 a_2984_0.t2 7.7829
R190 a_2984_0.n0 a_2984_0.t1 6.98348
R191 a_176_0.t0 a_176_0.n0 55.9115
R192 a_176_0.n0 a_176_0.t2 7.7829
R193 a_176_0.n0 a_176_0.t1 6.98348
R194 a_4282_1138.t0 a_4282_1138.t1 1.5755
R195 a_5026_1208.t0 a_5026_1208.n0 24.5469
R196 a_5026_1208.n0 a_5026_1208.t2 7.7829
R197 a_5026_1208.n0 a_5026_1208.t1 6.98348
R198 a_2882_1208.t1 a_2882_1208.n0 7.082
R199 a_2882_1208.n0 a_2882_1208.t0 22.7862
R200 a_2882_1208.n0 a_2882_1208.t2 7.88141
R201 a_1038_1208.t0 a_1038_1208.n0 24.5469
R202 a_1038_1208.n0 a_1038_1208.t2 7.7829
R203 a_1038_1208.n0 a_1038_1208.t1 6.98348
R204 a_n74_1208.t0 a_n74_1208.n0 44.2469
R205 a_n74_1208.n0 a_n74_1208.t2 7.7829
R206 a_n74_1208.n0 a_n74_1208.t1 6.98348
R207 a_3260_3548.t0 a_3260_3548.n0 11.1467
R208 a_3260_3548.n0 a_3260_3548.n1 31.7615
R209 a_3260_3548.n1 a_3260_3548.t1 10.1164
R210 a_3260_3548.n1 a_3260_3548.t3 33.2599
R211 a_3260_3548.n0 a_3260_3548.t2 26.4905
R212 a_n24_n116.t3 a_n24_n116.n9 14.2588
R213 a_n24_n116.n9 a_n24_n116.t4 19.4306
R214 a_n24_n116.n9 a_n24_n116.n0 0.239964
R215 a_n24_n116.n0 a_n24_n116.n1 0.4505
R216 a_n24_n116.n1 a_n24_n116.n2 0.4505
R217 a_n24_n116.n2 a_n24_n116.n3 0.4505
R218 a_n24_n116.n3 a_n24_n116.n4 1.14479
R219 a_n24_n116.n4 a_n24_n116.n5 1.14479
R220 a_n24_n116.n5 a_n24_n116.n6 27.1707
R221 a_n24_n116.n6 a_n24_n116.n7 0.1805
R222 a_n24_n116.n7 a_n24_n116.n8 0.239964
R223 a_n24_n116.n8 a_n24_n116.t10 23.8382
R224 a_n24_n116.n8 a_n24_n116.t1 8.88891
R225 a_n24_n116.n7 a_n24_n116.t0 20.4565
R226 a_n24_n116.n6 a_n24_n116.t11 17.9094
R227 a_n24_n116.n5 a_n24_n116.t9 16.7707
R228 a_n24_n116.n4 a_n24_n116.t8 16.7707
R229 a_n24_n116.n3 a_n24_n116.t7 14.7997
R230 a_n24_n116.n2 a_n24_n116.t6 14.7997
R231 a_n24_n116.n1 a_n24_n116.t5 14.7997
R232 a_n24_n116.n0 a_n24_n116.t2 14.7997
R233 VDD VDD 355.517
R234 VDD VDD 266.2
R235 VDD VDD 266.2
R236 VDD VDD 266.2
R237 VDD VDD 266.2
R238 VDD VDD 266.2
R239 VDD VDD 711.034
R240 VDD VDD 667.25
R241 VDD VDD 623.468
R242 VDD VDD 623.468
R243 VSS VSS 728.682
R244 VSS VSS 32.0119
R245 VSS VSS 256.091
R246 VSS VSS 328.538
R247 VSS VSS 352.125
R248 VSS VSS 256.091
R249 VSS VSS 8.42455
R250 VSS VSS 252.722
R251 VSS VSS 252.722
R252 VSS VSS 166.797
R253 VSS VSS 85.9259
R254 VSS VSS 530.716
R255 VSS VSS 85.9259
R256 VSS VSS 170.167
R257 VSS VSS 85.9259
R258 VSS VSS 594.739
R259 VSS VSS 85.9259
R260 VSS VSS 166.797
R261 VSS VSS 416.149
R262 VSS VSS 200.493
R263 VSS VSS 256.091
R264 VSS VSS 92.6651
R265 VSS VSS 549.249
R266 VSS VSS 38.7511
R267 VSS VSS 616.641
R268 VSS VSS 256.091
C0 VSS VDD 0.88275f
C1 WE VC 0.92889f
C2 WE OUT 0.31597f
C3 WE VSS 1.40231f
C4 VA OUT 0.06321f
C5 VSS VA 0.11644f
C6 VD WE 0.58893f
C7 VB VSS 0.11576f
C8 VC OUT_N 0.01282f
C9 WE VDD 3.94917f
C10 OUT OUT_N 3.84779f
C11 VSS OUT_N 0.23644f
C12 VDD VA 0.0389f
C13 VB VDD 0.14135f
C14 WE VA 0.63246f
C15 VDD OUT_N 0.19808f
C16 VB WE 0.70535f
C17 WE OUT_N 0.0267f
C18 VC OUT 0.07947f
C19 VSS VC 0.14051f
C20 VSS OUT 0.33476f
C21 VA OUT_N 0.52373f
C22 VD VSS 0.12312f
C23 VDD OUT 0.26987f
C24 VSS 0 7.26628f
C25 VC 0 0.83627f
C26 VA 0 1.4356f
C27 VB 0 1.13435f
C28 VD 0 0.8731f
C29 OUT_N 0 6.84061f
C30 VDD 0 7.59265f
C31 OUT 0 2.72271f
C32 WE 0 8.24694f
C33 VDD 0 0.23474f
C34 VDD 0 0.41051f
C35 VDD 0 0.35153f
C36 VDD 0 0.35153f
C37 VDD 0 0.35153f
C38 VDD 0 0.35153f
C39 VDD 0 0.64525f
C40 VDD 0 0.91005f
C41 VDD 0 0.85223f
C42 VDD 0 0.82333f
C43 VDD 0 0.82333f
C44 a_n24_n116.t3 0 0.13758f
C45 a_n24_n116.t2 0 0.26031f
C46 a_n24_n116.n0 0 0.26324f
C47 a_n24_n116.t5 0 0.26031f
C48 a_n24_n116.n1 0 0.28366f
C49 a_n24_n116.t6 0 0.26031f
C50 a_n24_n116.n2 0 0.28366f
C51 a_n24_n116.t7 0 0.26031f
C52 a_n24_n116.n3 0 0.35102f
C53 a_n24_n116.t8 0 0.34987f
C54 a_n24_n116.n4 0 0.44911f
C55 a_n24_n116.t9 0 0.34987f
C56 a_n24_n116.n5 0 1.38578f
C57 a_n24_n116.t11 0 0.40431f
C58 a_n24_n116.n6 0 1.79063f
C59 a_n24_n116.t0 0 0.51556f
C60 a_n24_n116.n7 0 0.39074f
C61 a_n24_n116.t1 0 0.47329f
C62 a_n24_n116.n8 0 1.45807f
C63 a_n24_n116.t10 0 0.62956f
C64 a_n24_n116.t4 0 0.41748f
C65 a_n24_n116.n9 0 0.8671f
C66 a_3260_3548.t0 0 0.41242f
C67 a_3260_3548.t2 0 0.30743f
C68 a_3260_3548.n0 0 3.00134f
C69 a_3260_3548.t3 0 0.3262f
C70 a_3260_3548.n1 0 3.49496f
C71 a_3260_3548.t1 0 0.62182f
C72 a_n74_1208.t0 0 1.44015f
C73 a_n74_1208.t1 0 0.39951f
C74 a_n74_1208.n0 0 1.71207f
C75 a_n74_1208.t2 0 0.42353f
C76 a_1038_1208.t0 0 1.08027f
C77 a_1038_1208.t1 0 0.57214f
C78 a_1038_1208.n0 0 1.72644f
C79 a_1038_1208.t2 0 0.60654f
C80 a_2882_1208.t1 0 0.46693f
C81 a_2882_1208.t2 0 0.50023f
C82 a_2882_1208.t0 0 1.35644f
C83 a_2882_1208.n0 0 1.70922f
C84 a_5026_1208.t0 0 1.04224f
C85 a_5026_1208.t1 0 0.55199f
C86 a_5026_1208.n0 0 1.66566f
C87 a_5026_1208.t2 0 0.58519f
C88 a_4282_1138.t0 0 0.01937f
C89 a_4282_1138.t1 0 0.01937f
C90 a_176_0.t0 0 2.72517f
C91 a_176_0.t1 0 0.45244f
C92 a_176_0.n0 0 3.80941f
C93 a_176_0.t2 0 0.47965f
C94 a_2984_0.t0 0 0.72359f
C95 a_2984_0.t1 0 0.37473f
C96 a_2984_0.n0 0 1.13341f
C97 a_2984_0.t2 0 0.39726f
C98 WE.t11 0 0.05923f
C99 WE.t9 0 0.05923f
C100 WE.n0 0 0.24117f
C101 WE.t15 0 0.05923f
C102 WE.t13 0 0.05923f
C103 WE.n1 0 0.22198f
C104 WE.n2 0 0.40964f
C105 WE.t19 0 0.05923f
C106 WE.t17 0 0.05923f
C107 WE.n3 0 0.22198f
C108 WE.n4 0 0.42938f
C109 WE.t2 0 0.07345f
C110 WE.t3 0 0.07345f
C111 WE.n5 0 0.40638f
C112 WE.t22 0 0.39489f
C113 WE.t20 0 0.41815f
C114 WE.n6 0 0.77656f
C115 WE.t29 0 0.20317f
C116 WE.n7 0 0.5098f
C117 WE.n8 0 0.24056f
C118 WE.t0 0 0.07345f
C119 WE.t1 0 0.07345f
C120 WE.n9 0 0.61569f
C121 WE.t5 0 0.07345f
C122 WE.t4 0 0.07345f
C123 WE.n10 0 0.40642f
C124 WE.t26 0 0.20812f
C125 WE.n11 0 1.41439f
C126 WE.n12 0 1.53554f
C127 WE.t25 0 0.07345f
C128 WE.t24 0 0.07345f
C129 WE.n13 0 0.53139f
C130 WE.n14 0 0.42985f
C131 WE.n15 0 0.35331f
C132 WE.t27 0 0.50113f
C133 WE.n16 0 0.51612f
C134 WE.t28 0 0.50113f
C135 WE.n17 0 0.39753f
C136 WE.t23 0 0.05923f
C137 WE.t21 0 0.05923f
C138 WE.n18 0 0.47377f
C139 WE.n19 0 0.44744f
C140 WE.n20 0 0.0978f
C141 WE.n21 0 2.31778f
C142 WE.n22 0 0.3661f
C143 WE.t16 0 0.35656f
C144 WE.t18 0 0.40929f
C145 WE.t14 0 0.39357f
C146 WE.n23 0 0.68747f
C147 WE.t10 0 0.39357f
C148 WE.n24 0 0.45312f
C149 WE.t8 0 0.34345f
C150 WE.n25 0 0.44672f
C151 WE.t12 0 0.34345f
C152 WE.n26 0 0.28454f
C153 WE.n27 0 0.54886f
C154 WE.t7 0 0.07345f
C155 WE.t6 0 0.07345f
C156 WE.n28 0 0.40613f
C157 WE.n29 0 0.69893f
C158 WE.n30 0 0.37672f
C159 WE.n31 0 0.49508f
C160 OUT.t0 0 0.44571f
C161 OUT.t1 0 0.26693f
C162 OUT.t2 0 0.3898f
C163 OUT.n0 0 3.2702f
C164 OUT.t3 0 0.41647f
C165 OUT.n1 0 3.7921f
C166 VDD.t7 0 0.06594f
C167 VDD.n0 0 1.78544f
C168 VDD.t1 0 0.05077f
C169 VDD.n1 0 0.12536f
C170 VDD.n2 0 0.14868f
C171 VDD.t2 0 0.05077f
C172 VDD.n3 0 0.10408f
C173 VDD.t8 0 0.05426f
C174 VDD.t9 0 0.10874f
C175 VDD.t0 0 0.02056f
C176 VDD.t6 0 0.02056f
C177 VDD.n4 0 0.07706f
C178 VDD.n5 0 0.15582f
C179 VDD.t4 0 0.02056f
C180 VDD.t5 0 0.02056f
C181 VDD.n6 0 0.07706f
C182 VDD.n7 0 0.09218f
C183 VDD.t3 0 0.10134f
C184 VDD.n8 0 0.133f
C185 VDD.n9 0 0.83672f
C186 VDD.t10 0 0.16631f
C187 VDD.t11 0 0.17395f
C188 VDD.n10 0 0.48678f
C189 VDD.n11 0 1.47488f
C190 VDD.n12 0 0.11505f
C191 VDD.n13 0 0.28135f
C192 VDD.n14 0 0.10671f
C193 VDD.n15 0 0.12946f
C194 VDD.n16 0 0.09886f
C195 VDD.n17 0 0.14868f
C196 VDD.n18 0 0.14868f
C197 VDD.n19 0 1.4585f
C198 VDD.n20 0 0.08137f
C199 VDD.n21 0 0.07864f
C200 OUT_N.t1 0 0.2852f
C201 OUT_N.t0 0 0.17033f
C202 VD.t0 0 0.41204f
C203 VD.t1 0 0.43097f
C204 VD.n0 0 0.72507f
C205 VB.t0 0 0.53344f
C206 VB.t1 0 0.55794f
C207 VB.n0 0 0.99635f
C208 VA.t0 0 0.51267f
C209 VA.t1 0 0.53622f
C210 VA.n0 0 1.01302f
C211 VC.t0 0 0.54152f
C212 VC.t1 0 0.56639f
C213 VC.n0 0 0.93347f
C214 VSS.t4 0 0.03127f
C215 VSS.n0 0 0.05949f
C216 VSS.t9 0 0.05308f
C217 VSS.n1 0 0.11552f
C218 VSS.n2 0 0.11552f
C219 VSS.t8 0 0.03317f
C220 VSS.n3 0 0.07792f
C221 VSS.t2 0 0.03062f
C222 VSS.n4 0 0.69245f
C223 VSS.t0 0 0.03317f
C224 VSS.n5 0 0.09229f
C225 VSS.t7 0 0.03317f
C226 VSS.n6 0 0.09423f
C227 VSS.n7 0 0.09506f
C228 VSS.n8 0 0.72719f
C229 VSS.n9 0 0.11552f
C230 VSS.n10 0 0.11552f
C231 VSS.n11 0 0.07736f
C232 VSS.n12 0 0.09423f
C233 VSS.n13 0 0.09838f
C234 VSS.n14 0 0.06796f
C235 VSS.n15 0 0.11552f
C236 VSS.n16 0 0.11552f
C237 VSS.t3 0 0.03062f
C238 VSS.n17 0 0.10064f
C239 VSS.n18 0 0.11552f
C240 VSS.t5 0 0.01853f
C241 VSS.t6 0 0.03127f
C242 VSS.n19 0 0.14676f
C243 VSS.t1 0 0.03725f
C244 VSS.n20 0 0.23999f
C245 VSS.n21 0 0.53118f
C246 VSS.n22 0 0.10612f
C247 VSS.n23 0 0.16052f
C248 VSS.n24 0 0.11525f
C249 VSS.n25 0 0.11552f
C250 VSS.n26 0 0.11552f
C251 VSS.n27 0 0.0605f
C252 VSS.n28 0 0.11552f
C253 VSS.n29 0 0.11552f
C254 VSS.n30 0 0.11552f
C255 VSS.n31 0 0.11552f
C256 VSS.n32 0 0.11552f
C257 VSS.n33 0 0.09368f
C258 VSS.n34 0 0.09646f
.ends
