* Nodos de bulk atados: 1 de pozo n -> VDD, 1 de sustrato -> VSS.
*   magic no extrae los taps de este layout y los dejaba flotando;
*   la conexion si existe (el LVS de KLayout da 'match uniquely').
*   Quien detecta un tap que falte de verdad es el LVS, no esto.
* NGSPICE file created from WEIGHT_COMP.ext - technology: gf180mcuD

.subckt WEIGHT_COMP VSS VDD VC VD WE VB OUT OUT_N VA
X0 OUT a_3260_3548# VDD VDD pfet_05v0 ad=0.8052p pd=4.54u as=0.8052p ps=4.54u w=1.83u l=0.5u
X1 WE WE VDD VDD pfet_06v0 ad=0.52p pd=2.52u as=0.88p ps=4.88u w=2u l=1u
X2 WE VA a_5026_1208# VSS nfet_06v0 ad=0.6448p pd=3u as=1.0912p ps=5.84u w=2.48u l=1u
X3 VDD WE WE VDD pfet_06v0 ad=0.88p pd=4.88u as=0.52p ps=2.52u w=2u l=1u
X4 a_2984_0# a_n24_n116# VSS VSS nfet_06v0 ad=0.5456p pd=3.36u as=0.5456p ps=3.36u w=1.24u l=1u
X5 a_3260_3548# WE VSS VSS nfet_05v0 ad=0.5808p pd=3.52u as=0.5808p ps=3.52u w=1.32u l=0.6u
X6 WE WE VDD VDD pfet_06v0 ad=0.52p pd=2.52u as=0.52p ps=2.52u w=2u l=1u
X7 a_1038_1208# VB WE VSS nfet_06v0 ad=1.0912p pd=5.84u as=0.6448p ps=3u w=2.48u l=1u
X8 a_2984_0# VDD WE VSS nfet_06v0 ad=1.0912p pd=5.84u as=0.6448p ps=3u w=2.48u l=1u
X9 OUT_N OUT VSS VSS nfet_05v0 ad=0.5808p pd=3.52u as=0.5808p ps=3.52u w=1.32u l=0.6u
X10 a_2882_1208# WE WE VSS nfet_06v0 ad=0.88p pd=4.88u as=0.52p ps=2.52u w=2u l=1u
X11 a_4282_1138# WE VSS VSS nfet_06v0 ad=0.5p pd=2.5u as=0.88p ps=4.88u w=2u l=1u
X12 a_176_0# a_n24_n116# VSS VSS nfet_06v0 ad=0.5456p pd=3.36u as=0.5456p ps=3.36u w=1.24u l=1u
X13 a_n24_n116# a_n24_n116# VDD VDD pfet_06v0 ad=0.88p pd=4.88u as=0.88p ps=4.88u w=2u l=1u
X14 a_5026_1208# VA WE VSS nfet_06v0 ad=1.0912p pd=5.84u as=0.6448p ps=3u w=2.48u l=1u
X15 a_5026_1208# a_n24_n116# VSS VSS nfet_06v0 ad=0.5456p pd=3.36u as=0.5456p ps=3.36u w=1.24u l=1u
X16 a_1940_0# a_n24_n116# a_1640_0# VSS nfet_06v0 ad=0.175p pd=1.2u as=0.175p ps=1.2u w=0.7u l=1u
X17 a_n24_n116# a_n24_n116# a_2240_0# VSS nfet_06v0 ad=0.308p pd=2.28u as=0.175p ps=1.2u w=0.7u l=1u
X18 OUT a_3260_3548# VSS VSS nfet_05v0 ad=0.5808p pd=3.52u as=0.5808p ps=3.52u w=1.32u l=0.6u
X19 VDD WE WE VDD pfet_06v0 ad=0.52p pd=2.52u as=0.52p ps=2.52u w=2u l=1u
X20 a_n74_1208# VD WE VSS nfet_06v0 ad=1.0912p pd=5.84u as=0.6448p ps=3u w=2.48u l=1u
X21 a_2882_1208# WE a_4282_1138# VSS nfet_06v0 ad=0.88p pd=4.88u as=0.5p ps=2.5u w=2u l=1u
X22 a_3260_3548# WE VDD VDD pfet_05v0 ad=0.8052p pd=4.54u as=0.8052p ps=4.54u w=1.83u l=0.5u
X23 a_n74_1208# a_n24_n116# VSS VSS nfet_06v0 ad=0.5456p pd=3.36u as=0.5456p ps=3.36u w=1.24u l=1u
X24 WE VB a_1038_1208# VSS nfet_06v0 ad=0.6448p pd=3u as=1.0912p ps=5.84u w=2.48u l=1u
X25 WE WE a_2882_1208# VSS nfet_06v0 ad=0.52p pd=2.52u as=0.88p ps=4.88u w=2u l=1u
X26 a_176_0# VC WE VSS nfet_06v0 ad=1.0912p pd=5.84u as=0.6448p ps=3u w=2.48u l=1u
X27 WE VD a_n74_1208# VSS nfet_06v0 ad=0.6448p pd=3u as=1.0912p ps=5.84u w=2.48u l=1u
X28 a_1640_0# a_n24_n116# VSS VSS nfet_06v0 ad=0.175p pd=1.2u as=0.308p ps=2.28u w=0.7u l=1u
X29 OUT_N OUT VDD VDD pfet_05v0 ad=0.8052p pd=4.54u as=0.8052p ps=4.54u w=1.83u l=0.5u
X30 WE VC a_176_0# VSS nfet_06v0 ad=0.6448p pd=3u as=1.0912p ps=5.84u w=2.48u l=1u
X31 a_2240_0# a_n24_n116# a_1940_0# VSS nfet_06v0 ad=0.175p pd=1.2u as=0.175p ps=1.2u w=0.7u l=1u
X32 WE WE VDD VDD pfet_06v0 ad=0.52p pd=2.52u as=0.52p ps=2.52u w=2u l=1u
X33 a_1038_1208# a_n24_n116# VSS VSS nfet_06v0 ad=0.5456p pd=3.36u as=0.5456p ps=3.36u w=1.24u l=1u
X34 WE VDD a_2984_0# VSS nfet_06v0 ad=0.6448p pd=3u as=1.0912p ps=5.84u w=2.48u l=1u
X35 VDD WE WE VDD pfet_06v0 ad=0.52p pd=2.52u as=0.52p ps=2.52u w=2u l=1u
C0 VDD VA 0.0389f
C1 a_5026_1208# VSS 0.20282f
C2 VDD a_2882_1208# 0.02027f
C3 a_5026_1208# a_n24_n116# 1.01164f
C4 a_5026_1208# VA 0.59694f
C5 a_176_0# VSS 0.33922f
C6 a_n24_n116# a_176_0# 1.69329f
C7 a_176_0# VA 0.05057f
C8 a_5026_1208# a_2882_1208# 0.23463f
C9 a_3260_3548# VSS 0.36996f
C10 a_3260_3548# a_n24_n116# 1.16168f
C11 VD a_n74_1208# 0.61602f
C12 a_176_0# a_2882_1208# 0.08221f
C13 a_3260_3548# VA 0.03417f
C14 VDD a_176_0# 0.05349f
C15 WE a_n74_1208# 0.71867f
C16 a_3260_3548# VDD 0.26134f
C17 a_5026_1208# a_176_0# 0.2576f
C18 a_3260_3548# a_5026_1208# 0.04094f
C19 WE VC 0.92889f
C20 a_3260_3548# a_176_0# 0.01931f
C21 a_n74_1208# VSS 0.39277f
C22 a_n24_n116# a_n74_1208# 1.87243f
C23 OUT_N OUT 3.84779f
C24 VC VSS 0.14051f
C25 a_176_0# a_n74_1208# 0.35923f
C26 VB a_1038_1208# 0.60279f
C27 a_176_0# VC 0.59234f
C28 WE OUT 0.31597f
C29 a_3260_3548# VC 0.11439f
C30 WE a_1038_1208# 1.74721f
C31 OUT VDD 0.39206f
C32 OUT_N WE 0.0267f
C33 OUT_N VDD 0.09286f
C34 OUT VSS 0.33476f
C35 OUT a_n24_n116# 0.01077f
C36 OUT VA 0.06321f
C37 a_1038_1208# VSS 0.19986f
C38 a_n24_n116# a_1038_1208# 1.04147f
C39 a_1038_1208# a_2882_1208# 0.2351f
C40 WE VB 0.70535f
C41 OUT_N VSS 0.23644f
C42 OUT VDD 0.26987f
C43 OUT_N VA 0.52373f
C44 VDD VB 0.03324f
C45 VDD a_1038_1208# 0.06259f
C46 WE VD 0.58893f
C47 a_4282_1138# VSS 0.02124f
C48 a_176_0# a_1038_1208# 0.08316f
C49 OUT_N VDD 0.19808f
C50 a_3260_3548# OUT 4.34856f
C51 WE VDD 2.38287f
C52 VB VSS 0.11576f
C53 a_n24_n116# VB 0.49585f
C54 a_4282_1138# a_2882_1208# 0.01098f
C55 a_2984_0# WE 0.83032f
C56 VD VSS 0.12312f
C57 a_n24_n116# VD 0.07456f
C58 OUT_N a_3260_3548# 0.0755f
C59 VDD VB 0.14135f
C60 WE VSS 1.40231f
C61 WE a_n24_n116# 1.13775f
C62 WE VA 0.63246f
C63 VDD a_n24_n116# 0.51361f
C64 VDD VA 0.02008f
C65 WE a_2882_1208# 2.50913f
C66 a_2984_0# VSS 0.16054f
C67 a_176_0# VB 0.05181f
C68 a_2984_0# a_n24_n116# 1.06076f
C69 WE VDD 3.94917f
C70 a_2984_0# a_2882_1208# 0.01513f
C71 a_176_0# VD 0.1908f
C72 a_n74_1208# a_1038_1208# 0.01003f
C73 VDD VDD 2.26878f
C74 WE a_5026_1208# 1.49147f
C75 a_n24_n116# VSS 0.5578f
C76 a_2984_0# VDD 0.53395f
C77 VSS VA 0.11644f
C78 WE a_176_0# 3.68558f
C79 a_n24_n116# VA 0.04099f
C80 OUT VC 0.07947f
C81 VSS a_2882_1208# 0.18557f
C82 a_3260_3548# WE 1.31539f
C83 a_n24_n116# a_2882_1208# 0.72581f
C84 a_3260_3548# VDD 0.39149f
C85 VDD VSS 0.88275f
C86 a_2984_0# a_3260_3548# 0.02691f
C87 VDD a_n24_n116# 0.42901f
C88 OUT_N VC 0.01282f
C89 VSS VSS 7.25218f
C90 VC VSS 1.00657f
C91 VA VSS 1.37901f
C92 VB VSS 1.06838f
C93 VD VSS 0.83016f
C94 OUT_N VSS 2.27294f
C95 VDD VSS 7.46581f
C96 OUT VSS 1.62777f
C97 WE VSS 7.30886f
C98 a_2984_0# VSS 1.03134f
C99 a_176_0# VSS 2.51914f
C100 a_5026_1208# VSS 0.7278f
C101 a_2882_1208# VSS 0.68541f
C102 a_1038_1208# VSS 0.68763f
C103 a_n74_1208# VSS 1.41205f
C104 a_3260_3548# VSS 2.53506f
C105 a_n24_n116# VSS 6.38865f
C106 VDD VSS 18.0893f
.ends
