* Nodos de bulk atados: 1 de pozo n -> VDD, 1 de sustrato -> VSS.
*   magic no extrae los taps de este layout y los dejaba flotando;
*   la conexion si existe (el LVS de KLayout da 'match uniquely').
*   Quien detecta un tap que falte de verdad es el LVS, no esto.
* NGSPICE file created from WEIGHT_COMP.ext - technology: gf180mcuD

.subckt WEIGHT_COMP VSS VDD VC VD WE VB OUT OUT_N VA
X0 OUT a_3260_3548# VDD VDD pfet_05v0 ad=0.8052p pd=4.54u as=0.8052p ps=4.54u w=1.83u l=0.5u
X1 WE WE VDD VDD pfet_06v0 ad=0.52p pd=2.52u as=0.88p ps=4.88u w=2u l=1u
X2 WE VA a_5026_1208# VSS nfet_06v0 ad=0.6448p pd=3u as=1.0912p ps=5.84u w=2.48u l=1u
X3 VDD WE WE VDD pfet_06v0 ad=0.88p pd=4.88u as=0.52p ps=2.52u w=2u l=1u
X4 a_2984_0# a_n24_n116# VSS VSS nfet_06v0 ad=0.5456p pd=3.36u as=0.5456p ps=3.36u w=1.24u l=1u
X5 a_3260_3548# WE VSS VSS nfet_05v0 ad=0.5808p pd=3.52u as=0.5808p ps=3.52u w=1.32u l=0.6u
X6 WE WE VDD VDD pfet_06v0 ad=0.52p pd=2.52u as=0.52p ps=2.52u w=2u l=1u
X7 a_1038_1208# VB WE VSS nfet_06v0 ad=1.0912p pd=5.84u as=0.6448p ps=3u w=2.48u l=1u
X8 a_2984_0# VDD WE VSS nfet_06v0 ad=1.0912p pd=5.84u as=0.6448p ps=3u w=2.48u l=1u
X9 OUT_N OUT VSS VSS nfet_05v0 ad=0.5808p pd=3.52u as=0.5808p ps=3.52u w=1.32u l=0.6u
X10 a_2882_1208# WE WE VSS nfet_06v0 ad=0.88p pd=4.88u as=0.52p ps=2.52u w=2u l=1u
X11 a_4282_1138# WE VSS VSS nfet_06v0 ad=0.5p pd=2.5u as=0.88p ps=4.88u w=2u l=1u
X12 a_176_0# a_n24_n116# VSS VSS nfet_06v0 ad=0.5456p pd=3.36u as=0.5456p ps=3.36u w=1.24u l=1u
X13 a_n24_n116# a_n24_n116# VDD VDD pfet_06v0 ad=0.88p pd=4.88u as=0.88p ps=4.88u w=2u l=1u
X14 a_5026_1208# VA WE VSS nfet_06v0 ad=1.0912p pd=5.84u as=0.6448p ps=3u w=2.48u l=1u
X15 a_5026_1208# a_n24_n116# VSS VSS nfet_06v0 ad=0.5456p pd=3.36u as=0.5456p ps=3.36u w=1.24u l=1u
X16 a_1940_0# a_n24_n116# a_1640_0# VSS nfet_06v0 ad=0.175p pd=1.2u as=0.175p ps=1.2u w=0.7u l=1u
X17 a_n24_n116# a_n24_n116# a_2240_0# VSS nfet_06v0 ad=0.308p pd=2.28u as=0.175p ps=1.2u w=0.7u l=1u
X18 OUT a_3260_3548# VSS VSS nfet_05v0 ad=0.5808p pd=3.52u as=0.5808p ps=3.52u w=1.32u l=0.6u
X19 VDD WE WE VDD pfet_06v0 ad=0.52p pd=2.52u as=0.52p ps=2.52u w=2u l=1u
X20 a_n74_1208# VD WE VSS nfet_06v0 ad=1.0912p pd=5.84u as=0.6448p ps=3u w=2.48u l=1u
X21 a_2882_1208# WE a_4282_1138# VSS nfet_06v0 ad=0.88p pd=4.88u as=0.5p ps=2.5u w=2u l=1u
X22 a_3260_3548# WE VDD VDD pfet_05v0 ad=0.8052p pd=4.54u as=0.8052p ps=4.54u w=1.83u l=0.5u
X23 a_908_0# a_n24_n116# VSS VSS nfet_06v0 ad=0.5456p pd=3.36u as=0.5456p ps=3.36u w=1.24u l=1u
X24 WE VB a_1038_1208# VSS nfet_06v0 ad=0.6448p pd=3u as=1.0912p ps=5.84u w=2.48u l=1u
X25 WE WE a_2882_1208# VSS nfet_06v0 ad=0.52p pd=2.52u as=0.88p ps=4.88u w=2u l=1u
X26 a_176_0# VC WE VSS nfet_06v0 ad=1.0912p pd=5.84u as=0.6448p ps=3u w=2.48u l=1u
X27 WE VD a_n74_1208# VSS nfet_06v0 ad=0.6448p pd=3u as=1.0912p ps=5.84u w=2.48u l=1u
X28 a_1640_0# a_n24_n116# VSS VSS nfet_06v0 ad=0.175p pd=1.2u as=0.308p ps=2.28u w=0.7u l=1u
X29 OUT_N OUT VDD VDD pfet_05v0 ad=0.8052p pd=4.54u as=0.8052p ps=4.54u w=1.83u l=0.5u
X30 WE VC a_176_0# VSS nfet_06v0 ad=0.6448p pd=3u as=1.0912p ps=5.84u w=2.48u l=1u
X31 a_2240_0# a_n24_n116# a_1940_0# VSS nfet_06v0 ad=0.175p pd=1.2u as=0.175p ps=1.2u w=0.7u l=1u
X32 WE WE VDD VDD pfet_06v0 ad=0.52p pd=2.52u as=0.52p ps=2.52u w=2u l=1u
X33 a_1038_1208# a_n24_n116# VSS VSS nfet_06v0 ad=0.5456p pd=3.36u as=0.5456p ps=3.36u w=1.24u l=1u
X34 WE VDD a_2984_0# VSS nfet_06v0 ad=0.6448p pd=3u as=1.0912p ps=5.84u w=2.48u l=1u
X35 VDD WE WE VDD pfet_06v0 ad=0.52p pd=2.52u as=0.52p ps=2.52u w=2u l=1u
C0 VA a_5026_1208# 0.59585f
C1 a_5026_1208# VSS 0.20282f
C2 a_n24_n116# a_3260_3548# 1.16168f
C3 VB a_1038_1208# 0.61112f
C4 VDD a_3260_3548# 0.26045f
C5 a_908_0# a_n74_1208# 0.19064f
C6 a_n24_n116# VDD 0.51361f
C7 a_176_0# VA 0.0504f
C8 a_176_0# VSS 0.33922f
C9 VDD VDD 2.2877f
C10 WE OUT_N 0.03539f
C11 VDD VB 0.04179f
C12 WE a_5026_1208# 1.49147f
C13 VA OUT 0.2105f
C14 OUT VSS 0.33536f
C15 a_n24_n116# a_n74_1208# 0.02465f
C16 VSS a_908_0# 0.26652f
C17 m2_n100_2216# a_n74_1208# 0.04637f
C18 VD a_n74_1208# 0.55797f
C19 a_176_0# WE 3.68558f
C20 VDD a_3260_3548# 0.39149f
C21 VSS a_2984_0# 0.16054f
C22 VC a_3260_3548# 0.11375f
C23 a_2882_1208# VSS 0.18557f
C24 WE OUT 0.38974f
C25 a_n24_n116# VA 0.04004f
C26 a_n24_n116# VSS 0.5578f
C27 VDD VA 0.06304f
C28 VDD VSS 0.88903f
C29 VSS VD 0.1224f
C30 a_176_0# a_5026_1208# 0.2576f
C31 WE a_2984_0# 0.83032f
C32 VSS VB 0.11576f
C33 OUT OUT_N 3.91953f
C34 a_2882_1208# WE 2.50913f
C35 VSS a_1038_1208# 0.19986f
C36 a_5026_1208# OUT 0.02223f
C37 a_n24_n116# WE 1.13775f
C38 VA a_3260_3548# 0.03253f
C39 a_4282_1138# VSS 0.02124f
C40 VDD WE 3.94771f
C41 VSS a_3260_3548# 0.36998f
C42 WE VD 0.5885f
C43 WE VB 0.71909f
C44 VA VDD 0.02008f
C45 a_176_0# a_908_0# 0.11973f
C46 VC VSS 0.15643f
C47 WE a_1038_1208# 1.74721f
C48 a_2882_1208# a_5026_1208# 0.23463f
C49 VDD OUT_N 0.19152f
C50 a_n24_n116# a_5026_1208# 1.01164f
C51 WE a_3260_3548# 1.31539f
C52 a_176_0# a_2882_1208# 0.08221f
C53 VSS a_n74_1208# 0.12587f
C54 WE VDD 2.38035f
C55 a_176_0# a_n24_n116# 1.71043f
C56 WE VC 0.95717f
C57 VDD a_176_0# 0.05337f
C58 m2_n100_2216# a_176_0# 0.09718f
C59 a_176_0# VD 0.19014f
C60 OUT_N a_3260_3548# 0.07476f
C61 a_176_0# VB 0.05402f
C62 a_n24_n116# OUT 0.0424f
C63 a_5026_1208# a_3260_3548# 0.04094f
C64 WE a_n74_1208# 0.70881f
C65 VA VSS 0.11644f
C66 VDD OUT 0.32316f
C67 a_176_0# a_1038_1208# 0.08316f
C68 VDD OUT_N 0.09793f
C69 a_2882_1208# a_2984_0# 0.01513f
C70 a_n24_n116# a_908_0# 1.77441f
C71 VC OUT_N 0.01339f
C72 VD a_908_0# 0.02657f
C73 a_n24_n116# a_2984_0# 1.06076f
C74 a_176_0# a_3260_3548# 0.01931f
C75 VDD a_2984_0# 0.53392f
C76 a_n24_n116# a_2882_1208# 0.72581f
C77 VDD a_2882_1208# 0.02021f
C78 VA WE 0.62238f
C79 a_176_0# VC 0.59541f
C80 OUT a_3260_3548# 4.46011f
C81 WE VSS 1.40185f
C82 VDD a_n24_n116# 0.42778f
C83 m2_n100_2216# a_n24_n116# 0.04746f
C84 a_n24_n116# VD 0.07387f
C85 OUT VDD 0.39206f
C86 a_2882_1208# a_1038_1208# 0.2351f
C87 a_n24_n116# VB 0.51631f
C88 m2_n100_2216# VD 0.03053f
C89 a_2984_0# a_3260_3548# 0.02691f
C90 VC OUT 0.08034f
C91 a_176_0# a_n74_1208# 0.08927f
C92 VDD VB 0.16099f
C93 a_n24_n116# a_1038_1208# 1.04147f
C94 VA OUT_N 0.54872f
C95 a_2882_1208# a_4282_1138# 0.01098f
C96 VSS OUT_N 0.24046f
C97 VDD a_1038_1208# 0.06255f
C98 VSS VSS 7.23071f
C99 VC VSS 1.05095f
C100 VA VSS 1.40336f
C101 VB VSS 1.12071f
C102 VD VSS 0.82849f
C103 OUT_N VSS 2.25337f
C104 VDD VSS 7.45793f
C105 OUT VSS 1.8677f
C106 WE VSS 7.26591f
C107 m2_n100_2216# VSS 0.01778f $ **FLOATING
C108 a_908_0# VSS 0.91698f
C109 a_2984_0# VSS 1.03134f
C110 a_176_0# VSS 2.52481f
C111 a_5026_1208# VSS 0.7278f
C112 a_2882_1208# VSS 0.68541f
C113 a_1038_1208# VSS 0.68763f
C114 a_n74_1208# VSS 0.47616f
C115 a_3260_3548# VSS 2.53506f
C116 a_n24_n116# VSS 6.39141f
C117 VDD VSS 18.0893f
.ends
