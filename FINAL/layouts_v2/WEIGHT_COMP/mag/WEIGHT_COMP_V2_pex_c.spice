* Nodos de bulk atados: 1 de pozo n -> VDD, 1 de sustrato -> VSS.
*   magic no extrae los taps de este layout y los dejaba flotando;
*   la conexion si existe (el LVS de KLayout da 'match uniquely').
*   Quien detecta un tap que falte de verdad es el LVS, no esto.
* NGSPICE file created from WEIGHT_COMP.ext - technology: gf180mcuD

.subckt WEIGHT_COMP_V2 VSS VDD VD WE VA VB OUT OUT_N VC
X0 OUT a_3260_3416# VSS VSS nfet_05v0 ad=0.5808p pd=3.52u as=0.5808p ps=3.52u w=1.32u l=0.6u
X1 a_1376_n116# a_1376_n116# VDD VDD pfet_06v0 ad=0.88p pd=4.88u as=0.88p ps=4.88u w=2u l=1u
X2 a_3260_3416# WE VDD VDD pfet_05v0 ad=0.8052p pd=4.54u as=0.8052p ps=4.54u w=1.83u l=0.5u
X3 WE VA a_5026_1208# VSS nfet_06v0 ad=0.6448p pd=3u as=1.0912p ps=5.84u w=2.48u l=1u
X4 a_1038_1208# VB WE VSS nfet_06v0 ad=1.0912p pd=5.84u as=0.6448p ps=3u w=2.48u l=1u
X5 a_2882_1208# WE WE VSS nfet_06v0 ad=0.88p pd=4.88u as=0.52p ps=2.52u w=2u l=1u
X6 a_4282_1138# WE VSS VSS nfet_06v0 ad=0.5p pd=2.5u as=0.88p ps=4.88u w=2u l=1u
X7 a_3040_0# a_1376_n116# VSS VSS nfet_06v0 ad=0.175p pd=1.2u as=0.308p ps=2.28u w=0.7u l=1u
X8 a_3260_3416# WE VSS VSS nfet_05v0 ad=0.5808p pd=3.52u as=0.5808p ps=3.52u w=1.32u l=0.6u
X9 a_3640_0# a_1376_n116# a_3340_0# VSS nfet_06v0 ad=0.175p pd=1.2u as=0.175p ps=1.2u w=0.7u l=1u
X10 OUT_N OUT VSS VSS nfet_05v0 ad=0.5808p pd=3.52u as=0.5808p ps=3.52u w=1.32u l=0.6u
X11 a_5026_1208# VA WE VSS nfet_06v0 ad=1.0912p pd=5.84u as=0.6448p ps=3u w=2.48u l=1u
X12 a_5026_1208# a_1376_n116# VSS VSS nfet_06v0 ad=0.5456p pd=3.36u as=0.5456p ps=3.36u w=1.24u l=1u
X13 OUT_N OUT VDD VDD pfet_05v0 ad=0.8052p pd=4.54u as=0.8052p ps=4.54u w=1.83u l=0.5u
X14 a_n74_1208# VD WE VSS nfet_06v0 ad=1.0912p pd=5.84u as=0.6448p ps=3u w=2.48u l=1u
X15 VDD WE WE VDD pfet_06v0 ad=0.52p pd=2.52u as=0.52p ps=2.52u w=2u l=1u
X16 WE WE VDD VDD pfet_06v0 ad=0.52p pd=2.52u as=0.52p ps=2.52u w=2u l=1u
X17 a_2882_1208# WE a_4282_1138# VSS nfet_06v0 ad=0.88p pd=4.88u as=0.5p ps=2.5u w=2u l=1u
X18 WE WE VDD VDD pfet_06v0 ad=0.52p pd=2.52u as=0.88p ps=4.88u w=2u l=1u
X19 OUT a_3260_3416# VDD VDD pfet_05v0 ad=0.8052p pd=4.54u as=0.8052p ps=4.54u w=1.83u l=0.5u
X20 WE VB a_1038_1208# VSS nfet_06v0 ad=0.6448p pd=3u as=1.0912p ps=5.84u w=2.48u l=1u
X21 VDD WE WE VDD pfet_06v0 ad=0.88p pd=4.88u as=0.52p ps=2.52u w=2u l=1u
X22 WE WE a_2882_1208# VSS nfet_06v0 ad=0.52p pd=2.52u as=0.88p ps=4.88u w=2u l=1u
X23 WE WE VDD VDD pfet_06v0 ad=0.52p pd=2.52u as=0.52p ps=2.52u w=2u l=1u
X24 a_n74_0# a_1376_n116# VSS VSS nfet_06v0 ad=0.5456p pd=3.36u as=0.5456p ps=3.36u w=1.24u l=1u
X25 a_n74_1208# a_1376_n116# VSS VSS nfet_06v0 ad=0.5456p pd=3.36u as=0.5456p ps=3.36u w=1.24u l=1u
X26 a_3340_0# a_1376_n116# a_3040_0# VSS nfet_06v0 ad=0.175p pd=1.2u as=0.175p ps=1.2u w=0.7u l=1u
X27 WE VD a_n74_1208# VSS nfet_06v0 ad=0.6448p pd=3u as=1.0912p ps=5.84u w=2.48u l=1u
X28 a_n74_0# VC WE VSS nfet_06v0 ad=1.0912p pd=5.84u as=0.6448p ps=3u w=2.48u l=1u
X29 a_1376_n116# a_1376_n116# a_3640_0# VSS nfet_06v0 ad=0.308p pd=2.28u as=0.175p ps=1.2u w=0.7u l=1u
X30 a_1038_1208# a_1376_n116# VSS VSS nfet_06v0 ad=0.5456p pd=3.36u as=0.5456p ps=3.36u w=1.24u l=1u
X31 VDD WE WE VDD pfet_06v0 ad=0.52p pd=2.52u as=0.52p ps=2.52u w=2u l=1u
X32 WE VC a_n74_0# VSS nfet_06v0 ad=0.6448p pd=3u as=1.0912p ps=5.84u w=2.48u l=1u
C0 VA OUT 0.1556f
C1 WE a_2882_1208# 2.37805f
C2 VA a_5026_1208# 0.74269f
C3 VD VSS 0.12009f
C4 VDD a_3260_3416# 0.26049f
C5 VDD OUT 0.33105f
C6 a_1376_n116# a_3260_3416# 1.6732f
C7 a_4282_1138# VSS 0.01844f
C8 a_n74_1208# a_n74_0# 0.03062f
C9 VB WE 0.78284f
C10 a_1376_n116# OUT 0.47095f
C11 a_1376_n116# a_5026_1208# 0.46704f
C12 a_n74_1208# VSS 0.58333f
C13 VDD VD 0.02903f
C14 a_1038_1208# a_2882_1208# 0.23221f
C15 VDD OUT_N 0.11386f
C16 a_n74_1208# VA 0.01086f
C17 a_n74_0# WE 1.19758f
C18 VB a_1038_1208# 1.03154f
C19 a_3260_3416# OUT 3.71099f
C20 VSS WE 1.28037f
C21 VB VDD 0.04238f
C22 a_3260_3416# a_5026_1208# 0.1533f
C23 OUT a_5026_1208# 0.01497f
C24 a_n74_1208# a_1376_n116# 0.52152f
C25 VA WE 1.00936f
C26 VDD WE 3.20075f
C27 a_1038_1208# VSS 0.1987f
C28 a_1376_n116# WE 2.22671f
C29 a_n74_1208# a_3260_3416# 0.04639f
C30 a_n74_1208# a_5026_1208# 0.01767f
C31 VDD VDD 2.14114f
C32 a_n74_1208# VD 0.84961f
C33 a_1376_n116# a_1038_1208# 0.53274f
C34 a_3260_3416# WE 0.90106f
C35 WE VC 0.56577f
C36 VDD a_1376_n116# 0.48842f
C37 a_n74_1208# a_4282_1138# 0.01796f
C38 WE a_5026_1208# 1.14226f
C39 VD WE 0.60265f
C40 VDD a_3260_3416# 0.39827f
C41 VDD OUT 0.41089f
C42 a_n74_1208# WE 3.96746f
C43 VDD VD 0.01317f
C44 OUT_N VSS 0.27572f
C45 VSS a_2882_1208# 0.1889f
C46 a_n74_1208# a_1038_1208# 0.09187f
C47 VA a_2882_1208# 0.04646f
C48 VB VSS 0.14225f
C49 VDD OUT_N 0.19846f
C50 a_1038_1208# WE 1.80481f
C51 OUT_N a_1376_n116# 0.32947f
C52 a_1376_n116# a_2882_1208# 0.73166f
C53 VDD WE 2.38633f
C54 a_n74_0# VSS 0.1616f
C55 VB VDD 0.09192f
C56 VB a_1376_n116# 0.01334f
C57 OUT_N a_3260_3416# 0.0734f
C58 VA VSS 0.1602f
C59 VDD a_1038_1208# 0.01561f
C60 OUT_N OUT 2.86376f
C61 a_n74_0# a_1376_n116# 0.32959f
C62 a_2882_1208# a_5026_1208# 0.17518f
C63 a_1376_n116# VSS 0.79509f
C64 a_1376_n116# VA 0.73744f
C65 a_4282_1138# a_2882_1208# 0.01057f
C66 a_n74_0# VC 0.93833f
C67 VDD a_1376_n116# 0.25981f
C68 a_n74_1208# a_2882_1208# 0.08315f
C69 a_3260_3416# VSS 0.36804f
C70 VSS VC 0.18688f
C71 VSS OUT 0.32988f
C72 VSS a_5026_1208# 0.21082f
C73 a_3260_3416# VA 0.0625f
C74 VB a_n74_1208# 0.05583f
C75 VC VSS 0.89576f
C76 VSS VSS 6.29861f
C77 VA VSS 1.02874f
C78 VB VSS 1.04396f
C79 VD VSS 0.89017f
C80 OUT_N VSS 2.02572f
C81 VDD VSS 4.62612f
C82 OUT VSS 1.69013f
C83 WE VSS 6.57334f
C84 a_n74_0# VSS 1.24479f
C85 a_5026_1208# VSS 0.79537f
C86 a_2882_1208# VSS 0.7341f
C87 a_1038_1208# VSS 0.71068f
C88 a_n74_1208# VSS 2.4296f
C89 a_3260_3416# VSS 2.05735f
C90 a_1376_n116# VSS 5.54286f
C91 VDD VSS 18.0893f
.ends
