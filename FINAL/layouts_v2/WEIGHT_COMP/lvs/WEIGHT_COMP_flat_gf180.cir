* Extracted by KLayout with GF180MCU LVS runset on : 29/08/2026 18:10

.SUBCKT WEIGHT_COMP OUT WE OUT_N VDD VD VB VC VA VSS
M$1 \$71 WE VSS VSS nfet_06v0 L=1U W=2U AS=0.88P AD=0.5P PS=4.88U PD=2.5U
M$2 \$64 WE \$71 VSS nfet_06v0 L=1U W=2U AS=0.5P AD=0.88P PS=2.5U PD=4.88U
M$3 \$29 \$11 VSS VSS nfet_06v0 L=1U W=0.7U AS=0.308P AD=0.175P PS=2.28U PD=1.2U
M$4 \$35 \$11 \$29 VSS nfet_06v0 L=1U W=0.7U AS=0.175P AD=0.175P PS=1.2U PD=1.2U
M$5 \$39 \$11 \$35 VSS nfet_06v0 L=1U W=0.7U AS=0.175P AD=0.175P PS=1.2U PD=1.2U
M$6 \$11 \$11 \$39 VSS nfet_06v0 L=1U W=0.7U AS=0.175P AD=0.308P PS=1.2U
+ PD=2.28U
M$7 OUT_N OUT VSS VSS nfet_05v0 L=0.6U W=1.32U AS=0.5808P AD=0.5808P PS=3.52U
+ PD=3.52U
M$8 OUT \$2 VSS VSS nfet_05v0 L=0.6U W=1.32U AS=0.5808P AD=0.5808P PS=3.52U
+ PD=3.52U
M$9 \$2 WE VSS VSS nfet_05v0 L=0.6U W=1.32U AS=0.5808P AD=0.5808P PS=3.52U
+ PD=3.52U
M$10 \$4 \$11 VSS VSS nfet_06v0 L=1U W=1.24U AS=0.5456P AD=0.5456P PS=3.36U
+ PD=3.36U
M$11 \$74 \$11 VSS VSS nfet_06v0 L=1U W=1.24U AS=0.5456P AD=0.5456P PS=3.36U
+ PD=3.36U
M$12 \$9 \$11 VSS VSS nfet_06v0 L=1U W=1.24U AS=0.5456P AD=0.5456P PS=3.36U
+ PD=3.36U
M$13 \$3 \$11 VSS VSS nfet_06v0 L=1U W=1.24U AS=0.5456P AD=0.5456P PS=3.36U
+ PD=3.36U
M$14 \$61 \$11 VSS VSS nfet_06v0 L=1U W=1.24U AS=0.5456P AD=0.5456P PS=3.36U
+ PD=3.36U
M$15 \$11 \$11 VDD VDD pfet_06v0 L=1U W=2U AS=0.88P AD=0.88P PS=4.88U PD=4.88U
M$16 WE WE VDD VDD pfet_06v0 L=1U W=2U AS=0.88P AD=0.52P PS=4.88U PD=2.52U
M$17 VDD WE WE VDD pfet_06v0 L=1U W=2U AS=0.52P AD=0.52P PS=2.52U PD=2.52U
M$18 WE WE VDD VDD pfet_06v0 L=1U W=2U AS=0.52P AD=0.52P PS=2.52U PD=2.52U
M$19 VDD WE WE VDD pfet_06v0 L=1U W=2U AS=0.52P AD=0.52P PS=2.52U PD=2.52U
M$20 WE WE VDD VDD pfet_06v0 L=1U W=2U AS=0.52P AD=0.52P PS=2.52U PD=2.52U
M$21 VDD WE WE VDD pfet_06v0 L=1U W=2U AS=0.52P AD=0.88P PS=2.52U PD=4.88U
M$22 \$2 WE VDD VDD pfet_05v0 L=0.5U W=1.83U AS=0.8052P AD=0.8052P PS=4.54U
+ PD=4.54U
M$23 OUT_N OUT VDD VDD pfet_05v0 L=0.5U W=1.83U AS=0.8052P AD=0.8052P PS=4.54U
+ PD=4.54U
M$24 OUT \$2 VDD VDD pfet_05v0 L=0.5U W=1.83U AS=0.8052P AD=0.8052P PS=4.54U
+ PD=4.54U
M$25 WE VDD \$4 VSS nfet_06v0 L=1U W=2.48U AS=1.0912P AD=0.6448P PS=5.84U PD=3U
M$26 \$4 VDD WE VSS nfet_06v0 L=1U W=2.48U AS=0.6448P AD=1.0912P PS=3U PD=5.84U
M$27 WE VC \$3 VSS nfet_06v0 L=1U W=2.48U AS=1.0912P AD=0.6448P PS=5.84U PD=3U
M$28 \$3 VC WE VSS nfet_06v0 L=1U W=2.48U AS=0.6448P AD=1.0912P PS=3U PD=5.84U
M$29 WE VA \$74 VSS nfet_06v0 L=1U W=2.48U AS=1.0912P AD=0.6448P PS=5.84U PD=3U
M$30 \$74 VA WE VSS nfet_06v0 L=1U W=2.48U AS=0.6448P AD=1.0912P PS=3U PD=5.84U
M$31 WE WE \$64 VSS nfet_06v0 L=1U W=2U AS=0.88P AD=0.52P PS=4.88U PD=2.52U
M$32 \$64 WE WE VSS nfet_06v0 L=1U W=2U AS=0.52P AD=0.88P PS=2.52U PD=4.88U
M$33 WE VB \$61 VSS nfet_06v0 L=1U W=2.48U AS=1.0912P AD=0.6448P PS=5.84U PD=3U
M$34 \$61 VB WE VSS nfet_06v0 L=1U W=2.48U AS=0.6448P AD=1.0912P PS=3U PD=5.84U
M$35 WE VD \$9 VSS nfet_06v0 L=1U W=2.48U AS=1.0912P AD=0.6448P PS=5.84U PD=3U
M$36 \$9 VD WE VSS nfet_06v0 L=1U W=2.48U AS=0.6448P AD=1.0912P PS=3U PD=5.84U
.ENDS WEIGHT_COMP
