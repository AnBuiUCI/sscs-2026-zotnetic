* Extracted by KLayout with GF180MCU LVS runset on : 29/08/2026 06:41

.SUBCKT OPAM_LIN_flat INN OUT INP VDD VSS
M$1 \$716 \$64 VDD VDD pfet_06v0 L=1U W=10U AS=4.4P AD=2.5P PS=20.88U PD=10.5U
M$2 \$64 \$41 \$716 VDD pfet_06v0 L=1U W=10U AS=2.5P AD=3.3P PS=10.5U PD=10.66U
M$3 \$54 \$54 \$64 VDD pfet_06v0 L=1U W=10U AS=3.3P AD=4.4P PS=10.66U PD=20.88U
M$4 \$615 \$37 VDD VDD pfet_06v0 L=1U W=10U AS=4.4P AD=2.5P PS=20.88U PD=10.5U
M$5 \$98 \$41 \$615 VDD pfet_06v0 L=1U W=10U AS=2.5P AD=4.4P PS=10.5U PD=20.88U
M$6 \$616 \$37 VDD VDD pfet_06v0 L=1U W=10U AS=4.4P AD=2.5P PS=20.88U PD=10.5U
M$7 \$98 \$41 \$616 VDD pfet_06v0 L=1U W=10U AS=2.5P AD=4.4P PS=10.5U PD=20.88U
M$8 \$626 \$37 VDD VDD pfet_06v0 L=1U W=10U AS=4.4P AD=2.5P PS=20.88U PD=10.5U
M$9 \$37 \$41 \$626 VDD pfet_06v0 L=1U W=10U AS=2.5P AD=4.4P PS=10.5U PD=20.88U
M$10 \$721 \$37 VDD VDD pfet_06v0 L=1U W=10U AS=4.4P AD=2.5P PS=20.88U PD=10.5U
M$11 \$13 \$41 \$721 VDD pfet_06v0 L=1U W=10U AS=2.5P AD=4.4P PS=10.5U PD=20.88U
M$12 \$729 \$37 VDD VDD pfet_06v0 L=1U W=10U AS=4.4P AD=2.5P PS=20.88U PD=10.5U
M$13 \$38 \$41 \$729 VDD pfet_06v0 L=1U W=10U AS=2.5P AD=4.4P PS=10.5U PD=20.88U
M$14 \$691 \$37 VDD VDD pfet_06v0 L=1U W=10U AS=4.4P AD=2.5P PS=20.88U PD=10.5U
M$15 \$10 \$41 \$691 VDD pfet_06v0 L=1U W=10U AS=2.5P AD=4.4P PS=10.5U PD=20.88U
M$16 \$79 \$41 VSS VSS nfet_06v0 L=1U W=1U AS=0.44P AD=0.25P PS=2.88U PD=1.5U
M$17 \$37 \$41 \$79 VSS nfet_06v0 L=1U W=1U AS=0.25P AD=0.44P PS=1.5U PD=2.88U
M$18 \$74 \$10 VSS VSS nfet_06v0 L=1U W=5U AS=2.2P AD=1.25P PS=10.88U PD=5.5U
M$19 \$10 \$13 \$74 VSS nfet_06v0 L=1U W=5U AS=1.25P AD=2.2P PS=5.5U PD=10.88U
M$20 \$14 \$10 VSS VSS nfet_06v0 L=1U W=5U AS=2.2P AD=1.25P PS=10.88U PD=5.5U
M$21 \$11 \$13 \$14 VSS nfet_06v0 L=1U W=5U AS=1.25P AD=2.2P PS=5.5U PD=10.88U
M$22 \$17 \$10 VSS VSS nfet_06v0 L=1U W=5U AS=2.2P AD=1.25P PS=10.88U PD=5.5U
M$23 \$11 \$13 \$17 VSS nfet_06v0 L=1U W=5U AS=1.25P AD=2.2P PS=5.5U PD=10.88U
M$24 \$48 \$10 VSS VSS nfet_06v0 L=1U W=5U AS=2.2P AD=1.25P PS=10.88U PD=5.5U
M$25 \$54 \$13 \$48 VSS nfet_06v0 L=1U W=5U AS=1.25P AD=2.2P PS=5.5U PD=10.88U
M$26 \$60 \$56 VSS VSS nfet_06v0 L=1U W=5U AS=2.2P AD=1.25P PS=10.88U PD=5.5U
M$27 \$56 \$13 \$60 VSS nfet_06v0 L=1U W=5U AS=1.25P AD=1.65P PS=5.5U PD=5.66U
M$28 \$38 \$38 \$56 VSS nfet_06v0 L=1U W=5U AS=1.65P AD=2.2P PS=5.66U PD=10.88U
M$29 \$83 \$41 VSS VSS nfet_06v0 L=1U W=1U AS=0.44P AD=0.25P PS=2.88U PD=1.5U
M$30 \$41 \$41 \$83 VSS nfet_06v0 L=1U W=1U AS=0.25P AD=0.44P PS=1.5U PD=2.88U
M$31 \$8 \$26 VSS VSS nfet_06v0 L=1U W=2.5U AS=1.1P AD=0.825P PS=5.88U PD=3.16U
M$32 \$46 \$13 \$8 VSS nfet_06v0 L=1U W=2.5U AS=0.825P AD=1.1P PS=3.16U PD=5.88U
M$33 \$29 \$26 VSS VSS nfet_06v0 L=1U W=2.5U AS=1.1P AD=0.825P PS=5.88U PD=3.16U
M$34 \$26 \$13 \$29 VSS nfet_06v0 L=1U W=2.5U AS=0.825P AD=1.1P PS=3.16U
+ PD=5.88U
C$35 OUT \$8 4e-13 cap_mim_2f0fF A=200P P=66U
C$36 \$3 OUT 4e-13 cap_mim_2f0fF A=200P P=66U
M$37 \$13 \$13 VSS VSS nfet_06v0 L=1U W=1U AS=0.44P AD=0.44P PS=2.88U PD=2.88U
M$38 OUT \$46 VSS VSS nfet_06v0 L=1U W=1U AS=0.44P AD=0.44P PS=2.88U PD=2.88U
M$39 \$104 \$38 \$26 VSS nfet_06v0 L=1U W=2U AS=0.88P AD=0.88P PS=4.88U PD=4.88U
M$40 \$92 \$38 \$46 VSS nfet_06v0 L=1U W=2U AS=0.88P AD=0.88P PS=4.88U PD=4.88U
M$41 \$3 INP \$11 VSS nfet_06v0 L=1U W=7.5U AS=3.3P AD=3.3P PS=15.88U PD=15.88U
M$42 \$22 INN \$11 VSS nfet_06v0 L=1U W=8.5U AS=3.74P AD=3.74P PS=17.88U
+ PD=17.88U
M$43 \$29 INN \$98 VDD pfet_06v0 L=1U W=0.5U AS=0.22P AD=0.22P PS=1.88U PD=1.88U
M$44 \$8 INP \$98 VDD pfet_06v0 L=1U W=0.55U AS=0.242P AD=0.242P PS=1.98U
+ PD=1.98U
M$45 \$46 \$54 \$92 VDD pfet_06v0 L=1U W=4U AS=1.76P AD=1.76P PS=8.88U PD=8.88U
M$46 \$26 \$54 \$104 VDD pfet_06v0 L=1U W=4U AS=1.76P AD=1.76P PS=8.88U PD=8.88U
M$47 \$3 \$104 VDD VDD pfet_06v0 L=1U W=5U AS=2.2P AD=2.2P PS=10.88U PD=10.88U
M$48 \$22 \$104 VDD VDD pfet_06v0 L=1U W=5U AS=2.2P AD=2.2P PS=10.88U PD=10.88U
M$49 \$92 \$41 \$3 VDD pfet_06v0 L=1U W=10U AS=4.4P AD=4.4P PS=20.88U PD=20.88U
M$50 \$104 \$41 \$22 VDD pfet_06v0 L=1U W=10U AS=4.4P AD=4.4P PS=20.88U
+ PD=20.88U
M$51 OUT \$92 VDD VDD pfet_06v0 L=1U W=1U AS=0.44P AD=0.44P PS=2.88U PD=2.88U
M$52 \$41 \$41 VDD VDD pfet_06v0 L=1U W=2U AS=0.88P AD=0.88P PS=4.88U PD=4.88U
M$53 OUT \$92 VDD VDD pfet_06v0 L=1U W=1U AS=0.44P AD=0.44P PS=2.88U PD=2.88U
M$54 OUT \$92 VDD VDD pfet_06v0 L=1U W=1U AS=0.44P AD=0.44P PS=2.88U PD=2.88U
M$55 OUT \$92 VDD VDD pfet_06v0 L=1U W=1U AS=0.44P AD=0.44P PS=2.88U PD=2.88U
R$56 \$92 \$I358 VSS 76450 ppolyf_u_1k L=76.45U W=1U
R$57 \$I359 \$I358 VSS 76450 ppolyf_u_1k L=76.45U W=1U
R$58 \$I359 \$I360 VSS 76450 ppolyf_u_1k L=76.45U W=1U
R$59 \$I361 \$I360 VSS 76450 ppolyf_u_1k L=76.45U W=1U
R$60 \$I361 OUT VSS 76450 ppolyf_u_1k L=76.45U W=1U
.ENDS OPAM_LIN_flat
