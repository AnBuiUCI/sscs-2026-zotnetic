* Extracted by KLayout with GF180MCU LVS runset on : 29/08/2026 18:10

.SUBCKT OPAM_LIN_flat INN OUT INP VDD VSS
M$1 \$717 \$66 VDD VDD pfet_06v0 L=1U W=10U AS=4.4P AD=2.5P PS=20.88U PD=10.5U
M$2 \$66 \$36 \$717 VDD pfet_06v0 L=1U W=10U AS=2.5P AD=3.3P PS=10.5U PD=10.66U
M$3 \$54 \$54 \$66 VDD pfet_06v0 L=1U W=10U AS=3.3P AD=4.4P PS=10.66U PD=20.88U
M$4 \$615 \$42 VDD VDD pfet_06v0 L=1U W=10U AS=4.4P AD=2.5P PS=20.88U PD=10.5U
M$5 \$107 \$36 \$615 VDD pfet_06v0 L=1U W=10U AS=2.5P AD=4.4P PS=10.5U PD=20.88U
M$6 \$616 \$42 VDD VDD pfet_06v0 L=1U W=10U AS=4.4P AD=2.5P PS=20.88U PD=10.5U
M$7 \$107 \$36 \$616 VDD pfet_06v0 L=1U W=10U AS=2.5P AD=4.4P PS=10.5U PD=20.88U
M$8 \$626 \$42 VDD VDD pfet_06v0 L=1U W=10U AS=4.4P AD=2.5P PS=20.88U PD=10.5U
M$9 \$42 \$36 \$626 VDD pfet_06v0 L=1U W=10U AS=2.5P AD=4.4P PS=10.5U PD=20.88U
M$10 \$721 \$42 VDD VDD pfet_06v0 L=1U W=10U AS=4.4P AD=2.5P PS=20.88U PD=10.5U
M$11 \$12 \$36 \$721 VDD pfet_06v0 L=1U W=10U AS=2.5P AD=4.4P PS=10.5U PD=20.88U
M$12 \$730 \$42 VDD VDD pfet_06v0 L=1U W=10U AS=4.4P AD=2.5P PS=20.88U PD=10.5U
M$13 \$43 \$36 \$730 VDD pfet_06v0 L=1U W=10U AS=2.5P AD=4.4P PS=10.5U PD=20.88U
M$14 \$691 \$42 VDD VDD pfet_06v0 L=1U W=10U AS=4.4P AD=2.5P PS=20.88U PD=10.5U
M$15 \$10 \$36 \$691 VDD pfet_06v0 L=1U W=10U AS=2.5P AD=4.4P PS=10.5U PD=20.88U
M$16 \$83 \$36 VSS VSS nfet_06v0 L=1U W=1U AS=0.44P AD=0.25P PS=2.88U PD=1.5U
M$17 \$42 \$36 \$83 VSS nfet_06v0 L=1U W=1U AS=0.25P AD=0.44P PS=1.5U PD=2.88U
M$18 \$75 \$10 VSS VSS nfet_06v0 L=1U W=5U AS=2.2P AD=1.25P PS=10.88U PD=5.5U
M$19 \$10 \$12 \$75 VSS nfet_06v0 L=1U W=5U AS=1.25P AD=2.2P PS=5.5U PD=10.88U
M$20 \$11 \$10 VSS VSS nfet_06v0 L=1U W=5U AS=2.2P AD=1.25P PS=10.88U PD=5.5U
M$21 \$14 \$12 \$11 VSS nfet_06v0 L=1U W=5U AS=1.25P AD=2.2P PS=5.5U PD=10.88U
M$22 \$17 \$10 VSS VSS nfet_06v0 L=1U W=5U AS=2.2P AD=1.25P PS=10.88U PD=5.5U
M$23 \$14 \$12 \$17 VSS nfet_06v0 L=1U W=5U AS=1.25P AD=2.2P PS=5.5U PD=10.88U
M$24 \$47 \$10 VSS VSS nfet_06v0 L=1U W=5U AS=2.2P AD=1.25P PS=10.88U PD=5.5U
M$25 \$54 \$12 \$47 VSS nfet_06v0 L=1U W=5U AS=1.25P AD=2.2P PS=5.5U PD=10.88U
M$26 \$60 \$56 VSS VSS nfet_06v0 L=1U W=5U AS=2.2P AD=1.25P PS=10.88U PD=5.5U
M$27 \$56 \$12 \$60 VSS nfet_06v0 L=1U W=5U AS=1.25P AD=1.65P PS=5.5U PD=5.66U
M$28 \$43 \$43 \$56 VSS nfet_06v0 L=1U W=5U AS=1.65P AD=2.2P PS=5.66U PD=10.88U
M$29 \$84 \$36 VSS VSS nfet_06v0 L=1U W=1U AS=0.44P AD=0.25P PS=2.88U PD=1.5U
M$30 \$36 \$36 \$84 VSS nfet_06v0 L=1U W=1U AS=0.25P AD=0.44P PS=1.5U PD=2.88U
M$31 \$8 \$27 VSS VSS nfet_06v0 L=1U W=2.5U AS=1.1P AD=0.825P PS=5.88U PD=3.16U
M$32 \$46 \$12 \$8 VSS nfet_06v0 L=1U W=2.5U AS=0.825P AD=1.1P PS=3.16U PD=5.88U
M$33 \$29 \$27 VSS VSS nfet_06v0 L=1U W=2.5U AS=1.1P AD=0.825P PS=5.88U PD=3.16U
M$34 \$27 \$12 \$29 VSS nfet_06v0 L=1U W=2.5U AS=0.825P AD=1.1P PS=3.16U
+ PD=5.88U
C$35 OUT \$8 4e-13 cap_mim_2f0fF A=200P P=66U
C$36 \$3 OUT 4e-13 cap_mim_2f0fF A=200P P=66U
M$37 \$12 \$12 VSS VSS nfet_06v0 L=1U W=1U AS=0.44P AD=0.44P PS=2.88U PD=2.88U
M$38 OUT \$46 VSS VSS nfet_06v0 L=1U W=1U AS=0.44P AD=0.44P PS=2.88U PD=2.88U
M$39 \$102 \$43 \$27 VSS nfet_06v0 L=1U W=2U AS=0.88P AD=0.88P PS=4.88U PD=4.88U
M$40 \$51 \$43 \$46 VSS nfet_06v0 L=1U W=2U AS=0.88P AD=0.88P PS=4.88U PD=4.88U
M$41 \$3 INP \$14 VSS nfet_06v0 L=1U W=7.5U AS=3.3P AD=3.3P PS=15.88U PD=15.88U
M$42 \$26 INN \$14 VSS nfet_06v0 L=1U W=8.5U AS=3.74P AD=3.74P PS=17.88U
+ PD=17.88U
M$43 \$29 INN \$107 VDD pfet_06v0 L=1U W=0.5U AS=0.22P AD=0.22P PS=1.88U
+ PD=1.88U
M$44 \$8 INP \$107 VDD pfet_06v0 L=1U W=0.55U AS=0.242P AD=0.242P PS=1.98U
+ PD=1.98U
M$45 \$46 \$54 \$51 VDD pfet_06v0 L=1U W=4U AS=1.76P AD=1.76P PS=8.88U PD=8.88U
M$46 \$27 \$54 \$102 VDD pfet_06v0 L=1U W=4U AS=1.76P AD=1.76P PS=8.88U PD=8.88U
M$47 \$3 \$102 VDD VDD pfet_06v0 L=1U W=5U AS=2.2P AD=2.2P PS=10.88U PD=10.88U
M$48 \$26 \$102 VDD VDD pfet_06v0 L=1U W=5U AS=2.2P AD=2.2P PS=10.88U PD=10.88U
M$49 \$51 \$36 \$3 VDD pfet_06v0 L=1U W=10U AS=4.4P AD=4.4P PS=20.88U PD=20.88U
M$50 \$102 \$36 \$26 VDD pfet_06v0 L=1U W=10U AS=4.4P AD=4.4P PS=20.88U
+ PD=20.88U
M$51 OUT \$51 VDD VDD pfet_06v0 L=1U W=1U AS=0.44P AD=0.44P PS=2.88U PD=2.88U
M$52 \$36 \$36 VDD VDD pfet_06v0 L=1U W=2U AS=0.88P AD=0.88P PS=4.88U PD=4.88U
M$53 OUT \$51 VDD VDD pfet_06v0 L=1U W=1U AS=0.44P AD=0.44P PS=2.88U PD=2.88U
M$54 OUT \$51 VDD VDD pfet_06v0 L=1U W=1U AS=0.44P AD=0.44P PS=2.88U PD=2.88U
M$55 OUT \$51 VDD VDD pfet_06v0 L=1U W=1U AS=0.44P AD=0.44P PS=2.88U PD=2.88U
R$56 \$51 \$I362 VSS 76450 ppolyf_u_1k L=76.45U W=1U
R$57 \$I363 \$I362 VSS 76450 ppolyf_u_1k L=76.45U W=1U
R$58 \$I363 \$I364 VSS 76450 ppolyf_u_1k L=76.45U W=1U
R$59 \$I365 \$I364 VSS 76450 ppolyf_u_1k L=76.45U W=1U
R$60 \$I365 OUT VSS 76450 ppolyf_u_1k L=76.45U W=1U
.ENDS OPAM_LIN_flat
