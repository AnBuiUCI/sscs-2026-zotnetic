* Nodos de bulk atados: 0 de pozo n -> VDD, 1 de sustrato -> VSS.
*   magic no extrae los taps de este layout y los dejaba flotando;
*   la conexion si existe (el LVS de KLayout da 'match uniquely').
*   Quien detecta un tap que falte de verdad es el LVS, no esto.
* NGSPICE file created from OPAM_LIN_flat.ext - technology: gf180mcuD

.subckt OPAM_LIN_flat VSS VDD INN OUT INP
X0 a_1366_7234# a_54_7118# VDD VDD pfet_06v0 ad=2.5p pd=10.5u as=4.4p ps=20.88u w=10u l=1u
X1 OUT a_928_4838# VDD VDD pfet_06v0 ad=0.44p pd=2.88u as=0.44p ps=2.88u w=1u l=1u
X2 a_2478_9124# OUT cap_mim_2f0_m4m5_noshield c_width=25u c_length=8u
X3 a_928_4838# a_16346_4838# VSS ppolyf_u_1k r_width=1u r_length=76.45u
X4 a_314_332# a_314_332# VSS VSS nfet_06v0 ad=0.44p pd=2.88u as=0.44p ps=2.88u w=1u l=1u
X5 a_2278_376# INP a_514_376# VSS nfet_06v0 ad=3.3p pd=15.88u as=3.3p ps=15.88u w=7.5u l=1u
X6 a_5162_376# a_314_332# a_2478_9124# VSS nfet_06v0 ad=1.1p pd=5.88u as=0.825p ps=3.16u w=2.5u l=1u
X7 a_7358_376# a_14_332# VSS VSS nfet_06v0 ad=1.25p pd=5.5u as=2.2p ps=10.88u w=5u l=1u
X8 a_254_7234# a_54_7118# VDD VDD pfet_06v0 ad=2.5p pd=10.5u as=4.4p ps=20.88u w=10u l=1u
X9 a_10430_7234# a_54_7118# VDD VDD pfet_06v0 ad=2.5p pd=10.5u as=4.4p ps=20.88u w=10u l=1u
X10 OUT a_928_4838# VDD VDD pfet_06v0 ad=0.44p pd=2.88u as=0.44p ps=2.88u w=1u l=1u
X11 a_514_376# a_314_332# a_214_376# VSS nfet_06v0 ad=2.2p pd=10.88u as=1.25p ps=5.5u w=5u l=1u
X12 a_3290_9134# a_3554_332# VSS VSS nfet_06v0 ad=0.825p pd=3.16u as=1.1p ps=5.88u w=2.5u l=1u
X13 a_13294_376# a_354_7118# VSS VSS nfet_06v0 ad=0.25p pd=1.5u as=0.44p ps=2.88u w=1u l=1u
X14 a_7150_8318# a_314_332# a_7358_376# VSS nfet_06v0 ad=2.2p pd=10.88u as=1.25p ps=5.5u w=5u l=1u
X15 a_554_7234# a_354_7118# a_1366_7234# VDD pfet_06v0 ad=4.4p pd=20.88u as=2.5p ps=10.5u w=10u l=1u
X16 a_928_4838# a_354_7118# a_2278_376# VDD pfet_06v0 ad=4.4p pd=20.88u as=4.4p ps=20.88u w=10u l=1u
X17 a_8986_7234# a_8786_7118# VDD VDD pfet_06v0 ad=2.5p pd=10.5u as=4.4p ps=20.88u w=10u l=1u
X18 a_14790_7234# a_54_7118# VDD VDD pfet_06v0 ad=2.5p pd=10.5u as=4.4p ps=20.88u w=10u l=1u
X19 a_928_5288# a_16346_5738# VSS ppolyf_u_1k r_width=1u r_length=76.45u
X20 a_354_7118# a_354_7118# a_13294_376# VSS nfet_06v0 ad=0.44p pd=2.88u as=0.25p ps=1.5u w=1u l=1u
X21 a_17826_7234# a_54_7118# VDD VDD pfet_06v0 ad=2.5p pd=10.5u as=4.4p ps=20.88u w=10u l=1u
X22 a_928_5288# a_16346_4838# VSS ppolyf_u_1k r_width=1u r_length=76.45u
X23 a_2478_9124# INP a_554_7234# VDD pfet_06v0 ad=0.242p pd=1.98u as=0.242p ps=1.98u w=0.55u l=1u
X24 a_2278_376# a_4102_7234# VDD VDD pfet_06v0 ad=2.2p pd=10.88u as=2.2p ps=10.88u w=5u l=1u
X25 OUT a_928_4838# VDD VDD pfet_06v0 ad=0.44p pd=2.88u as=0.44p ps=2.88u w=1u l=1u
X26 a_4102_7234# a_5694_332# a_3554_332# VSS nfet_06v0 ad=0.88p pd=4.88u as=0.88p ps=4.88u w=2u l=1u
X27 a_5694_332# a_354_7118# a_10430_7234# VDD pfet_06v0 ad=4.4p pd=20.88u as=2.5p ps=10.5u w=10u l=1u
X28 a_214_376# a_14_332# VSS VSS nfet_06v0 ad=1.25p pd=5.5u as=2.2p ps=10.88u w=5u l=1u
X29 a_2478_9124# a_3554_332# VSS VSS nfet_06v0 ad=0.825p pd=3.16u as=1.1p ps=5.88u w=2.5u l=1u
X30 OUT a_2278_376# cap_mim_2f0_m4m5_noshield c_width=25u c_length=8u
X31 a_7150_8318# a_7150_8318# a_8786_7118# VDD pfet_06v0 ad=4.4p pd=20.88u as=3.3p ps=10.66u w=10u l=1u
X32 a_14_332# a_354_7118# a_15902_7234# VDD pfet_06v0 ad=4.4p pd=20.88u as=2.5p ps=10.5u w=10u l=1u
X33 a_11230_376# a_14_332# VSS VSS nfet_06v0 ad=1.25p pd=5.5u as=2.2p ps=10.88u w=5u l=1u
X34 a_314_332# a_354_7118# a_14790_7234# VDD pfet_06v0 ad=4.4p pd=20.88u as=2.5p ps=10.5u w=10u l=1u
X35 OUT a_928_4838# VDD VDD pfet_06v0 ad=0.44p pd=2.88u as=0.44p ps=2.88u w=1u l=1u
X36 a_928_6188# OUT VSS ppolyf_u_1k r_width=1u r_length=76.45u
X37 a_928_6188# a_16346_5738# VSS ppolyf_u_1k r_width=1u r_length=76.45u
X38 a_5694_332# a_5694_332# a_8202_332# VSS nfet_06v0 ad=2.2p pd=10.88u as=1.65p ps=5.66u w=5u l=1u
X39 a_54_7118# a_354_7118# a_17826_7234# VDD pfet_06v0 ad=4.4p pd=20.88u as=2.5p ps=10.5u w=10u l=1u
X40 a_14_332# a_314_332# a_11230_376# VSS nfet_06v0 ad=2.2p pd=10.88u as=1.25p ps=5.5u w=5u l=1u
X41 a_3554_332# a_7150_8318# a_4102_7234# VDD pfet_06v0 ad=1.76p pd=8.88u as=1.76p ps=8.88u w=4u l=1u
X42 a_4102_7234# a_354_7118# a_3010_376# VDD pfet_06v0 ad=4.4p pd=20.88u as=4.4p ps=20.88u w=10u l=1u
X43 a_554_7234# a_354_7118# a_254_7234# VDD pfet_06v0 ad=4.4p pd=20.88u as=2.5p ps=10.5u w=10u l=1u
X44 a_1246_376# a_14_332# VSS VSS nfet_06v0 ad=1.25p pd=5.5u as=2.2p ps=10.88u w=5u l=1u
X45 a_8402_376# a_8202_332# VSS VSS nfet_06v0 ad=1.25p pd=5.5u as=2.2p ps=10.88u w=5u l=1u
X46 a_3010_376# a_4102_7234# VDD VDD pfet_06v0 ad=2.2p pd=10.88u as=2.2p ps=10.88u w=5u l=1u
X47 OUT a_5162_376# VSS VSS nfet_06v0 ad=0.44p pd=2.88u as=0.44p ps=2.88u w=1u l=1u
X48 a_5162_376# a_7150_8318# a_928_4838# VDD pfet_06v0 ad=1.76p pd=8.88u as=1.76p ps=8.88u w=4u l=1u
X49 a_354_7118# a_354_7118# VDD VDD pfet_06v0 ad=0.88p pd=4.88u as=0.88p ps=4.88u w=2u l=1u
X50 a_3010_376# INN a_514_376# VSS nfet_06v0 ad=3.74p pd=17.88u as=3.74p ps=17.88u w=8.5u l=1u
X51 a_12262_376# a_354_7118# VSS VSS nfet_06v0 ad=0.25p pd=1.5u as=0.44p ps=2.88u w=1u l=1u
X52 a_15902_7234# a_54_7118# VDD VDD pfet_06v0 ad=2.5p pd=10.5u as=4.4p ps=20.88u w=10u l=1u
X53 a_514_376# a_314_332# a_1246_376# VSS nfet_06v0 ad=2.2p pd=10.88u as=1.25p ps=5.5u w=5u l=1u
X54 a_3554_332# a_314_332# a_3290_9134# VSS nfet_06v0 ad=1.1p pd=5.88u as=0.825p ps=3.16u w=2.5u l=1u
X55 a_928_4838# a_5694_332# a_5162_376# VSS nfet_06v0 ad=0.88p pd=4.88u as=0.88p ps=4.88u w=2u l=1u
X56 a_8202_332# a_314_332# a_8402_376# VSS nfet_06v0 ad=1.65p pd=5.66u as=1.25p ps=5.5u w=5u l=1u
X57 a_3290_9134# INN a_554_7234# VDD pfet_06v0 ad=0.22p pd=1.88u as=0.22p ps=1.88u w=0.5u l=1u
X58 a_8786_7118# a_354_7118# a_8986_7234# VDD pfet_06v0 ad=3.3p pd=10.66u as=2.5p ps=10.5u w=10u l=1u
X59 a_54_7118# a_354_7118# a_12262_376# VSS nfet_06v0 ad=0.44p pd=2.88u as=0.25p ps=1.5u w=1u l=1u
C0 a_928_4838# a_314_332# 0.03204f
C1 a_928_4838# a_3554_332# 0.58846f
C2 a_54_7118# VDD 3.80166f
C3 a_14_332# a_314_332# 7.36269f
C4 a_8202_332# a_14_332# 0.06489f
C5 a_3554_332# a_14_332# 0.11137f
C6 OUT a_54_7118# 0.63612f
C7 a_8202_332# a_7150_8318# 0.13127f
C8 a_7150_8318# a_314_332# 0.63925f
C9 a_3554_332# a_7150_8318# 1.90941f
C10 a_2478_9124# a_3290_9134# 0.27432f
C11 INN a_2478_9124# 0.24615f
C12 a_5162_376# VDD 0.60553f
C13 a_5162_376# OUT 1.27119f
C14 a_5694_332# VDD 0.54088f
C15 OUT a_5694_332# 0.06525f
C16 a_3010_376# a_314_332# 0.02156f
C17 a_3554_332# a_3010_376# 1.29777f
C18 a_2478_9124# INP 2.012f
C19 a_354_7118# a_54_7118# 7.92294f
C20 a_514_376# a_14_332# 0.26459f
C21 a_354_7118# a_16346_4838# 0.06559f
C22 a_928_4838# a_14_332# 0.11831f
C23 a_54_7118# a_17826_7234# 0.05253f
C24 VDD a_2478_9124# 0.47257f
C25 a_928_4838# a_7150_8318# 2.01788f
C26 OUT a_2478_9124# 3.36641f
C27 a_2278_376# a_54_7118# 0.04466f
C28 a_7150_8318# a_14_332# 0.05997f
C29 a_5162_376# a_354_7118# 0.10943f
C30 a_514_376# a_1246_376# 0.02626f
C31 a_354_7118# a_5694_332# 1.90221f
C32 a_1366_7234# a_554_7234# 0.05253f
C33 a_514_376# a_3010_376# 0.33769f
C34 a_5162_376# a_2278_376# 0.82601f
C35 a_928_4838# a_3010_376# 0.05281f
C36 a_14790_7234# a_314_332# 0.05253f
C37 a_3010_376# a_14_332# 0.0305f
C38 a_2278_376# a_5694_332# 0.01307f
C39 a_8786_7118# a_8986_7234# 0.06563f
C40 a_928_4838# a_8786_7118# 0.06124f
C41 a_354_7118# a_2478_9124# 0.70196f
C42 a_16346_5738# a_14_332# 0.28594f
C43 a_7150_8318# a_8786_7118# 1.91591f
C44 a_2278_376# a_2478_9124# 0.37023f
C45 a_554_7234# a_3290_9134# 0.02653f
C46 INN a_554_7234# 1.94091f
C47 a_54_7118# a_8202_332# 0.04439f
C48 a_54_7118# a_314_332# 6.03791f
C49 a_54_7118# a_3554_332# 0.09489f
C50 a_214_376# a_514_376# 0.02626f
C51 a_554_7234# INP 2.46298f
C52 VDD a_15902_7234# 0.07562f
C53 a_1366_7234# VDD 0.07139f
C54 a_5694_332# a_10430_7234# 0.05253f
C55 a_5162_376# a_314_332# 0.80429f
C56 INN a_3290_9134# 2.20398f
C57 a_5162_376# a_3554_332# 0.45764f
C58 a_554_7234# VDD 2.07653f
C59 OUT a_554_7234# 0.15808f
C60 a_5694_332# a_8202_332# 1.13208f
C61 a_5694_332# a_314_332# 0.12459f
C62 a_3554_332# a_5694_332# 1.05787f
C63 a_54_7118# a_514_376# 1.02072f
C64 INN INP 0.01104f
C65 a_928_4838# a_54_7118# 0.10835f
C66 a_54_7118# a_14_332# 0.47275f
C67 a_2478_9124# a_8202_332# 0.03355f
C68 a_2478_9124# a_314_332# 0.87185f
C69 a_3554_332# a_2478_9124# 0.96722f
C70 VDD a_4102_7234# 2.14619f
C71 OUT a_4102_7234# 0.66806f
C72 a_54_7118# a_7150_8318# 0.25684f
C73 VDD a_3290_9134# 0.45937f
C74 OUT a_3290_9134# 0.07216f
C75 a_16346_4838# a_14_332# 0.28594f
C76 a_54_7118# a_928_6188# 0.11941f
C77 INN VDD 0.59359f
C78 INN OUT 0.07828f
C79 a_354_7118# a_554_7234# 3.07159f
C80 a_928_4838# a_928_5288# 0.02812f
C81 a_5162_376# a_928_4838# 1.10093f
C82 a_5162_376# a_14_332# 0.08182f
C83 VDD INP 0.59272f
C84 a_928_4838# a_5694_332# 1.28723f
C85 OUT INP 0.02584f
C86 a_5162_376# a_7150_8318# 2.79795f
C87 a_5694_332# a_14_332# 0.10698f
C88 a_2278_376# a_554_7234# 0.09891f
C89 a_928_5288# a_928_6188# 0.01879f
C90 a_54_7118# a_3010_376# 0.1225f
C91 a_5694_332# a_7150_8318# 0.03423f
C92 a_354_7118# a_4102_7234# 1.52032f
C93 a_54_7118# a_8786_7118# 0.01547f
C94 a_2478_9124# a_514_376# 0.10847f
C95 a_354_7118# a_3290_9134# 0.02369f
C96 OUT VDD 2.55297f
C97 a_354_7118# INN 0.48037f
C98 a_928_4838# a_2478_9124# 0.12757f
C99 a_2478_9124# a_14_332# 0.16441f
C100 a_16346_4838# a_16346_5738# 0.01879f
C101 a_2278_376# a_4102_7234# 3.109f
C102 a_2478_9124# a_7150_8318# 0.01132f
C103 a_5162_376# a_3010_376# 0.09302f
C104 a_2278_376# a_3290_9134# 0.05982f
C105 a_5694_332# a_3010_376# 0.02987f
C106 a_354_7118# INP 0.15973f
C107 a_5162_376# a_8786_7118# 0.39938f
C108 a_2278_376# INN 0.13158f
C109 a_5694_332# a_8786_7118# 0.1169f
C110 a_354_7118# VDD 4.75528f
C111 a_354_7118# OUT 0.74339f
C112 a_2278_376# INP 1.29089f
C113 a_2478_9124# a_3010_376# 0.75847f
C114 a_2478_9124# a_8786_7118# 0.01134f
C115 VDD a_17826_7234# 0.07672f
C116 a_2278_376# VDD 0.94296f
C117 a_2278_376# OUT 2.62029f
C118 a_4102_7234# a_314_332# 0.0199f
C119 a_3554_332# a_4102_7234# 0.30782f
C120 a_7358_376# a_7150_8318# 0.02626f
C121 a_3290_9134# a_314_332# 0.70059f
C122 a_3554_332# a_3290_9134# 1.02607f
C123 INN a_314_332# 0.02004f
C124 INN a_3554_332# 0.03198f
C125 a_15902_7234# a_14_332# 0.05253f
C126 a_354_7118# a_2278_376# 2.312f
C127 a_54_7118# a_928_5288# 0.11941f
C128 a_5162_376# a_54_7118# 0.07616f
C129 a_928_4838# a_554_7234# 0.06602f
C130 INP a_314_332# 0.01883f
C131 a_54_7118# a_5694_332# 2.11259f
C132 VDD a_10430_7234# 0.07139f
C133 a_554_7234# a_928_6188# 0.04286f
C134 VDD a_314_332# 0.68269f
C135 a_3554_332# VDD 0.4092f
C136 OUT a_314_332# 0.26284f
C137 OUT a_3554_332# 0.07493f
C138 a_254_7234# a_554_7234# 0.05253f
C139 a_928_4838# a_4102_7234# 0.43055f
C140 INN a_514_376# 0.55478f
C141 a_54_7118# a_2478_9124# 0.77843f
C142 a_4102_7234# a_14_332# 0.02705f
C143 a_928_4838# a_3290_9134# 0.01817f
C144 a_5162_376# a_5694_332# 1.09841f
C145 a_3290_9134# a_14_332# 0.02698f
C146 a_4102_7234# a_7150_8318# 1.7925f
C147 a_8202_332# a_8402_376# 0.03311f
C148 a_928_4838# INN 0.03915f
C149 a_2478_9124# a_16346_4838# 0.04829f
C150 INN a_14_332# 0.04284f
C151 INP a_514_376# 0.61513f
C152 a_928_4838# INP 0.03305f
C153 a_5162_376# a_2478_9124# 0.18775f
C154 INP a_14_332# 0.03537f
C155 a_354_7118# a_314_332# 1.81769f
C156 a_354_7118# a_8202_332# 0.07129f
C157 a_354_7118# a_3554_332# 1.47517f
C158 a_5694_332# a_2478_9124# 0.09739f
C159 a_4102_7234# a_3010_376# 2.74656f
C160 VDD a_8986_7234# 0.07305f
C161 a_3290_9134# a_3010_376# 0.67217f
C162 a_928_4838# VDD 4.01381f
C163 a_928_4838# OUT 12.9095f
C164 VDD a_14_332# 0.5563f
C165 OUT a_14_332# 0.18333f
C166 INN a_3010_376# 0.85042f
C167 a_2278_376# a_314_332# 0.04056f
C168 a_2278_376# a_3554_332# 0.10279f
C169 VDD a_7150_8318# 1.83728f
C170 OUT a_7150_8318# 0.12371f
C171 VDD a_928_6188# 0.02455f
C172 a_254_7234# VDD 0.07875f
C173 a_354_7118# a_514_376# 0.17392f
C174 VDD a_3010_376# 1.03084f
C175 a_354_7118# a_928_4838# 5.13277f
C176 OUT a_3010_376# 0.16402f
C177 a_354_7118# a_14_332# 2.2665f
C178 VDD a_8786_7118# 0.94259f
C179 OUT a_8786_7118# 0.02561f
C180 a_354_7118# a_7150_8318# 0.10295f
C181 a_2278_376# a_514_376# 0.63032f
C182 OUT a_16346_5738# 0.03734f
C183 a_554_7234# a_54_7118# 0.28231f
C184 a_2278_376# a_928_4838# 1.58778f
C185 a_2278_376# a_14_332# 0.04282f
C186 a_2278_376# a_7150_8318# 0.04643f
C187 a_8202_332# a_314_332# 0.85581f
C188 a_3554_332# a_314_332# 0.91731f
C189 a_354_7118# a_3010_376# 1.71723f
C190 a_554_7234# a_928_5288# 0.04313f
C191 a_54_7118# a_4102_7234# 0.01977f
C192 a_354_7118# a_8786_7118# 2.48396f
C193 a_354_7118# a_16346_5738# 0.06508f
C194 a_11230_376# a_14_332# 0.02789f
C195 a_54_7118# a_3290_9134# 0.24848f
C196 VDD a_14790_7234# 0.07139f
C197 INN a_54_7118# 0.02415f
C198 a_2278_376# a_3010_376# 0.12461f
C199 a_5162_376# a_4102_7234# 1.17211f
C200 a_54_7118# INP 0.04054f
C201 a_554_7234# a_2478_9124# 0.57228f
C202 a_514_376# a_314_332# 1.32615f
C203 a_5694_332# a_4102_7234# 0.88497f
C204 OUT VSS 11.3839f
C205 INN VSS 1.21874f
C206 INP VSS 1.25321f
C207 VDD VSS 0.15518p
C208 a_13294_376# VSS 0.01198f
C209 a_12262_376# VSS 0.01425f
C210 a_11230_376# VSS 0.04308f
C211 a_8402_376# VSS 0.04308f
C212 a_7358_376# VSS 0.04308f
C213 a_8202_332# VSS 1.48047f
C214 a_1246_376# VSS 0.04308f
C215 a_214_376# VSS 0.04686f
C216 a_514_376# VSS 2.19215f
C217 a_16346_4838# VSS 0.47474f
C218 a_928_5288# VSS 0.57275f
C219 a_16346_5738# VSS 0.45835f
C220 a_928_6188# VSS 0.56459f
C221 a_14_332# VSS 7.25272f
C222 a_314_332# VSS 7.04948f
C223 a_5694_332# VSS 3.57364f
C224 a_5162_376# VSS 3.33848f
C225 a_3554_332# VSS 4.00332f
C226 a_2278_376# VSS 4.25455f
C227 a_3010_376# VSS 2.14964f
C228 a_3290_9134# VSS 1.29357f
C229 a_2478_9124# VSS 6.38354f
C230 a_554_7234# VSS 3.45628f
C231 a_928_4838# VSS 7.29456f
C232 a_8786_7118# VSS 1.67907f
C233 a_7150_8318# VSS 3.14571f
C234 a_4102_7234# VSS 3.62868f
C235 a_354_7118# VSS 13.6999f
C236 a_54_7118# VSS 10.6933f
.ends
