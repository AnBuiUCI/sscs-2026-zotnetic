* Nodos de bulk atados: 28 de pozo n -> VDD, 26 de sustrato -> VSS.
*   magic no extrae los taps de este layout y los dejaba flotando;
*   la conexion si existe (el LVS de KLayout da 'match uniquely').
*   Quien detecta un tap que falte de verdad es el LVS, no esto.
* NGSPICE file created from OPAM_LIN_flat.ext - technology: gf180mcuD

.subckt OPAM_LIN_flat_V2 VSS VDD INP OUT INN
X0 a_3566_332.t1 a_314_332.t7 a_3290_8994.t1 VSS nfet_06v0 ad=0.825p pd=3.16u as=0.825p ps=3.16u w=2.5u l=1u
X1 OUT.t0 a_5518_376.t3 VSS.t1 VSS nfet_06v0 ad=0.44p pd=2.88u as=0.44p ps=2.88u w=1u l=1u
X2 a_5518_376.t1 a_314_332.t6 a_2478_8974.t2 VSS nfet_06v0 ad=0.825p pd=3.16u as=0.825p ps=3.16u w=2.5u l=1u
X3 a_4712_8078.t2 a_314_332.t5 a_6582_376.t1 VSS nfet_06v0 ad=2.2p pd=10.88u as=1.25p ps=5.5u w=5u l=1u
X4 OUT.t7 a_2278_376.t1 cap_mim_2f0_m4m5_noshield c_width=25u c_length=4u
X5 a_2478_8974.t3 OUT.t1 cap_mim_2f0_m4m5_noshield c_width=25u c_length=4u
X6 OUT.t3 a_1088_4798.t6 VDD.t4 VDD pfet_06v0 ad=0.22p pd=1.88u as=0.22p ps=1.88u w=0.5u l=1u
X7 a_7072_7078.t0 a_354_7078.t11 a_7272_7194.t0 VDD pfet_06v0 ad=3.3p pd=10.66u as=2.5p ps=10.5u w=10u l=1u
X8 a_14188_7194.t1 a_54_7078.t3 VDD.t17 VDD pfet_06v0 ad=2.5p pd=10.5u as=4.4p ps=20.88u w=10u l=1u
X9 a_2278_376.t2 INP.t0 a_514_376.t0 VSS nfet_06v0 ad=0.44p pd=2.88u as=0.44p ps=2.88u w=1u l=1u
X10 a_54_7078.t1 a_354_7078.t7 a_16112_7194.t0 VDD pfet_06v0 ad=4.4p pd=20.88u as=2.5p ps=10.5u w=10u l=1u
X11 a_3566_332.t0 a_4712_8078.t4 a_4048_8078.t1 VDD pfet_06v0 ad=2.2p pd=10.88u as=1.65p ps=5.66u w=5u l=1u
X12 a_1088_4798.t1 a_16506_4798.t0 VSS.t11 ppolyf_u_3k r_width=1u r_length=76.45u
X13 a_514_376.t2 a_314_332.t9 a_214_376.t1 VSS nfet_06v0 ad=2.2p pd=10.88u as=1.25p ps=5.5u w=5u l=1u
X14 a_554_7194.t1 a_354_7078.t15 a_254_7194.t0 VDD pfet_06v0 ad=4.4p pd=20.88u as=2.5p ps=10.5u w=10u l=1u
X15 a_4230_332.t2 a_4230_332.t1 a_7438_332.t0 VSS nfet_06v0 ad=2.2p pd=10.88u as=1.65p ps=5.66u w=5u l=1u
X16 a_314_332.t2 a_314_332.t1 VSS.t25 VSS nfet_06v0 ad=0.44p pd=2.88u as=0.44p ps=2.88u w=1u l=1u
X17 OUT.t4 a_1088_4798.t4 VDD.t35 VDD pfet_06v0 ad=0.22p pd=1.88u as=0.22p ps=1.88u w=0.5u l=1u
X18 a_13076_7194.t1 a_54_7078.t4 VDD.t37 VDD pfet_06v0 ad=2.5p pd=10.5u as=4.4p ps=20.88u w=10u l=1u
X19 a_1088_5248.t1 a_16506_4798.t1 VSS.t11 ppolyf_u_3k r_width=1u r_length=76.45u
X20 a_3290_8994.t0 a_3566_332.t4 VSS.t17 VSS nfet_06v0 ad=0.825p pd=3.16u as=1.1p ps=5.88u w=2.5u l=1u
X21 a_2478_8974.t0 a_3566_332.t3 VSS.t31 VSS nfet_06v0 ad=0.825p pd=3.16u as=1.1p ps=5.88u w=2.5u l=1u
X22 a_8716_7194.t1 a_54_7078.t5 VDD.t29 VDD pfet_06v0 ad=2.5p pd=10.5u as=4.4p ps=20.88u w=10u l=1u
X23 a_12530_376.t0 a_354_7078.t4 VSS.t10 VSS nfet_06v0 ad=0.25p pd=1.5u as=0.44p ps=2.88u w=1u l=1u
X24 a_2478_8974.t1 INP.t1 a_554_7194.t0 VDD pfet_06v0 ad=0.484p pd=3.08u as=0.484p ps=3.08u w=1.1u l=1u
X25 a_1088_4798.t0 a_354_7078.t12 a_2278_376.t0 VDD pfet_06v0 ad=1.65p pd=5.66u as=1.65p ps=5.66u w=5u l=1u
X26 a_1366_7194.t0 a_54_7078.t6 VDD.t9 VDD pfet_06v0 ad=2.5p pd=10.5u as=4.4p ps=20.88u w=10u l=1u
X27 OUT.t6 a_1088_4798.t7 VDD.t39 VDD pfet_06v0 ad=0.22p pd=1.88u as=0.22p ps=1.88u w=0.5u l=1u
X28 a_354_7078.t1 a_354_7078.t0 VDD.t13 VDD pfet_06v0 ad=0.88p pd=4.88u as=0.88p ps=4.88u w=2u l=1u
X29 a_214_376.t0 a_14_332.t5 VSS.t33 VSS nfet_06v0 ad=1.25p pd=5.5u as=2.2p ps=10.88u w=5u l=1u
X30 a_10466_376.t0 a_14_332.t2 VSS.t15 VSS nfet_06v0 ad=1.25p pd=5.5u as=2.2p ps=10.88u w=5u l=1u
X31 a_3010_376.t1 a_4048_8078.t4 VDD.t24 VDD pfet_06v0 ad=1.65p pd=5.66u as=2.2p ps=10.88u w=5u l=1u
X32 a_1088_5248.t0 a_16506_5698.t0 VSS.t11 ppolyf_u_3k r_width=1u r_length=76.45u
X33 a_354_7078.t3 a_354_7078.t2 a_12530_376.t1 VSS nfet_06v0 ad=0.44p pd=2.88u as=0.25p ps=1.5u w=1u l=1u
X34 a_1088_6148.t0 a_16506_5698.t1 VSS.t11 ppolyf_u_3k r_width=1u r_length=76.45u
X35 a_16112_7194.t1 a_54_7078.t2 VDD.t31 VDD pfet_06v0 ad=2.5p pd=10.5u as=4.4p ps=20.88u w=10u l=1u
X36 a_14_332.t1 a_314_332.t3 a_10466_376.t1 VSS nfet_06v0 ad=2.2p pd=10.88u as=1.25p ps=5.5u w=5u l=1u
X37 a_4048_8078.t0 a_354_7078.t13 a_3010_376.t0 VDD pfet_06v0 ad=1.65p pd=5.66u as=1.65p ps=5.66u w=5u l=1u
X38 a_4230_332.t0 a_354_7078.t10 a_8716_7194.t0 VDD pfet_06v0 ad=4.4p pd=20.88u as=2.5p ps=10.5u w=10u l=1u
X39 a_254_7194.t1 a_54_7078.t7 VDD.t33 VDD pfet_06v0 ad=2.5p pd=10.5u as=4.4p ps=20.88u w=10u l=1u
X40 a_3290_8994.t2 INN.t1 a_554_7194.t3 VDD pfet_06v0 ad=0.44p pd=2.88u as=0.44p ps=2.88u w=1u l=1u
X41 a_5518_376.t0 a_4712_8078.t3 a_1088_4798.t2 VDD pfet_06v0 ad=2.2p pd=10.88u as=1.65p ps=5.66u w=5u l=1u
X42 a_4048_8078.t2 a_4230_332.t4 a_3566_332.t2 VSS nfet_06v0 ad=1.1p pd=5.88u as=0.825p ps=3.16u w=2.5u l=1u
X43 OUT.t2 a_1088_4798.t5 VDD.t2 VDD pfet_06v0 ad=0.22p pd=1.88u as=0.22p ps=1.88u w=0.5u l=1u
X44 a_1088_4798.t3 a_4230_332.t3 a_5518_376.t2 VSS nfet_06v0 ad=1.1p pd=5.88u as=0.825p ps=3.16u w=2.5u l=1u
X45 a_554_7194.t2 a_354_7078.t14 a_1366_7194.t1 VDD pfet_06v0 ad=4.4p pd=20.88u as=2.5p ps=10.5u w=10u l=1u
X46 a_14_332.t0 a_354_7078.t8 a_14188_7194.t0 VDD pfet_06v0 ad=4.4p pd=20.88u as=2.5p ps=10.5u w=10u l=1u
X47 a_7638_376.t0 a_7438_332.t2 VSS.t13 VSS nfet_06v0 ad=1.25p pd=5.5u as=2.2p ps=10.88u w=5u l=1u
X48 a_4712_8078.t1 a_4712_8078.t0 a_7072_7078.t1 VDD pfet_06v0 ad=4.4p pd=20.88u as=3.3p ps=10.66u w=10u l=1u
X49 a_1088_6148.t1 OUT.t5 VSS.t11 ppolyf_u_3k r_width=1u r_length=76.45u
X50 a_1246_376.t0 a_14_332.t4 VSS.t7 VSS nfet_06v0 ad=1.25p pd=5.5u as=2.2p ps=10.88u w=5u l=1u
X51 a_11498_376.t0 a_354_7078.t6 VSS.t4 VSS nfet_06v0 ad=0.25p pd=1.5u as=0.44p ps=2.88u w=1u l=1u
X52 a_2278_376.t3 a_4048_8078.t3 VDD.t26 VDD pfet_06v0 ad=1.65p pd=5.66u as=2.2p ps=10.88u w=5u l=1u
X53 a_3010_376.t2 INN.t0 a_514_376.t3 VSS nfet_06v0 ad=0.44p pd=2.88u as=0.44p ps=2.88u w=1u l=1u
X54 a_7438_332.t1 a_314_332.t4 a_7638_376.t1 VSS nfet_06v0 ad=1.65p pd=5.66u as=1.25p ps=5.5u w=5u l=1u
X55 a_7272_7194.t1 a_7072_7078.t2 VDD.t19 VDD pfet_06v0 ad=2.5p pd=10.5u as=4.4p ps=20.88u w=10u l=1u
X56 a_314_332.t0 a_354_7078.t9 a_13076_7194.t0 VDD pfet_06v0 ad=4.4p pd=20.88u as=2.5p ps=10.5u w=10u l=1u
X57 a_514_376.t1 a_314_332.t8 a_1246_376.t1 VSS nfet_06v0 ad=2.2p pd=10.88u as=1.25p ps=5.5u w=5u l=1u
X58 a_6582_376.t0 a_14_332.t3 VSS.t22 VSS nfet_06v0 ad=1.25p pd=5.5u as=2.2p ps=10.88u w=5u l=1u
X59 a_54_7078.t0 a_354_7078.t5 a_11498_376.t1 VSS nfet_06v0 ad=0.44p pd=2.88u as=0.25p ps=1.5u w=1u l=1u
R0 OUT.n0 OUT.t5 27.6542
R1 OUT.n1 OUT.t4 24.4525
R2 OUT.n3 OUT.t3 24.1318
R3 OUT.n2 OUT.t2 24.0668
R4 OUT OUT.t6 19.5668
R5 OUT.n4 OUT.t7 16.0468
R6 OUT.n4 OUT.t0 15.5511
R7 OUT.n0 OUT.t1 4.67993
R8 OUT.n1 OUT.n0 4.5005
R9 OUT OUT.n5 4.5005
R10 OUT.n5 OUT.n4 1.0661
R11 OUT.n3 OUT.n2 1.02777
R12 OUT.n5 OUT.n3 1.02677
R13 OUT.n2 OUT.n1 0.849071
R14 INN INN.t0 24.1616
R15 INN INN.t1 22.3787
R16 INP INP.t0 23.8647
R17 INP INP.t1 23.0366
R18 VDD VDD 358.534
R19 VDD VDD 303.892
R20 VDD VDD 303.892
R21 VDD VDD 303.892
R22 VDD VDD 303.892
R23 VDD VDD 303.892
R24 VDD.n69 VDD 170.66
R25 VDD.n68 VDD 161.678
R26 VDD.n38 VDD 152.696
R27 VDD.n40 VDD 152.696
R28 VDD VDD.n39 152.696
R29 VDD.n66 VDD 152.696
R30 VDD.n67 VDD 152.696
R31 VDD.n70 VDD 152.696
R32 VDD.n71 VDD 152.696
R33 VDD VDD.n38 151.198
R34 VDD.n40 VDD 151.198
R35 VDD.n39 VDD 151.198
R36 VDD VDD.n66 151.198
R37 VDD VDD.n67 151.198
R38 VDD VDD.n68 151.198
R39 VDD VDD.n69 151.198
R40 VDD VDD.n70 151.198
R41 VDD.n71 VDD 151.198
R42 VDD VDD 124.252
R43 VDD VDD 124.252
R44 VDD VDD 124.252
R45 VDD VDD 124.252
R46 VDD VDD 124.252
R47 VDD VDD 112.275
R48 VDD VDD 112.275
R49 VDD VDD 112.275
R50 VDD VDD 112.275
R51 VDD VDD 112.275
R52 VDD VDD 112.275
R53 VDD VDD 112.275
R54 VDD.n38 VDD.n37 12.6005
R55 VDD.n41 VDD.n40 12.6005
R56 VDD.n39 VDD.n20 12.6005
R57 VDD.n66 VDD.n65 12.6005
R58 VDD.n67 VDD.n1 12.6005
R59 VDD.n68 VDD.n6 12.6005
R60 VDD.n69 VDD.n10 12.6005
R61 VDD.n70 VDD.n13 12.6005
R62 VDD.n72 VDD.n71 12.6005
R63 VDD.n18 VDD.t39 9.28167
R64 VDD.n55 VDD.t4 9.28167
R65 VDD.n53 VDD.t2 9.28167
R66 VDD.n48 VDD.t35 9.28167
R67 VDD.n75 VDD.n74 9.0005
R68 VDD.n76 VDD.n15 9.0005
R69 VDD.n78 VDD.n77 9.0005
R70 VDD.n79 VDD.n14 9.0005
R71 VDD.n81 VDD.n80 9.0005
R72 VDD.n83 VDD.n82 9.0005
R73 VDD.n84 VDD.n12 9.0005
R74 VDD.n86 VDD.n85 9.0005
R75 VDD.n88 VDD.n87 9.0005
R76 VDD.n89 VDD.n8 9.0005
R77 VDD.n91 VDD.n90 9.0005
R78 VDD.n92 VDD.n7 9.0005
R79 VDD.n94 VDD.n93 9.0005
R80 VDD.n95 VDD.n5 9.0005
R81 VDD.n97 VDD.n96 9.0005
R82 VDD.n99 VDD.n98 9.0005
R83 VDD.n100 VDD.n3 9.0005
R84 VDD.n102 VDD.n101 9.0005
R85 VDD.n104 VDD.n103 9.0005
R86 VDD.n2 VDD.n0 9.0005
R87 VDD.n60 VDD.n59 9.0005
R88 VDD.n62 VDD.n61 9.0005
R89 VDD.n64 VDD.n63 9.0005
R90 VDD.n58 VDD.n17 9.0005
R91 VDD.n57 VDD.n56 9.0005
R92 VDD.n54 VDD.n19 9.0005
R93 VDD.n52 VDD.n51 9.0005
R94 VDD.n50 VDD.n49 9.0005
R95 VDD.n47 VDD.n21 9.0005
R96 VDD.n46 VDD.n45 9.0005
R97 VDD.n44 VDD.n43 9.0005
R98 VDD.n42 VDD.n23 9.0005
R99 VDD.n27 VDD.n24 9.0005
R100 VDD.n31 VDD.n28 9.0005
R101 VDD.n33 VDD.n32 9.0005
R102 VDD.n34 VDD.n26 9.0005
R103 VDD.n36 VDD.n35 9.0005
R104 VDD.n35 VDD.n25 3.4478
R105 VDD.n75 VDD.n16 3.23511
R106 VDD.n29 VDD.t13 2.82475
R107 VDD.n16 VDD.t33 2.14376
R108 VDD.n73 VDD.t9 1.96744
R109 VDD.n4 VDD.t19 1.96744
R110 VDD.n105 VDD.t29 1.96744
R111 VDD.n22 VDD.t37 1.96744
R112 VDD.n30 VDD.t17 1.96744
R113 VDD.n25 VDD.t31 1.96744
R114 VDD.n11 VDD.t24 1.8449
R115 VDD.n9 VDD.t26 1.8449
R116 VDD.n72 VDD.n16 0.25569
R117 VDD.n35 VDD.n34 0.2005
R118 VDD.n34 VDD.n33 0.2005
R119 VDD.n33 VDD.n28 0.2005
R120 VDD.n28 VDD.n27 0.2005
R121 VDD.n27 VDD.n23 0.2005
R122 VDD.n44 VDD.n23 0.2005
R123 VDD.n45 VDD.n44 0.2005
R124 VDD.n45 VDD.n21 0.2005
R125 VDD.n50 VDD.n21 0.2005
R126 VDD.n51 VDD.n50 0.2005
R127 VDD.n51 VDD.n19 0.2005
R128 VDD.n57 VDD.n19 0.2005
R129 VDD.n58 VDD.n57 0.2005
R130 VDD.n63 VDD.n58 0.2005
R131 VDD.n63 VDD.n62 0.2005
R132 VDD.n62 VDD.n59 0.2005
R133 VDD.n59 VDD.n2 0.2005
R134 VDD.n103 VDD.n2 0.2005
R135 VDD.n103 VDD.n102 0.2005
R136 VDD.n102 VDD.n3 0.2005
R137 VDD.n98 VDD.n3 0.2005
R138 VDD.n98 VDD.n97 0.2005
R139 VDD.n97 VDD.n5 0.2005
R140 VDD.n93 VDD.n5 0.2005
R141 VDD.n93 VDD.n92 0.2005
R142 VDD.n92 VDD.n91 0.2005
R143 VDD.n91 VDD.n8 0.2005
R144 VDD.n87 VDD.n8 0.2005
R145 VDD.n87 VDD.n86 0.2005
R146 VDD.n86 VDD.n12 0.2005
R147 VDD.n82 VDD.n12 0.2005
R148 VDD.n82 VDD.n81 0.2005
R149 VDD.n81 VDD.n14 0.2005
R150 VDD.n77 VDD.n14 0.2005
R151 VDD.n77 VDD.n76 0.2005
R152 VDD.n76 VDD.n75 0.2005
R153 VDD.n36 VDD.n26 0.2005
R154 VDD.n32 VDD.n31 0.2005
R155 VDD.n43 VDD.n42 0.2005
R156 VDD.n47 VDD.n46 0.2005
R157 VDD.n56 VDD.n54 0.2005
R158 VDD.n61 VDD.n60 0.2005
R159 VDD.n60 VDD.n0 0.2005
R160 VDD.n101 VDD.n100 0.2005
R161 VDD.n100 VDD.n99 0.2005
R162 VDD.n96 VDD.n95 0.2005
R163 VDD.n95 VDD.n94 0.2005
R164 VDD.n94 VDD.n7 0.2005
R165 VDD.n90 VDD.n89 0.2005
R166 VDD.n89 VDD.n88 0.2005
R167 VDD.n85 VDD.n84 0.2005
R168 VDD.n84 VDD.n83 0.2005
R169 VDD.n80 VDD.n79 0.2005
R170 VDD.n79 VDD.n78 0.2005
R171 VDD.n78 VDD.n15 0.2005
R172 VDD.n74 VDD.n15 0.2005
R173 VDD.n31 VDD.n30 0.195
R174 VDD.n64 VDD.n18 0.175
R175 VDD.n56 VDD.n55 0.169
R176 VDD.n88 VDD.n11 0.165
R177 VDD.n83 VDD.n13 0.1635
R178 VDD.n53 VDD.n52 0.163
R179 VDD.n32 VDD.n29 0.162
R180 VDD.n48 VDD.n47 0.157
R181 VDD.n43 VDD.n22 0.151
R182 VDD.n101 VDD.n1 0.1505
R183 VDD.n10 VDD.n9 0.144
R184 VDD.n6 VDD.n4 0.132
R185 VDD.n52 VDD.n20 0.1245
R186 VDD.n37 VDD.n25 0.12
R187 VDD.n73 VDD.n72 0.12
R188 VDD.n41 VDD.n24 0.1145
R189 VDD.n65 VDD.n64 0.1125
R190 VDD VDD.n0 0.102
R191 VDD.n65 VDD.n17 0.0885
R192 VDD.n42 VDD.n41 0.0865
R193 VDD.n49 VDD.n20 0.0765
R194 VDD.n105 VDD.n104 0.07
R195 VDD.n90 VDD.n10 0.0545
R196 VDD.n99 VDD.n4 0.053
R197 VDD.n104 VDD.n1 0.0505
R198 VDD.n46 VDD.n22 0.05
R199 VDD.n37 VDD.n36 0.0485
R200 VDD.n49 VDD.n48 0.044
R201 VDD.n29 VDD.n26 0.039
R202 VDD.n54 VDD.n53 0.038
R203 VDD.n80 VDD.n13 0.0375
R204 VDD.n85 VDD.n11 0.036
R205 VDD.n55 VDD.n17 0.032
R206 VDD VDD.n105 0.0295
R207 VDD.n61 VDD.n18 0.026
R208 VDD.n96 VDD.n6 0.0165
R209 VDD.n30 VDD.n24 0.006
R210 VDD.n74 VDD.n73 0.006
R211 VDD.n9 VDD.n7 0.003
R212 VSS VSS 356.19
R213 VSS VSS 356.19
R214 VSS VSS 344.884
R215 VSS VSS 344.884
R216 VSS VSS 344.884
R217 VSS VSS.n13 260.99
R218 VSS VSS.n68 184.691
R219 VSS.n14 VSS 173.385
R220 VSS.n33 VSS 173.385
R221 VSS.n69 VSS 173.385
R222 VSS.n48 VSS 173.385
R223 VSS.n49 VSS 173.385
R224 VSS.n14 VSS 171.5
R225 VSS VSS.n33 171.5
R226 VSS VSS.n34 171.5
R227 VSS.n69 VSS 171.5
R228 VSS.n68 VSS 171.5
R229 VSS VSS.n48 171.5
R230 VSS.n49 VSS 171.5
R231 VSS VSS 156.423
R232 VSS VSS 156.423
R233 VSS VSS 156.423
R234 VSS VSS 156.423
R235 VSS VSS 156.423
R236 VSS.n34 VSS.t11 154.066
R237 VSS VSS 141.345
R238 VSS VSS 141.345
R239 VSS VSS 141.345
R240 VSS VSS 141.345
R241 VSS VSS 141.345
R242 VSS VSS 141.345
R243 VSS VSS 141.345
R244 VSS.t11 VSS 19.3177
R245 VSS.n15 VSS.n14 10.4005
R246 VSS.n33 VSS.n32 10.4005
R247 VSS.n34 VSS.n0 10.4005
R248 VSS.n70 VSS.n69 10.4005
R249 VSS.n68 VSS.n67 10.4005
R250 VSS.n48 VSS.n44 10.4005
R251 VSS.n50 VSS.n49 10.4005
R252 VSS.n52 VSS.n46 9.0005
R253 VSS.n54 VSS.n53 9.0005
R254 VSS.n55 VSS.n45 9.0005
R255 VSS.n57 VSS.n56 9.0005
R256 VSS.n59 VSS.n58 9.0005
R257 VSS.n60 VSS.n43 9.0005
R258 VSS.n63 VSS.n62 9.0005
R259 VSS.n64 VSS.n36 9.0005
R260 VSS.n66 VSS.n65 9.0005
R261 VSS.n42 VSS.n35 9.0005
R262 VSS.n41 VSS.n40 9.0005
R263 VSS.n38 VSS.n37 9.0005
R264 VSS.n6 VSS.n5 9.0005
R265 VSS.n72 VSS.n71 9.0005
R266 VSS.n74 VSS.n73 9.0005
R267 VSS.n75 VSS.n3 9.0005
R268 VSS.n78 VSS.n77 9.0005
R269 VSS.n79 VSS.n1 9.0005
R270 VSS.n81 VSS.n80 9.0005
R271 VSS.n25 VSS.n2 9.0005
R272 VSS.n28 VSS.n27 9.0005
R273 VSS.n29 VSS.n8 9.0005
R274 VSS.n31 VSS.n30 9.0005
R275 VSS.n23 VSS.n22 9.0005
R276 VSS.n21 VSS.n9 9.0005
R277 VSS.n20 VSS.n19 9.0005
R278 VSS.n18 VSS.n17 9.0005
R279 VSS.n16 VSS.n11 9.0005
R280 VSS.n12 VSS.t10 5.28916
R281 VSS.n10 VSS.t4 5.28916
R282 VSS.n24 VSS.t25 5.28916
R283 VSS.n26 VSS.t1 5.28916
R284 VSS.n52 VSS.n51 3.22882
R285 VSS.n39 VSS.t31 2.58836
R286 VSS.n61 VSS.t17 2.58836
R287 VSS.n51 VSS.t33 2.10811
R288 VSS.n7 VSS.t15 1.91886
R289 VSS.n76 VSS.t13 1.91886
R290 VSS.n4 VSS.t22 1.91886
R291 VSS.n47 VSS.t7 1.91886
R292 VSS.n13 VSS.n11 1.59849
R293 VSS.n13 VSS.n12 0.361511
R294 VSS.n51 VSS.n50 0.221979
R295 VSS.n18 VSS.n11 0.2005
R296 VSS.n19 VSS.n18 0.2005
R297 VSS.n19 VSS.n9 0.2005
R298 VSS.n23 VSS.n9 0.2005
R299 VSS.n30 VSS.n23 0.2005
R300 VSS.n30 VSS.n29 0.2005
R301 VSS.n29 VSS.n28 0.2005
R302 VSS.n28 VSS.n2 0.2005
R303 VSS.n80 VSS.n2 0.2005
R304 VSS.n80 VSS.n79 0.2005
R305 VSS.n79 VSS.n78 0.2005
R306 VSS.n78 VSS.n3 0.2005
R307 VSS.n73 VSS.n3 0.2005
R308 VSS.n73 VSS.n72 0.2005
R309 VSS.n72 VSS.n5 0.2005
R310 VSS.n37 VSS.n5 0.2005
R311 VSS.n41 VSS.n37 0.2005
R312 VSS.n42 VSS.n41 0.2005
R313 VSS.n65 VSS.n42 0.2005
R314 VSS.n65 VSS.n64 0.2005
R315 VSS.n64 VSS.n63 0.2005
R316 VSS.n63 VSS.n43 0.2005
R317 VSS.n58 VSS.n43 0.2005
R318 VSS.n58 VSS.n57 0.2005
R319 VSS.n57 VSS.n45 0.2005
R320 VSS.n53 VSS.n45 0.2005
R321 VSS.n53 VSS.n52 0.2005
R322 VSS.n17 VSS.n16 0.2005
R323 VSS.n21 VSS.n20 0.2005
R324 VSS.n22 VSS.n21 0.2005
R325 VSS.n31 VSS.n8 0.2005
R326 VSS.n81 VSS.n1 0.2005
R327 VSS.n77 VSS.n1 0.2005
R328 VSS.n75 VSS.n74 0.2005
R329 VSS.n38 VSS.n6 0.2005
R330 VSS.n40 VSS.n38 0.2005
R331 VSS.n66 VSS.n36 0.2005
R332 VSS.n62 VSS.n36 0.2005
R333 VSS.n60 VSS.n59 0.2005
R334 VSS.n56 VSS.n55 0.2005
R335 VSS.n55 VSS.n54 0.2005
R336 VSS.n54 VSS.n46 0.2005
R337 VSS.n74 VSS.n4 0.198
R338 VSS.n61 VSS.n60 0.195
R339 VSS.n67 VSS.n66 0.1935
R340 VSS.n27 VSS.n26 0.188
R341 VSS.n27 VSS.n24 0.179
R342 VSS.n17 VSS.n10 0.14
R343 VSS.n76 VSS.n75 0.131
R344 VSS.n56 VSS.n44 0.1175
R345 VSS.n39 VSS.n35 0.105
R346 VSS.n70 VSS.n6 0.1035
R347 VSS.n15 VSS.n12 0.1
R348 VSS.n32 VSS.n7 0.1
R349 VSS.n50 VSS.n47 0.1
R350 VSS VSS.n81 0.099
R351 VSS.n71 VSS.n70 0.0975
R352 VSS.n40 VSS.n39 0.096
R353 VSS.n25 VSS.n0 0.0875
R354 VSS.n59 VSS.n44 0.0835
R355 VSS.n16 VSS.n15 0.0775
R356 VSS.n77 VSS.n76 0.07
R357 VSS.n47 VSS.n46 0.066
R358 VSS.n20 VSS.n10 0.061
R359 VSS.n22 VSS.n7 0.056
R360 VSS.n32 VSS.n31 0.0455
R361 VSS.n24 VSS.n8 0.022
R362 VSS VSS.n0 0.015
R363 VSS.n26 VSS.n25 0.013
R364 VSS.n67 VSS.n35 0.0075
R365 VSS.n62 VSS.n61 0.006
R366 VSS.n71 VSS.n4 0.003
R367 a_12530_376.t0 a_12530_376.t1 3.1505
R368 a_11498_376.t0 a_11498_376.t1 3.1505
R369 a_10466_376.t0 a_10466_376.t1 0.6305
R370 a_7638_376.t0 a_7638_376.t1 0.6305
R371 a_6582_376.t0 a_6582_376.t1 0.6305
R372 a_1246_376.t0 a_1246_376.t1 0.6305
R373 a_514_376.t0 a_514_376.n1 12.2624
R374 a_514_376.n1 a_514_376.t3 13.4066
R375 a_514_376.n1 a_514_376.n0 0.601571
R376 a_514_376.n0 a_514_376.t2 8.95471
R377 a_514_376.n0 a_514_376.t1 7.32828
R378 a_214_376.t0 a_214_376.t1 0.6305
R379 a_7438_332.n0 a_7438_332.t1 0.4163
R380 a_7438_332.t0 a_7438_332.n0 0.4163
R381 a_7438_332.n0 a_7438_332.t2 47.8339
R382 a_16506_4798.t0 a_16506_4798.t1 15.2227
R383 a_1088_5248.t0 a_1088_5248.t1 15.2227
R384 a_16506_5698.t0 a_16506_5698.t1 15.2227
R385 a_1088_6148.t0 a_1088_6148.t1 15.2227
R386 a_16112_7194.t0 a_16112_7194.t1 0.3505
R387 a_14_332.t1 a_14_332.n3 6.81176
R388 a_14_332.n3 a_14_332.t0 22.597
R389 a_14_332.n3 a_14_332.n0 0.722107
R390 a_14_332.n0 a_14_332.n1 6.2105
R391 a_14_332.n1 a_14_332.n2 8.54407
R392 a_14_332.n2 a_14_332.t5 31.8629
R393 a_14_332.n2 a_14_332.t4 30.2365
R394 a_14_332.n1 a_14_332.t3 30.2365
R395 a_14_332.n0 a_14_332.t2 30.2365
R396 a_14188_7194.t0 a_14188_7194.t1 0.3505
R397 a_314_332.t2 a_314_332.n7 12.0041
R398 a_314_332.n7 a_314_332.n6 1.35532
R399 a_314_332.n6 a_314_332.t0 20.8233
R400 a_314_332.n6 a_314_332.t3 30.4947
R401 a_314_332.n7 a_314_332.n0 0.239964
R402 a_314_332.n0 a_314_332.n1 2.85479
R403 a_314_332.n1 a_314_332.n2 1.6655
R404 a_314_332.n2 a_314_332.n3 2.1605
R405 a_314_332.n3 a_314_332.n4 2.2505
R406 a_314_332.n4 a_314_332.n5 4.06979
R407 a_314_332.n5 a_314_332.t9 32.1212
R408 a_314_332.n5 a_314_332.t8 30.4947
R409 a_314_332.n4 a_314_332.t7 22.348
R410 a_314_332.n3 a_314_332.t6 22.348
R411 a_314_332.n2 a_314_332.t5 30.4947
R412 a_314_332.n1 a_314_332.t4 30.4947
R413 a_314_332.n0 a_314_332.t1 17.46
R414 a_13076_7194.t0 a_13076_7194.t1 0.3505
R415 a_4230_332.t2 a_4230_332.n2 10.6857
R416 a_4230_332.n2 a_4230_332.t0 13.9403
R417 a_4230_332.n2 a_4230_332.n0 0.239964
R418 a_4230_332.n0 a_4230_332.n1 3.85764
R419 a_4230_332.n1 a_4230_332.t4 28.2778
R420 a_4230_332.n1 a_4230_332.t3 25.9637
R421 a_4230_332.n0 a_4230_332.t1 34.1104
R422 a_8716_7194.t0 a_8716_7194.t1 0.3505
R423 a_7272_7194.t0 a_7272_7194.t1 0.3505
R424 a_5518_376.t1 a_5518_376.n0 0.8321
R425 a_5518_376.n0 a_5518_376.t2 0.8321
R426 a_5518_376.n0 a_5518_376.n1 18.5989
R427 a_5518_376.n1 a_5518_376.t3 21.5384
R428 a_5518_376.n1 a_5518_376.t0 17.965
R429 a_2278_376.t2 a_2278_376.n0 16.0677
R430 a_2278_376.n0 a_2278_376.n1 28.1826
R431 a_2278_376.n1 a_2278_376.t3 0.4625
R432 a_2278_376.n1 a_2278_376.t0 0.4625
R433 a_2278_376.n0 a_2278_376.t1 9.17993
R434 a_3566_332.t1 a_3566_332.n0 0.8321
R435 a_3566_332.n0 a_3566_332.t2 0.8321
R436 a_3566_332.n0 a_3566_332.n2 17.6722
R437 a_3566_332.n2 a_3566_332.n1 1.27657
R438 a_3566_332.n1 a_3566_332.t3 23.3028
R439 a_3566_332.n1 a_3566_332.t0 17.4485
R440 a_3566_332.n2 a_3566_332.t4 23.8958
R441 a_3010_376.t2 a_3010_376.n0 40.5944
R442 a_3010_376.n0 a_3010_376.t1 0.4625
R443 a_3010_376.n0 a_3010_376.t0 0.4625
R444 a_3290_8994.t2 a_3290_8994.n0 40.4942
R445 a_3290_8994.n0 a_3290_8994.t0 0.8321
R446 a_3290_8994.n0 a_3290_8994.t1 0.8321
R447 a_2478_8974.t1 a_2478_8974.n0 25.8388
R448 a_2478_8974.n0 a_2478_8974.n1 17.9926
R449 a_2478_8974.n1 a_2478_8974.t0 0.8321
R450 a_2478_8974.n1 a_2478_8974.t2 0.8321
R451 a_2478_8974.n0 a_2478_8974.t3 16.6408
R452 a_1366_7194.t0 a_1366_7194.t1 0.3505
R453 a_554_7194.t3 a_554_7194.n0 22.0155
R454 a_554_7194.n0 a_554_7194.n1 0.730143
R455 a_554_7194.n1 a_554_7194.t1 16.0781
R456 a_554_7194.n1 a_554_7194.t2 14.3231
R457 a_554_7194.n0 a_554_7194.t0 20.6051
R458 a_254_7194.t0 a_254_7194.t1 0.3505
R459 a_1088_4798.t1 a_1088_4798.n5 30.3543
R460 a_1088_4798.n5 a_1088_4798.n1 0.0620789
R461 a_1088_4798.n1 a_1088_4798.n2 5.68175
R462 a_1088_4798.n2 a_1088_4798.n3 1.27336
R463 a_1088_4798.n3 a_1088_4798.n4 1.27336
R464 a_1088_4798.n4 a_1088_4798.t4 25.2309
R465 a_1088_4798.n4 a_1088_4798.t5 23.958
R466 a_1088_4798.n3 a_1088_4798.t6 23.958
R467 a_1088_4798.n2 a_1088_4798.t7 23.958
R468 a_1088_4798.n1 a_1088_4798.n0 23.6024
R469 a_1088_4798.n0 a_1088_4798.t0 0.4625
R470 a_1088_4798.n0 a_1088_4798.t2 0.4625
R471 a_1088_4798.n5 a_1088_4798.t3 12.1026
R472 a_7072_7078.t0 a_7072_7078.n0 0.2315
R473 a_7072_7078.n0 a_7072_7078.t1 0.2315
R474 a_7072_7078.n0 a_7072_7078.t2 82.2509
R475 a_4712_8078.t2 a_4712_8078.n2 8.10307
R476 a_4712_8078.n2 a_4712_8078.n1 1.33925
R477 a_4712_8078.n1 a_4712_8078.t1 15.5956
R478 a_4712_8078.n1 a_4712_8078.t0 56.9817
R479 a_4712_8078.n2 a_4712_8078.n0 0.95675
R480 a_4712_8078.n0 a_4712_8078.t4 43.1054
R481 a_4712_8078.n0 a_4712_8078.t3 40.6882
R482 a_4048_8078.t2 a_4048_8078.n2 11.2322
R483 a_4048_8078.n2 a_4048_8078.n1 0.1805
R484 a_4048_8078.n1 a_4048_8078.t3 40.7008
R485 a_4048_8078.n1 a_4048_8078.n0 24.1194
R486 a_4048_8078.n0 a_4048_8078.t0 0.4625
R487 a_4048_8078.n0 a_4048_8078.t1 0.4625
R488 a_4048_8078.n2 a_4048_8078.t4 39.7092
R489 a_354_7078.t3 a_354_7078.n13 14.845
R490 a_354_7078.n13 a_354_7078.n9 0.57425
R491 a_354_7078.n9 a_354_7078.n10 1.7555
R492 a_354_7078.n10 a_354_7078.n11 1.27336
R493 a_354_7078.n11 a_354_7078.n12 0.239964
R494 a_354_7078.n12 a_354_7078.t7 56.6573
R495 a_354_7078.n12 a_354_7078.t1 17.5367
R496 a_354_7078.n11 a_354_7078.t0 29.1043
R497 a_354_7078.n10 a_354_7078.t8 55.1739
R498 a_354_7078.n9 a_354_7078.t9 55.1739
R499 a_354_7078.n13 a_354_7078.n0 0.239964
R500 a_354_7078.n0 a_354_7078.n1 0.4505
R501 a_354_7078.n1 a_354_7078.n2 1.14479
R502 a_354_7078.n2 a_354_7078.n3 0.4505
R503 a_354_7078.n3 a_354_7078.n4 3.95729
R504 a_354_7078.n4 a_354_7078.n5 2.28907
R505 a_354_7078.n5 a_354_7078.n6 2.29871
R506 a_354_7078.n6 a_354_7078.n7 2.37746
R507 a_354_7078.n7 a_354_7078.n8 4.72068
R508 a_354_7078.n8 a_354_7078.t15 56.9289
R509 a_354_7078.n8 a_354_7078.t14 55.1739
R510 a_354_7078.n7 a_354_7078.t13 38.9179
R511 a_354_7078.n6 a_354_7078.t12 38.8804
R512 a_354_7078.n5 a_354_7078.t11 55.1739
R513 a_354_7078.n4 a_354_7078.t10 55.1739
R514 a_354_7078.n3 a_354_7078.t6 20.3008
R515 a_354_7078.n2 a_354_7078.t5 20.3008
R516 a_354_7078.n1 a_354_7078.t4 20.3008
R517 a_354_7078.n0 a_354_7078.t2 20.3008
R518 a_54_7078.t0 a_54_7078.n5 13.2954
R519 a_54_7078.n5 a_54_7078.n2 1.79246
R520 a_54_7078.n2 a_54_7078.n3 1.71371
R521 a_54_7078.n3 a_54_7078.n4 3.0605
R522 a_54_7078.n4 a_54_7078.t1 15.8194
R523 a_54_7078.n4 a_54_7078.t2 56.7234
R524 a_54_7078.n3 a_54_7078.t3 56.7234
R525 a_54_7078.n2 a_54_7078.t4 56.7234
R526 a_54_7078.n5 a_54_7078.n0 5.19318
R527 a_54_7078.n0 a_54_7078.n1 11.7809
R528 a_54_7078.n1 a_54_7078.t7 58.4784
R529 a_54_7078.n1 a_54_7078.t6 56.7234
R530 a_54_7078.n0 a_54_7078.t5 56.7234
C0 INN VDD 0.59211f
C1 INN OUT 0.04353f
C2 INP INN 0.21072f
C3 OUT VDD 2.55057f
C4 INP VDD 0.57544f
C5 OUT VSS 11.67139f
C6 INN VSS 5.93199f
C7 INP VSS 7.71382f
C8 VDD VSS 0.1407p
C9 a_54_7078.t0 VSS 0.24497f
C10 a_54_7078.t5 VSS 1.4637f
C11 a_54_7078.n0 VSS 2.24031f
C12 a_54_7078.t6 VSS 1.4637f
C13 a_54_7078.n1 VSS 3.16641f
C14 a_54_7078.t7 VSS 1.49968f
C15 a_54_7078.t4 VSS 1.4637f
C16 a_54_7078.n2 VSS 1.31306f
C17 a_54_7078.t3 VSS 1.4637f
C18 a_54_7078.n3 VSS 1.40036f
C19 a_54_7078.t2 VSS 1.4637f
C20 a_54_7078.n4 VSS 1.76023f
C21 a_54_7078.t1 VSS 1.77802f
C22 a_54_7078.n5 VSS 0.69392f
C23 a_354_7078.t3 VSS 0.41885f
C24 a_354_7078.t2 VSS 0.50762f
C25 a_354_7078.n0 VSS 0.59096f
C26 a_354_7078.t4 VSS 0.50762f
C27 a_354_7078.n1 VSS 0.67358f
C28 a_354_7078.t5 VSS 0.50762f
C29 a_354_7078.n2 VSS 0.67358f
C30 a_354_7078.t6 VSS 0.50762f
C31 a_354_7078.n3 VSS 0.9304f
C32 a_354_7078.t10 VSS 1.88937f
C33 a_354_7078.n4 VSS 1.85264f
C34 a_354_7078.t11 VSS 1.88937f
C35 a_354_7078.n5 VSS 1.70119f
C36 a_354_7078.t12 VSS 1.23147f
C37 a_354_7078.n6 VSS 1.56002f
C38 a_354_7078.t13 VSS 1.23141f
C39 a_354_7078.n7 VSS 1.78124f
C40 a_354_7078.t14 VSS 1.88937f
C41 a_354_7078.n8 VSS 3.27973f
C42 a_354_7078.t15 VSS 1.93409f
C43 a_354_7078.t9 VSS 1.88937f
C44 a_354_7078.n9 VSS 1.495f
C45 a_354_7078.t8 VSS 1.88937f
C46 a_354_7078.n10 VSS 1.55884f
C47 a_354_7078.t0 VSS 0.89654f
C48 a_354_7078.n11 VSS 1.12186f
C49 a_354_7078.t1 VSS 1.0488f
C50 a_354_7078.n12 VSS 2.17698f
C51 a_354_7078.t7 VSS 1.9267f
C52 a_354_7078.n13 VSS 0.4538f
C53 a_4048_8078.t2 VSS 1.07652f
C54 a_4048_8078.t4 VSS 2.25049f
C55 a_4048_8078.t0 VSS 0.30893f
C56 a_4048_8078.t1 VSS 0.30893f
C57 a_4048_8078.n0 VSS 2.49711f
C58 a_4048_8078.n1 VSS 3.99756f
C59 a_4048_8078.t3 VSS 2.30878f
C60 a_4048_8078.n2 VSS 2.73535f
C61 a_4712_8078.t2 VSS 0.83081f
C62 a_4712_8078.t3 VSS 1.70285f
C63 a_4712_8078.n0 VSS 3.90927f
C64 a_4712_8078.t4 VSS 1.81266f
C65 a_4712_8078.t0 VSS 2.53505f
C66 a_4712_8078.n1 VSS 2.78802f
C67 a_4712_8078.t1 VSS 3.06455f
C68 a_4712_8078.n2 VSS 0.43515f
C69 a_7072_7078.t0 VSS 0.32502f
C70 a_7072_7078.n0 VSS 3.74627f
C71 a_7072_7078.t2 VSS 2.53683f
C72 a_7072_7078.t1 VSS 0.32502f
C73 a_1088_4798.t1 VSS 1.57902f
C74 a_1088_4798.t3 VSS 1.19009f
C75 a_1088_4798.t0 VSS 0.33309f
C76 a_1088_4798.t2 VSS 0.33309f
C77 a_1088_4798.n0 VSS 2.64101f
C78 a_1088_4798.n1 VSS 2.52712f
C79 a_1088_4798.t7 VSS 1.44931f
C80 a_1088_4798.n2 VSS 2.86714f
C81 a_1088_4798.t6 VSS 1.44931f
C82 a_1088_4798.n3 VSS 2.09192f
C83 a_1088_4798.t5 VSS 1.44931f
C84 a_1088_4798.n4 VSS 3.88078f
C85 a_1088_4798.t4 VSS 1.54435f
C86 a_1088_4798.n5 VSS 3.51137f
C87 a_254_7194.t0 VSS 0.06564f
C88 a_254_7194.t1 VSS 0.06564f
C89 a_554_7194.t3 VSS 1.13126f
C90 a_554_7194.t0 VSS 1.08182f
C91 a_554_7194.n0 VSS 2.1759f
C92 a_554_7194.t2 VSS 2.75376f
C93 a_554_7194.n1 VSS 1.55163f
C94 a_554_7194.t1 VSS 2.83926f
C95 a_1366_7194.t0 VSS 0.06196f
C96 a_1366_7194.t1 VSS 0.06196f
C97 a_2478_8974.t1 VSS 0.30736f
C98 a_2478_8974.n0 VSS 0.66748f
C99 a_2478_8974.t3 VSS 12.3409f
C100 a_2478_8974.t0 VSS 0.02276f
C101 a_2478_8974.t2 VSS 0.02276f
C102 a_2478_8974.n1 VSS 0.15554f
C103 a_3290_8994.t2 VSS 2.94622f
C104 a_3290_8994.t0 VSS 0.1634f
C105 a_3290_8994.t1 VSS 0.1634f
C106 a_3290_8994.n0 VSS 2.46151f
C107 a_3010_376.t2 VSS 2.56196f
C108 a_3010_376.t1 VSS 0.3262f
C109 a_3010_376.t0 VSS 0.3262f
C110 a_3010_376.n0 VSS 3.79516f
C111 a_3566_332.t1 VSS 0.10962f
C112 a_3566_332.n0 VSS 0.74981f
C113 a_3566_332.t4 VSS 0.77559f
C114 a_3566_332.t0 VSS 2.10431f
C115 a_3566_332.n1 VSS 1.55168f
C116 a_3566_332.t3 VSS 0.75925f
C117 a_3566_332.n2 VSS 1.26739f
C118 a_3566_332.t2 VSS 0.10962f
C119 a_2278_376.t2 VSS 0.31574f
C120 a_2278_376.n0 VSS 1.33235f
C121 a_2278_376.t1 VSS 8.98788f
C122 a_2278_376.t3 VSS 0.11209f
C123 a_2278_376.t0 VSS 0.11209f
C124 a_2278_376.n1 VSS 1.01292f
C125 a_5518_376.t1 VSS 0.1323f
C126 a_5518_376.n0 VSS 0.91773f
C127 a_5518_376.t0 VSS 2.59217f
C128 a_5518_376.n1 VSS 3.23673f
C129 a_5518_376.t3 VSS 0.76695f
C130 a_5518_376.t2 VSS 0.1323f
C131 a_7272_7194.t0 VSS 0.07008f
C132 a_7272_7194.t1 VSS 0.07008f
C133 a_8716_7194.t0 VSS 0.06565f
C134 a_8716_7194.t1 VSS 0.06565f
C135 a_4230_332.t2 VSS 1.13029f
C136 a_4230_332.t1 VSS 1.41099f
C137 a_4230_332.n0 VSS 1.50402f
C138 a_4230_332.t3 VSS 0.97379f
C139 a_4230_332.n1 VSS 2.6423f
C140 a_4230_332.t4 VSS 1.01672f
C141 a_4230_332.t0 VSS 2.99543f
C142 a_4230_332.n2 VSS 1.14782f
C143 a_13076_7194.t0 VSS 0.06795f
C144 a_13076_7194.t1 VSS 0.06795f
C145 a_314_332.t2 VSS 0.24958f
C146 a_314_332.t1 VSS 0.3692f
C147 a_314_332.n0 VSS 0.60931f
C148 a_314_332.t4 VSS 0.92832f
C149 a_314_332.n1 VSS 0.83444f
C150 a_314_332.t5 VSS 0.92832f
C151 a_314_332.n2 VSS 0.77035f
C152 a_314_332.t6 VSS 0.57028f
C153 a_314_332.n3 VSS 0.77447f
C154 a_314_332.t7 VSS 0.57028f
C155 a_314_332.n4 VSS 0.95069f
C156 a_314_332.t8 VSS 0.92832f
C157 a_314_332.n5 VSS 1.4896f
C158 a_314_332.t9 VSS 0.95747f
C159 a_314_332.t3 VSS 0.92832f
C160 a_314_332.n6 VSS 1.75087f
C161 a_314_332.t0 VSS 2.66178f
C162 a_314_332.n7 VSS 0.35074f
C163 a_14188_7194.t0 VSS 0.06556f
C164 a_14188_7194.t1 VSS 0.06556f
C165 a_14_332.t1 VSS 0.42594f
C166 a_14_332.t2 VSS 0.72971f
C167 a_14_332.n0 VSS 0.81888f
C168 a_14_332.t3 VSS 0.72971f
C169 a_14_332.n1 VSS 1.39126f
C170 a_14_332.t4 VSS 0.72971f
C171 a_14_332.n2 VSS 1.47078f
C172 a_14_332.t5 VSS 0.75203f
C173 a_14_332.t0 VSS 2.19714f
C174 a_14_332.n3 VSS 1.23049f
C175 a_16112_7194.t0 VSS 0.06464f
C176 a_16112_7194.t1 VSS 0.06464f
C177 a_1088_6148.t0 VSS 0.2318f
C178 a_1088_6148.t1 VSS 0.2318f
C179 a_16506_5698.t0 VSS 0.32534f
C180 a_16506_5698.t1 VSS 0.32534f
C181 a_1088_5248.t0 VSS 0.22994f
C182 a_1088_5248.t1 VSS 0.22994f
C183 a_16506_4798.t0 VSS 0.31729f
C184 a_16506_4798.t1 VSS 0.31729f
C185 a_7438_332.t0 VSS 0.09906f
C186 a_7438_332.n0 VSS 0.87146f
C187 a_7438_332.t2 VSS 0.7035f
C188 a_7438_332.t1 VSS 0.09906f
C189 a_214_376.t0 VSS 0.01645f
C190 a_214_376.t1 VSS 0.01645f
C191 a_514_376.t0 VSS 0.33988f
C192 a_514_376.t1 VSS 0.7455f
C193 a_514_376.n0 VSS 0.64865f
C194 a_514_376.t2 VSS 0.80426f
C195 a_514_376.t3 VSS 0.37639f
C196 a_514_376.n1 VSS 0.87949f
C197 a_1246_376.t0 VSS 0.01666f
C198 a_1246_376.t1 VSS 0.01666f
C199 a_6582_376.t0 VSS 0.02025f
C200 a_6582_376.t1 VSS 0.02025f
C201 a_7638_376.t0 VSS 0.02188f
C202 a_7638_376.t1 VSS 0.02188f
C203 a_10466_376.t0 VSS 0.01817f
C204 a_10466_376.t1 VSS 0.01817f
C205 VDD.n0 VSS 0.02989f
C206 VDD.t29 VSS 0.07658f
C207 VDD.n1 VSS 0.01533f
C208 VDD.n2 VSS 0.03912f
C209 VDD.n3 VSS 0.03912f
C210 VDD.t19 VSS 0.07658f
C211 VDD.n4 VSS 0.04001f
C212 VDD.n5 VSS 0.03912f
C213 VDD.n6 VSS 0.01041f
C214 VDD.n7 VSS 0.02062f
C215 VDD.n8 VSS 0.03912f
C216 VDD.t26 VSS 0.03754f
C217 VDD.n9 VSS 0.02816f
C218 VDD.n10 VSS 0.0151f
C219 VDD.t24 VSS 0.03754f
C220 VDD.n11 VSS 0.03321f
C221 VDD.n12 VSS 0.03912f
C222 VDD.n13 VSS 0.01533f
C223 VDD.n14 VSS 0.03912f
C224 VDD.n15 VSS 0.03912f
C225 VDD.t33 VSS 0.08257f
C226 VDD.n16 VSS 0.09794f
C227 VDD.t9 VSS 0.07658f
C228 VDD VSS 0.84781f
C229 VDD.n17 VSS 0.01285f
C230 VDD.n18 VSS 0.02474f
C231 VDD.n19 VSS 0.03912f
C232 VDD.n20 VSS 0.01533f
C233 VDD.n21 VSS 0.03912f
C234 VDD.t37 VSS 0.07658f
C235 VDD.n22 VSS 0.04151f
C236 VDD.n23 VSS 0.03912f
C237 VDD.n24 VSS 0.01285f
C238 VDD VSS 0.77276f
C239 VDD VSS 0.49201f
C240 VDD.t31 VSS 0.07658f
C241 VDD.n25 VSS 0.17416f
C242 VDD.n26 VSS 0.02399f
C243 VDD.n27 VSS 0.03912f
C244 VDD.n28 VSS 0.03912f
C245 VDD.t13 VSS 0.01428f
C246 VDD.n29 VSS 0.02807f
C247 VDD.t17 VSS 0.07658f
C248 VDD.n30 VSS 0.04151f
C249 VDD.n31 VSS 0.0386f
C250 VDD.n32 VSS 0.03551f
C251 VDD.n33 VSS 0.03912f
C252 VDD.n34 VSS 0.03912f
C253 VDD.n35 VSS 0.17753f
C254 VDD.n36 VSS 0.02488f
C255 VDD.n37 VSS 0.01229f
C256 VDD.n38 VSS 0.56188f
C257 VDD VSS 0.84503f
C258 VDD VSS 0.77276f
C259 VDD VSS 0.49201f
C260 VDD VSS 0.84503f
C261 VDD.n39 VSS 0.56188f
C262 VDD VSS 0.84781f
C263 VDD VSS 0.77276f
C264 VDD VSS 0.48923f
C265 VDD.n40 VSS 0.56188f
C266 VDD.n41 VSS 0.01533f
C267 VDD.n42 VSS 0.02844f
C268 VDD.n43 VSS 0.03448f
C269 VDD.n44 VSS 0.03912f
C270 VDD.n45 VSS 0.03912f
C271 VDD.n46 VSS 0.02502f
C272 VDD.n47 VSS 0.03504f
C273 VDD.n48 VSS 0.02474f
C274 VDD.n49 VSS 0.01285f
C275 VDD.n50 VSS 0.03912f
C276 VDD.n51 VSS 0.03912f
C277 VDD.n52 VSS 0.02849f
C278 VDD.n53 VSS 0.02474f
C279 VDD.n54 VSS 0.0239f
C280 VDD.n55 VSS 0.02474f
C281 VDD.n56 VSS 0.03617f
C282 VDD.n57 VSS 0.03912f
C283 VDD.n58 VSS 0.03912f
C284 VDD.n59 VSS 0.03912f
C285 VDD.n60 VSS 0.03912f
C286 VDD.n61 VSS 0.02278f
C287 VDD.n62 VSS 0.03912f
C288 VDD.n63 VSS 0.03912f
C289 VDD.n64 VSS 0.02849f
C290 VDD.n65 VSS 0.01533f
C291 VDD.n66 VSS 0.56188f
C292 VDD VSS 0.84503f
C293 VDD VSS 0.77276f
C294 VDD VSS 0.49201f
C295 VDD.n67 VSS 0.56188f
C296 VDD VSS 0.51147f
C297 VDD VSS 0.43919f
C298 VDD VSS 0.50868f
C299 VDD.n68 VSS 0.57856f
C300 VDD VSS 0.51147f
C301 VDD VSS 0.46143f
C302 VDD VSS 0.5476f
C303 VDD.n69 VSS 0.59524f
C304 VDD VSS 0.51147f
C305 VDD VSS 0.46143f
C306 VDD VSS 0.89645f
C307 VDD VSS 0.94927f
C308 VDD.n70 VSS 0.56188f
C309 VDD VSS 0.84503f
C310 VDD VSS 0.77276f
C311 VDD VSS 0.49201f
C312 VDD VSS 0.77276f
C313 VDD VSS 0.48923f
C314 VDD.n71 VSS 0.56188f
C315 VDD.n72 VSS 0.0413f
C316 VDD.n73 VSS 0.03449f
C317 VDD.n74 VSS 0.02091f
C318 VDD.n75 VSS 0.1421f
C319 VDD.n76 VSS 0.03912f
C320 VDD.n77 VSS 0.03912f
C321 VDD.n78 VSS 0.03912f
C322 VDD.n79 VSS 0.03912f
C323 VDD.n80 VSS 0.02385f
C324 VDD.n81 VSS 0.03912f
C325 VDD.n82 VSS 0.03912f
C326 VDD.n83 VSS 0.03565f
C327 VDD.n84 VSS 0.03912f
C328 VDD.n85 VSS 0.02371f
C329 VDD.n86 VSS 0.03912f
C330 VDD.n87 VSS 0.03912f
C331 VDD.n88 VSS 0.03579f
C332 VDD.n89 VSS 0.03912f
C333 VDD.n90 VSS 0.02545f
C334 VDD.n91 VSS 0.03912f
C335 VDD.n92 VSS 0.03912f
C336 VDD.n93 VSS 0.03912f
C337 VDD.n94 VSS 0.03912f
C338 VDD.n95 VSS 0.03912f
C339 VDD.n96 VSS 0.02189f
C340 VDD.n97 VSS 0.03912f
C341 VDD.n98 VSS 0.03912f
C342 VDD.n99 VSS 0.02531f
C343 VDD.n100 VSS 0.03912f
C344 VDD.n101 VSS 0.03443f
C345 VDD.n102 VSS 0.03912f
C346 VDD.n103 VSS 0.03912f
C347 VDD.n104 VSS 0.01285f
C348 VDD.n105 VSS 0.032f
C349 INP.t1 VSS 2.52331f
C350 INP.t0 VSS 2.11279f
C351 INN.t1 VSS 1.72838f
C352 INN.t0 VSS 1.54006f
C353 OUT.t6 VSS 0.13573f
C354 OUT.t4 VSS 0.20054f
C355 OUT.t5 VSS 0.22257f
C356 OUT.t1 VSS 4.46298f
C357 OUT.n0 VSS 0.66945f
C358 OUT.n1 VSS 0.31856f
C359 OUT.t2 VSS 0.19611f
C360 OUT.n2 VSS 0.39474f
C361 OUT.t3 VSS 0.19702f
C362 OUT.n3 VSS 0.43217f
C363 OUT.t0 VSS 0.14731f
C364 OUT.t7 VSS 14.8552f
C365 OUT.n4 VSS 0.36443f
C366 OUT.n5 VSS 0.14251f
.ends
