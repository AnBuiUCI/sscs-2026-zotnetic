* Nodos de bulk atados: 28 de pozo n -> VDD, 26 de sustrato -> VSS.
*   magic no extrae los taps de este layout y los dejaba flotando;
*   la conexion si existe (el LVS de KLayout da 'match uniquely').
*   Quien detecta un tap que falte de verdad es el LVS, no esto.
* NGSPICE file created from OPAM_LIN_flat.ext - technology: gf180mcuD

.subckt OPAM_LIN_flat VSS VDD INN OUT INP
X0 a_1366_7234.t1 a_54_7118.t6 VDD.t40 VDD pfet_06v0 ad=2.5p pd=10.5u as=4.4p ps=20.88u w=10u l=1u
X1 OUT.t3 a_928_4838.t4 VDD.t17 VDD pfet_06v0 ad=0.44p pd=2.88u as=0.44p ps=2.88u w=1u l=1u
X2 a_2478_9124.t3 OUT.t6 cap_mim_2f0_m4m5_noshield c_width=25u c_length=8u
X3 a_928_4838.t2 a_16346_4838.t0 VSS.t0 ppolyf_u_1k r_width=1u r_length=76.45u
X4 a_314_332.t2 a_314_332.t1 VSS.t32 VSS nfet_06v0 ad=0.44p pd=2.88u as=0.44p ps=2.88u w=1u l=1u
X5 a_2278_376.t1 INP.t0 a_514_376.t2 VSS nfet_06v0 ad=3.3p pd=15.88u as=3.3p ps=15.88u w=7.5u l=1u
X6 a_5162_376.t2 a_314_332.t6 a_2478_9124.t2 VSS nfet_06v0 ad=1.1p pd=5.88u as=0.825p ps=3.16u w=2.5u l=1u
X7 a_7358_376.t1 a_14_332.t3 VSS.t15 VSS nfet_06v0 ad=1.25p pd=5.5u as=2.2p ps=10.88u w=5u l=1u
X8 a_254_7234.t1 a_54_7118.t7 VDD.t28 VDD pfet_06v0 ad=2.5p pd=10.5u as=4.4p ps=20.88u w=10u l=1u
X9 a_10430_7234.t0 a_54_7118.t5 VDD.t31 VDD pfet_06v0 ad=2.5p pd=10.5u as=4.4p ps=20.88u w=10u l=1u
X10 OUT.t1 a_928_4838.t6 VDD.t12 VDD pfet_06v0 ad=0.44p pd=2.88u as=0.44p ps=2.88u w=1u l=1u
X11 a_514_376.t1 a_314_332.t9 a_214_376.t1 VSS nfet_06v0 ad=2.2p pd=10.88u as=1.25p ps=5.5u w=5u l=1u
X12 a_3290_9134.t0 a_3554_332.t4 VSS.t4 VSS nfet_06v0 ad=0.825p pd=3.16u as=1.1p ps=5.88u w=2.5u l=1u
X13 a_13294_376.t0 a_354_7118.t4 VSS.t7 VSS nfet_06v0 ad=0.25p pd=1.5u as=0.44p ps=2.88u w=1u l=1u
X14 a_7150_8318.t2 a_314_332.t5 a_7358_376.t0 VSS nfet_06v0 ad=2.2p pd=10.88u as=1.25p ps=5.5u w=5u l=1u
X15 a_554_7234.t1 a_354_7118.t14 a_1366_7234.t0 VDD pfet_06v0 ad=4.4p pd=20.88u as=2.5p ps=10.5u w=10u l=1u
X16 a_928_4838.t0 a_354_7118.t12 a_2278_376.t0 VDD pfet_06v0 ad=4.4p pd=20.88u as=4.4p ps=20.88u w=10u l=1u
X17 a_8986_7234.t0 a_8786_7118.t2 VDD.t4 VDD pfet_06v0 ad=2.5p pd=10.5u as=4.4p ps=20.88u w=10u l=1u
X18 a_14790_7234.t1 a_54_7118.t4 VDD.t22 VDD pfet_06v0 ad=2.5p pd=10.5u as=4.4p ps=20.88u w=10u l=1u
X19 a_928_5288.t0 a_16346_5738.t0 VSS.t0 ppolyf_u_1k r_width=1u r_length=76.45u
X20 a_354_7118.t1 a_354_7118.t0 a_13294_376.t1 VSS nfet_06v0 ad=0.44p pd=2.88u as=0.25p ps=1.5u w=1u l=1u
X21 a_17826_7234.t1 a_54_7118.t2 VDD.t10 VDD pfet_06v0 ad=2.5p pd=10.5u as=4.4p ps=20.88u w=10u l=1u
X22 a_928_5288.t1 a_16346_4838.t1 VSS.t0 ppolyf_u_1k r_width=1u r_length=76.45u
X23 a_2478_9124.t0 INP.t1 a_554_7234.t2 VDD pfet_06v0 ad=0.242p pd=1.98u as=0.242p ps=1.98u w=0.55u l=1u
X24 a_2278_376.t3 a_4102_7234.t3 VDD.t37 VDD pfet_06v0 ad=2.2p pd=10.88u as=2.2p ps=10.88u w=5u l=1u
X25 OUT.t0 a_928_4838.t5 VDD.t1 VDD pfet_06v0 ad=0.44p pd=2.88u as=0.44p ps=2.88u w=1u l=1u
X26 a_4102_7234.t2 a_5694_332.t4 a_3554_332.t1 VSS nfet_06v0 ad=0.88p pd=4.88u as=0.88p ps=4.88u w=2u l=1u
X27 a_5694_332.t2 a_354_7118.t10 a_10430_7234.t1 VDD pfet_06v0 ad=4.4p pd=20.88u as=2.5p ps=10.5u w=10u l=1u
X28 a_214_376.t0 a_14_332.t5 VSS.t9 VSS nfet_06v0 ad=1.25p pd=5.5u as=2.2p ps=10.88u w=5u l=1u
X29 a_2478_9124.t1 a_3554_332.t3 VSS.t34 VSS nfet_06v0 ad=0.825p pd=3.16u as=1.1p ps=5.88u w=2.5u l=1u
X30 OUT.t7 a_2278_376.t2 cap_mim_2f0_m4m5_noshield c_width=25u c_length=8u
X31 a_7150_8318.t1 a_7150_8318.t0 a_8786_7118.t1 VDD pfet_06v0 ad=4.4p pd=20.88u as=3.3p ps=10.66u w=10u l=1u
X32 a_14_332.t0 a_354_7118.t8 a_15902_7234.t1 VDD pfet_06v0 ad=4.4p pd=20.88u as=2.5p ps=10.5u w=10u l=1u
X33 a_11230_376.t0 a_14_332.t2 VSS.t20 VSS nfet_06v0 ad=1.25p pd=5.5u as=2.2p ps=10.88u w=5u l=1u
X34 a_314_332.t0 a_354_7118.t9 a_14790_7234.t0 VDD pfet_06v0 ad=4.4p pd=20.88u as=2.5p ps=10.5u w=10u l=1u
X35 OUT.t2 a_928_4838.t7 VDD.t14 VDD pfet_06v0 ad=0.44p pd=2.88u as=0.44p ps=2.88u w=1u l=1u
X36 a_928_6188.t1 OUT.t4 VSS.t0 ppolyf_u_1k r_width=1u r_length=76.45u
X37 a_928_6188.t0 a_16346_5738.t1 VSS.t0 ppolyf_u_1k r_width=1u r_length=76.45u
X38 a_5694_332.t1 a_5694_332.t0 a_8202_332.t0 VSS nfet_06v0 ad=2.2p pd=10.88u as=1.65p ps=5.66u w=5u l=1u
X39 a_54_7118.t1 a_354_7118.t7 a_17826_7234.t0 VDD pfet_06v0 ad=4.4p pd=20.88u as=2.5p ps=10.5u w=10u l=1u
X40 a_14_332.t1 a_314_332.t3 a_11230_376.t1 VSS nfet_06v0 ad=2.2p pd=10.88u as=1.25p ps=5.5u w=5u l=1u
X41 a_3554_332.t0 a_7150_8318.t4 a_4102_7234.t1 VDD pfet_06v0 ad=1.76p pd=8.88u as=1.76p ps=8.88u w=4u l=1u
X42 a_4102_7234.t0 a_354_7118.t13 a_3010_376.t0 VDD pfet_06v0 ad=4.4p pd=20.88u as=4.4p ps=20.88u w=10u l=1u
X43 a_554_7234.t0 a_354_7118.t15 a_254_7234.t0 VDD pfet_06v0 ad=4.4p pd=20.88u as=2.5p ps=10.5u w=10u l=1u
X44 a_1246_376.t1 a_14_332.t4 VSS.t29 VSS nfet_06v0 ad=1.25p pd=5.5u as=2.2p ps=10.88u w=5u l=1u
X45 a_8402_376.t1 a_8202_332.t2 VSS.t27 VSS nfet_06v0 ad=1.25p pd=5.5u as=2.2p ps=10.88u w=5u l=1u
X46 a_3010_376.t2 a_4102_7234.t4 VDD.t35 VDD pfet_06v0 ad=2.2p pd=10.88u as=2.2p ps=10.88u w=5u l=1u
X47 OUT.t5 a_5162_376.t3 VSS.t25 VSS nfet_06v0 ad=0.44p pd=2.88u as=0.44p ps=2.88u w=1u l=1u
X48 a_5162_376.t0 a_7150_8318.t3 a_928_4838.t1 VDD pfet_06v0 ad=1.76p pd=8.88u as=1.76p ps=8.88u w=4u l=1u
X49 a_354_7118.t3 a_354_7118.t2 VDD.t33 VDD pfet_06v0 ad=0.88p pd=4.88u as=0.88p ps=4.88u w=2u l=1u
X50 a_3010_376.t1 INN.t0 a_514_376.t3 VSS nfet_06v0 ad=3.74p pd=17.88u as=3.74p ps=17.88u w=8.5u l=1u
X51 a_12262_376.t1 a_354_7118.t6 VSS.t23 VSS nfet_06v0 ad=0.25p pd=1.5u as=0.44p ps=2.88u w=1u l=1u
X52 a_15902_7234.t0 a_54_7118.t3 VDD.t24 VDD pfet_06v0 ad=2.5p pd=10.5u as=4.4p ps=20.88u w=10u l=1u
X53 a_514_376.t0 a_314_332.t8 a_1246_376.t0 VSS nfet_06v0 ad=2.2p pd=10.88u as=1.25p ps=5.5u w=5u l=1u
X54 a_3554_332.t2 a_314_332.t7 a_3290_9134.t2 VSS nfet_06v0 ad=1.1p pd=5.88u as=0.825p ps=3.16u w=2.5u l=1u
X55 a_928_4838.t3 a_5694_332.t3 a_5162_376.t1 VSS nfet_06v0 ad=0.88p pd=4.88u as=0.88p ps=4.88u w=2u l=1u
X56 a_8202_332.t1 a_314_332.t4 a_8402_376.t0 VSS nfet_06v0 ad=1.65p pd=5.66u as=1.25p ps=5.5u w=5u l=1u
X57 a_3290_9134.t1 INN.t1 a_554_7234.t3 VDD pfet_06v0 ad=0.22p pd=1.88u as=0.22p ps=1.88u w=0.5u l=1u
X58 a_8786_7118.t0 a_354_7118.t11 a_8986_7234.t1 VDD pfet_06v0 ad=3.3p pd=10.66u as=2.5p ps=10.5u w=10u l=1u
X59 a_54_7118.t0 a_354_7118.t5 a_12262_376.t0 VSS nfet_06v0 ad=0.44p pd=2.88u as=0.25p ps=1.5u w=1u l=1u
R0 OUT.n0 OUT.t4 24.8582
R1 OUT.n1 OUT.t3 19.9088
R2 OUT.n3 OUT.t1 19.507
R3 OUT.n2 OUT.t0 19.507
R4 OUT.n4 OUT.t7 16.0963
R5 OUT.n4 OUT.t5 15.6294
R6 OUT OUT.t2 15.007
R7 OUT.n0 OUT.t6 4.77572
R8 OUT.n1 OUT.n0 4.5005
R9 OUT OUT.n5 4.5005
R10 OUT.n5 OUT.n4 2.55586
R11 OUT.n5 OUT.n3 1.23479
R12 OUT.n3 OUT.n2 1.23479
R13 OUT.n2 OUT.n1 0.833
R14 INN INN.t0 49.4447
R15 INN INN.t1 19.9745
R16 INP INP.t0 47.1247
R17 INP INP.t1 19.1044
R18 VDD VDD 308.384
R19 VDD VDD 303.892
R20 VDD VDD 303.892
R21 VDD VDD 303.892
R22 VDD VDD 303.892
R23 VDD VDD 303.892
R24 VDD VDD 303.892
R25 VDD VDD 303.892
R26 VDD VDD 303.892
R27 VDD.n39 VDD 152.696
R28 VDD.n40 VDD 152.696
R29 VDD.n61 VDD 152.696
R30 VDD.n62 VDD 152.696
R31 VDD.n74 VDD 152.696
R32 VDD.n75 VDD 152.696
R33 VDD.n76 VDD 152.696
R34 VDD.n77 VDD 152.696
R35 VDD.n78 VDD 152.696
R36 VDD.n79 VDD 152.696
R37 VDD VDD.n39 151.198
R38 VDD.n40 VDD 151.198
R39 VDD VDD.n61 151.198
R40 VDD.n62 VDD 151.198
R41 VDD VDD.n74 151.198
R42 VDD VDD.n75 151.198
R43 VDD VDD.n76 151.198
R44 VDD VDD.n77 151.198
R45 VDD VDD.n78 151.198
R46 VDD.n79 VDD 151.198
R47 VDD VDD 124.252
R48 VDD VDD 112.275
R49 VDD VDD 112.275
R50 VDD VDD 112.275
R51 VDD VDD 112.275
R52 VDD VDD 112.275
R53 VDD VDD 112.275
R54 VDD VDD 112.275
R55 VDD.n39 VDD.n38 12.6005
R56 VDD.n41 VDD.n40 12.6005
R57 VDD.n61 VDD.n60 12.6005
R58 VDD.n63 VDD.n62 12.6005
R59 VDD.n74 VDD.n73 12.6005
R60 VDD.n75 VDD.n4 12.6005
R61 VDD.n76 VDD.n9 12.6005
R62 VDD.n77 VDD.n12 12.6005
R63 VDD.n78 VDD.n15 12.6005
R64 VDD.n80 VDD.n79 12.6005
R65 VDD.n83 VDD.n82 9.0005
R66 VDD.n84 VDD.n16 9.0005
R67 VDD.n86 VDD.n85 9.0005
R68 VDD.n87 VDD.n14 9.0005
R69 VDD.n89 VDD.n88 9.0005
R70 VDD.n90 VDD.n13 9.0005
R71 VDD.n92 VDD.n91 9.0005
R72 VDD.n93 VDD.n11 9.0005
R73 VDD.n95 VDD.n94 9.0005
R74 VDD.n96 VDD.n10 9.0005
R75 VDD.n98 VDD.n97 9.0005
R76 VDD.n100 VDD.n7 9.0005
R77 VDD.n102 VDD.n101 9.0005
R78 VDD.n103 VDD.n6 9.0005
R79 VDD.n105 VDD.n104 9.0005
R80 VDD.n106 VDD.n5 9.0005
R81 VDD.n108 VDD.n107 9.0005
R82 VDD.n110 VDD.n109 9.0005
R83 VDD.n111 VDD.n3 9.0005
R84 VDD.n113 VDD.n112 9.0005
R85 VDD.n115 VDD.n114 9.0005
R86 VDD.n2 VDD.n0 9.0005
R87 VDD.n72 VDD.n71 9.0005
R88 VDD.n70 VDD.n69 9.0005
R89 VDD.n68 VDD.n19 9.0005
R90 VDD.n67 VDD.n66 9.0005
R91 VDD.n65 VDD.n64 9.0005
R92 VDD.n22 VDD.n21 9.0005
R93 VDD.n55 VDD.n53 9.0005
R94 VDD.n57 VDD.n56 9.0005
R95 VDD.n59 VDD.n58 9.0005
R96 VDD.n52 VDD.n23 9.0005
R97 VDD.n51 VDD.n50 9.0005
R98 VDD.n48 VDD.n25 9.0005
R99 VDD.n46 VDD.n45 9.0005
R100 VDD.n44 VDD.n26 9.0005
R101 VDD.n43 VDD.n42 9.0005
R102 VDD.n32 VDD.n27 9.0005
R103 VDD.n33 VDD.n31 9.0005
R104 VDD.n35 VDD.n34 9.0005
R105 VDD.n37 VDD.n36 9.0005
R106 VDD.n20 VDD.t14 4.91936
R107 VDD.n54 VDD.t12 4.91936
R108 VDD.n24 VDD.t1 4.91936
R109 VDD.n49 VDD.t17 4.91936
R110 VDD.n83 VDD.n17 3.23511
R111 VDD.n30 VDD.t33 2.82475
R112 VDD.n36 VDD.n29 2.76249
R113 VDD.n17 VDD.t28 2.14376
R114 VDD.n29 VDD.t10 1.97492
R115 VDD.n81 VDD.t40 1.96744
R116 VDD.n1 VDD.t4 1.96744
R117 VDD.n18 VDD.t31 1.96744
R118 VDD.n47 VDD.t22 1.96744
R119 VDD.n28 VDD.t24 1.96744
R120 VDD.n99 VDD.t35 1.8449
R121 VDD.n8 VDD.t37 1.8449
R122 VDD.n80 VDD.n17 0.25569
R123 VDD.n36 VDD.n35 0.2005
R124 VDD.n35 VDD.n31 0.2005
R125 VDD.n31 VDD.n27 0.2005
R126 VDD.n43 VDD.n27 0.2005
R127 VDD.n44 VDD.n43 0.2005
R128 VDD.n45 VDD.n44 0.2005
R129 VDD.n45 VDD.n25 0.2005
R130 VDD.n51 VDD.n25 0.2005
R131 VDD.n52 VDD.n51 0.2005
R132 VDD.n58 VDD.n52 0.2005
R133 VDD.n58 VDD.n57 0.2005
R134 VDD.n57 VDD.n53 0.2005
R135 VDD.n53 VDD.n21 0.2005
R136 VDD.n65 VDD.n21 0.2005
R137 VDD.n66 VDD.n65 0.2005
R138 VDD.n66 VDD.n19 0.2005
R139 VDD.n70 VDD.n19 0.2005
R140 VDD.n71 VDD.n70 0.2005
R141 VDD.n71 VDD.n2 0.2005
R142 VDD.n114 VDD.n2 0.2005
R143 VDD.n114 VDD.n113 0.2005
R144 VDD.n113 VDD.n3 0.2005
R145 VDD.n109 VDD.n3 0.2005
R146 VDD.n109 VDD.n108 0.2005
R147 VDD.n108 VDD.n5 0.2005
R148 VDD.n104 VDD.n5 0.2005
R149 VDD.n104 VDD.n103 0.2005
R150 VDD.n103 VDD.n102 0.2005
R151 VDD.n102 VDD.n7 0.2005
R152 VDD.n97 VDD.n7 0.2005
R153 VDD.n97 VDD.n96 0.2005
R154 VDD.n96 VDD.n95 0.2005
R155 VDD.n95 VDD.n11 0.2005
R156 VDD.n91 VDD.n11 0.2005
R157 VDD.n91 VDD.n90 0.2005
R158 VDD.n90 VDD.n89 0.2005
R159 VDD.n89 VDD.n14 0.2005
R160 VDD.n85 VDD.n14 0.2005
R161 VDD.n85 VDD.n84 0.2005
R162 VDD.n84 VDD.n83 0.2005
R163 VDD.n34 VDD.n33 0.2005
R164 VDD.n33 VDD.n32 0.2005
R165 VDD.n46 VDD.n26 0.2005
R166 VDD.n50 VDD.n48 0.2005
R167 VDD.n56 VDD.n55 0.2005
R168 VDD.n68 VDD.n67 0.2005
R169 VDD.n69 VDD.n68 0.2005
R170 VDD.n72 VDD.n0 0.2005
R171 VDD.n112 VDD.n111 0.2005
R172 VDD.n111 VDD.n110 0.2005
R173 VDD.n107 VDD.n106 0.2005
R174 VDD.n106 VDD.n105 0.2005
R175 VDD.n105 VDD.n6 0.2005
R176 VDD.n101 VDD.n100 0.2005
R177 VDD.n98 VDD.n10 0.2005
R178 VDD.n94 VDD.n93 0.2005
R179 VDD.n93 VDD.n92 0.2005
R180 VDD.n92 VDD.n13 0.2005
R181 VDD.n88 VDD.n87 0.2005
R182 VDD.n87 VDD.n86 0.2005
R183 VDD.n86 VDD.n16 0.2005
R184 VDD.n82 VDD.n16 0.2005
R185 VDD.n115 VDD.n1 0.196
R186 VDD.n37 VDD.n30 0.182
R187 VDD.n60 VDD.n59 0.1815
R188 VDD.n99 VDD.n98 0.175
R189 VDD.n64 VDD.n63 0.1695
R190 VDD.n15 VDD.n13 0.1635
R191 VDD.n12 VDD.n10 0.1515
R192 VDD.n41 VDD.n26 0.1435
R193 VDD.n32 VDD.n28 0.138
R194 VDD VDD.n115 0.1275
R195 VDD.n110 VDD.n4 0.1275
R196 VDD.n73 VDD.n18 0.12
R197 VDD.n9 VDD.n8 0.12
R198 VDD.n81 VDD.n80 0.12
R199 VDD.n64 VDD.n20 0.118
R200 VDD.n38 VDD.n29 0.113479
R201 VDD.n55 VDD.n54 0.112
R202 VDD.n48 VDD.n47 0.107
R203 VDD.n59 VDD.n24 0.106
R204 VDD.n38 VDD.n37 0.1055
R205 VDD.n49 VDD.n23 0.101
R206 VDD.n50 VDD.n49 0.1
R207 VDD.n56 VDD.n24 0.095
R208 VDD.n47 VDD.n46 0.094
R209 VDD.n54 VDD.n22 0.089
R210 VDD.n67 VDD.n20 0.083
R211 VDD.n69 VDD.n18 0.074
R212 VDD VDD.n0 0.0735
R213 VDD.n107 VDD.n4 0.0735
R214 VDD.n42 VDD.n28 0.063
R215 VDD.n101 VDD.n9 0.0615
R216 VDD.n42 VDD.n41 0.0575
R217 VDD.n94 VDD.n12 0.0495
R218 VDD.n88 VDD.n15 0.0375
R219 VDD.n63 VDD.n22 0.0315
R220 VDD.n100 VDD.n99 0.026
R221 VDD.n8 VDD.n6 0.02
R222 VDD.n60 VDD.n23 0.0195
R223 VDD.n34 VDD.n30 0.019
R224 VDD.n73 VDD.n72 0.0075
R225 VDD.n82 VDD.n81 0.006
R226 VDD.n112 VDD.n1 0.005
R227 VSS.n25 VSS 410.356
R228 VSS VSS 348.515
R229 VSS VSS 348.515
R230 VSS VSS 342.894
R231 VSS VSS 342.894
R232 VSS VSS 342.894
R233 VSS VSS 342.894
R234 VSS.n24 VSS 321.346
R235 VSS VSS.n53 298.861
R236 VSS VSS.n50 291.366
R237 VSS VSS.n48 287.62
R238 VSS.n51 VSS 270.755
R239 VSS.n54 VSS 263.26
R240 VSS VSS.n38 242.649
R241 VSS.n39 VSS 178.942
R242 VSS.n39 VSS 163.952
R243 VSS VSS 155.52
R244 VSS.n52 VSS 147.089
R245 VSS VSS 140.53
R246 VSS VSS 140.53
R247 VSS VSS 140.53
R248 VSS VSS 140.53
R249 VSS VSS 140.53
R250 VSS.n55 VSS 139.595
R251 VSS.n49 VSS 118.983
R252 VSS.t0 VSS 109.145
R253 VSS.n38 VSS 100.246
R254 VSS.n56 VSS 88.1607
R255 VSS VSS.n54 79.6344
R256 VSS VSS.n51 72.1394
R257 VSS.n48 VSS 55.2758
R258 VSS.n50 VSS 51.5283
R259 VSS.n53 VSS 49.6546
R260 VSS VSS.t0 46.3755
R261 VSS VSS.n24 21.5485
R262 VSS VSS.n49 21.5485
R263 VSS.n24 VSS.n23 10.4005
R264 VSS.n38 VSS.n37 10.4005
R265 VSS.n40 VSS.n39 10.4005
R266 VSS.n48 VSS.n47 10.4005
R267 VSS.n49 VSS.n4 10.4005
R268 VSS.n50 VSS.n5 10.4005
R269 VSS.n51 VSS.n7 10.4005
R270 VSS.n52 VSS.n9 10.4005
R271 VSS.n53 VSS.n11 10.4005
R272 VSS.n54 VSS.n13 10.4005
R273 VSS.n55 VSS.n15 10.4005
R274 VSS.n58 VSS.n57 9.219
R275 VSS.n27 VSS.n26 9.0005
R276 VSS.n29 VSS.n22 9.0005
R277 VSS.n31 VSS.n30 9.0005
R278 VSS.n36 VSS.n35 9.0005
R279 VSS.n34 VSS.n21 9.0005
R280 VSS.n33 VSS.n32 9.0005
R281 VSS.n41 VSS.n18 9.0005
R282 VSS.n43 VSS.n42 9.0005
R283 VSS.n45 VSS.n44 9.0005
R284 VSS.n46 VSS.n2 9.0005
R285 VSS.n100 VSS.n99 9.0005
R286 VSS.n98 VSS.n1 9.0005
R287 VSS.n97 VSS.n96 9.0005
R288 VSS.n94 VSS.n3 9.0005
R289 VSS.n93 VSS.n92 9.0005
R290 VSS.n91 VSS.n90 9.0005
R291 VSS.n88 VSS.n6 9.0005
R292 VSS.n87 VSS.n86 9.0005
R293 VSS.n85 VSS.n84 9.0005
R294 VSS.n83 VSS.n8 9.0005
R295 VSS.n82 VSS.n81 9.0005
R296 VSS.n80 VSS.n79 9.0005
R297 VSS.n77 VSS.n10 9.0005
R298 VSS.n76 VSS.n75 9.0005
R299 VSS.n74 VSS.n73 9.0005
R300 VSS.n71 VSS.n12 9.0005
R301 VSS.n70 VSS.n69 9.0005
R302 VSS.n68 VSS.n67 9.0005
R303 VSS.n66 VSS.n14 9.0005
R304 VSS.n65 VSS.n64 9.0005
R305 VSS.n63 VSS.n62 9.0005
R306 VSS.n60 VSS.n16 9.0005
R307 VSS.n59 VSS.n58 9.0005
R308 VSS VSS.n52 8.43233
R309 VSS.n28 VSS.t7 5.28916
R310 VSS.n20 VSS.t23 5.28916
R311 VSS.n17 VSS.t32 5.28916
R312 VSS.n0 VSS.t25 5.28916
R313 VSS.n78 VSS.t34 2.58836
R314 VSS.n72 VSS.t4 2.58836
R315 VSS.n19 VSS.t20 1.91886
R316 VSS.n95 VSS.t27 1.91886
R317 VSS.n89 VSS.t15 1.91886
R318 VSS.n61 VSS.t29 1.91886
R319 VSS.n57 VSS.t9 1.91886
R320 VSS.n26 VSS.n25 1.61287
R321 VSS VSS.n55 0.937369
R322 VSS.n25 VSS.n23 0.489637
R323 VSS.n26 VSS.n22 0.2005
R324 VSS.n31 VSS.n22 0.2005
R325 VSS.n35 VSS.n31 0.2005
R326 VSS.n35 VSS.n34 0.2005
R327 VSS.n34 VSS.n33 0.2005
R328 VSS.n33 VSS.n18 0.2005
R329 VSS.n43 VSS.n18 0.2005
R330 VSS.n44 VSS.n43 0.2005
R331 VSS.n44 VSS.n2 0.2005
R332 VSS.n99 VSS.n2 0.2005
R333 VSS.n99 VSS.n98 0.2005
R334 VSS.n98 VSS.n97 0.2005
R335 VSS.n97 VSS.n3 0.2005
R336 VSS.n92 VSS.n3 0.2005
R337 VSS.n92 VSS.n91 0.2005
R338 VSS.n91 VSS.n6 0.2005
R339 VSS.n86 VSS.n6 0.2005
R340 VSS.n86 VSS.n85 0.2005
R341 VSS.n85 VSS.n8 0.2005
R342 VSS.n81 VSS.n8 0.2005
R343 VSS.n81 VSS.n80 0.2005
R344 VSS.n80 VSS.n10 0.2005
R345 VSS.n75 VSS.n10 0.2005
R346 VSS.n75 VSS.n74 0.2005
R347 VSS.n74 VSS.n12 0.2005
R348 VSS.n69 VSS.n12 0.2005
R349 VSS.n69 VSS.n68 0.2005
R350 VSS.n68 VSS.n14 0.2005
R351 VSS.n64 VSS.n14 0.2005
R352 VSS.n64 VSS.n63 0.2005
R353 VSS.n63 VSS.n16 0.2005
R354 VSS.n58 VSS.n16 0.2005
R355 VSS.n30 VSS.n29 0.2005
R356 VSS.n36 VSS.n21 0.2005
R357 VSS.n32 VSS.n21 0.2005
R358 VSS.n42 VSS.n41 0.2005
R359 VSS.n100 VSS.n1 0.2005
R360 VSS.n94 VSS.n93 0.2005
R361 VSS.n88 VSS.n87 0.2005
R362 VSS.n84 VSS.n83 0.2005
R363 VSS.n83 VSS.n82 0.2005
R364 VSS.n77 VSS.n76 0.2005
R365 VSS.n71 VSS.n70 0.2005
R366 VSS.n67 VSS.n66 0.2005
R367 VSS.n66 VSS.n65 0.2005
R368 VSS.n60 VSS.n59 0.2005
R369 VSS.n89 VSS.n88 0.191
R370 VSS.n72 VSS.n71 0.189
R371 VSS.n47 VSS.n45 0.1805
R372 VSS.n4 VSS.n1 0.1805
R373 VSS.n93 VSS.n5 0.1805
R374 VSS.n87 VSS.n7 0.1805
R375 VSS.n82 VSS.n9 0.1805
R376 VSS.n76 VSS.n11 0.1805
R377 VSS.n70 VSS.n13 0.1805
R378 VSS.n65 VSS.n15 0.1805
R379 VSS.n59 VSS.n56 0.1805
R380 VSS.n45 VSS.n17 0.161
R381 VSS.n29 VSS.n28 0.159
R382 VSS.n30 VSS.n20 0.158
R383 VSS.n61 VSS.n60 0.135
R384 VSS VSS.n100 0.1275
R385 VSS.n78 VSS.n77 0.127
R386 VSS.n95 VSS.n94 0.113
R387 VSS.n40 VSS.n19 0.107
R388 VSS.n96 VSS.n95 0.088
R389 VSS.n32 VSS.n19 0.074
R390 VSS.n79 VSS.n78 0.074
R391 VSS VSS.n0 0.068
R392 VSS.n62 VSS.n61 0.066
R393 VSS.n28 VSS.n27 0.042
R394 VSS.n42 VSS.n17 0.04
R395 VSS.n37 VSS.n20 0.023
R396 VSS.n27 VSS.n23 0.0205
R397 VSS.n37 VSS.n36 0.0205
R398 VSS.n41 VSS.n40 0.0205
R399 VSS.n47 VSS.n46 0.0205
R400 VSS.n96 VSS.n4 0.0205
R401 VSS.n90 VSS.n5 0.0205
R402 VSS.n84 VSS.n7 0.0205
R403 VSS.n79 VSS.n9 0.0205
R404 VSS.n73 VSS.n11 0.0205
R405 VSS.n67 VSS.n13 0.0205
R406 VSS.n62 VSS.n15 0.0205
R407 VSS.n73 VSS.n72 0.012
R408 VSS.n90 VSS.n89 0.01
R409 VSS.n46 VSS.n0 0.006
R410 VSS.n57 VSS.n56 0.002
R411 a_13294_376.t0 a_13294_376.t1 3.1505
R412 a_12262_376.t0 a_12262_376.t1 3.1505
R413 a_11230_376.t0 a_11230_376.t1 0.6305
R414 a_8402_376.t0 a_8402_376.t1 0.6305
R415 a_7358_376.t0 a_7358_376.t1 0.6305
R416 a_8202_332.n0 a_8202_332.t1 0.4163
R417 a_8202_332.t0 a_8202_332.n0 0.4163
R418 a_8202_332.n0 a_8202_332.t2 51.0844
R419 a_1246_376.t0 a_1246_376.t1 0.6305
R420 a_214_376.t0 a_214_376.t1 0.6305
R421 a_514_376.t0 a_514_376.n1 8.95611
R422 a_514_376.n1 a_514_376.n0 0.601571
R423 a_514_376.n0 a_514_376.t3 8.71978
R424 a_514_376.n0 a_514_376.t2 7.94711
R425 a_514_376.n1 a_514_376.t1 10.5825
R426 a_16346_4838.t0 a_16346_4838.t1 15.2227
R427 a_928_5288.t0 a_928_5288.t1 15.2227
R428 a_16346_5738.t0 a_16346_5738.t1 15.2227
R429 a_928_6188.t0 a_928_6188.t1 15.2227
R430 a_17826_7234.t0 a_17826_7234.t1 0.3505
R431 a_14_332.t1 a_14_332.n3 8.18133
R432 a_14_332.n3 a_14_332.t0 22.8325
R433 a_14_332.n3 a_14_332.n0 0.722107
R434 a_14_332.n0 a_14_332.n1 6.19121
R435 a_14_332.n1 a_14_332.n2 9.79121
R436 a_14_332.n2 a_14_332.t5 33.2325
R437 a_14_332.n2 a_14_332.t4 31.606
R438 a_14_332.n1 a_14_332.t3 31.606
R439 a_14_332.n0 a_14_332.t2 31.606
R440 a_15902_7234.t0 a_15902_7234.t1 0.3505
R441 a_314_332.t2 a_314_332.n7 13.3737
R442 a_314_332.n7 a_314_332.n6 1.35532
R443 a_314_332.n6 a_314_332.t0 21.0587
R444 a_314_332.n6 a_314_332.t3 31.8643
R445 a_314_332.n7 a_314_332.n0 0.239964
R446 a_314_332.n0 a_314_332.n1 2.85479
R447 a_314_332.n1 a_314_332.n2 1.64621
R448 a_314_332.n2 a_314_332.n3 3.97979
R449 a_314_332.n3 a_314_332.n4 1.69764
R450 a_314_332.n4 a_314_332.n5 4.0505
R451 a_314_332.n5 a_314_332.t9 33.4907
R452 a_314_332.n5 a_314_332.t8 31.8643
R453 a_314_332.n4 a_314_332.t7 23.7176
R454 a_314_332.n3 a_314_332.t6 23.7176
R455 a_314_332.n2 a_314_332.t5 31.8643
R456 a_314_332.n1 a_314_332.t4 31.8643
R457 a_314_332.n0 a_314_332.t1 18.8295
R458 a_14790_7234.t0 a_14790_7234.t1 0.3505
R459 a_5694_332.t1 a_5694_332.n2 8.95611
R460 a_5694_332.n2 a_5694_332.t2 17.2749
R461 a_5694_332.n2 a_5694_332.n0 0.239964
R462 a_5694_332.n0 a_5694_332.n1 3.83836
R463 a_5694_332.n1 a_5694_332.t4 23.749
R464 a_5694_332.n1 a_5694_332.t3 22.6047
R465 a_5694_332.n0 a_5694_332.t0 32.3808
R466 a_10430_7234.t0 a_10430_7234.t1 0.3505
R467 a_8986_7234.t0 a_8986_7234.t1 0.3505
R468 a_5162_376.t1 a_5162_376.n1 13.0281
R469 a_5162_376.n1 a_5162_376.n0 2.98014
R470 a_5162_376.n0 a_5162_376.t3 23.428
R471 a_5162_376.n0 a_5162_376.t0 15.1047
R472 a_5162_376.n1 a_5162_376.t2 14.1888
R473 a_3554_332.t1 a_3554_332.n2 11.9951
R474 a_3554_332.n2 a_3554_332.t0 18.9888
R475 a_3554_332.n2 a_3554_332.n0 1.40675
R476 a_3554_332.n0 a_3554_332.n1 0.892464
R477 a_3554_332.n1 a_3554_332.t4 25.7819
R478 a_3554_332.n1 a_3554_332.t2 11.3783
R479 a_3554_332.n0 a_3554_332.t3 25.0089
R480 a_2278_376.t3 a_2278_376.n0 17.987
R481 a_2278_376.n0 a_2278_376.n1 3.43336
R482 a_2278_376.n1 a_2278_376.t1 9.68632
R483 a_2278_376.n1 a_2278_376.t2 9.27572
R484 a_2278_376.n0 a_2278_376.t0 13.0318
R485 a_3010_376.t2 a_3010_376.n0 19.02
R486 a_3010_376.n0 a_3010_376.t1 9.27166
R487 a_3010_376.n0 a_3010_376.t0 14.0648
R488 a_3290_9134.t1 a_3290_9134.n0 45.1076
R489 a_3290_9134.n0 a_3290_9134.t0 0.8321
R490 a_3290_9134.n0 a_3290_9134.t2 0.8321
R491 a_2478_9124.t0 a_2478_9124.n0 28.5134
R492 a_2478_9124.n0 a_2478_9124.n1 19.2454
R493 a_2478_9124.n1 a_2478_9124.t1 0.8321
R494 a_2478_9124.n1 a_2478_9124.t2 0.8321
R495 a_2478_9124.n0 a_2478_9124.t3 16.8696
R496 a_1366_7234.t0 a_1366_7234.t1 0.3505
R497 a_554_7234.t3 a_554_7234.n0 24.8231
R498 a_554_7234.n0 a_554_7234.n1 0.730143
R499 a_554_7234.n1 a_554_7234.t0 14.2702
R500 a_554_7234.n1 a_554_7234.t1 12.5152
R501 a_554_7234.n0 a_554_7234.t2 23.2052
R502 a_254_7234.t0 a_254_7234.t1 0.3505
R503 a_928_4838.t2 a_928_4838.n5 29.1003
R504 a_928_4838.n5 a_928_4838.n0 2.49157
R505 a_928_4838.n0 a_928_4838.n1 1.89371
R506 a_928_4838.n1 a_928_4838.n2 5.67211
R507 a_928_4838.n2 a_928_4838.n3 1.27336
R508 a_928_4838.n3 a_928_4838.n4 1.27336
R509 a_928_4838.n4 a_928_4838.t4 26.8602
R510 a_928_4838.n4 a_928_4838.t5 25.5874
R511 a_928_4838.n3 a_928_4838.t6 25.5874
R512 a_928_4838.n2 a_928_4838.t7 25.5874
R513 a_928_4838.n1 a_928_4838.t1 15.6212
R514 a_928_4838.n0 a_928_4838.t3 12.5116
R515 a_928_4838.n5 a_928_4838.t0 13.4797
R516 a_8786_7118.t0 a_8786_7118.n0 0.2315
R517 a_8786_7118.n0 a_8786_7118.t1 0.2315
R518 a_8786_7118.n0 a_8786_7118.t2 79.1468
R519 a_7150_8318.t2 a_7150_8318.n2 11.0222
R520 a_7150_8318.n2 a_7150_8318.n0 0.50675
R521 a_7150_8318.n0 a_7150_8318.n1 2.30836
R522 a_7150_8318.n1 a_7150_8318.t1 12.7547
R523 a_7150_8318.n1 a_7150_8318.t0 54.1408
R524 a_7150_8318.n0 a_7150_8318.t3 34.5887
R525 a_7150_8318.n2 a_7150_8318.t4 35.3231
R526 a_4102_7234.t2 a_4102_7234.n2 13.2864
R527 a_4102_7234.n2 a_4102_7234.n1 0.73175
R528 a_4102_7234.n1 a_4102_7234.t1 15.8477
R529 a_4102_7234.n1 a_4102_7234.t3 37.8474
R530 a_4102_7234.n2 a_4102_7234.n0 0.509964
R531 a_4102_7234.n0 a_4102_7234.t0 14.8215
R532 a_4102_7234.n0 a_4102_7234.t4 37.8474
R533 a_354_7118.t1 a_354_7118.n13 14.9232
R534 a_354_7118.n13 a_354_7118.n9 2.10104
R535 a_354_7118.n9 a_354_7118.n10 1.7555
R536 a_354_7118.n10 a_354_7118.n11 1.27336
R537 a_354_7118.n11 a_354_7118.n12 0.239964
R538 a_354_7118.n12 a_354_7118.t7 56.6573
R539 a_354_7118.n12 a_354_7118.t3 17.5367
R540 a_354_7118.n11 a_354_7118.t2 29.1043
R541 a_354_7118.n10 a_354_7118.t8 55.1739
R542 a_354_7118.n9 a_354_7118.t9 55.1739
R543 a_354_7118.n13 a_354_7118.n0 0.239964
R544 a_354_7118.n0 a_354_7118.n1 0.4505
R545 a_354_7118.n1 a_354_7118.n2 1.14479
R546 a_354_7118.n2 a_354_7118.n3 0.4505
R547 a_354_7118.n3 a_354_7118.n4 2.4305
R548 a_354_7118.n4 a_354_7118.n5 2.28907
R549 a_354_7118.n5 a_354_7118.n6 6.99479
R550 a_354_7118.n6 a_354_7118.n7 1.27336
R551 a_354_7118.n7 a_354_7118.n8 3.88336
R552 a_354_7118.n8 a_354_7118.t15 56.9289
R553 a_354_7118.n8 a_354_7118.t14 55.1739
R554 a_354_7118.n7 a_354_7118.t13 55.1739
R555 a_354_7118.n6 a_354_7118.t12 55.1739
R556 a_354_7118.n5 a_354_7118.t11 55.1739
R557 a_354_7118.n4 a_354_7118.t10 55.1739
R558 a_354_7118.n3 a_354_7118.t6 20.3791
R559 a_354_7118.n2 a_354_7118.t5 20.3791
R560 a_354_7118.n1 a_354_7118.t4 20.3791
R561 a_354_7118.n0 a_354_7118.t0 20.3791
R562 a_54_7118.t0 a_54_7118.n5 13.6319
R563 a_54_7118.n5 a_54_7118.n2 3.27746
R564 a_54_7118.n2 a_54_7118.n3 1.7555
R565 a_54_7118.n3 a_54_7118.n4 3.0605
R566 a_54_7118.n4 a_54_7118.t1 15.5612
R567 a_54_7118.n4 a_54_7118.t2 56.4652
R568 a_54_7118.n3 a_54_7118.t3 56.4652
R569 a_54_7118.n2 a_54_7118.t4 56.4652
R570 a_54_7118.n5 a_54_7118.n0 3.66639
R571 a_54_7118.n0 a_54_7118.n1 14.5355
R572 a_54_7118.n1 a_54_7118.t7 58.2202
R573 a_54_7118.n1 a_54_7118.t6 56.4652
R574 a_54_7118.n0 a_54_7118.t5 56.4652
C0 INN INP 0.02117f
C1 OUT INN 0.0659f
C2 INN VDD 0.59359f
C3 OUT INP 0.03436f
C4 VDD INP 0.59272f
C5 OUT VDD 2.55297f
C6 OUT VSS 11.12816f
C7 INN VSS 4.22404f
C8 INP VSS 4.65104f
C9 VDD VSS 0.1552p
C10 a_54_7118.t0 VSS 0.29393f
C11 a_54_7118.t5 VSS 1.64507f
C12 a_54_7118.n0 VSS 2.60525f
C13 a_54_7118.t6 VSS 1.64507f
C14 a_54_7118.n1 VSS 3.75036f
C15 a_54_7118.t7 VSS 1.68528f
C16 a_54_7118.t4 VSS 1.64507f
C17 a_54_7118.n2 VSS 1.58159f
C18 a_54_7118.t3 VSS 1.64507f
C19 a_54_7118.n3 VSS 1.56472f
C20 a_54_7118.t2 VSS 1.64507f
C21 a_54_7118.n4 VSS 1.95607f
C22 a_54_7118.t1 VSS 1.99207f
C23 a_54_7118.n5 VSS 0.79818f
C24 a_354_7118.t1 VSS 0.39182f
C25 a_354_7118.t0 VSS 0.47329f
C26 a_354_7118.n0 VSS 0.5518f
C27 a_354_7118.t4 VSS 0.47329f
C28 a_354_7118.n1 VSS 0.62822f
C29 a_354_7118.t5 VSS 0.47329f
C30 a_354_7118.n2 VSS 0.62822f
C31 a_354_7118.t6 VSS 0.47329f
C32 a_354_7118.n3 VSS 0.73681f
C33 a_354_7118.t10 VSS 1.74762f
C34 a_354_7118.n4 VSS 1.58469f
C35 a_354_7118.t11 VSS 1.74762f
C36 a_354_7118.n5 VSS 1.9702f
C37 a_354_7118.t12 VSS 1.74762f
C38 a_354_7118.n6 VSS 1.88441f
C39 a_354_7118.t13 VSS 1.74762f
C40 a_354_7118.n7 VSS 1.62161f
C41 a_354_7118.t14 VSS 1.74762f
C42 a_354_7118.n8 VSS 2.96295f
C43 a_354_7118.t15 VSS 1.78899f
C44 a_354_7118.t9 VSS 1.74762f
C45 a_354_7118.n9 VSS 1.5118f
C46 a_354_7118.t8 VSS 1.74762f
C47 a_354_7118.n10 VSS 1.44189f
C48 a_354_7118.t2 VSS 0.82928f
C49 a_354_7118.n11 VSS 1.03769f
C50 a_354_7118.t3 VSS 0.97011f
C51 a_354_7118.n12 VSS 2.01365f
C52 a_354_7118.t7 VSS 1.78215f
C53 a_354_7118.n13 VSS 0.55323f
C54 a_4102_7234.t2 VSS 0.86677f
C55 a_4102_7234.t4 VSS 1.65971f
C56 a_4102_7234.n0 VSS 2.53729f
C57 a_4102_7234.t0 VSS 3.13293f
C58 a_4102_7234.t3 VSS 1.65971f
C59 a_4102_7234.n1 VSS 2.46484f
C60 a_4102_7234.t1 VSS 1.87272f
C61 a_4102_7234.n2 VSS 0.66408f
C62 a_7150_8318.t2 VSS 1.01708f
C63 a_7150_8318.t4 VSS 1.28996f
C64 a_7150_8318.t3 VSS 1.26322f
C65 a_7150_8318.n0 VSS 1.50164f
C66 a_7150_8318.t0 VSS 2.1999f
C67 a_7150_8318.n1 VSS 2.16672f
C68 a_7150_8318.t1 VSS 2.55577f
C69 a_7150_8318.n2 VSS 1.70893f
C70 a_8786_7118.t0 VSS 0.29928f
C71 a_8786_7118.n0 VSS 3.24164f
C72 a_8786_7118.t2 VSS 2.21211f
C73 a_8786_7118.t1 VSS 0.29928f
C74 a_928_4838.t2 VSS 1.27617f
C75 a_928_4838.t0 VSS 3.8995f
C76 a_928_4838.t3 VSS 1.00309f
C77 a_928_4838.n0 VSS 1.26784f
C78 a_928_4838.t1 VSS 2.39152f
C79 a_928_4838.n1 VSS 2.16659f
C80 a_928_4838.t7 VSS 1.39683f
C81 a_928_4838.n2 VSS 2.69769f
C82 a_928_4838.t6 VSS 1.39683f
C83 a_928_4838.n3 VSS 1.98917f
C84 a_928_4838.t5 VSS 1.39683f
C85 a_928_4838.n4 VSS 3.70257f
C86 a_928_4838.t4 VSS 1.48206f
C87 a_928_4838.n5 VSS 3.52675f
C88 a_254_7234.t0 VSS 0.06564f
C89 a_254_7234.t1 VSS 0.06564f
C90 a_554_7234.t3 VSS 0.80366f
C91 a_554_7234.t2 VSS 0.76058f
C92 a_554_7234.n0 VSS 2.36101f
C93 a_554_7234.t1 VSS 2.76481f
C94 a_554_7234.n1 VSS 1.41193f
C95 a_554_7234.t0 VSS 2.8524f
C96 a_1366_7234.t0 VSS 0.06196f
C97 a_1366_7234.t1 VSS 0.06196f
C98 a_2478_9124.t0 VSS 0.10957f
C99 a_2478_9124.n0 VSS 0.34388f
C100 a_2478_9124.t3 VSS 11.602f
C101 a_2478_9124.t1 VSS 0.01122f
C102 a_2478_9124.t2 VSS 0.01122f
C103 a_2478_9124.n1 VSS 0.08606f
C104 a_3290_9134.t1 VSS 2.57996f
C105 a_3290_9134.t0 VSS 0.16925f
C106 a_3290_9134.t2 VSS 0.16925f
C107 a_3290_9134.n0 VSS 2.90362f
C108 a_3010_376.t2 VSS 2.52667f
C109 a_3010_376.t0 VSS 3.36723f
C110 a_3010_376.n0 VSS 2.66779f
C111 a_3010_376.t1 VSS 1.47845f
C112 a_2278_376.t3 VSS 1.055f
C113 a_2278_376.t0 VSS 1.42102f
C114 a_2278_376.n0 VSS 1.08199f
C115 a_2278_376.n1 VSS 0.43413f
C116 a_2278_376.t2 VSS 9.7582f
C117 a_2278_376.t1 VSS 0.64033f
C118 a_3554_332.t1 VSS 0.79895f
C119 a_3554_332.t3 VSS 1.01149f
C120 a_3554_332.n0 VSS 1.18173f
C121 a_3554_332.t2 VSS 0.86806f
C122 a_3554_332.n1 VSS 1.58312f
C123 a_3554_332.t4 VSS 1.04104f
C124 a_3554_332.t0 VSS 2.26891f
C125 a_3554_332.n2 VSS 2.07689f
C126 a_5162_376.t1 VSS 1.07973f
C127 a_5162_376.t2 VSS 1.27592f
C128 a_5162_376.t0 VSS 2.36375f
C129 a_5162_376.n0 VSS 3.06993f
C130 a_5162_376.t3 VSS 1.12796f
C131 a_5162_376.n1 VSS 2.17255f
C132 a_8986_7234.t0 VSS 0.06934f
C133 a_8986_7234.t1 VSS 0.06934f
C134 a_10430_7234.t0 VSS 0.06417f
C135 a_10430_7234.t1 VSS 0.06417f
C136 a_5694_332.t1 VSS 0.85049f
C137 a_5694_332.t0 VSS 1.1805f
C138 a_5694_332.n0 VSS 1.15246f
C139 a_5694_332.t3 VSS 0.69739f
C140 a_5694_332.n1 VSS 1.85508f
C141 a_5694_332.t4 VSS 0.73301f
C142 a_5694_332.t2 VSS 2.9062f
C143 a_5694_332.n2 VSS 1.27996f
C144 a_14790_7234.t0 VSS 0.06464f
C145 a_14790_7234.t1 VSS 0.06464f
C146 a_314_332.t2 VSS 0.40702f
C147 a_314_332.t1 VSS 0.53423f
C148 a_314_332.n0 VSS 0.86947f
C149 a_314_332.t4 VSS 1.1881f
C150 a_314_332.n1 VSS 1.17143f
C151 a_314_332.t5 VSS 1.1881f
C152 a_314_332.n2 VSS 1.29828f
C153 a_314_332.t6 VSS 0.76578f
C154 a_314_332.n3 VSS 1.22808f
C155 a_314_332.t7 VSS 0.76578f
C156 a_314_332.n4 VSS 1.23605f
C157 a_314_332.t8 VSS 1.1881f
C158 a_314_332.n5 VSS 2.12002f
C159 a_314_332.t9 VSS 1.22975f
C160 a_314_332.t3 VSS 1.1881f
C161 a_314_332.n6 VSS 2.43909f
C162 a_314_332.t0 VSS 3.25335f
C163 a_314_332.n7 VSS 0.53469f
C164 a_15902_7234.t0 VSS 0.06676f
C165 a_15902_7234.t1 VSS 0.06676f
C166 a_14_332.t1 VSS 0.57362f
C167 a_14_332.t2 VSS 0.84768f
C168 a_14_332.n0 VSS 1.01836f
C169 a_14_332.t3 VSS 0.84768f
C170 a_14_332.n1 VSS 1.75443f
C171 a_14_332.t4 VSS 0.84768f
C172 a_14_332.n2 VSS 1.95142f
C173 a_14_332.t5 VSS 0.87688f
C174 a_14_332.t0 VSS 2.4445f
C175 a_14_332.n3 VSS 1.51244f
C176 a_17826_7234.t0 VSS 0.06463f
C177 a_17826_7234.t1 VSS 0.06463f
C178 a_928_6188.t0 VSS 0.10389f
C179 a_928_6188.t1 VSS 0.10389f
C180 a_16346_5738.t0 VSS 0.20599f
C181 a_16346_5738.t1 VSS 0.20599f
C182 a_928_5288.t0 VSS 0.10605f
C183 a_928_5288.t1 VSS 0.10605f
C184 a_16346_4838.t0 VSS 0.21243f
C185 a_16346_4838.t1 VSS 0.21243f
C186 a_514_376.t0 VSS 0.81886f
C187 a_514_376.t1 VSS 0.87599f
C188 a_514_376.t2 VSS 0.99649f
C189 a_514_376.n0 VSS 0.56642f
C190 a_514_376.t3 VSS 1.0986f
C191 a_514_376.n1 VSS 0.74045f
C192 a_214_376.t0 VSS 0.01394f
C193 a_214_376.t1 VSS 0.01394f
C194 a_1246_376.t0 VSS 0.01406f
C195 a_1246_376.t1 VSS 0.01406f
C196 a_8202_332.t0 VSS 0.11795f
C197 a_8202_332.n0 VSS 1.2038f
C198 a_8202_332.t2 VSS 0.94424f
C199 a_8202_332.t1 VSS 0.11795f
C200 a_7358_376.t0 VSS 0.01482f
C201 a_7358_376.t1 VSS 0.01482f
C202 a_8402_376.t0 VSS 0.01741f
C203 a_8402_376.t1 VSS 0.01741f
C204 a_11230_376.t0 VSS 0.01398f
C205 a_11230_376.t1 VSS 0.01398f
C206 VDD.n0 VSS 0.02635f
C207 VDD.t4 VSS 0.07412f
C208 VDD.n1 VSS 0.04018f
C209 VDD.n2 VSS 0.03786f
C210 VDD.n3 VSS 0.03786f
C211 VDD.n4 VSS 0.01484f
C212 VDD.n5 VSS 0.03786f
C213 VDD.n6 VSS 0.0215f
C214 VDD.n7 VSS 0.03786f
C215 VDD.t37 VSS 0.03633f
C216 VDD.n8 VSS 0.02662f
C217 VDD.n9 VSS 0.01307f
C218 VDD.t35 VSS 0.03633f
C219 VDD.n10 VSS 0.03342f
C220 VDD.n11 VSS 0.03786f
C221 VDD.n12 VSS 0.01484f
C222 VDD.n13 VSS 0.03451f
C223 VDD.n14 VSS 0.03786f
C224 VDD.n15 VSS 0.01484f
C225 VDD.n16 VSS 0.03786f
C226 VDD.t28 VSS 0.07992f
C227 VDD.n17 VSS 0.0948f
C228 VDD.t40 VSS 0.07412f
C229 VDD VSS 0.47622f
C230 VDD.t31 VSS 0.07412f
C231 VDD.n18 VSS 0.03954f
C232 VDD.n19 VSS 0.03786f
C233 VDD.n20 VSS 0.02511f
C234 VDD.n21 VSS 0.03786f
C235 VDD.n22 VSS 0.01244f
C236 VDD VSS 0.82061f
C237 VDD.n23 VSS 0.01244f
C238 VDD.n24 VSS 0.02511f
C239 VDD.n25 VSS 0.03786f
C240 VDD.t22 VSS 0.07412f
C241 VDD.n26 VSS 0.03269f
C242 VDD.n27 VSS 0.03786f
C243 VDD.t24 VSS 0.07412f
C244 VDD.n28 VSS 0.04018f
C245 VDD VSS 0.74796f
C246 VDD VSS 0.47622f
C247 VDD.t10 VSS 0.0747f
C248 VDD.n29 VSS 0.17476f
C249 VDD.t33 VSS 0.01382f
C250 VDD.n30 VSS 0.02717f
C251 VDD.n31 VSS 0.03786f
C252 VDD.n32 VSS 0.0322f
C253 VDD.n33 VSS 0.03786f
C254 VDD.n34 VSS 0.02141f
C255 VDD.n35 VSS 0.03786f
C256 VDD.n36 VSS 0.17886f
C257 VDD.n37 VSS 0.02757f
C258 VDD.n38 VSS 0.01682f
C259 VDD.n39 VSS 0.54385f
C260 VDD VSS 0.81792f
C261 VDD VSS 0.74796f
C262 VDD VSS 0.47622f
C263 VDD VSS 0.74796f
C264 VDD VSS 0.47353f
C265 VDD.n40 VSS 0.54385f
C266 VDD.n41 VSS 0.01484f
C267 VDD.n42 VSS 0.01244f
C268 VDD.n43 VSS 0.03786f
C269 VDD.n44 VSS 0.03786f
C270 VDD.n45 VSS 0.03786f
C271 VDD.n46 VSS 0.02821f
C272 VDD.n47 VSS 0.04018f
C273 VDD.n48 VSS 0.02939f
C274 VDD.n49 VSS 0.02511f
C275 VDD.n50 VSS 0.02875f
C276 VDD.n51 VSS 0.03786f
C277 VDD.n52 VSS 0.03786f
C278 VDD.n53 VSS 0.03786f
C279 VDD.n54 VSS 0.02511f
C280 VDD.n55 VSS 0.02984f
C281 VDD.n56 VSS 0.0283f
C282 VDD.n57 VSS 0.03786f
C283 VDD.n58 VSS 0.03786f
C284 VDD.n59 VSS 0.02757f
C285 VDD.n60 VSS 0.01484f
C286 VDD.n61 VSS 0.54385f
C287 VDD VSS 0.81792f
C288 VDD VSS 0.82061f
C289 VDD VSS 0.74796f
C290 VDD VSS 0.81792f
C291 VDD.n62 VSS 0.54385f
C292 VDD.n63 VSS 0.01484f
C293 VDD.n64 VSS 0.02757f
C294 VDD.n65 VSS 0.03786f
C295 VDD.n66 VSS 0.03786f
C296 VDD.n67 VSS 0.02721f
C297 VDD.n68 VSS 0.03786f
C298 VDD.n69 VSS 0.0264f
C299 VDD.n70 VSS 0.03786f
C300 VDD.n71 VSS 0.03786f
C301 VDD.n72 VSS 0.02037f
C302 VDD.n74 VSS 0.54385f
C303 VDD VSS 0.49505f
C304 VDD VSS 0.4251f
C305 VDD VSS 0.75603f
C306 VDD VSS 0.82868f
C307 VDD.n75 VSS 0.54385f
C308 VDD VSS 0.81792f
C309 VDD VSS 0.82061f
C310 VDD.n76 VSS 0.54385f
C311 VDD VSS 0.81792f
C312 VDD VSS 0.82061f
C313 VDD.n77 VSS 0.54385f
C314 VDD VSS 0.81792f
C315 VDD VSS 0.82061f
C316 VDD.n78 VSS 0.54385f
C317 VDD VSS 0.81792f
C318 VDD VSS 0.74796f
C319 VDD VSS 0.47622f
C320 VDD VSS 0.74796f
C321 VDD VSS 0.47353f
C322 VDD.n79 VSS 0.54385f
C323 VDD.n80 VSS 0.03998f
C324 VDD.n81 VSS 0.03338f
C325 VDD.n82 VSS 0.02023f
C326 VDD.n83 VSS 0.13754f
C327 VDD.n84 VSS 0.03786f
C328 VDD.n85 VSS 0.03786f
C329 VDD.n86 VSS 0.03786f
C330 VDD.n87 VSS 0.03786f
C331 VDD.n88 VSS 0.02309f
C332 VDD.n89 VSS 0.03786f
C333 VDD.n90 VSS 0.03786f
C334 VDD.n91 VSS 0.03786f
C335 VDD.n92 VSS 0.03786f
C336 VDD.n93 VSS 0.03786f
C337 VDD.n94 VSS 0.02418f
C338 VDD.n95 VSS 0.03786f
C339 VDD.n96 VSS 0.03786f
C340 VDD.n97 VSS 0.03786f
C341 VDD.n98 VSS 0.03555f
C342 VDD.n99 VSS 0.03215f
C343 VDD.n100 VSS 0.02205f
C344 VDD.n101 VSS 0.02526f
C345 VDD.n102 VSS 0.03786f
C346 VDD.n103 VSS 0.03786f
C347 VDD.n104 VSS 0.03786f
C348 VDD.n105 VSS 0.03786f
C349 VDD.n106 VSS 0.03786f
C350 VDD.n107 VSS 0.02635f
C351 VDD.n108 VSS 0.03786f
C352 VDD.n109 VSS 0.03786f
C353 VDD.n110 VSS 0.03125f
C354 VDD.n111 VSS 0.03786f
C355 VDD.n112 VSS 0.02014f
C356 VDD.n113 VSS 0.03786f
C357 VDD.n114 VSS 0.03786f
C358 VDD.n115 VSS 0.03084f
C359 INP.t1 VSS 1.05932f
C360 INP.t0 VSS 2.90639f
C361 INN.t1 VSS 1.12016f
C362 INN.t0 VSS 2.98727f
C363 OUT.t2 VSS 0.13369f
C364 OUT.t3 VSS 0.18364f
C365 OUT.t4 VSS 0.11418f
C366 OUT.t6 VSS 3.38144f
C367 OUT.n0 VSS 0.39224f
C368 OUT.n1 VSS 0.19456f
C369 OUT.t0 VSS 0.18024f
C370 OUT.n2 VSS 0.19732f
C371 OUT.t1 VSS 0.18024f
C372 OUT.n3 VSS 0.2023f
C373 OUT.t5 VSS 0.10437f
C374 OUT.t7 VSS 20.0004f
C375 OUT.n4 VSS 0.27661f
C376 OUT.n5 VSS 0.07264f
.ends
