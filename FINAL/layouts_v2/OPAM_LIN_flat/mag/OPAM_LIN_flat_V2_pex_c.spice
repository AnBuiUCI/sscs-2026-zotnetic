* Nodos de bulk atados: 0 de pozo n -> VDD, 1 de sustrato -> VSS.
*   magic no extrae los taps de este layout y los dejaba flotando;
*   la conexion si existe (el LVS de KLayout da 'match uniquely').
*   Quien detecta un tap que falte de verdad es el LVS, no esto.
* NGSPICE file created from OPAM_LIN_flat.ext - technology: gf180mcuD

.subckt OPAM_LIN_flat_V2 VSS VDD INP OUT INN
X0 a_3566_332# a_314_332# a_3290_8994# VSS nfet_06v0 ad=0.825p pd=3.16u as=0.825p ps=3.16u w=2.5u l=1u
X1 OUT a_5518_376# VSS VSS nfet_06v0 ad=0.44p pd=2.88u as=0.44p ps=2.88u w=1u l=1u
X2 a_5518_376# a_314_332# a_2478_8974# VSS nfet_06v0 ad=0.825p pd=3.16u as=0.825p ps=3.16u w=2.5u l=1u
X3 a_4712_8078# a_314_332# a_6582_376# VSS nfet_06v0 ad=2.2p pd=10.88u as=1.25p ps=5.5u w=5u l=1u
X4 OUT a_2278_376# cap_mim_2f0_m4m5_noshield c_width=25u c_length=4u
X5 a_2478_8974# OUT cap_mim_2f0_m4m5_noshield c_width=25u c_length=4u
X6 OUT a_1088_4798# VDD VDD pfet_06v0 ad=0.22p pd=1.88u as=0.22p ps=1.88u w=0.5u l=1u
X7 a_7072_7078# a_354_7078# a_7272_7194# VDD pfet_06v0 ad=3.3p pd=10.66u as=2.5p ps=10.5u w=10u l=1u
X8 a_14188_7194# a_54_7078# VDD VDD pfet_06v0 ad=2.5p pd=10.5u as=4.4p ps=20.88u w=10u l=1u
X9 a_2278_376# INP a_514_376# VSS nfet_06v0 ad=0.44p pd=2.88u as=0.44p ps=2.88u w=1u l=1u
X10 a_54_7078# a_354_7078# a_16112_7194# VDD pfet_06v0 ad=4.4p pd=20.88u as=2.5p ps=10.5u w=10u l=1u
X11 a_3566_332# a_4712_8078# a_4048_8078# VDD pfet_06v0 ad=2.2p pd=10.88u as=1.65p ps=5.66u w=5u l=1u
X12 a_1088_4798# a_16506_4798# VSS ppolyf_u_3k r_width=1u r_length=76.45u
X13 a_514_376# a_314_332# a_214_376# VSS nfet_06v0 ad=2.2p pd=10.88u as=1.25p ps=5.5u w=5u l=1u
X14 a_554_7194# a_354_7078# a_254_7194# VDD pfet_06v0 ad=4.4p pd=20.88u as=2.5p ps=10.5u w=10u l=1u
X15 a_4230_332# a_4230_332# a_7438_332# VSS nfet_06v0 ad=2.2p pd=10.88u as=1.65p ps=5.66u w=5u l=1u
X16 a_314_332# a_314_332# VSS VSS nfet_06v0 ad=0.44p pd=2.88u as=0.44p ps=2.88u w=1u l=1u
X17 OUT a_1088_4798# VDD VDD pfet_06v0 ad=0.22p pd=1.88u as=0.22p ps=1.88u w=0.5u l=1u
X18 a_13076_7194# a_54_7078# VDD VDD pfet_06v0 ad=2.5p pd=10.5u as=4.4p ps=20.88u w=10u l=1u
X19 a_1088_5248# a_16506_4798# VSS ppolyf_u_3k r_width=1u r_length=76.45u
X20 a_3290_8994# a_3566_332# VSS VSS nfet_06v0 ad=0.825p pd=3.16u as=1.1p ps=5.88u w=2.5u l=1u
X21 a_2478_8974# a_3566_332# VSS VSS nfet_06v0 ad=0.825p pd=3.16u as=1.1p ps=5.88u w=2.5u l=1u
X22 a_8716_7194# a_54_7078# VDD VDD pfet_06v0 ad=2.5p pd=10.5u as=4.4p ps=20.88u w=10u l=1u
X23 a_12530_376# a_354_7078# VSS VSS nfet_06v0 ad=0.25p pd=1.5u as=0.44p ps=2.88u w=1u l=1u
X24 a_2478_8974# INP a_554_7194# VDD pfet_06v0 ad=0.484p pd=3.08u as=0.484p ps=3.08u w=1.1u l=1u
X25 a_1088_4798# a_354_7078# a_2278_376# VDD pfet_06v0 ad=1.65p pd=5.66u as=1.65p ps=5.66u w=5u l=1u
X26 a_1366_7194# a_54_7078# VDD VDD pfet_06v0 ad=2.5p pd=10.5u as=4.4p ps=20.88u w=10u l=1u
X27 OUT a_1088_4798# VDD VDD pfet_06v0 ad=0.22p pd=1.88u as=0.22p ps=1.88u w=0.5u l=1u
X28 a_354_7078# a_354_7078# VDD VDD pfet_06v0 ad=0.88p pd=4.88u as=0.88p ps=4.88u w=2u l=1u
X29 a_214_376# a_14_332# VSS VSS nfet_06v0 ad=1.25p pd=5.5u as=2.2p ps=10.88u w=5u l=1u
X30 a_10466_376# a_14_332# VSS VSS nfet_06v0 ad=1.25p pd=5.5u as=2.2p ps=10.88u w=5u l=1u
X31 a_3010_376# a_4048_8078# VDD VDD pfet_06v0 ad=1.65p pd=5.66u as=2.2p ps=10.88u w=5u l=1u
X32 a_1088_5248# a_16506_5698# VSS ppolyf_u_3k r_width=1u r_length=76.45u
X33 a_354_7078# a_354_7078# a_12530_376# VSS nfet_06v0 ad=0.44p pd=2.88u as=0.25p ps=1.5u w=1u l=1u
X34 a_1088_6148# a_16506_5698# VSS ppolyf_u_3k r_width=1u r_length=76.45u
X35 a_16112_7194# a_54_7078# VDD VDD pfet_06v0 ad=2.5p pd=10.5u as=4.4p ps=20.88u w=10u l=1u
X36 a_14_332# a_314_332# a_10466_376# VSS nfet_06v0 ad=2.2p pd=10.88u as=1.25p ps=5.5u w=5u l=1u
X37 a_4048_8078# a_354_7078# a_3010_376# VDD pfet_06v0 ad=1.65p pd=5.66u as=1.65p ps=5.66u w=5u l=1u
X38 a_4230_332# a_354_7078# a_8716_7194# VDD pfet_06v0 ad=4.4p pd=20.88u as=2.5p ps=10.5u w=10u l=1u
X39 a_254_7194# a_54_7078# VDD VDD pfet_06v0 ad=2.5p pd=10.5u as=4.4p ps=20.88u w=10u l=1u
X40 a_3290_8994# INN a_554_7194# VDD pfet_06v0 ad=0.44p pd=2.88u as=0.44p ps=2.88u w=1u l=1u
X41 a_5518_376# a_4712_8078# a_1088_4798# VDD pfet_06v0 ad=2.2p pd=10.88u as=1.65p ps=5.66u w=5u l=1u
X42 a_4048_8078# a_4230_332# a_3566_332# VSS nfet_06v0 ad=1.1p pd=5.88u as=0.825p ps=3.16u w=2.5u l=1u
X43 OUT a_1088_4798# VDD VDD pfet_06v0 ad=0.22p pd=1.88u as=0.22p ps=1.88u w=0.5u l=1u
X44 a_1088_4798# a_4230_332# a_5518_376# VSS nfet_06v0 ad=1.1p pd=5.88u as=0.825p ps=3.16u w=2.5u l=1u
X45 a_554_7194# a_354_7078# a_1366_7194# VDD pfet_06v0 ad=4.4p pd=20.88u as=2.5p ps=10.5u w=10u l=1u
X46 a_14_332# a_354_7078# a_14188_7194# VDD pfet_06v0 ad=4.4p pd=20.88u as=2.5p ps=10.5u w=10u l=1u
X47 a_7638_376# a_7438_332# VSS VSS nfet_06v0 ad=1.25p pd=5.5u as=2.2p ps=10.88u w=5u l=1u
X48 a_4712_8078# a_4712_8078# a_7072_7078# VDD pfet_06v0 ad=4.4p pd=20.88u as=3.3p ps=10.66u w=10u l=1u
X49 a_1088_6148# OUT VSS ppolyf_u_3k r_width=1u r_length=76.45u
X50 a_1246_376# a_14_332# VSS VSS nfet_06v0 ad=1.25p pd=5.5u as=2.2p ps=10.88u w=5u l=1u
X51 a_11498_376# a_354_7078# VSS VSS nfet_06v0 ad=0.25p pd=1.5u as=0.44p ps=2.88u w=1u l=1u
X52 a_2278_376# a_4048_8078# VDD VDD pfet_06v0 ad=1.65p pd=5.66u as=2.2p ps=10.88u w=5u l=1u
X53 a_3010_376# INN a_514_376# VSS nfet_06v0 ad=0.44p pd=2.88u as=0.44p ps=2.88u w=1u l=1u
X54 a_7438_332# a_314_332# a_7638_376# VSS nfet_06v0 ad=1.65p pd=5.66u as=1.25p ps=5.5u w=5u l=1u
X55 a_7272_7194# a_7072_7078# VDD VDD pfet_06v0 ad=2.5p pd=10.5u as=4.4p ps=20.88u w=10u l=1u
X56 a_314_332# a_354_7078# a_13076_7194# VDD pfet_06v0 ad=4.4p pd=20.88u as=2.5p ps=10.5u w=10u l=1u
X57 a_514_376# a_314_332# a_1246_376# VSS nfet_06v0 ad=2.2p pd=10.88u as=1.25p ps=5.5u w=5u l=1u
X58 a_6582_376# a_14_332# VSS VSS nfet_06v0 ad=1.25p pd=5.5u as=2.2p ps=10.88u w=5u l=1u
X59 a_54_7078# a_354_7078# a_11498_376# VSS nfet_06v0 ad=0.44p pd=2.88u as=0.25p ps=1.5u w=1u l=1u
C0 a_1088_4798# INP 0.01608f
C1 a_5518_376# a_2478_8974# 0.25491f
C2 INP a_14_332# 0.02723f
C3 a_354_7078# a_314_332# 1.89392f
C4 a_354_7078# a_2278_376# 1.87472f
C5 a_4230_332# a_2478_8974# 0.08075f
C6 a_4048_8078# a_3010_376# 2.3007f
C7 INN a_514_376# 0.61271f
C8 VDD a_7272_7194# 0.07139f
C9 a_3290_8994# a_3010_376# 0.19977f
C10 a_1088_4798# VDD 3.4313f
C11 a_1088_4798# OUT 12.2603f
C12 VDD a_14_332# 0.55461f
C13 OUT a_14_332# 0.08067f
C14 INN a_3010_376# 1.21212f
C15 a_3566_332# a_314_332# 0.5742f
C16 a_3566_332# a_2278_376# 0.0592f
C17 VDD a_4712_8078# 1.77427f
C18 a_7638_376# a_7438_332# 0.03308f
C19 OUT a_4712_8078# 0.09331f
C20 VDD a_1088_6148# 0.02652f
C21 INP a_514_376# 0.63802f
C22 a_254_7194# VDD 0.07875f
C23 VDD a_3010_376# 0.48157f
C24 a_354_7078# a_1088_4798# 4.89382f
C25 OUT a_3010_376# 0.03917f
C26 a_354_7078# a_14_332# 2.31751f
C27 VDD a_7072_7078# 0.94761f
C28 OUT a_7072_7078# 0.06846f
C29 a_354_7078# a_4712_8078# 0.25481f
C30 OUT a_16506_5698# 0.03324f
C31 a_554_7194# a_54_7078# 0.5592f
C32 a_3566_332# a_1088_4798# 0.02154f
C33 a_3566_332# a_14_332# 0.09595f
C34 a_3566_332# a_4712_8078# 2.40702f
C35 a_2278_376# a_314_332# 0.01978f
C36 a_354_7078# a_3010_376# 1.50285f
C37 a_554_7194# a_1088_5248# 0.02662f
C38 a_54_7078# a_4048_8078# 0.12215f
C39 a_354_7078# a_7072_7078# 2.3399f
C40 a_54_7078# a_3290_8994# 0.03093f
C41 a_10466_376# a_14_332# 0.0329f
C42 VDD a_13076_7194# 0.07801f
C43 INN a_54_7078# 0.17585f
C44 a_3566_332# a_3010_376# 0.09068f
C45 a_54_7078# INP 0.52268f
C46 a_554_7194# a_2478_8974# 0.71827f
C47 a_7438_332# a_314_332# 0.47901f
C48 a_4230_332# a_4048_8078# 2.73423f
C49 a_4230_332# a_3290_8994# 0.02956f
C50 a_1088_4798# a_314_332# 0.02966f
C51 a_1088_4798# a_2278_376# 0.95232f
C52 a_14_332# a_314_332# 6.05286f
C53 a_54_7078# VDD 3.79052f
C54 a_2278_376# a_14_332# 0.02703f
C55 OUT a_54_7078# 0.84302f
C56 a_4712_8078# a_314_332# 0.4181f
C57 a_2278_376# a_4712_8078# 0.08627f
C58 a_2478_8974# a_4048_8078# 0.02977f
C59 OUT a_16506_4798# 0.01028f
C60 a_2478_8974# a_3290_8994# 0.25483f
C61 INN a_2478_8974# 0.1476f
C62 a_5518_376# VDD 0.591f
C63 a_514_376# a_314_332# 1.66609f
C64 a_1246_376# a_514_376# 0.02626f
C65 a_5518_376# OUT 0.66159f
C66 a_2278_376# a_514_376# 0.27522f
C67 a_4230_332# VDD 0.53439f
C68 OUT a_4230_332# 0.25522f
C69 a_3010_376# a_314_332# 0.0247f
C70 a_2278_376# a_3010_376# 0.05838f
C71 a_354_7078# a_54_7078# 8.77965f
C72 a_2478_8974# INP 5.47302f
C73 a_7438_332# a_14_332# 0.09052f
C74 a_2278_376# a_7072_7078# 0.04563f
C75 a_4712_8078# a_7438_332# 0.13167f
C76 a_1088_4798# a_14_332# 0.06227f
C77 a_54_7078# a_16112_7194# 0.05253f
C78 VDD a_2478_8974# 0.40104f
C79 a_1088_4798# a_4712_8078# 2.10802f
C80 OUT a_2478_8974# 2.15329f
C81 a_3566_332# a_54_7078# 0.23858f
C82 a_4712_8078# a_14_332# 0.06083f
C83 a_5518_376# a_354_7078# 0.03044f
C84 a_354_7078# a_4230_332# 2.38558f
C85 a_1366_7194# a_554_7194# 0.05253f
C86 a_514_376# a_14_332# 0.20977f
C87 a_7438_332# a_7072_7078# 0.09715f
C88 a_1088_4798# a_3010_376# 0.01678f
C89 a_13076_7194# a_314_332# 0.05253f
C90 a_3010_376# a_14_332# 0.02841f
C91 a_3566_332# a_4230_332# 0.4598f
C92 a_7072_7078# a_7272_7194# 0.06557f
C93 a_1088_4798# a_7072_7078# 0.06893f
C94 a_354_7078# a_2478_8974# 0.47312f
C95 a_4712_8078# a_7072_7078# 2.75495f
C96 a_3566_332# a_2478_8974# 1.34301f
C97 a_554_7194# a_3290_8994# 0.04548f
C98 a_514_376# a_3010_376# 0.04537f
C99 INN a_554_7194# 1.87377f
C100 a_54_7078# a_314_332# 0.86459f
C101 a_54_7078# a_2278_376# 0.04696f
C102 a_554_7194# INP 1.37569f
C103 VDD a_14188_7194# 0.07323f
C104 a_4048_8078# a_3290_8994# 0.27506f
C105 a_1366_7194# VDD 0.07139f
C106 a_4230_332# a_8716_7194# 0.05253f
C107 a_5518_376# a_314_332# 1.73704f
C108 a_5518_376# a_2278_376# 0.02908f
C109 INN a_3290_8994# 2.71535f
C110 a_554_7194# VDD 2.13051f
C111 OUT a_554_7194# 0.05122f
C112 a_4230_332# a_314_332# 0.2111f
C113 a_2278_376# a_4230_332# 0.7763f
C114 INN INP 0.21072f
C115 a_214_376# a_514_376# 0.02626f
C116 a_1088_4798# a_54_7078# 0.19286f
C117 a_54_7078# a_14_332# 0.31388f
C118 a_2478_8974# a_314_332# 0.97504f
C119 VDD a_4048_8078# 1.65358f
C120 a_2278_376# a_2478_8974# 0.21371f
C121 OUT a_4048_8078# 0.13053f
C122 a_54_7078# a_4712_8078# 1.54937f
C123 VDD a_3290_8994# 0.56911f
C124 OUT a_3290_8994# 0.05007f
C125 a_54_7078# a_1088_6148# 0.38982f
C126 INN VDD 0.59211f
C127 INN OUT 0.04353f
C128 a_5518_376# a_7438_332# 0.27373f
C129 a_354_7078# a_554_7194# 3.74076f
C130 a_4230_332# a_7438_332# 0.61447f
C131 a_1088_4798# a_1088_5248# 0.02812f
C132 a_5518_376# a_1088_4798# 0.39305f
C133 a_5518_376# a_14_332# 0.07931f
C134 a_54_7078# a_514_376# 0.17815f
C135 VDD INP 0.57544f
C136 a_1088_4798# a_4230_332# 2.12593f
C137 a_5518_376# a_4712_8078# 2.5284f
C138 a_4230_332# a_14_332# 0.12928f
C139 a_54_7078# a_3010_376# 0.08961f
C140 a_1088_5248# a_1088_6148# 0.01879f
C141 a_4230_332# a_4712_8078# 0.54136f
C142 a_354_7078# a_4048_8078# 3.4806f
C143 a_54_7078# a_7072_7078# 0.06917f
C144 a_2478_8974# a_7438_332# 0.04206f
C145 a_54_7078# a_16506_5698# 0.5965f
C146 a_354_7078# a_3290_8994# 0.02968f
C147 OUT VDD 2.55057f
C148 a_354_7078# INN 0.03207f
C149 a_1088_4798# a_2478_8974# 0.08115f
C150 a_2478_8974# a_14_332# 0.14681f
C151 a_16506_4798# a_16506_5698# 0.01879f
C152 a_3566_332# a_4048_8078# 0.80639f
C153 a_2478_8974# a_4712_8078# 0.0856f
C154 a_3566_332# a_3290_8994# 0.73318f
C155 a_354_7078# INP 0.0268f
C156 a_4230_332# a_3010_376# 0.66965f
C157 a_5518_376# a_7072_7078# 0.38121f
C158 a_4230_332# a_7072_7078# 0.07447f
C159 a_2478_8974# a_514_376# 0.10622f
C160 a_354_7078# VDD 5.02715f
C161 a_354_7078# OUT 0.89749f
C162 a_2478_8974# a_3010_376# 0.03263f
C163 a_2478_8974# a_7072_7078# 0.01367f
C164 VDD a_16112_7194# 0.07139f
C165 a_554_7194# a_2278_376# 0.6054f
C166 a_3566_332# VDD 0.51639f
C167 a_3566_332# OUT 0.05096f
C168 a_4048_8078# a_314_332# 0.02355f
C169 a_2278_376# a_4048_8078# 1.57323f
C170 a_3290_8994# a_314_332# 0.68112f
C171 a_6582_376# a_4712_8078# 0.02626f
C172 a_2278_376# a_3290_8994# 0.06351f
C173 a_54_7078# a_16506_4798# 0.5965f
C174 INN a_314_332# 0.022f
C175 INN a_2278_376# 0.06708f
C176 a_14188_7194# a_14_332# 0.05253f
C177 a_354_7078# a_3566_332# 0.02703f
C178 a_54_7078# a_1088_5248# 0.38589f
C179 a_5518_376# a_54_7078# 0.10593f
C180 a_1088_4798# a_554_7194# 0.05729f
C181 INP a_314_332# 0.01968f
C182 a_2278_376# INP 2.072f
C183 a_54_7078# a_4230_332# 0.43867f
C184 VDD a_8716_7194# 0.07433f
C185 a_554_7194# a_1088_6148# 0.02662f
C186 VDD a_314_332# 0.67809f
C187 a_2278_376# VDD 0.45837f
C188 OUT a_314_332# 0.19807f
C189 OUT a_2278_376# 2.56866f
C190 a_254_7194# a_554_7194# 0.05253f
C191 a_1088_4798# a_4048_8078# 0.06718f
C192 a_54_7078# a_2478_8974# 0.46858f
C193 a_4048_8078# a_14_332# 0.02684f
C194 a_1088_4798# a_3290_8994# 0.01897f
C195 a_5518_376# a_4230_332# 0.70725f
C196 a_3290_8994# a_14_332# 0.03031f
C197 a_4048_8078# a_4712_8078# 2.25741f
C198 a_1088_4798# INN 0.01664f
C199 a_554_7194# a_3010_376# 0.21503f
C200 INN a_14_332# 0.02748f
C201 OUT VSS 11.3485f
C202 INN VSS 1.44789f
C203 INP VSS 1.38533f
C204 VDD VSS 0.14069p
C205 a_12530_376# VSS 0.01198f
C206 a_11498_376# VSS 0.0134f
C207 a_10466_376# VSS 0.04308f
C208 a_7638_376# VSS 0.04308f
C209 a_6582_376# VSS 0.04423f
C210 a_1246_376# VSS 0.04308f
C211 a_514_376# VSS 1.79034f
C212 a_214_376# VSS 0.04686f
C213 a_7438_332# VSS 1.12811f
C214 a_16506_4798# VSS 0.51837f
C215 a_1088_5248# VSS 0.55006f
C216 a_16506_5698# VSS 0.50197f
C217 a_1088_6148# VSS 0.53965f
C218 a_14_332# VSS 6.36322f
C219 a_314_332# VSS 6.4687f
C220 a_4230_332# VSS 4.22674f
C221 a_5518_376# VSS 2.24648f
C222 a_2278_376# VSS 3.54477f
C223 a_3566_332# VSS 2.80444f
C224 a_3010_376# VSS 1.24685f
C225 a_3290_8994# VSS 1.46475f
C226 a_2478_8974# VSS 5.66229f
C227 a_554_7194# VSS 3.56114f
C228 a_1088_4798# VSS 6.38123f
C229 a_7072_7078# VSS 1.96928f
C230 a_4712_8078# VSS 3.35744f
C231 a_4048_8078# VSS 2.69588f
C232 a_354_7078# VSS 13.5286f
C233 a_54_7078# VSS 11.2111f
.ends
