* Nodos de bulk atados: 1 de pozo n -> VDD, 1 de sustrato -> VSS.
*   magic no extrae los taps de este layout y los dejaba flotando;
*   la conexion si existe (el LVS de KLayout da 'match uniquely').
*   Quien detecta un tap que falte de verdad es el LVS, no esto.
* NGSPICE file created from DECODER_MAX.ext - technology: gf180mcuD

.subckt DECODER_MAX VSS VDD Z YZ XZ Y XY X
X0 VDD YZ a_14_332# VDD pfet_06v0 ad=1.32p pd=6.88u as=0.99p ps=3.66u w=3u l=1u
X1 VDD a_1690_376# a_2510_332# VDD pfet_06v0 ad=1.32p pd=6.88u as=0.99p ps=3.66u w=3u l=1u
X2 a_3442_376# a_1690_376# a_2510_332# VSS nfet_06v0 ad=0.25p pd=1.5u as=0.44p ps=2.88u w=1u l=1u
X3 a_2510_332# XY VDD VDD pfet_06v0 ad=0.99p pd=3.66u as=1.32p ps=6.88u w=3u l=1u
X4 VSS XY a_3442_376# VSS nfet_06v0 ad=0.44p pd=2.88u as=0.25p ps=1.5u w=1u l=1u
X5 Z a_14_332# VDD VDD pfet_06v0 ad=1.32p pd=6.88u as=1.32p ps=6.88u w=3u l=1u
X6 a_5026_1920# XZ X VDD pfet_06v0 ad=0.75p pd=3.5u as=1.32p ps=6.88u w=3u l=1u
X7 VSS YZ a_1690_376# VSS nfet_06v0 ad=0.44p pd=2.88u as=0.44p ps=2.88u w=1u l=1u
X8 a_14_332# XZ VDD VDD pfet_06v0 ad=0.99p pd=3.66u as=1.32p ps=6.88u w=3u l=1u
X9 VSS a_14_332# Z VSS nfet_06v0 ad=0.44p pd=2.88u as=0.44p ps=2.88u w=1u l=1u
X10 VSS XY X VSS nfet_06v0 ad=0.44p pd=2.88u as=0.33p ps=1.66u w=1u l=1u
X11 a_1690_376# YZ VDD VDD pfet_06v0 ad=1.32p pd=6.88u as=1.32p ps=6.88u w=3u l=1u
X12 X XZ VSS VSS nfet_06v0 ad=0.33p pd=1.66u as=0.44p ps=2.88u w=1u l=1u
X13 a_946_376# YZ a_14_332# VSS nfet_06v0 ad=0.25p pd=1.5u as=0.44p ps=2.88u w=1u l=1u
X14 VSS a_2510_332# Y VSS nfet_06v0 ad=0.44p pd=2.88u as=0.44p ps=2.88u w=1u l=1u
X15 Y a_2510_332# VDD VDD pfet_06v0 ad=1.32p pd=6.88u as=1.32p ps=6.88u w=3u l=1u
X16 VSS XZ a_946_376# VSS nfet_06v0 ad=0.44p pd=2.88u as=0.25p ps=1.5u w=1u l=1u
X17 VDD XY a_5026_1920# VDD pfet_06v0 ad=1.32p pd=6.88u as=0.75p ps=3.5u w=3u l=1u
C0 Y VDD 0.23848f
C1 VDD Z 0.20349f
C2 VDD Z 0.14888f
C3 a_14_332# Z 1.11572f
C4 Y a_1690_376# 0.64822f
C5 XZ X 0.57855f
C6 Y YZ 0.0824f
C7 XY VDD 0.30147f
C8 XY VDD 0.63295f
C9 YZ Z 0.03366f
C10 Y a_2510_332# 0.65499f
C11 X a_5026_1920# 0.0251f
C12 Y VSS 0.08789f
C13 XY a_1690_376# 0.48608f
C14 Z VSS 0.1034f
C15 VDD VDD 2.74323f
C16 a_14_332# VDD 0.41584f
C17 XY a_2510_332# 0.4088f
C18 Y XZ 0.17601f
C19 a_14_332# VDD 0.46186f
C20 XY VSS 0.21155f
C21 XZ Z 0.0411f
C22 VDD a_1690_376# 0.34023f
C23 YZ VDD 0.25138f
C24 VDD a_1690_376# 0.48426f
C25 YZ VDD 0.62406f
C26 a_14_332# YZ 0.57795f
C27 XY XZ 0.58497f
C28 XY X 0.94084f
C29 VDD a_2510_332# 0.3978f
C30 a_3442_376# VSS 0.01408f
C31 YZ a_1690_376# 0.74716f
C32 VDD a_2510_332# 0.4243f
C33 VDD VSS 0.01999f
C34 a_14_332# VSS 0.1458f
C35 a_2510_332# a_1690_376# 0.68701f
C36 YZ a_2510_332# 0.01547f
C37 a_1690_376# VSS 0.14801f
C38 XZ VDD 0.24318f
C39 X VDD 0.16848f
C40 YZ VSS 0.22368f
C41 XZ VDD 0.62872f
C42 a_14_332# XZ 0.52478f
C43 X VDD 0.22246f
C44 XY Y 0.05936f
C45 VDD a_5026_1920# 0.03287f
C46 a_2510_332# VSS 0.18717f
C47 XZ a_1690_376# 1.10479f
C48 X a_1690_376# 0.09535f
C49 XZ YZ 0.83416f
C50 VSS a_946_376# 0.01198f
C51 XZ a_2510_332# 0.70747f
C52 Y VDD 0.24777f
C53 XZ VSS 0.31023f
C54 X VSS 0.12602f
C55 VSS VSS 5.50622f
C56 X VSS 0.44775f
C57 Y VSS 0.43116f
C58 Z VSS 0.5165f
C59 VDD VSS 3.37873f
C60 XY VSS 1.41222f
C61 YZ VSS 1.39371f
C62 XZ VSS 1.63477f
C63 a_1690_376# VSS 0.97518f
C64 a_2510_332# VSS 1.11175f
C65 a_14_332# VSS 1.07814f
C66 VDD VSS 22.4533f
.ends
