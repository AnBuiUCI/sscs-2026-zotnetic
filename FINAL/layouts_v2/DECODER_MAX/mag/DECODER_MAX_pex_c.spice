* Nodos de bulk atados: 1 de pozo n -> VDD, 1 de sustrato -> VSS.
*   magic no extrae los taps de este layout y los dejaba flotando;
*   la conexion si existe (el LVS de KLayout da 'match uniquely').
*   Quien detecta un tap que falte de verdad es el LVS, no esto.
* NGSPICE file created from DECODER_MAX.ext - technology: gf180mcuD

.subckt DECODER_MAX VSS VDD Z YZ XZ Y XY X
X0 a_3442_376# a_1690_376# a_2510_332# VSS nfet_06v0 ad=0.25p pd=1.5u as=0.44p ps=2.88u w=1u l=1u
X1 VSS XY a_3442_376# VSS nfet_06v0 ad=0.44p pd=2.88u as=0.25p ps=1.5u w=1u l=1u
X2 Z a_14_332# VDD VDD pfet_06v0 ad=1.32p pd=6.88u as=1.32p ps=6.88u w=3u l=1u
X3 VSS YZ a_1690_376# VSS nfet_06v0 ad=0.44p pd=2.88u as=0.44p ps=2.88u w=1u l=1u
X4 a_1690_376# YZ VDD VDD pfet_06v0 ad=1.32p pd=6.88u as=1.32p ps=6.88u w=3u l=1u
X5 a_2510_332# XY VDD VDD pfet_06v0 ad=0.99p pd=3.66u as=1.32p ps=6.88u w=3u l=1u
X6 VSS XY X VSS nfet_06v0 ad=0.44p pd=2.88u as=0.33p ps=1.66u w=1u l=1u
X7 X XZ VSS VSS nfet_06v0 ad=0.33p pd=1.66u as=0.44p ps=2.88u w=1u l=1u
X8 VDD XY a_5002_1920# VDD pfet_06v0 ad=1.32p pd=6.88u as=0.75p ps=3.5u w=3u l=1u
X9 VSS a_14_332# Z VSS nfet_06v0 ad=0.44p pd=2.88u as=0.44p ps=2.88u w=1u l=1u
X10 VDD a_1690_376# a_2510_332# VDD pfet_06v0 ad=1.32p pd=6.88u as=0.99p ps=3.66u w=3u l=1u
X11 Y a_2510_332# VDD VDD pfet_06v0 ad=1.32p pd=6.88u as=1.32p ps=6.88u w=3u l=1u
X12 a_946_376# YZ a_14_332# VSS nfet_06v0 ad=0.25p pd=1.5u as=0.44p ps=2.88u w=1u l=1u
X13 VSS a_2510_332# Y VSS nfet_06v0 ad=0.44p pd=2.88u as=0.44p ps=2.88u w=1u l=1u
X14 VDD YZ a_14_332# VDD pfet_06v0 ad=1.32p pd=6.88u as=0.99p ps=3.66u w=3u l=1u
X15 VSS XZ a_946_376# VSS nfet_06v0 ad=0.44p pd=2.88u as=0.25p ps=1.5u w=1u l=1u
X16 a_5002_1920# XZ X VDD pfet_06v0 ad=0.75p pd=3.5u as=1.32p ps=6.88u w=3u l=1u
X17 a_14_332# XZ VDD VDD pfet_06v0 ad=0.99p pd=3.66u as=1.32p ps=6.88u w=3u l=1u
C0 a_2510_332# a_1690_376# 0.67967f
C1 YZ a_2510_332# 0.01541f
C2 XZ VDD 0.26096f
C3 a_1690_376# VSS 0.14787f
C4 X VDD 0.16024f
C5 YZ VSS 0.22627f
C6 XZ VDD 0.63811f
C7 a_14_332# XZ 0.53785f
C8 X VDD 0.21827f
C9 XY Y 0.05872f
C10 VDD a_5002_1920# 0.03135f
C11 a_2510_332# VSS 0.18679f
C12 XZ a_1690_376# 1.10054f
C13 X a_1690_376# 0.09413f
C14 XZ YZ 0.84627f
C15 VSS a_946_376# 0.01198f
C16 XZ a_2510_332# 0.77013f
C17 Y VDD 0.22452f
C18 XZ VSS 0.31705f
C19 X VSS 0.11559f
C20 Y VDD 0.22491f
C21 VDD Z 0.20499f
C22 VDD Z 0.14761f
C23 a_14_332# Z 1.11676f
C24 Y a_1690_376# 0.60954f
C25 Y YZ 0.08f
C26 XZ X 0.56488f
C27 XY VDD 0.30258f
C28 XY VDD 0.63338f
C29 YZ Z 0.03584f
C30 Y a_2510_332# 0.63543f
C31 X a_5002_1920# 0.02264f
C32 Y VSS 0.08797f
C33 XY a_1690_376# 0.46568f
C34 Z VSS 0.10403f
C35 VDD VDD 2.73245f
C36 a_14_332# VDD 0.41666f
C37 XY a_2510_332# 0.41022f
C38 Y XZ 0.08956f
C39 a_14_332# VDD 0.46036f
C40 XY VSS 0.21382f
C41 XZ Z 0.04204f
C42 VDD a_1690_376# 0.34012f
C43 YZ VDD 0.25179f
C44 VDD a_1690_376# 0.48271f
C45 YZ VDD 0.6243f
C46 a_14_332# YZ 0.56945f
C47 XY XZ 0.61339f
C48 XY X 0.96287f
C49 VDD a_2510_332# 0.40003f
C50 a_3442_376# VSS 0.01408f
C51 YZ a_1690_376# 0.74931f
C52 VDD a_2510_332# 0.42417f
C53 VDD VSS 0.02041f
C54 a_14_332# VSS 0.14578f
C55 VSS VSS 5.49058f
C56 X VSS 0.43239f
C57 Y VSS 0.42529f
C58 Z VSS 0.52326f
C59 VDD VSS 3.38129f
C60 XY VSS 1.40853f
C61 YZ VSS 1.39862f
C62 XZ VSS 1.66569f
C63 a_1690_376# VSS 0.97366f
C64 a_2510_332# VSS 1.10456f
C65 a_14_332# VSS 1.074f
C66 VDD VSS 22.3618f
.ends
