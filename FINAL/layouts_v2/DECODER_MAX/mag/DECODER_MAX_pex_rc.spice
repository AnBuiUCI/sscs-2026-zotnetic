* Nodos de bulk atados: 10 de pozo n -> VDD, 11 de sustrato -> VSS.
*   magic no extrae los taps de este layout y los dejaba flotando;
*   la conexion si existe (el LVS de KLayout da 'match uniquely').
*   Quien detecta un tap que falte de verdad es el LVS, no esto.
* NGSPICE file created from DECODER_MAX.ext - technology: gf180mcuD

.subckt DECODER_MAX VSS VDD Z YZ XZ Y XY X
X0 VDD.t6 YZ.t3 a_14_332.t1 VDD pfet_06v0 ad=1.32p pd=6.88u as=0.99p ps=3.66u w=3u l=1u
X1 VDD.t5 a_1690_376.t3 a_2510_332.t0 VDD pfet_06v0 ad=1.32p pd=6.88u as=0.99p ps=3.66u w=3u l=1u
X2 a_3442_376.t1 a_1690_376.t2 a_2510_332.t1 VSS nfet_06v0 ad=0.25p pd=1.5u as=0.44p ps=2.88u w=1u l=1u
X3 a_2510_332.t2 XY.t3 VDD.t0 VDD pfet_06v0 ad=0.99p pd=3.66u as=1.32p ps=6.88u w=3u l=1u
X4 VSS.t1 XY.t1 a_3442_376.t0 VSS nfet_06v0 ad=0.44p pd=2.88u as=0.25p ps=1.5u w=1u l=1u
X5 Z.t1 a_14_332.t4 VDD.t2 VDD pfet_06v0 ad=1.32p pd=6.88u as=1.32p ps=6.88u w=3u l=1u
X6 a_5026_1920.t0 XZ.t2 X.t1 VDD pfet_06v0 ad=0.75p pd=3.5u as=1.32p ps=6.88u w=3u l=1u
X7 VSS.t2 YZ.t0 a_1690_376.t1 VSS nfet_06v0 ad=0.44p pd=2.88u as=0.44p ps=2.88u w=1u l=1u
X8 a_14_332.t2 XZ.t3 VDD.t1 VDD pfet_06v0 ad=0.99p pd=3.66u as=1.32p ps=6.88u w=3u l=1u
X9 VSS.t3 a_14_332.t3 Z.t0 VSS nfet_06v0 ad=0.44p pd=2.88u as=0.44p ps=2.88u w=1u l=1u
X10 VSS.t4 XY.t0 X.t0 VSS nfet_06v0 ad=0.44p pd=2.88u as=0.33p ps=1.66u w=1u l=1u
X11 a_1690_376.t0 YZ.t2 VDD.t7 VDD pfet_06v0 ad=1.32p pd=6.88u as=1.32p ps=6.88u w=3u l=1u
X12 X.t2 XZ.t0 VSS.t6 VSS nfet_06v0 ad=0.33p pd=1.66u as=0.44p ps=2.88u w=1u l=1u
X13 a_946_376.t0 YZ.t1 a_14_332.t0 VSS nfet_06v0 ad=0.25p pd=1.5u as=0.44p ps=2.88u w=1u l=1u
X14 VSS.t0 a_2510_332.t3 Y.t0 VSS nfet_06v0 ad=0.44p pd=2.88u as=0.44p ps=2.88u w=1u l=1u
X15 Y.t1 a_2510_332.t4 VDD.t4 VDD pfet_06v0 ad=1.32p pd=6.88u as=1.32p ps=6.88u w=3u l=1u
X16 VSS.t5 XZ.t1 a_946_376.t1 VSS nfet_06v0 ad=0.44p pd=2.88u as=0.25p ps=1.5u w=1u l=1u
X17 VDD.t3 XY.t2 a_5026_1920.t1 VDD pfet_06v0 ad=1.32p pd=6.88u as=0.75p ps=3.5u w=3u l=1u
R0 VSS.n14 VSS.n10 9.0005
R1 VSS.n16 VSS.n15 9.0005
R2 VSS.n17 VSS.n1 9.0005
R3 VSS.n19 VSS.n18 9.0005
R4 VSS.n9 VSS.n0 9.0005
R5 VSS.n8 VSS.n7 9.0005
R6 VSS.n5 VSS.n2 9.0005
R7 VSS.n12 VSS.t3 5.45448
R8 VSS.n3 VSS.t4 5.3776
R9 VSS.n4 VSS.t6 5.28916
R10 VSS.n6 VSS.t1 5.28916
R11 VSS.n20 VSS.t0 5.28916
R12 VSS.n11 VSS.t2 5.28916
R13 VSS.n13 VSS.t5 5.28916
R14 VSS.n12 VSS.n10 2.54215
R15 VSS.n3 VSS.n2 2.2379
R16 VSS.n13 VSS.n12 0.342317
R17 VSS.n4 VSS.n3 0.242313
R18 VSS.n8 VSS.n2 0.2005
R19 VSS.n9 VSS.n8 0.2005
R20 VSS.n18 VSS.n9 0.2005
R21 VSS.n18 VSS.n17 0.2005
R22 VSS.n17 VSS.n16 0.2005
R23 VSS.n16 VSS.n10 0.2005
R24 VSS.n7 VSS.n0 0.2005
R25 VSS.n19 VSS.n1 0.2005
R26 VSS.n15 VSS.n14 0.2005
R27 VSS.n5 VSS.n4 0.161
R28 VSS.n7 VSS.n6 0.152
R29 VSS.n11 VSS.n1 0.131
R30 VSS.n14 VSS.n13 0.097
R31 VSS VSS.n20 0.092
R32 VSS VSS.n0 0.0735
R33 VSS.n15 VSS.n11 0.07
R34 VSS.n6 VSS.n5 0.049
R35 VSS.n20 VSS.n19 0.036
R36 X X.n0 26.3304
R37 X X.t1 2.59733
R38 X.n0 X.t0 2.0795
R39 X.n0 X.t2 2.0795
R40 Y Y.t0 16.3601
R41 Y Y.t1 2.85559
R42 Z Z.t0 15.2356
R43 Z Z.t1 3.63037
R44 VDD.n15 VDD.n14 9.0005
R45 VDD.n17 VDD.n10 9.0005
R46 VDD.n19 VDD.n18 9.0005
R47 VDD.n20 VDD.n1 9.0005
R48 VDD.n22 VDD.n21 9.0005
R49 VDD.n9 VDD.n0 9.0005
R50 VDD.n8 VDD.n7 9.0005
R51 VDD.n5 VDD.n2 9.0005
R52 VDD.n14 VDD.n13 3.23511
R53 VDD.n3 VDD.t3 2.41967
R54 VDD.n13 VDD.t2 2.37978
R55 VDD.n12 VDD.t1 2.20347
R56 VDD.n16 VDD.t6 2.20347
R57 VDD.n11 VDD.t7 2.20347
R58 VDD.n23 VDD.t4 2.20347
R59 VDD.n6 VDD.t0 2.20347
R60 VDD.n4 VDD.t5 2.20347
R61 VDD.n3 VDD.n2 2.13218
R62 VDD.n4 VDD.n3 0.321039
R63 VDD.n13 VDD.n12 0.23719
R64 VDD.n8 VDD.n2 0.2005
R65 VDD.n9 VDD.n8 0.2005
R66 VDD.n21 VDD.n9 0.2005
R67 VDD.n21 VDD.n20 0.2005
R68 VDD.n20 VDD.n19 0.2005
R69 VDD.n19 VDD.n10 0.2005
R70 VDD.n14 VDD.n10 0.2005
R71 VDD.n7 VDD.n0 0.2005
R72 VDD.n22 VDD.n1 0.2005
R73 VDD.n18 VDD.n17 0.2005
R74 VDD.n16 VDD.n15 0.192
R75 VDD.n5 VDD.n4 0.188
R76 VDD.n11 VDD.n1 0.172
R77 VDD.n6 VDD.n5 0.148
R78 VDD.n15 VDD.n12 0.144
R79 VDD VDD.n23 0.093
R80 VDD VDD.n0 0.0735
R81 VDD.n7 VDD.n6 0.053
R82 VDD.n23 VDD.n22 0.035
R83 VDD.n18 VDD.n11 0.029
R84 VDD.n17 VDD.n16 0.009
R85 XY.n0 XY.t2 23.9597
R86 XY XY.t3 18.6947
R87 XY.n1 XY.t1 16.6041
R88 XY.n0 XY.t0 16.4113
R89 XY XY.n1 4.5005
R90 XY.n1 XY.n0 1.28908
R91 YZ.n0 YZ.t2 24.3488
R92 YZ YZ.t3 19.4695
R93 YZ.n1 YZ.t1 16.3693
R94 YZ.n0 YZ.t0 15.6365
R95 YZ YZ.n1 4.5005
R96 YZ.n1 YZ.n0 0.719853
R97 XZ.n0 XZ.t2 24.5277
R98 XZ XZ.t3 19.2113
R99 XZ.n1 XZ.t1 15.8947
R100 XZ.n0 XZ.t0 15.8947
R101 XZ XZ.n1 4.71907
R102 XZ.n1 XZ.n0 4.69007
R103 a_3442_376.t0 a_3442_376.t1 3.1505
R104 a_946_376.t0 a_946_376.t1 3.1505
R105 a_5026_1920.t0 a_5026_1920.t1 1.16717
R106 a_1690_376.t1 a_1690_376.n0 11.6196
R107 a_1690_376.n0 a_1690_376.n1 1.63818
R108 a_1690_376.n1 a_1690_376.t3 24.6616
R109 a_1690_376.n1 a_1690_376.t2 16.153
R110 a_1690_376.n0 a_1690_376.t0 7.61385
R111 a_2510_332.t1 a_2510_332.n2 10.1806
R112 a_2510_332.n2 a_2510_332.n1 17.6445
R113 a_2510_332.n1 a_2510_332.t2 0.7705
R114 a_2510_332.n1 a_2510_332.t0 0.7705
R115 a_2510_332.n2 a_2510_332.n0 0.333179
R116 a_2510_332.n0 a_2510_332.t3 16.1443
R117 a_2510_332.n0 a_2510_332.t4 23.9695
R118 a_14_332.t0 a_14_332.n2 10.6971
R119 a_14_332.n2 a_14_332.n1 16.6522
R120 a_14_332.n1 a_14_332.t2 0.7705
R121 a_14_332.n1 a_14_332.t1 0.7705
R122 a_14_332.n2 a_14_332.n0 5.39086
R123 a_14_332.n0 a_14_332.t3 11.7754
R124 a_14_332.n0 a_14_332.t4 18.9954
R125 VDD VDD 319.183
R126 VDD VDD 657.234
R127 VDD VDD 261.007
R128 VDD VDD 638.365
R129 VDD VDD 638.365
R130 VDD VDD 657.234
R131 VDD VDD 261.007
R132 VDD VDD 638.365
R133 VDD VDD 235.85
R134 VSS VSS 732.452
R135 VSS VSS 1464.9
R136 VSS VSS 600.37
R137 VSS VSS 1464.9
R138 VSS VSS 1464.9
R139 VSS VSS 1464.9
R140 VSS VSS 600.37
R141 VSS VSS 1512.93
R142 VSS VSS 664.409
C0 XZ Y 0.17601f
C1 VSS YZ 0.22368f
C2 VDD YZ 0.25138f
C3 Z YZ 0.03366f
C4 XZ YZ 0.83416f
C5 VSS XY 0.21155f
C6 VDD XY 0.30147f
C7 XY XZ 0.58497f
C8 X XY 0.94084f
C9 Y YZ 0.0824f
C10 XY Y 0.05936f
C11 VSS Z 0.1034f
C12 VSS XZ 0.31023f
C13 Z VDD 0.20349f
C14 VSS X 0.12602f
C15 VDD XZ 0.24318f
C16 Z XZ 0.0411f
C17 X VDD 0.16848f
C18 X XZ 0.57855f
C19 VSS Y 0.08789f
C20 VDD Y 0.24777f
C21 VSS 0 5.52383f
C22 X 0 1.44436f
C23 Y 0 1.46258f
C24 Z 0 1.1478f
C25 VDD 0 3.43385f
C26 XY 0 1.76517f
C27 YZ 0 1.81769f
C28 XZ 0 2.14052f
C29 VDD 0 0.22871f
C30 VDD 0 0.69965f
C31 VDD 0 0.65796f
C32 VDD 0 0.64444f
C33 VDD 0 0.91484f
C34 VDD 0 0.92836f
C35 VDD 0 0.65796f
C36 VDD 0 0.64444f
C37 VDD 0 0.62642f
C38 VDD 0 0.62642f
C39 a_14_332.t0 0 0.1773f
C40 a_14_332.t4 0 0.5686f
C41 a_14_332.t3 0 0.23747f
C42 a_14_332.n0 0 0.74337f
C43 a_14_332.n1 0 0.65863f
C44 a_14_332.t2 0 0.10928f
C45 a_14_332.t1 0 0.10928f
C46 a_14_332.n2 0 0.65308f
C47 a_2510_332.t1 0 0.15148f
C48 a_2510_332.t4 0 0.69767f
C49 a_2510_332.n0 0 0.7483f
C50 a_2510_332.t3 0 0.31686f
C51 a_2510_332.n1 0 0.72968f
C52 a_2510_332.t2 0 0.11436f
C53 a_2510_332.t0 0 0.11436f
C54 a_2510_332.n2 0 0.62911f
C55 a_1690_376.t1 0 0.27792f
C56 a_1690_376.t0 0 0.85175f
C57 a_1690_376.n0 0 0.8488f
C58 a_1690_376.t2 0 0.45578f
C59 a_1690_376.n1 0 1.36176f
C60 a_1690_376.t3 0 0.95476f
C61 a_5026_1920.t0 0 0.02971f
C62 a_5026_1920.t1 0 0.02971f
C63 a_946_376.t0 0 0.01039f
C64 a_946_376.t1 0 0.01039f
C65 a_3442_376.t0 0 0.0119f
C66 a_3442_376.t1 0 0.0119f
C67 XZ.t3 0 0.65619f
C68 XZ.t2 0 0.76918f
C69 XZ.t0 0 0.35182f
C70 XZ.n0 0 1.92192f
C71 XZ.t1 0 0.35182f
C72 XZ.n1 0 1.18008f
C73 YZ.t3 0 0.52514f
C74 YZ.t2 0 0.61095f
C75 YZ.t0 0 0.26759f
C76 YZ.n0 0 0.79047f
C77 YZ.t1 0 0.27853f
C78 YZ.n1 0 0.49555f
C79 XY.t3 0 0.51787f
C80 XY.t2 0 0.59827f
C81 XY.t0 0 0.30596f
C82 XY.n0 0 1.00329f
C83 XY.t1 0 0.30896f
C84 XY.n1 0 0.53871f
C85 VDD.n0 0 0.09684f
C86 VDD.t4 0 0.07789f
C87 VDD.n1 0 0.12813f
C88 VDD.n2 0 0.70645f
C89 VDD.t0 0 0.07789f
C90 VDD.t5 0 0.07789f
C91 VDD.t3 0 0.12124f
C92 VDD.n3 0 0.60681f
C93 VDD.n4 0 0.26469f
C94 VDD.n5 0 0.11748f
C95 VDD.n6 0 0.10642f
C96 VDD.n7 0 0.09001f
C97 VDD.n8 0 0.13913f
C98 VDD.n9 0 0.13913f
C99 VDD.n10 0 0.13913f
C100 VDD.t7 0 0.07789f
C101 VDD.n11 0 0.10642f
C102 VDD.t6 0 0.07789f
C103 VDD.t1 0 0.07789f
C104 VDD.n12 0 0.20132f
C105 VDD.t2 0 0.09402f
C106 VDD.n13 0 0.30195f
C107 VDD.n14 0 0.50544f
C108 VDD.n15 0 0.11748f
C109 VDD.n16 0 0.10642f
C110 VDD.n17 0 0.07536f
C111 VDD.n18 0 0.08202f
C112 VDD.n19 0 0.13913f
C113 VDD.n20 0 0.13913f
C114 VDD.n21 0 0.13913f
C115 VDD.n22 0 0.08197f
C116 VDD.n23 0 0.08211f
C117 Z.t1 0 0.72666f
C118 Z.t0 0 0.28829f
C119 Y.t1 0 0.61724f
C120 Y.t0 0 0.54785f
C121 X.t1 0 0.54916f
C122 X.t0 0 0.05597f
C123 X.t2 0 0.05597f
C124 X.n0 0 0.51073f
C125 VSS.n0 0 0.03113f
C126 VSS.n1 0 0.03729f
C127 VSS.n2 0 0.23445f
C128 VSS.t4 0 0.01234f
C129 VSS.n3 0 0.22599f
C130 VSS.n4 0 0.06721f
C131 VSS.n5 0 0.02428f
C132 VSS.n6 0 0.03699f
C133 VSS.n7 0 0.03954f
C134 VSS.n8 0 0.04473f
C135 VSS.n9 0 0.04473f
C136 VSS.n10 0 0.19509f
C137 VSS.n11 0 0.03699f
C138 VSS.t3 0 0.01267f
C139 VSS.n12 0 0.15841f
C140 VSS.n13 0 0.07367f
C141 VSS.n14 0 0.03365f
C142 VSS.n15 0 0.03076f
C143 VSS.n16 0 0.04473f
C144 VSS.n17 0 0.04473f
C145 VSS.n18 0 0.04473f
C146 VSS.n19 0 0.02712f
C147 VSS.n20 0 0.02918f
.ends
