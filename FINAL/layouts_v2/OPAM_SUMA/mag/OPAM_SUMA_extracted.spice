* Nodos de bulk atados: 0 de pozo n -> VDD, 1 de sustrato -> VSS.
*   magic no extrae los taps de este layout y los dejaba flotando;
*   la conexion si existe (el LVS de KLayout da 'match uniquely').
*   Quien detecta un tap que falte de verdad es el LVS, no esto.
* NGSPICE file created from OPAM_SUMA.ext - technology: gf180mcuD

.subckt OPAM_SUMA VSS VDD OUT B2
X0 a_7382_332# a_11298_15666# a_8250_14582# VDD pfet_06v0 ad=1.76p pd=8.88u as=1.76p ps=8.88u w=4u l=1u
X1 a_14578_14582# a_54_14466# VDD VDD pfet_06v0 ad=2.5p pd=10.5u as=4.4p ps=20.88u w=10u l=1u
X2 OUT a_2028_12186# VDD VDD pfet_06v0 ad=0.44p pd=2.88u as=0.44p ps=2.88u w=1u l=1u
X3 a_2848_6666# a_7382_332# VSS VSS nfet_06v0 ad=0.825p pd=3.16u as=1.1p ps=5.88u w=2.5u l=1u
X4 a_2848_6666# a_14088_10806# VSS ppolyf_u_1k r_width=1u r_length=55.56u
X5 a_4342_376# a_14_332# a_4042_376# VSS nfet_06v0 ad=2.2p pd=10.88u as=1.25p ps=5.5u w=5u l=1u
X6 a_8250_14582# a_354_14466# a_6838_376# VDD pfet_06v0 ad=4.4p pd=20.88u as=4.4p ps=20.88u w=10u l=1u
X7 a_2848_9876# a_14088_9426# VSS ppolyf_u_1k r_width=1u r_length=55.56u
X8 a_9522_332# a_9522_332# a_12030_332# VSS nfet_06v0 ad=2.2p pd=10.88u as=1.65p ps=5.66u w=5u l=1u
X9 a_2848_6666# OUT cap_mim_2f0_m4m5_noshield c_width=25u c_length=8u
X10 a_1366_14582# a_54_14466# VDD VDD pfet_06v0 ad=2.5p pd=10.5u as=4.4p ps=20.88u w=10u l=1u
X11 a_2848_6666# a_14088_6666# VSS ppolyf_u_1k r_width=1u r_length=55.56u
X12 a_2028_13536# a_17446_13086# VSS ppolyf_u_1k r_width=1u r_length=76.45u
X13 a_2028_12636# a_17446_13086# VSS ppolyf_u_1k r_width=1u r_length=76.45u
X14 a_2848_7116# a_14088_6666# VSS ppolyf_u_1k r_width=1u r_length=55.56u
X15 a_54_14466# a_354_14466# a_1978_376# VSS nfet_06v0 ad=0.44p pd=2.88u as=0.25p ps=1.5u w=1u l=1u
X16 a_6106_376# a_2848_6666# a_4342_376# VSS nfet_06v0 ad=3.3p pd=15.88u as=3.3p ps=15.88u w=7.5u l=1u
X17 a_8250_14582# a_9522_332# a_7382_332# VSS nfet_06v0 ad=0.88p pd=4.88u as=0.88p ps=4.88u w=2u l=1u
X18 a_3290_14582# a_54_14466# VDD VDD pfet_06v0 ad=2.5p pd=10.5u as=4.4p ps=20.88u w=10u l=1u
X19 a_4042_376# a_746_332# VSS VSS nfet_06v0 ad=1.25p pd=5.5u as=2.2p ps=10.88u w=5u l=1u
X20 VSS B2 VSS VSS nfet_06v0 ad=0.88p pd=4.88u as=22p ps=0.11672m w=2u l=2u
X21 a_2848_6666# a_2848_6666# a_4702_14582# VDD pfet_06v0 ad=0.242p pd=1.98u as=0.242p ps=1.98u w=0.55u l=1u
X22 a_7438_16482# a_2848_6666# a_4702_14582# VDD pfet_06v0 ad=0.22p pd=1.88u as=0.22p ps=1.88u w=0.5u l=1u
X23 a_12934_14466# a_354_14466# a_13134_14582# VDD pfet_06v0 ad=3.3p pd=10.66u as=2.5p ps=10.5u w=10u l=1u
X24 a_1978_376# a_354_14466# VSS VSS nfet_06v0 ad=0.25p pd=1.5u as=0.44p ps=2.88u w=1u l=1u
X25 a_12230_376# a_12030_332# VSS VSS nfet_06v0 ad=1.25p pd=5.5u as=2.2p ps=10.88u w=5u l=1u
X26 a_354_14466# a_354_14466# VDD VDD pfet_06v0 ad=0.88p pd=4.88u as=0.88p ps=4.88u w=2u l=1u
X27 a_6106_376# a_8250_14582# VDD VDD pfet_06v0 ad=2.2p pd=10.88u as=2.2p ps=10.88u w=5u l=1u
X28 OUT a_2028_12186# VDD VDD pfet_06v0 ad=0.44p pd=2.88u as=0.44p ps=2.88u w=1u l=1u
X29 a_2848_11256# B2 VSS ppolyf_u_1k r_width=1u r_length=55.56u
X30 a_2848_11256# a_14088_10806# VSS ppolyf_u_1k r_width=1u r_length=55.56u
X31 OUT a_8990_376# VSS VSS nfet_06v0 ad=0.44p pd=2.88u as=0.44p ps=2.88u w=1u l=1u
X32 a_4702_14582# a_354_14466# a_4402_14582# VDD pfet_06v0 ad=4.4p pd=20.88u as=2.5p ps=10.5u w=10u l=1u
X33 OUT a_2028_12186# VDD VDD pfet_06v0 ad=0.44p pd=2.88u as=0.44p ps=2.88u w=1u l=1u
X34 VSS B2 VSS VSS nfet_06v0 ad=0.88p pd=4.88u as=0 ps=0 w=2u l=2u
X35 a_4702_14582# a_354_14466# a_5514_14582# VDD pfet_06v0 ad=4.4p pd=20.88u as=2.5p ps=10.5u w=10u l=1u
X36 a_2028_13536# OUT VSS ppolyf_u_1k r_width=1u r_length=76.45u
X37 a_2028_12186# a_9522_332# a_8990_376# VSS nfet_06v0 ad=0.88p pd=4.88u as=0.88p ps=4.88u w=2u l=1u
X38 a_12030_332# a_14_332# a_12230_376# VSS nfet_06v0 ad=1.65p pd=5.66u as=1.25p ps=5.5u w=5u l=1u
X39 OUT a_6106_376# cap_mim_2f0_m4m5_noshield c_width=25u c_length=8u
X40 a_8990_376# a_11298_15666# a_2028_12186# VDD pfet_06v0 ad=1.76p pd=8.88u as=1.76p ps=8.88u w=4u l=1u
X41 a_2848_7116# B2 VSS ppolyf_u_1k r_width=1u r_length=55.56u
X42 a_4342_376# a_14_332# a_5074_376# VSS nfet_06v0 ad=2.2p pd=10.88u as=1.25p ps=5.5u w=5u l=1u
X43 a_6838_376# a_2848_6666# a_4342_376# VSS nfet_06v0 ad=3.74p pd=17.88u as=3.74p ps=17.88u w=8.5u l=1u
X44 a_14_332# a_14_332# VSS VSS nfet_06v0 ad=0.44p pd=2.88u as=0.44p ps=2.88u w=1u l=1u
X45 VSS B2 VSS VSS nfet_06v0 ad=0.88p pd=4.88u as=0 ps=0 w=2u l=2u
X46 a_254_14582# a_54_14466# VDD VDD pfet_06v0 ad=2.5p pd=10.5u as=4.4p ps=20.88u w=10u l=1u
X47 a_2028_12186# a_354_14466# a_6106_376# VDD pfet_06v0 ad=4.4p pd=20.88u as=4.4p ps=20.88u w=10u l=1u
X48 a_2848_6666# a_14088_8046# VSS ppolyf_u_1k r_width=1u r_length=55.56u
X49 a_5074_376# a_746_332# VSS VSS nfet_06v0 ad=1.25p pd=5.5u as=2.2p ps=10.88u w=5u l=1u
X50 a_4402_14582# a_54_14466# VDD VDD pfet_06v0 ad=2.5p pd=10.5u as=4.4p ps=20.88u w=10u l=1u
X51 a_946_376# a_746_332# VSS VSS nfet_06v0 ad=1.25p pd=5.5u as=2.2p ps=10.88u w=5u l=1u
X52 a_5514_14582# a_54_14466# VDD VDD pfet_06v0 ad=2.5p pd=10.5u as=4.4p ps=20.88u w=10u l=1u
X53 a_13134_14582# a_12934_14466# VDD VDD pfet_06v0 ad=2.5p pd=10.5u as=4.4p ps=20.88u w=10u l=1u
X54 a_7382_332# a_14_332# a_7438_16482# VSS nfet_06v0 ad=1.1p pd=5.88u as=0.825p ps=3.16u w=2.5u l=1u
X55 a_8990_376# a_14_332# a_2848_6666# VSS nfet_06v0 ad=1.1p pd=5.88u as=0.825p ps=3.16u w=2.5u l=1u
X56 a_11298_15666# a_11298_15666# a_12934_14466# VDD pfet_06v0 ad=4.4p pd=20.88u as=3.3p ps=10.66u w=10u l=1u
X57 a_9522_332# a_354_14466# a_14578_14582# VDD pfet_06v0 ad=4.4p pd=20.88u as=2.5p ps=10.5u w=10u l=1u
X58 a_354_14466# a_354_14466# a_3010_376# VSS nfet_06v0 ad=0.44p pd=2.88u as=0.25p ps=1.5u w=1u l=1u
X59 a_7438_16482# a_7382_332# VSS VSS nfet_06v0 ad=0.825p pd=3.16u as=1.1p ps=5.88u w=2.5u l=1u
X60 a_11298_15666# a_14_332# a_11186_376# VSS nfet_06v0 ad=2.2p pd=10.88u as=1.25p ps=5.5u w=5u l=1u
X61 OUT a_2028_12186# VDD VDD pfet_06v0 ad=0.44p pd=2.88u as=0.44p ps=2.88u w=1u l=1u
X62 a_2848_8496# B2 VSS ppolyf_u_1k r_width=1u r_length=55.56u
X63 a_2848_8496# a_14088_8046# VSS ppolyf_u_1k r_width=1u r_length=55.56u
X64 a_6838_376# a_8250_14582# VDD VDD pfet_06v0 ad=2.2p pd=10.88u as=2.2p ps=10.88u w=5u l=1u
X65 a_746_332# a_14_332# a_946_376# VSS nfet_06v0 ad=2.2p pd=10.88u as=1.25p ps=5.5u w=5u l=1u
X66 VSS B2 VSS VSS nfet_06v0 ad=0.88p pd=4.88u as=0 ps=0 w=2u l=2u
X67 a_746_332# a_354_14466# a_1366_14582# VDD pfet_06v0 ad=4.4p pd=20.88u as=2.5p ps=10.5u w=10u l=1u
X68 a_14_332# a_354_14466# a_254_14582# VDD pfet_06v0 ad=4.4p pd=20.88u as=2.5p ps=10.5u w=10u l=1u
X69 a_2028_12636# a_17446_12186# VSS ppolyf_u_1k r_width=1u r_length=76.45u
X70 a_2028_12186# a_17446_12186# VSS ppolyf_u_1k r_width=1u r_length=76.45u
X71 a_2848_6666# a_14088_9426# VSS ppolyf_u_1k r_width=1u r_length=55.56u
X72 a_3010_376# a_354_14466# VSS VSS nfet_06v0 ad=0.25p pd=1.5u as=0.44p ps=2.88u w=1u l=1u
X73 a_11186_376# a_746_332# VSS VSS nfet_06v0 ad=1.25p pd=5.5u as=2.2p ps=10.88u w=5u l=1u
X74 a_54_14466# a_354_14466# a_3290_14582# VDD pfet_06v0 ad=4.4p pd=20.88u as=2.5p ps=10.5u w=10u l=1u
X75 a_2848_9876# B2 VSS ppolyf_u_1k r_width=1u r_length=55.56u
.ends
