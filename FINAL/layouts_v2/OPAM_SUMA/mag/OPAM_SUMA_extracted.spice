* Nodos de bulk atados: 0 de pozo n -> VDD, 1 de sustrato -> VSS.
*   magic no extrae los taps de este layout y los dejaba flotando;
*   la conexion si existe (el LVS de KLayout da 'match uniquely').
*   Quien detecta un tap que falte de verdad es el LVS, no esto.
* NGSPICE file created from OPAM_SUMA.ext - technology: gf180mcuD

.subckt OPAM_SUMA VSS VDD B2
X0 a_6106_376# a_8074_14766# VDD VDD pfet_06v0 ad=1.65p pd=5.66u as=2.2p ps=10.88u w=5u l=1u
X1 a_8058_332# a_8058_332# a_11266_332# VSS nfet_06v0 ad=2.2p pd=10.88u as=1.65p ps=5.66u w=5u l=1u
X2 a_54_13766# a_354_13766# a_3290_13882# VDD pfet_06v0 ad=4.4p pd=20.88u as=2.5p ps=10.5u w=10u l=1u
X3 a_4342_376# a_14_332# a_4042_376# VSS nfet_06v0 ad=2.2p pd=10.88u as=1.25p ps=5.5u w=5u l=1u
X4 a_8738_14766# a_8738_14766# a_11074_13766# VDD pfet_06v0 ad=4.4p pd=20.88u as=3.3p ps=10.66u w=10u l=1u
X5 B2 a_948_11486# VDD VDD pfet_06v0 ad=0.22p pd=1.88u as=0.22p ps=1.88u w=0.5u l=1u
X6 B2 a_6106_376# cap_mim_2f0_m4m5_noshield c_width=25u c_length=4u
X7 a_928_9176# B2 VSS ppolyf_u_3k r_width=1u r_length=55.56u
X8 a_928_9176# a_12168_8726# VSS ppolyf_u_3k r_width=1u r_length=55.56u
X9 a_928_5966# a_12168_5966# VSS ppolyf_u_3k r_width=1u r_length=55.56u
X10 a_928_5966# a_7394_332# VSS VSS nfet_06v0 ad=0.825p pd=3.16u as=1.1p ps=5.88u w=2.5u l=1u
X11 a_8058_332# a_354_13766# a_12718_13882# VDD pfet_06v0 ad=4.4p pd=20.88u as=2.5p ps=10.5u w=10u l=1u
X12 a_948_12836# B2 VSS ppolyf_u_3k r_width=1u r_length=76.45u
X13 a_928_6416# a_12168_5966# VSS ppolyf_u_3k r_width=1u r_length=55.56u
X14 a_54_13766# a_354_13766# a_1978_376# VSS nfet_06v0 ad=0.44p pd=2.88u as=0.25p ps=1.5u w=1u l=1u
X15 a_6106_376# a_928_5966# a_4342_376# VSS nfet_06v0 ad=0.44p pd=2.88u as=0.44p ps=2.88u w=1u l=1u
X16 a_8074_14766# a_8058_332# a_7394_332# VSS nfet_06v0 ad=1.1p pd=5.88u as=0.825p ps=3.16u w=2.5u l=1u
X17 a_1366_13882# a_54_13766# VDD VDD pfet_06v0 ad=2.5p pd=10.5u as=4.4p ps=20.88u w=10u l=1u
X18 a_8074_14766# a_354_13766# a_6838_376# VDD pfet_06v0 ad=1.65p pd=5.66u as=1.65p ps=5.66u w=5u l=1u
X19 a_9346_376# a_8738_14766# a_948_11486# VDD pfet_06v0 ad=2.2p pd=10.88u as=1.65p ps=5.66u w=5u l=1u
X20 a_4042_376# a_746_332# VSS VSS nfet_06v0 ad=1.25p pd=5.5u as=2.2p ps=10.88u w=5u l=1u
X21 a_11466_376# a_11266_332# VSS VSS nfet_06v0 ad=1.25p pd=5.5u as=2.2p ps=10.88u w=5u l=1u
X22 a_948_11486# a_8058_332# a_9346_376# VSS nfet_06v0 ad=1.1p pd=5.88u as=0.825p ps=3.16u w=2.5u l=1u
X23 a_1978_376# a_354_13766# VSS VSS nfet_06v0 ad=0.25p pd=1.5u as=0.44p ps=2.88u w=1u l=1u
X24 VSS B2 VSS VSS nfet_06v0 ad=0.88p pd=4.88u as=22p ps=0.11672m w=2u l=2u
X25 a_3290_13882# a_54_13766# VDD VDD pfet_06v0 ad=2.5p pd=10.5u as=4.4p ps=20.88u w=10u l=1u
X26 a_11266_332# a_14_332# a_11466_376# VSS nfet_06v0 ad=1.65p pd=5.66u as=1.25p ps=5.5u w=5u l=1u
X27 a_11074_13766# a_354_13766# a_11274_13882# VDD pfet_06v0 ad=3.3p pd=10.66u as=2.5p ps=10.5u w=10u l=1u
X28 a_928_6416# B2 VSS ppolyf_u_3k r_width=1u r_length=55.56u
X29 VSS B2 VSS VSS nfet_06v0 ad=0.88p pd=4.88u as=0 ps=0 w=2u l=2u
X30 B2 a_948_11486# VDD VDD pfet_06v0 ad=0.22p pd=1.88u as=0.22p ps=1.88u w=0.5u l=1u
X31 a_4342_376# a_14_332# a_5074_376# VSS nfet_06v0 ad=2.2p pd=10.88u as=1.25p ps=5.5u w=5u l=1u
X32 a_6838_376# a_928_5966# a_4342_376# VSS nfet_06v0 ad=0.44p pd=2.88u as=0.44p ps=2.88u w=1u l=1u
X33 a_354_13766# a_354_13766# VDD VDD pfet_06v0 ad=0.88p pd=4.88u as=0.88p ps=4.88u w=2u l=1u
X34 a_4702_13882# a_354_13766# a_4402_13882# VDD pfet_06v0 ad=4.4p pd=20.88u as=2.5p ps=10.5u w=10u l=1u
X35 a_12718_13882# a_54_13766# VDD VDD pfet_06v0 ad=2.5p pd=10.5u as=4.4p ps=20.88u w=10u l=1u
X36 a_928_5966# B2 cap_mim_2f0_m4m5_noshield c_width=25u c_length=4u
X37 a_6838_376# a_8074_14766# VDD VDD pfet_06v0 ad=1.65p pd=5.66u as=2.2p ps=10.88u w=5u l=1u
X38 B2 a_948_11486# VDD VDD pfet_06v0 ad=0.22p pd=1.88u as=0.22p ps=1.88u w=0.5u l=1u
X39 a_14_332# a_14_332# VSS VSS nfet_06v0 ad=0.44p pd=2.88u as=0.44p ps=2.88u w=1u l=1u
X40 a_4702_13882# a_354_13766# a_5514_13882# VDD pfet_06v0 ad=4.4p pd=20.88u as=2.5p ps=10.5u w=10u l=1u
X41 a_928_5966# a_12168_7346# VSS ppolyf_u_3k r_width=1u r_length=55.56u
X42 B2 a_9346_376# VSS VSS nfet_06v0 ad=0.44p pd=2.88u as=0.44p ps=2.88u w=1u l=1u
X43 a_928_5966# a_12168_10106# VSS ppolyf_u_3k r_width=1u r_length=55.56u
X44 a_5074_376# a_746_332# VSS VSS nfet_06v0 ad=1.25p pd=5.5u as=2.2p ps=10.88u w=5u l=1u
X45 a_9346_376# a_14_332# a_928_5966# VSS nfet_06v0 ad=0.825p pd=3.16u as=0.825p ps=3.16u w=2.5u l=1u
X46 a_254_13882# a_54_13766# VDD VDD pfet_06v0 ad=2.5p pd=10.5u as=4.4p ps=20.88u w=10u l=1u
X47 a_7394_332# a_8738_14766# a_8074_14766# VDD pfet_06v0 ad=2.2p pd=10.88u as=1.65p ps=5.66u w=5u l=1u
X48 a_11274_13882# a_11074_13766# VDD VDD pfet_06v0 ad=2.5p pd=10.5u as=4.4p ps=20.88u w=10u l=1u
X49 a_948_11936# a_16366_11486# VSS ppolyf_u_3k r_width=1u r_length=76.45u
X50 a_948_11486# a_16366_11486# VSS ppolyf_u_3k r_width=1u r_length=76.45u
X51 a_946_376# a_746_332# VSS VSS nfet_06v0 ad=1.25p pd=5.5u as=2.2p ps=10.88u w=5u l=1u
X52 a_7438_15682# a_928_5966# a_4702_13882# VDD pfet_06v0 ad=0.44p pd=2.88u as=0.44p ps=2.88u w=1u l=1u
X53 a_10410_376# a_746_332# VSS VSS nfet_06v0 ad=1.25p pd=5.5u as=2.2p ps=10.88u w=5u l=1u
X54 a_4402_13882# a_54_13766# VDD VDD pfet_06v0 ad=2.5p pd=10.5u as=4.4p ps=20.88u w=10u l=1u
X55 a_354_13766# a_354_13766# a_3010_376# VSS nfet_06v0 ad=0.44p pd=2.88u as=0.25p ps=1.5u w=1u l=1u
X56 a_5514_13882# a_54_13766# VDD VDD pfet_06v0 ad=2.5p pd=10.5u as=4.4p ps=20.88u w=10u l=1u
X57 a_948_11486# a_354_13766# a_6106_376# VDD pfet_06v0 ad=1.65p pd=5.66u as=1.65p ps=5.66u w=5u l=1u
X58 a_928_10556# a_12168_10106# VSS ppolyf_u_3k r_width=1u r_length=55.56u
X59 a_928_7796# a_12168_7346# VSS ppolyf_u_3k r_width=1u r_length=55.56u
X60 a_7394_332# a_14_332# a_7438_15682# VSS nfet_06v0 ad=0.825p pd=3.16u as=0.825p ps=3.16u w=2.5u l=1u
X61 VSS B2 VSS VSS nfet_06v0 ad=0.88p pd=4.88u as=0 ps=0 w=2u l=2u
X62 B2 a_948_11486# VDD VDD pfet_06v0 ad=0.22p pd=1.88u as=0.22p ps=1.88u w=0.5u l=1u
X63 a_928_10556# B2 VSS ppolyf_u_3k r_width=1u r_length=55.56u
X64 a_928_7796# B2 VSS ppolyf_u_3k r_width=1u r_length=55.56u
X65 a_8738_14766# a_14_332# a_10410_376# VSS nfet_06v0 ad=2.2p pd=10.88u as=1.25p ps=5.5u w=5u l=1u
X66 a_746_332# a_14_332# a_946_376# VSS nfet_06v0 ad=2.2p pd=10.88u as=1.25p ps=5.5u w=5u l=1u
X67 a_7438_15682# a_7394_332# VSS VSS nfet_06v0 ad=0.825p pd=3.16u as=1.1p ps=5.88u w=2.5u l=1u
X68 a_928_5966# a_12168_8726# VSS ppolyf_u_3k r_width=1u r_length=55.56u
X69 a_948_12836# a_16366_12386# VSS ppolyf_u_3k r_width=1u r_length=76.45u
X70 a_3010_376# a_354_13766# VSS VSS nfet_06v0 ad=0.25p pd=1.5u as=0.44p ps=2.88u w=1u l=1u
X71 a_948_11936# a_16366_12386# VSS ppolyf_u_3k r_width=1u r_length=76.45u
X72 a_746_332# a_354_13766# a_1366_13882# VDD pfet_06v0 ad=4.4p pd=20.88u as=2.5p ps=10.5u w=10u l=1u
X73 VSS B2 VSS VSS nfet_06v0 ad=0.88p pd=4.88u as=0 ps=0 w=2u l=2u
X74 a_14_332# a_354_13766# a_254_13882# VDD pfet_06v0 ad=4.4p pd=20.88u as=2.5p ps=10.5u w=10u l=1u
X75 a_928_5966# a_928_5966# a_4702_13882# VDD pfet_06v0 ad=0.484p pd=3.08u as=0.484p ps=3.08u w=1.1u l=1u
.ends
