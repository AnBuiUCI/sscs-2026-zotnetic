* Nodos de bulk atados: 0 de pozo n -> VDD, 1 de sustrato -> VSS.
*   magic no extrae los taps de este layout y los dejaba flotando;
*   la conexion si existe (el LVS de KLayout da 'match uniquely').
*   Quien detecta un tap que falte de verdad es el LVS, no esto.
* NGSPICE file created from OPAM_SUMA.ext - technology: gf180mcuD

.subckt OPAM_SUMA VSS VDD B2
X0 a_6106_376# a_8074_14766# VDD VDD pfet_06v0 ad=1.65p pd=5.66u as=2.2p ps=10.88u w=5u l=1u
X1 a_8058_332# a_8058_332# a_11266_332# VSS nfet_06v0 ad=2.2p pd=10.88u as=1.65p ps=5.66u w=5u l=1u
X2 a_54_13766# a_354_13766# a_3290_13882# VDD pfet_06v0 ad=4.4p pd=20.88u as=2.5p ps=10.5u w=10u l=1u
X3 a_4342_376# a_14_332# a_4042_376# VSS nfet_06v0 ad=2.2p pd=10.88u as=1.25p ps=5.5u w=5u l=1u
X4 a_8738_14766# a_8738_14766# a_11074_13766# VDD pfet_06v0 ad=4.4p pd=20.88u as=3.3p ps=10.66u w=10u l=1u
X5 B2 a_948_11486# VDD VDD pfet_06v0 ad=0.22p pd=1.88u as=0.22p ps=1.88u w=0.5u l=1u
X6 B2 a_6106_376# cap_mim_2f0_m4m5_noshield c_width=25u c_length=4u
X7 a_928_9176# B2 VSS ppolyf_u_3k r_width=1u r_length=55.56u
X8 a_928_9176# a_12168_8726# VSS ppolyf_u_3k r_width=1u r_length=55.56u
X9 a_928_5966# a_12168_5966# VSS ppolyf_u_3k r_width=1u r_length=55.56u
X10 a_928_5966# a_7394_332# VSS VSS nfet_06v0 ad=0.825p pd=3.16u as=1.1p ps=5.88u w=2.5u l=1u
X11 a_8058_332# a_354_13766# a_12718_13882# VDD pfet_06v0 ad=4.4p pd=20.88u as=2.5p ps=10.5u w=10u l=1u
X12 a_948_12836# B2 VSS ppolyf_u_3k r_width=1u r_length=76.45u
X13 a_928_6416# a_12168_5966# VSS ppolyf_u_3k r_width=1u r_length=55.56u
X14 a_54_13766# a_354_13766# a_1978_376# VSS nfet_06v0 ad=0.44p pd=2.88u as=0.25p ps=1.5u w=1u l=1u
X15 a_6106_376# a_928_5966# a_4342_376# VSS nfet_06v0 ad=0.44p pd=2.88u as=0.44p ps=2.88u w=1u l=1u
X16 a_8074_14766# a_8058_332# a_7394_332# VSS nfet_06v0 ad=1.1p pd=5.88u as=0.825p ps=3.16u w=2.5u l=1u
X17 a_1366_13882# a_54_13766# VDD VDD pfet_06v0 ad=2.5p pd=10.5u as=4.4p ps=20.88u w=10u l=1u
X18 a_8074_14766# a_354_13766# a_6838_376# VDD pfet_06v0 ad=1.65p pd=5.66u as=1.65p ps=5.66u w=5u l=1u
X19 a_9346_376# a_8738_14766# a_948_11486# VDD pfet_06v0 ad=2.2p pd=10.88u as=1.65p ps=5.66u w=5u l=1u
X20 a_4042_376# a_746_332# VSS VSS nfet_06v0 ad=1.25p pd=5.5u as=2.2p ps=10.88u w=5u l=1u
X21 a_11466_376# a_11266_332# VSS VSS nfet_06v0 ad=1.25p pd=5.5u as=2.2p ps=10.88u w=5u l=1u
X22 a_948_11486# a_8058_332# a_9346_376# VSS nfet_06v0 ad=1.1p pd=5.88u as=0.825p ps=3.16u w=2.5u l=1u
X23 a_1978_376# a_354_13766# VSS VSS nfet_06v0 ad=0.25p pd=1.5u as=0.44p ps=2.88u w=1u l=1u
X24 VSS B2 VSS VSS nfet_06v0 ad=0.88p pd=4.88u as=22p ps=0.11672m w=2u l=2u
X25 a_3290_13882# a_54_13766# VDD VDD pfet_06v0 ad=2.5p pd=10.5u as=4.4p ps=20.88u w=10u l=1u
X26 a_11266_332# a_14_332# a_11466_376# VSS nfet_06v0 ad=1.65p pd=5.66u as=1.25p ps=5.5u w=5u l=1u
X27 a_11074_13766# a_354_13766# a_11274_13882# VDD pfet_06v0 ad=3.3p pd=10.66u as=2.5p ps=10.5u w=10u l=1u
X28 a_928_6416# B2 VSS ppolyf_u_3k r_width=1u r_length=55.56u
X29 VSS B2 VSS VSS nfet_06v0 ad=0.88p pd=4.88u as=0 ps=0 w=2u l=2u
X30 B2 a_948_11486# VDD VDD pfet_06v0 ad=0.22p pd=1.88u as=0.22p ps=1.88u w=0.5u l=1u
X31 a_4342_376# a_14_332# a_5074_376# VSS nfet_06v0 ad=2.2p pd=10.88u as=1.25p ps=5.5u w=5u l=1u
X32 a_6838_376# a_928_5966# a_4342_376# VSS nfet_06v0 ad=0.44p pd=2.88u as=0.44p ps=2.88u w=1u l=1u
X33 a_354_13766# a_354_13766# VDD VDD pfet_06v0 ad=0.88p pd=4.88u as=0.88p ps=4.88u w=2u l=1u
X34 a_4702_13882# a_354_13766# a_4402_13882# VDD pfet_06v0 ad=4.4p pd=20.88u as=2.5p ps=10.5u w=10u l=1u
X35 a_12718_13882# a_54_13766# VDD VDD pfet_06v0 ad=2.5p pd=10.5u as=4.4p ps=20.88u w=10u l=1u
X36 a_928_5966# B2 cap_mim_2f0_m4m5_noshield c_width=25u c_length=4u
X37 a_6838_376# a_8074_14766# VDD VDD pfet_06v0 ad=1.65p pd=5.66u as=2.2p ps=10.88u w=5u l=1u
X38 B2 a_948_11486# VDD VDD pfet_06v0 ad=0.22p pd=1.88u as=0.22p ps=1.88u w=0.5u l=1u
X39 a_14_332# a_14_332# VSS VSS nfet_06v0 ad=0.44p pd=2.88u as=0.44p ps=2.88u w=1u l=1u
X40 a_4702_13882# a_354_13766# a_5514_13882# VDD pfet_06v0 ad=4.4p pd=20.88u as=2.5p ps=10.5u w=10u l=1u
X41 a_928_5966# a_12168_7346# VSS ppolyf_u_3k r_width=1u r_length=55.56u
X42 B2 a_9346_376# VSS VSS nfet_06v0 ad=0.44p pd=2.88u as=0.44p ps=2.88u w=1u l=1u
X43 a_928_5966# a_12168_10106# VSS ppolyf_u_3k r_width=1u r_length=55.56u
X44 a_5074_376# a_746_332# VSS VSS nfet_06v0 ad=1.25p pd=5.5u as=2.2p ps=10.88u w=5u l=1u
X45 a_9346_376# a_14_332# a_928_5966# VSS nfet_06v0 ad=0.825p pd=3.16u as=0.825p ps=3.16u w=2.5u l=1u
X46 a_254_13882# a_54_13766# VDD VDD pfet_06v0 ad=2.5p pd=10.5u as=4.4p ps=20.88u w=10u l=1u
X47 a_7394_332# a_8738_14766# a_8074_14766# VDD pfet_06v0 ad=2.2p pd=10.88u as=1.65p ps=5.66u w=5u l=1u
X48 a_11274_13882# a_11074_13766# VDD VDD pfet_06v0 ad=2.5p pd=10.5u as=4.4p ps=20.88u w=10u l=1u
X49 a_948_11936# a_16366_11486# VSS ppolyf_u_3k r_width=1u r_length=76.45u
X50 a_948_11486# a_16366_11486# VSS ppolyf_u_3k r_width=1u r_length=76.45u
X51 a_946_376# a_746_332# VSS VSS nfet_06v0 ad=1.25p pd=5.5u as=2.2p ps=10.88u w=5u l=1u
X52 a_7438_15682# a_928_5966# a_4702_13882# VDD pfet_06v0 ad=0.44p pd=2.88u as=0.44p ps=2.88u w=1u l=1u
X53 a_10410_376# a_746_332# VSS VSS nfet_06v0 ad=1.25p pd=5.5u as=2.2p ps=10.88u w=5u l=1u
X54 a_4402_13882# a_54_13766# VDD VDD pfet_06v0 ad=2.5p pd=10.5u as=4.4p ps=20.88u w=10u l=1u
X55 a_354_13766# a_354_13766# a_3010_376# VSS nfet_06v0 ad=0.44p pd=2.88u as=0.25p ps=1.5u w=1u l=1u
X56 a_5514_13882# a_54_13766# VDD VDD pfet_06v0 ad=2.5p pd=10.5u as=4.4p ps=20.88u w=10u l=1u
X57 a_948_11486# a_354_13766# a_6106_376# VDD pfet_06v0 ad=1.65p pd=5.66u as=1.65p ps=5.66u w=5u l=1u
X58 a_928_10556# a_12168_10106# VSS ppolyf_u_3k r_width=1u r_length=55.56u
X59 a_928_7796# a_12168_7346# VSS ppolyf_u_3k r_width=1u r_length=55.56u
X60 a_7394_332# a_14_332# a_7438_15682# VSS nfet_06v0 ad=0.825p pd=3.16u as=0.825p ps=3.16u w=2.5u l=1u
X61 VSS B2 VSS VSS nfet_06v0 ad=0.88p pd=4.88u as=0 ps=0 w=2u l=2u
X62 B2 a_948_11486# VDD VDD pfet_06v0 ad=0.22p pd=1.88u as=0.22p ps=1.88u w=0.5u l=1u
X63 a_928_10556# B2 VSS ppolyf_u_3k r_width=1u r_length=55.56u
X64 a_928_7796# B2 VSS ppolyf_u_3k r_width=1u r_length=55.56u
X65 a_8738_14766# a_14_332# a_10410_376# VSS nfet_06v0 ad=2.2p pd=10.88u as=1.25p ps=5.5u w=5u l=1u
X66 a_746_332# a_14_332# a_946_376# VSS nfet_06v0 ad=2.2p pd=10.88u as=1.25p ps=5.5u w=5u l=1u
X67 a_7438_15682# a_7394_332# VSS VSS nfet_06v0 ad=0.825p pd=3.16u as=1.1p ps=5.88u w=2.5u l=1u
X68 a_928_5966# a_12168_8726# VSS ppolyf_u_3k r_width=1u r_length=55.56u
X69 a_948_12836# a_16366_12386# VSS ppolyf_u_3k r_width=1u r_length=76.45u
X70 a_3010_376# a_354_13766# VSS VSS nfet_06v0 ad=0.25p pd=1.5u as=0.44p ps=2.88u w=1u l=1u
X71 a_948_11936# a_16366_12386# VSS ppolyf_u_3k r_width=1u r_length=76.45u
X72 a_746_332# a_354_13766# a_1366_13882# VDD pfet_06v0 ad=4.4p pd=20.88u as=2.5p ps=10.5u w=10u l=1u
X73 VSS B2 VSS VSS nfet_06v0 ad=0.88p pd=4.88u as=0 ps=0 w=2u l=2u
X74 a_14_332# a_354_13766# a_254_13882# VDD pfet_06v0 ad=4.4p pd=20.88u as=2.5p ps=10.5u w=10u l=1u
X75 a_928_5966# a_928_5966# a_4702_13882# VDD pfet_06v0 ad=0.484p pd=3.08u as=0.484p ps=3.08u w=1.1u l=1u
C0 a_6106_376# a_54_13766# 0.3353f
C1 VDD a_8738_14766# 1.77464f
C2 a_54_13766# a_8074_14766# 0.14098f
C3 a_354_13766# a_746_332# 5.90538f
C4 a_54_13766# a_8738_14766# 1.81059f
C5 a_948_12836# a_14_332# 0.03985f
C6 VDD a_8058_332# 0.53454f
C7 a_7438_15682# a_746_332# 0.02406f
C8 a_9346_376# VDD 0.59098f
C9 a_7394_332# a_354_13766# 0.03009f
C10 a_8058_332# a_54_13766# 0.07242f
C11 a_6838_376# a_948_11486# 0.02502f
C12 a_12168_7346# a_8738_14766# 0.12872f
C13 a_9346_376# a_54_13766# 0.02097f
C14 a_11266_332# a_948_11486# 0.26967f
C15 a_14_332# a_928_5966# 0.50515f
C16 a_7394_332# a_7438_15682# 1.17074f
C17 a_6106_376# B2 1.62866f
C18 B2 a_8074_14766# 0.05648f
C19 B2 a_8738_14766# 0.27685f
C20 a_4342_376# a_6106_376# 0.32044f
C21 a_11074_13766# a_8738_14766# 4.98758f
C22 a_948_11486# a_746_332# 0.08598f
C23 VDD a_14_332# 0.6777f
C24 B2 a_8058_332# 0.80336f
C25 a_16366_12386# B2 0.56971f
C26 a_14_332# a_54_13766# 0.59332f
C27 a_11274_13882# VDD 0.07139f
C28 a_9346_376# B2 0.65396f
C29 a_8058_332# a_11074_13766# 0.27963f
C30 a_6106_376# a_354_13766# 4.84411f
C31 a_7394_332# a_948_11486# 0.04431f
C32 a_8074_14766# a_354_13766# 4.50048f
C33 a_9346_376# a_11074_13766# 0.76963f
C34 a_8738_14766# a_354_13766# 0.24108f
C35 a_928_7796# a_14_332# 0.04286f
C36 a_6106_376# a_7438_15682# 0.05445f
C37 a_7438_15682# a_8074_14766# 0.82621f
C38 a_16366_11486# B2 0.54093f
C39 a_8058_332# a_354_13766# 4.15307f
C40 a_11466_376# a_11266_332# 0.03308f
C41 a_12168_8726# a_8738_14766# 0.12872f
C42 a_928_5966# a_4702_13882# 12.6668f
C43 a_9346_376# a_354_13766# 0.02971f
C44 a_948_11486# a_928_10556# 0.02341f
C45 B2 a_14_332# 0.4768f
C46 a_14_332# a_11074_13766# 0.26968f
C47 a_948_12836# VDD 0.02456f
C48 a_4342_376# a_14_332# 0.75648f
C49 a_6106_376# a_948_11486# 0.65887f
C50 a_11274_13882# a_11074_13766# 0.06557f
C51 a_948_11486# a_8074_14766# 0.15104f
C52 VDD a_1366_13882# 0.07139f
C53 a_8738_14766# a_12168_5966# 0.12872f
C54 VDD a_4702_13882# 2.06944f
C55 a_948_12836# a_54_13766# 0.13088f
C56 a_948_11486# a_8738_14766# 5.00288f
C57 a_12168_10106# a_8738_14766# 0.12872f
C58 a_54_13766# a_4702_13882# 1.07841f
C59 VDD a_928_5966# 1.60454f
C60 a_14_332# a_354_13766# 4.32961f
C61 a_54_13766# a_928_5966# 0.82902f
C62 a_8058_332# a_948_11486# 1.59438f
C63 a_9346_376# a_948_11486# 1.65929f
C64 a_6838_376# a_746_332# 0.02025f
C65 a_7438_15682# a_14_332# 0.41441f
C66 a_928_7796# a_928_5966# 0.0559f
C67 VDD a_54_13766# 4.09927f
C68 a_7394_332# a_6838_376# 0.13298f
C69 B2 a_4702_13882# 0.15937f
C70 B2 a_928_5966# 3.8926f
C71 a_4342_376# a_4702_13882# 0.73632f
C72 a_14_332# a_948_11486# 0.03383f
C73 a_11074_13766# a_928_5966# 0.07085f
C74 a_14_332# a_928_6416# 0.04286f
C75 a_4342_376# a_928_5966# 1.28181f
C76 a_928_7796# a_54_13766# 0.11941f
C77 a_12168_7346# a_54_13766# 0.09144f
C78 a_7394_332# a_746_332# 0.07121f
C79 a_354_13766# a_4702_13882# 8.43661f
C80 a_5514_13882# a_4702_13882# 0.05253f
C81 VDD B2 2.04653f
C82 a_354_13766# a_928_5966# 0.78341f
C83 VDD a_11074_13766# 0.94785f
C84 a_6838_376# a_6106_376# 0.08302f
C85 B2 a_54_13766# 0.98581f
C86 a_6838_376# a_8074_14766# 4.92667f
C87 a_7438_15682# a_4702_13882# 0.04822f
C88 a_54_13766# a_11074_13766# 0.05583f
C89 a_7438_15682# a_928_5966# 4.83799f
C90 a_4342_376# a_54_13766# 0.02106f
C91 a_11266_332# a_8738_14766# 0.11782f
C92 a_14_332# a_928_9176# 0.04286f
C93 B2 a_12168_7346# 0.05825f
C94 a_4342_376# a_4042_376# 0.02626f
C95 VDD a_354_13766# 5.03108f
C96 a_948_11936# a_14_332# 0.03985f
C97 VDD a_5514_13882# 0.07452f
C98 a_11266_332# a_8058_332# 0.62263f
C99 a_54_13766# a_354_13766# 22.7219f
C100 a_6106_376# a_746_332# 0.20035f
C101 a_8074_14766# a_746_332# 0.02068f
C102 a_9346_376# a_11266_332# 0.04971f
C103 VDD a_3290_13882# 0.07139f
C104 a_948_11486# a_4702_13882# 0.07331f
C105 a_8738_14766# a_746_332# 0.04644f
C106 a_7438_15682# VDD 0.57803f
C107 a_54_13766# a_3290_13882# 0.05253f
C108 a_948_11486# a_928_5966# 0.98756f
C109 a_7438_15682# a_54_13766# 0.02179f
C110 B2 a_11074_13766# 0.0872f
C111 a_54_13766# a_12168_8726# 0.09144f
C112 a_4702_13882# a_4402_13882# 0.05253f
C113 a_7394_332# a_6106_376# 0.68245f
C114 a_928_6416# a_928_5966# 0.0559f
C115 a_7394_332# a_8074_14766# 1.75591f
C116 a_10410_376# a_8738_14766# 0.02626f
C117 a_4342_376# B2 0.07108f
C118 a_8058_332# a_746_332# 0.8716f
C119 a_7394_332# a_8738_14766# 4.51971f
C120 a_9346_376# a_746_332# 0.027f
C121 a_6838_376# a_14_332# 0.02833f
C122 B2 a_354_13766# 0.98417f
C123 a_11266_332# a_14_332# 0.41562f
C124 a_7394_332# a_8058_332# 0.51568f
C125 VDD a_948_11486# 3.43178f
C126 a_54_13766# a_12168_5966# 0.09144f
C127 a_11074_13766# a_354_13766# 5.98802f
C128 a_54_13766# a_948_11486# 0.23786f
C129 a_4342_376# a_5074_376# 0.02626f
C130 a_12168_10106# a_54_13766# 0.09144f
C131 VDD a_4402_13882# 0.07139f
C132 a_54_13766# a_928_6416# 0.11941f
C133 a_948_12836# a_948_11936# 0.01879f
C134 a_946_376# a_746_332# 0.02626f
C135 a_7438_15682# B2 0.0238f
C136 B2 a_12168_8726# 0.05825f
C137 a_928_9176# a_928_5966# 0.0559f
C138 a_14_332# a_746_332# 4.66755f
C139 a_6106_376# a_8074_14766# 4.6522f
C140 a_6106_376# a_8738_14766# 0.0513f
C141 a_8074_14766# a_8738_14766# 5.03481f
C142 a_7394_332# a_14_332# 0.55376f
C143 B2 a_12168_5966# 0.0342f
C144 a_7438_15682# a_354_13766# 0.02881f
C145 a_6106_376# a_8058_332# 0.03217f
C146 B2 a_948_11486# 23.9379f
C147 a_12168_10106# B2 0.05825f
C148 a_12718_13882# a_8058_332# 0.05253f
C149 a_8058_332# a_8074_14766# 0.56524f
C150 a_9346_376# a_6106_376# 0.06266f
C151 a_11074_13766# a_948_11486# 0.07824f
C152 a_8058_332# a_8738_14766# 0.03968f
C153 a_54_13766# a_928_9176# 0.11941f
C154 a_9346_376# a_8738_14766# 4.67767f
C155 a_6838_376# a_4702_13882# 0.20227f
C156 a_948_11936# a_54_13766# 0.13088f
C157 a_6838_376# a_928_5966# 0.96255f
C158 a_14_332# a_254_13882# 0.05253f
C159 a_11266_332# a_928_5966# 0.09358f
C160 a_14_332# a_928_10556# 0.04286f
C161 a_9346_376# a_8058_332# 1.96438f
C162 a_948_11486# a_354_13766# 4.71735f
C163 a_1366_13882# a_746_332# 0.05253f
C164 a_746_332# a_4702_13882# 0.02111f
C165 a_6106_376# a_14_332# 0.09705f
C166 a_14_332# a_8074_14766# 0.02988f
C167 a_7438_15682# a_948_11486# 0.01898f
C168 a_6838_376# VDD 0.46368f
C169 a_14_332# a_8738_14766# 0.35412f
C170 a_16366_11486# a_16366_12386# 0.01879f
C171 a_746_332# a_928_5966# 0.50645f
C172 a_6838_376# a_54_13766# 0.5868f
C173 a_11466_376# B2 0.01009f
C174 a_8058_332# a_14_332# 0.341f
C175 a_7394_332# a_928_5966# 0.90343f
C176 a_9346_376# a_14_332# 0.40542f
C177 VDD a_746_332# 0.55461f
C178 a_54_13766# a_746_332# 0.28853f
C179 a_6838_376# B2 0.03766f
C180 a_7394_332# VDD 0.5177f
C181 a_928_10556# a_928_5966# 0.02812f
C182 a_11266_332# B2 0.08479f
C183 a_7394_332# a_54_13766# 0.02157f
C184 a_11266_332# a_11074_13766# 0.52362f
C185 a_4342_376# a_6838_376# 0.04526f
C186 a_6106_376# a_4702_13882# 0.4039f
C187 a_6106_376# a_928_5966# 2.74798f
C188 a_8074_14766# a_928_5966# 0.18806f
C189 a_8738_14766# a_928_5966# 0.30174f
C190 a_6838_376# a_354_13766# 4.58928f
C191 B2 a_746_332# 0.37547f
C192 VDD a_254_13882# 0.07875f
C193 a_54_13766# a_928_10556# 0.11941f
C194 a_948_11936# a_948_11486# 0.02812f
C195 a_4342_376# a_746_332# 1.06062f
C196 a_8058_332# a_928_5966# 0.33751f
C197 a_10410_376# B2 0.01009f
C198 a_6838_376# a_7438_15682# 0.2533f
C199 a_9346_376# a_928_5966# 0.45556f
C200 a_6106_376# VDD 0.44182f
C201 a_7394_332# B2 0.08583f
C202 VDD a_12718_13882# 0.07415f
C203 VDD a_8074_14766# 1.64908f
C204 B2 VSS 34.8238f
C205 VDD VSS 0.13968p
C206 a_11466_376# VSS 0.04965f
C207 a_10410_376# VSS 0.04308f
C208 a_5074_376# VSS 0.04916f
C209 a_4342_376# VSS 1.71522f
C210 a_4042_376# VSS 0.04308f
C211 a_3010_376# VSS 0.01317f
C212 a_1978_376# VSS 0.01198f
C213 a_946_376# VSS 0.04308f
C214 a_11266_332# VSS 1.20992f
C215 a_12168_5966# VSS 0.48372f
C216 a_928_6416# VSS 0.574f
C217 a_12168_7346# VSS 0.46858f
C218 a_928_7796# VSS 0.574f
C219 a_12168_8726# VSS 0.46858f
C220 a_928_9176# VSS 0.574f
C221 a_12168_10106# VSS 0.46858f
C222 a_928_10556# VSS 0.57718f
C223 a_16366_11486# VSS 0.51972f
C224 a_948_11936# VSS 0.57071f
C225 a_16366_12386# VSS 0.50333f
C226 a_948_12836# VSS 0.56255f
C227 a_8058_332# VSS 4.66504f
C228 a_9346_376# VSS 3.52433f
C229 a_6106_376# VSS 3.97224f
C230 a_7394_332# VSS 4.18252f
C231 a_6838_376# VSS 1.88039f
C232 a_7438_15682# VSS 2.72936f
C233 a_4702_13882# VSS 8.90708f
C234 a_746_332# VSS 5.84263f
C235 a_14_332# VSS 10.7078f
C236 a_948_11486# VSS 17.2779f
C237 a_11074_13766# VSS 4.3496f
C238 a_8738_14766# VSS 6.47954f
C239 a_8074_14766# VSS 6.33367f
C240 a_928_5966# VSS 16.0791f
C241 a_354_13766# VSS 24.3866f
C242 a_54_13766# VSS 19.8314f
.ends
