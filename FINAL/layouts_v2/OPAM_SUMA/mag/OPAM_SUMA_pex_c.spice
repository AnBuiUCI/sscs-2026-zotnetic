* Nodos de bulk atados: 0 de pozo n -> VDD, 1 de sustrato -> VSS.
*   magic no extrae los taps de este layout y los dejaba flotando;
*   la conexion si existe (el LVS de KLayout da 'match uniquely').
*   Quien detecta un tap que falte de verdad es el LVS, no esto.
* NGSPICE file created from OPAM_SUMA.ext - technology: gf180mcuD

.subckt OPAM_SUMA VSS VDD OUT B2
X0 a_7382_332# a_11298_15666# a_8250_14582# VDD pfet_06v0 ad=1.76p pd=8.88u as=1.76p ps=8.88u w=4u l=1u
X1 a_14578_14582# a_54_14466# VDD VDD pfet_06v0 ad=2.5p pd=10.5u as=4.4p ps=20.88u w=10u l=1u
X2 OUT a_2028_12186# VDD VDD pfet_06v0 ad=0.44p pd=2.88u as=0.44p ps=2.88u w=1u l=1u
X3 a_2848_6666# a_7382_332# VSS VSS nfet_06v0 ad=0.825p pd=3.16u as=1.1p ps=5.88u w=2.5u l=1u
X4 a_2848_6666# a_14088_10806# VSS ppolyf_u_1k r_width=1u r_length=55.56u
X5 a_4342_376# a_14_332# a_4042_376# VSS nfet_06v0 ad=2.2p pd=10.88u as=1.25p ps=5.5u w=5u l=1u
X6 a_8250_14582# a_354_14466# a_6838_376# VDD pfet_06v0 ad=4.4p pd=20.88u as=4.4p ps=20.88u w=10u l=1u
X7 a_2848_9876# a_14088_9426# VSS ppolyf_u_1k r_width=1u r_length=55.56u
X8 a_9522_332# a_9522_332# a_12030_332# VSS nfet_06v0 ad=2.2p pd=10.88u as=1.65p ps=5.66u w=5u l=1u
X9 a_2848_6666# OUT cap_mim_2f0_m4m5_noshield c_width=25u c_length=8u
X10 a_1366_14582# a_54_14466# VDD VDD pfet_06v0 ad=2.5p pd=10.5u as=4.4p ps=20.88u w=10u l=1u
X11 a_2848_6666# a_14088_6666# VSS ppolyf_u_1k r_width=1u r_length=55.56u
X12 a_2028_13536# a_17446_13086# VSS ppolyf_u_1k r_width=1u r_length=76.45u
X13 a_2028_12636# a_17446_13086# VSS ppolyf_u_1k r_width=1u r_length=76.45u
X14 a_2848_7116# a_14088_6666# VSS ppolyf_u_1k r_width=1u r_length=55.56u
X15 a_54_14466# a_354_14466# a_1978_376# VSS nfet_06v0 ad=0.44p pd=2.88u as=0.25p ps=1.5u w=1u l=1u
X16 a_6106_376# a_2848_6666# a_4342_376# VSS nfet_06v0 ad=3.3p pd=15.88u as=3.3p ps=15.88u w=7.5u l=1u
X17 a_8250_14582# a_9522_332# a_7382_332# VSS nfet_06v0 ad=0.88p pd=4.88u as=0.88p ps=4.88u w=2u l=1u
X18 a_3290_14582# a_54_14466# VDD VDD pfet_06v0 ad=2.5p pd=10.5u as=4.4p ps=20.88u w=10u l=1u
X19 a_4042_376# a_746_332# VSS VSS nfet_06v0 ad=1.25p pd=5.5u as=2.2p ps=10.88u w=5u l=1u
X20 VSS B2 VSS VSS nfet_06v0 ad=0.88p pd=4.88u as=22p ps=0.11672m w=2u l=2u
X21 a_2848_6666# a_2848_6666# a_4702_14582# VDD pfet_06v0 ad=0.242p pd=1.98u as=0.242p ps=1.98u w=0.55u l=1u
X22 a_7438_16482# a_2848_6666# a_4702_14582# VDD pfet_06v0 ad=0.22p pd=1.88u as=0.22p ps=1.88u w=0.5u l=1u
X23 a_12934_14466# a_354_14466# a_13134_14582# VDD pfet_06v0 ad=3.3p pd=10.66u as=2.5p ps=10.5u w=10u l=1u
X24 a_1978_376# a_354_14466# VSS VSS nfet_06v0 ad=0.25p pd=1.5u as=0.44p ps=2.88u w=1u l=1u
X25 a_12230_376# a_12030_332# VSS VSS nfet_06v0 ad=1.25p pd=5.5u as=2.2p ps=10.88u w=5u l=1u
X26 a_354_14466# a_354_14466# VDD VDD pfet_06v0 ad=0.88p pd=4.88u as=0.88p ps=4.88u w=2u l=1u
X27 a_6106_376# a_8250_14582# VDD VDD pfet_06v0 ad=2.2p pd=10.88u as=2.2p ps=10.88u w=5u l=1u
X28 OUT a_2028_12186# VDD VDD pfet_06v0 ad=0.44p pd=2.88u as=0.44p ps=2.88u w=1u l=1u
X29 a_2848_11256# B2 VSS ppolyf_u_1k r_width=1u r_length=55.56u
X30 a_2848_11256# a_14088_10806# VSS ppolyf_u_1k r_width=1u r_length=55.56u
X31 OUT a_8990_376# VSS VSS nfet_06v0 ad=0.44p pd=2.88u as=0.44p ps=2.88u w=1u l=1u
X32 a_4702_14582# a_354_14466# a_4402_14582# VDD pfet_06v0 ad=4.4p pd=20.88u as=2.5p ps=10.5u w=10u l=1u
X33 OUT a_2028_12186# VDD VDD pfet_06v0 ad=0.44p pd=2.88u as=0.44p ps=2.88u w=1u l=1u
X34 VSS B2 VSS VSS nfet_06v0 ad=0.88p pd=4.88u as=0 ps=0 w=2u l=2u
X35 a_4702_14582# a_354_14466# a_5514_14582# VDD pfet_06v0 ad=4.4p pd=20.88u as=2.5p ps=10.5u w=10u l=1u
X36 a_2028_13536# OUT VSS ppolyf_u_1k r_width=1u r_length=76.45u
X37 a_2028_12186# a_9522_332# a_8990_376# VSS nfet_06v0 ad=0.88p pd=4.88u as=0.88p ps=4.88u w=2u l=1u
X38 a_12030_332# a_14_332# a_12230_376# VSS nfet_06v0 ad=1.65p pd=5.66u as=1.25p ps=5.5u w=5u l=1u
X39 OUT a_6106_376# cap_mim_2f0_m4m5_noshield c_width=25u c_length=8u
X40 a_8990_376# a_11298_15666# a_2028_12186# VDD pfet_06v0 ad=1.76p pd=8.88u as=1.76p ps=8.88u w=4u l=1u
X41 a_2848_7116# B2 VSS ppolyf_u_1k r_width=1u r_length=55.56u
X42 a_4342_376# a_14_332# a_5074_376# VSS nfet_06v0 ad=2.2p pd=10.88u as=1.25p ps=5.5u w=5u l=1u
X43 a_6838_376# a_2848_6666# a_4342_376# VSS nfet_06v0 ad=3.74p pd=17.88u as=3.74p ps=17.88u w=8.5u l=1u
X44 a_14_332# a_14_332# VSS VSS nfet_06v0 ad=0.44p pd=2.88u as=0.44p ps=2.88u w=1u l=1u
X45 VSS B2 VSS VSS nfet_06v0 ad=0.88p pd=4.88u as=0 ps=0 w=2u l=2u
X46 a_254_14582# a_54_14466# VDD VDD pfet_06v0 ad=2.5p pd=10.5u as=4.4p ps=20.88u w=10u l=1u
X47 a_2028_12186# a_354_14466# a_6106_376# VDD pfet_06v0 ad=4.4p pd=20.88u as=4.4p ps=20.88u w=10u l=1u
X48 a_2848_6666# a_14088_8046# VSS ppolyf_u_1k r_width=1u r_length=55.56u
X49 a_5074_376# a_746_332# VSS VSS nfet_06v0 ad=1.25p pd=5.5u as=2.2p ps=10.88u w=5u l=1u
X50 a_4402_14582# a_54_14466# VDD VDD pfet_06v0 ad=2.5p pd=10.5u as=4.4p ps=20.88u w=10u l=1u
X51 a_946_376# a_746_332# VSS VSS nfet_06v0 ad=1.25p pd=5.5u as=2.2p ps=10.88u w=5u l=1u
X52 a_5514_14582# a_54_14466# VDD VDD pfet_06v0 ad=2.5p pd=10.5u as=4.4p ps=20.88u w=10u l=1u
X53 a_13134_14582# a_12934_14466# VDD VDD pfet_06v0 ad=2.5p pd=10.5u as=4.4p ps=20.88u w=10u l=1u
X54 a_7382_332# a_14_332# a_7438_16482# VSS nfet_06v0 ad=1.1p pd=5.88u as=0.825p ps=3.16u w=2.5u l=1u
X55 a_8990_376# a_14_332# a_2848_6666# VSS nfet_06v0 ad=1.1p pd=5.88u as=0.825p ps=3.16u w=2.5u l=1u
X56 a_11298_15666# a_11298_15666# a_12934_14466# VDD pfet_06v0 ad=4.4p pd=20.88u as=3.3p ps=10.66u w=10u l=1u
X57 a_9522_332# a_354_14466# a_14578_14582# VDD pfet_06v0 ad=4.4p pd=20.88u as=2.5p ps=10.5u w=10u l=1u
X58 a_354_14466# a_354_14466# a_3010_376# VSS nfet_06v0 ad=0.44p pd=2.88u as=0.25p ps=1.5u w=1u l=1u
X59 a_7438_16482# a_7382_332# VSS VSS nfet_06v0 ad=0.825p pd=3.16u as=1.1p ps=5.88u w=2.5u l=1u
X60 a_11298_15666# a_14_332# a_11186_376# VSS nfet_06v0 ad=2.2p pd=10.88u as=1.25p ps=5.5u w=5u l=1u
X61 OUT a_2028_12186# VDD VDD pfet_06v0 ad=0.44p pd=2.88u as=0.44p ps=2.88u w=1u l=1u
X62 a_2848_8496# B2 VSS ppolyf_u_1k r_width=1u r_length=55.56u
X63 a_2848_8496# a_14088_8046# VSS ppolyf_u_1k r_width=1u r_length=55.56u
X64 a_6838_376# a_8250_14582# VDD VDD pfet_06v0 ad=2.2p pd=10.88u as=2.2p ps=10.88u w=5u l=1u
X65 a_746_332# a_14_332# a_946_376# VSS nfet_06v0 ad=2.2p pd=10.88u as=1.25p ps=5.5u w=5u l=1u
X66 VSS B2 VSS VSS nfet_06v0 ad=0.88p pd=4.88u as=0 ps=0 w=2u l=2u
X67 a_746_332# a_354_14466# a_1366_14582# VDD pfet_06v0 ad=4.4p pd=20.88u as=2.5p ps=10.5u w=10u l=1u
X68 a_14_332# a_354_14466# a_254_14582# VDD pfet_06v0 ad=4.4p pd=20.88u as=2.5p ps=10.5u w=10u l=1u
X69 a_2028_12636# a_17446_12186# VSS ppolyf_u_1k r_width=1u r_length=76.45u
X70 a_2028_12186# a_17446_12186# VSS ppolyf_u_1k r_width=1u r_length=76.45u
X71 a_2848_6666# a_14088_9426# VSS ppolyf_u_1k r_width=1u r_length=55.56u
X72 a_3010_376# a_354_14466# VSS VSS nfet_06v0 ad=0.25p pd=1.5u as=0.44p ps=2.88u w=1u l=1u
X73 a_11186_376# a_746_332# VSS VSS nfet_06v0 ad=1.25p pd=5.5u as=2.2p ps=10.88u w=5u l=1u
X74 a_54_14466# a_354_14466# a_3290_14582# VDD pfet_06v0 ad=4.4p pd=20.88u as=2.5p ps=10.5u w=10u l=1u
X75 a_2848_9876# B2 VSS ppolyf_u_1k r_width=1u r_length=55.56u
C0 a_7438_16482# a_354_14466# 0.02866f
C1 a_7382_332# a_2028_12186# 1.45978f
C2 a_14088_6666# a_54_14466# 0.11594f
C3 B2 a_354_14466# 0.21166f
C4 OUT a_54_14466# 0.77572f
C5 a_2848_6666# a_11298_15666# 0.33834f
C6 a_14088_9426# a_54_14466# 0.11594f
C7 a_9522_332# a_354_14466# 4.1712f
C8 a_6838_376# a_354_14466# 4.20911f
C9 a_4342_376# a_14_332# 1.2584f
C10 OUT a_2028_12186# 22.9539f
C11 a_4702_14582# a_354_14466# 8.4367f
C12 a_2848_11256# a_354_14466# 0.04443f
C13 a_6106_376# a_8990_376# 0.0101f
C14 a_8990_376# a_8250_14582# 0.32543f
C15 a_7438_16482# a_6838_376# 1.54823f
C16 a_12030_332# OUT 0.11341f
C17 a_4702_14582# a_4402_14582# 0.05253f
C18 a_6106_376# a_746_332# 0.21001f
C19 a_4702_14582# a_7438_16482# 0.02904f
C20 a_9522_332# B2 0.26178f
C21 VDD a_14_332# 0.6777f
C22 a_746_332# a_8250_14582# 0.02036f
C23 VDD a_12934_14466# 0.95753f
C24 a_2848_7116# a_354_14466# 0.04443f
C25 VDD a_1366_14582# 0.07139f
C26 a_2848_6666# a_354_14466# 1.02662f
C27 a_4342_376# a_54_14466# 0.02051f
C28 a_4702_14582# a_6838_376# 0.17744f
C29 a_54_14466# a_14_332# 0.91354f
C30 a_6106_376# a_11298_15666# 0.0336f
C31 a_8250_14582# a_11298_15666# 4.54274f
C32 a_54_14466# a_12934_14466# 0.13779f
C33 a_7382_332# a_8990_376# 0.31168f
C34 a_7438_16482# a_2848_6666# 4.86253f
C35 a_2848_8496# a_354_14466# 0.04443f
C36 a_14_332# a_2028_12186# 0.03098f
C37 a_746_332# a_7382_332# 0.09802f
C38 VDD a_54_14466# 4.09417f
C39 B2 a_2848_6666# 0.09103f
C40 OUT a_8990_376# 0.92531f
C41 a_9522_332# a_2848_6666# 0.29947f
C42 a_12030_332# a_14_332# 0.93803f
C43 VDD a_2028_12186# 3.98963f
C44 a_6838_376# a_2848_6666# 0.92147f
C45 a_746_332# OUT 0.40124f
C46 a_4702_14582# a_2848_6666# 12.7082f
C47 a_2848_6666# a_2848_11256# 0.02812f
C48 a_4702_14582# a_5514_14582# 0.05253f
C49 a_2028_12636# a_2028_12186# 0.02812f
C50 a_7382_332# a_11298_15666# 4.80208f
C51 a_6106_376# a_354_14466# 4.42846f
C52 a_354_14466# a_8250_14582# 4.26678f
C53 a_54_14466# a_2028_12186# 0.16307f
C54 a_14088_6666# a_11298_15666# 0.09999f
C55 a_2848_7116# a_2848_6666# 0.0559f
C56 OUT a_11298_15666# 0.10246f
C57 a_6106_376# a_7438_16482# 0.02783f
C58 a_14088_9426# a_11298_15666# 0.09999f
C59 VDD a_14578_14582# 0.07231f
C60 a_8990_376# a_14_332# 0.92645f
C61 a_17446_12186# a_17446_13086# 0.01879f
C62 a_6106_376# a_9522_332# 0.46089f
C63 a_746_332# a_4342_376# 1.11602f
C64 a_6106_376# a_6838_376# 0.17907f
C65 a_8990_376# a_12934_14466# 0.77309f
C66 a_9522_332# a_8250_14582# 0.80557f
C67 a_2848_8496# a_2848_6666# 0.0559f
C68 a_6838_376# a_8250_14582# 4.79834f
C69 a_6106_376# a_4702_14582# 0.41997f
C70 a_746_332# a_14_332# 5.67091f
C71 a_7382_332# a_354_14466# 0.02849f
C72 VDD a_8990_376# 0.60817f
C73 a_746_332# a_1366_14582# 0.05253f
C74 a_746_332# VDD 0.55461f
C75 OUT a_354_14466# 1.18514f
C76 a_7382_332# a_7438_16482# 1.17752f
C77 OUT a_17446_13086# 0.3807f
C78 a_11298_15666# a_14_332# 0.60698f
C79 a_8990_376# a_54_14466# 0.02648f
C80 a_7438_16482# OUT 0.02001f
C81 a_6106_376# a_2848_6666# 2.76492f
C82 a_2028_12636# a_746_332# 0.04489f
C83 a_12934_14466# a_11298_15666# 5.03102f
C84 a_7382_332# a_9522_332# 1.01365f
C85 a_54_14466# a_2848_9876# 0.17472f
C86 a_7382_332# a_6838_376# 1.15677f
C87 a_14088_6666# B2 0.05792f
C88 a_2848_6666# a_8250_14582# 0.30267f
C89 a_11186_376# a_11298_15666# 0.02626f
C90 a_746_332# a_54_14466# 0.28753f
C91 a_8990_376# a_2028_12186# 2.00276f
C92 B2 OUT 4.1f
C93 VDD a_11298_15666# 1.83548f
C94 B2 a_14088_9426# 0.07541f
C95 a_9522_332# OUT 0.14714f
C96 a_746_332# a_2028_12186# 0.12731f
C97 OUT a_6838_376# 0.04717f
C98 a_12030_332# a_8990_376# 0.23661f
C99 a_4702_14582# OUT 0.23868f
C100 a_3290_14582# VDD 0.07139f
C101 a_54_14466# a_11298_15666# 0.77601f
C102 a_354_14466# a_14_332# 4.32149f
C103 a_54_14466# a_14088_8046# 0.11594f
C104 a_7382_332# a_2848_6666# 1.49199f
C105 a_354_14466# a_12934_14466# 6.09276f
C106 a_11298_15666# a_2028_12186# 4.78516f
C107 a_54_14466# a_14088_10806# 0.11594f
C108 a_3290_14582# a_54_14466# 0.05253f
C109 a_7438_16482# a_14_332# 0.66071f
C110 VDD a_354_14466# 4.7562f
C111 a_6106_376# a_8250_14582# 7.10643f
C112 OUT a_2848_6666# 4.17412f
C113 a_2028_13536# VDD 0.02455f
C114 a_12030_332# a_11298_15666# 0.10093f
C115 a_4342_376# a_6838_376# 0.33698f
C116 B2 a_12934_14466# 0.05043f
C117 VDD a_4402_14582# 0.07139f
C118 VDD a_7438_16482# 0.46314f
C119 a_2028_12636# a_354_14466# 0.11398f
C120 a_4702_14582# a_4342_376# 0.73685f
C121 a_9522_332# a_14_332# 0.09853f
C122 a_6838_376# a_14_332# 0.03107f
C123 a_2028_13536# a_2028_12636# 0.01879f
C124 a_54_14466# a_354_14466# 23.4614f
C125 a_13134_14582# a_12934_14466# 0.06563f
C126 a_746_332# a_8990_376# 0.83127f
C127 VDD a_9522_332# 0.53929f
C128 a_354_14466# a_2028_12186# 4.49473f
C129 VDD a_6838_376# 1.06085f
C130 a_17446_13086# a_2028_12186# 0.06261f
C131 VDD a_13134_14582# 0.07268f
C132 a_7438_16482# a_54_14466# 0.24942f
C133 a_6106_376# a_7382_332# 1.4429f
C134 a_4702_14582# VDD 2.08378f
C135 a_7382_332# a_8250_14582# 0.54553f
C136 B2 a_54_14466# 0.35564f
C137 a_7438_16482# a_2028_12186# 0.01885f
C138 a_12030_332# a_12230_376# 0.03311f
C139 a_4342_376# a_2848_6666# 1.0972f
C140 a_6106_376# OUT 1.75439f
C141 a_8990_376# a_11298_15666# 4.752f
C142 a_9522_332# a_54_14466# 0.11884f
C143 B2 a_2028_12186# 1.3774f
C144 a_2848_6666# a_14_332# 0.77493f
C145 a_6838_376# a_54_14466# 0.19711f
C146 OUT a_8250_14582# 0.07203f
C147 a_2848_6666# a_12934_14466# 0.15066f
C148 a_4702_14582# a_54_14466# 1.08166f
C149 a_746_332# a_11298_15666# 0.04337f
C150 a_9522_332# a_2028_12186# 3.91637f
C151 a_54_14466# a_2848_11256# 0.17472f
C152 a_6838_376# a_2028_12186# 0.12719f
C153 VDD a_2848_6666# 1.64273f
C154 a_4702_14582# a_2028_12186# 0.07331f
C155 a_746_332# a_946_376# 0.02626f
C156 a_12030_332# a_9522_332# 0.76776f
C157 VDD a_5514_14582# 0.07452f
C158 a_17446_12186# OUT 0.36015f
C159 a_2848_7116# a_54_14466# 0.17472f
C160 a_7382_332# OUT 0.09029f
C161 a_2848_6666# a_54_14466# 1.12238f
C162 a_8990_376# a_354_14466# 0.02847f
C163 a_11298_15666# a_14088_8046# 0.09999f
C164 a_6106_376# a_4342_376# 0.65272f
C165 a_354_14466# a_2848_9876# 0.04443f
C166 a_14088_10806# a_11298_15666# 0.09999f
C167 a_2848_6666# a_2028_12186# 1.25252f
C168 a_9522_332# a_14578_14582# 0.05253f
C169 a_746_332# a_354_14466# 5.91708f
C170 a_6106_376# a_14_332# 0.0882f
C171 a_2028_13536# a_746_332# 0.04489f
C172 a_2848_8496# a_54_14466# 0.17472f
C173 a_8250_14582# a_14_332# 0.02765f
C174 a_14_332# a_254_14582# 0.05253f
C175 a_12030_332# a_2848_6666# 0.01051f
C176 B2 a_8990_376# 0.01473f
C177 a_746_332# a_7438_16482# 0.02399f
C178 a_6106_376# VDD 0.91306f
C179 VDD a_8250_14582# 2.16316f
C180 VDD a_254_14582# 0.07875f
C181 a_9522_332# a_8990_376# 1.14696f
C182 a_354_14466# a_11298_15666# 0.14746f
C183 a_4042_376# a_4342_376# 0.02626f
C184 a_746_332# a_9522_332# 0.03608f
C185 a_746_332# a_6838_376# 0.0204f
C186 a_4702_14582# a_746_332# 0.02078f
C187 a_6106_376# a_54_14466# 0.37483f
C188 a_7382_332# a_14_332# 0.89977f
C189 a_54_14466# a_8250_14582# 1.20596f
C190 a_6106_376# a_2028_12186# 0.7278f
C191 OUT a_4342_376# 0.0791f
C192 B2 a_11298_15666# 0.268f
C193 a_8250_14582# a_2028_12186# 1.19761f
C194 OUT a_14_332# 0.54464f
C195 B2 a_14088_8046# 0.07541f
C196 VDD a_7382_332# 0.41268f
C197 a_9522_332# a_11298_15666# 1.01498f
C198 OUT a_12934_14466# 0.02205f
C199 a_8990_376# a_2848_6666# 0.45463f
C200 B2 a_14088_10806# 0.07501f
C201 a_2848_6666# a_2848_9876# 0.0559f
C202 VDD OUT 2.09101f
C203 a_746_332# a_2848_6666# 0.54636f
C204 a_2028_13536# a_354_14466# 0.11398f
C205 a_5074_376# a_4342_376# 0.02626f
C206 a_17446_12186# a_2028_12186# 0.06261f
C207 a_7382_332# a_54_14466# 0.06665f
C208 B2 VSS 13.2374f
C209 OUT VSS 23.8213f
C210 VDD VSS 0.15519p
C211 a_12230_376# VSS 0.04817f
C212 a_11186_376# VSS 0.04308f
C213 a_12030_332# VSS 1.27294f
C214 a_5074_376# VSS 0.04916f
C215 a_4042_376# VSS 0.04308f
C216 a_3010_376# VSS 0.01317f
C217 a_1978_376# VSS 0.01198f
C218 a_946_376# VSS 0.04308f
C219 a_4342_376# VSS 2.02593f
C220 a_14088_6666# VSS 0.48404f
C221 a_2848_7116# VSS 0.56125f
C222 a_14088_8046# VSS 0.4689f
C223 a_2848_8496# VSS 0.56125f
C224 a_14088_9426# VSS 0.4689f
C225 a_2848_9876# VSS 0.56125f
C226 a_14088_10806# VSS 0.4689f
C227 a_2848_11256# VSS 0.57639f
C228 a_17446_12186# VSS 0.47328f
C229 a_2028_12636# VSS 0.57385f
C230 a_17446_13086# VSS 0.45689f
C231 a_2028_13536# VSS 0.5657f
C232 a_9522_332# VSS 5.24588f
C233 a_8990_376# VSS 4.4656f
C234 a_7382_332# VSS 5.21182f
C235 a_6106_376# VSS 7.10557f
C236 a_6838_376# VSS 5.17449f
C237 a_7438_16482# VSS 2.6014f
C238 a_4702_14582# VSS 8.91169f
C239 a_746_332# VSS 7.67228f
C240 a_14_332# VSS 10.2274f
C241 a_2028_12186# VSS 20.2099f
C242 a_12934_14466# VSS 4.11731f
C243 a_11298_15666# VSS 6.9311f
C244 a_8250_14582# VSS 9.25038f
C245 a_2848_6666# VSS 15.5265f
C246 a_354_14466# VSS 27.3451f
C247 a_54_14466# VSS 20.2885f
.ends
