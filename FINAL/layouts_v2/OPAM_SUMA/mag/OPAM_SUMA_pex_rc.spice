* Nodos de bulk atados: 0 de pozo n -> VDD, 1 de sustrato -> VSS.
*   magic no extrae los taps de este layout y los dejaba flotando;
*   la conexion si existe (el LVS de KLayout da 'match uniquely').
*   Quien detecta un tap que falte de verdad es el LVS, no esto.
* Nodos de bulk atados: 28 de pozo n -> VDD, 26 de sustrato -> VSS.
*   magic no extrae los taps de este layout y los dejaba flotando;
*   la conexion si existe (el LVS de KLayout da 'match uniquely').
*   Quien detecta un tap que falte de verdad es el LVS, no esto.
* NGSPICE file created from OPAM_SUMA.ext - technology: gf180mcuD

.subckt OPAM_SUMA VSS VDD OUT
X0 a_6106_376.t2 a_8074_14766.t3 VDD.t38 VDD pfet_06v0 ad=1.65p pd=5.66u as=2.2p ps=10.88u w=5u l=1u
X1 a_928_5966.t8 OUT.t6 cap_mim_2f0_m4m5_noshield c_width=25u c_length=4u
X2 a_8058_332.t2 a_8058_332.t1 a_11266_332.t1 VSS nfet_06v0 ad=2.2p pd=10.88u as=1.65p ps=5.66u w=5u l=1u
X3 a_54_13766.t1 a_354_13766.t13 a_3290_13882.t0 VDD pfet_06v0 ad=4.4p pd=20.88u as=2.5p ps=10.5u w=10u l=1u
X4 a_4342_376.t2 a_14_332.t8 a_4042_376.t1 VSS nfet_06v0 ad=2.2p pd=10.88u as=1.25p ps=5.5u w=5u l=1u
X5 a_8738_14766.t2 a_8738_14766.t1 a_11074_13766.t0 VDD pfet_06v0 ad=4.4p pd=20.88u as=3.3p ps=10.66u w=10u l=1u
X6 OUT.t2 a_948_11486.t5 VDD.t14 VDD pfet_06v0 ad=0.22p pd=1.88u as=0.22p ps=1.88u w=0.5u l=1u
X7 OUT.t7 a_6106_376.t3 cap_mim_2f0_m4m5_noshield c_width=25u c_length=4u
X8 a_928_9176.t0 a_12168_9626.t0 VSS.t0 ppolyf_u_3k r_width=1u r_length=55.56u
X9 a_928_9176.t1 a_12168_8726.t1 VSS.t0 ppolyf_u_3k r_width=1u r_length=55.56u
X10 a_928_5966.t7 a_12168_5966.t1 VSS.t0 ppolyf_u_3k r_width=1u r_length=55.56u
X11 a_928_5966.t1 a_7394_332.t3 VSS.t30 VSS nfet_06v0 ad=0.825p pd=3.16u as=1.1p ps=5.88u w=2.5u l=1u
X12 a_8058_332.t0 a_354_13766.t7 a_12718_13882.t0 VDD pfet_06v0 ad=4.4p pd=20.88u as=2.5p ps=10.5u w=10u l=1u
X13 a_948_12836.t0 OUT.t4 VSS.t8 ppolyf_u_3k r_width=1u r_length=76.45u
X14 a_928_6416.t1 a_12168_5966.t0 VSS.t0 ppolyf_u_3k r_width=1u r_length=55.56u
X15 a_54_13766.t0 a_354_13766.t5 a_1978_376.t1 VSS nfet_06v0 ad=0.44p pd=2.88u as=0.25p ps=1.5u w=1u l=1u
X16 a_6106_376.t0 a_928_5966.t10 a_4342_376.t0 VSS nfet_06v0 ad=0.44p pd=2.88u as=0.44p ps=2.88u w=1u l=1u
X17 a_8074_14766.t0 a_8058_332.t4 a_7394_332.t1 VSS nfet_06v0 ad=1.1p pd=5.88u as=0.825p ps=3.16u w=2.5u l=1u
X18 a_1366_13882.t0 a_54_13766.t6 VDD.t10 VDD pfet_06v0 ad=2.5p pd=10.5u as=4.4p ps=20.88u w=10u l=1u
X19 a_8074_14766.t1 a_354_13766.t10 a_6838_376.t0 VDD pfet_06v0 ad=1.65p pd=5.66u as=1.65p ps=5.66u w=5u l=1u
X20 a_9346_376.t2 a_8738_14766.t3 a_948_11486.t3 VDD pfet_06v0 ad=2.2p pd=10.88u as=1.65p ps=5.66u w=5u l=1u
X21 a_4042_376.t0 a_746_332.t4 VSS.t19 VSS nfet_06v0 ad=1.25p pd=5.5u as=2.2p ps=10.88u w=5u l=1u
X22 a_11466_376.t1 a_11266_332.t2 VSS.t33 VSS nfet_06v0 ad=1.25p pd=5.5u as=2.2p ps=10.88u w=5u l=1u
X23 a_948_11486.t1 a_8058_332.t3 a_9346_376.t1 VSS nfet_06v0 ad=1.1p pd=5.88u as=0.825p ps=3.16u w=2.5u l=1u
X24 a_1978_376.t0 a_354_13766.t6 VSS.t2 VSS nfet_06v0 ad=0.25p pd=1.5u as=0.44p ps=2.88u w=1u l=1u
X25 a_3290_13882.t1 a_54_13766.t5 VDD.t21 VDD pfet_06v0 ad=2.5p pd=10.5u as=4.4p ps=20.88u w=10u l=1u
X26 a_11266_332.t0 a_14_332.t3 a_11466_376.t0 VSS nfet_06v0 ad=1.65p pd=5.66u as=1.25p ps=5.5u w=5u l=1u
X27 a_11074_13766.t1 a_354_13766.t8 a_11274_13882.t1 VDD pfet_06v0 ad=3.3p pd=10.66u as=2.5p ps=10.5u w=10u l=1u
X28 a_928_6416.t0 a_12168_6866.t0 VSS.t0 ppolyf_u_3k r_width=1u r_length=55.56u
X29 OUT.t0 a_948_11486.t4 VDD.t7 VDD pfet_06v0 ad=0.22p pd=1.88u as=0.22p ps=1.88u w=0.5u l=1u
X30 a_4342_376.t1 a_14_332.t7 a_5074_376.t0 VSS nfet_06v0 ad=2.2p pd=10.88u as=1.25p ps=5.5u w=5u l=1u
X31 a_6838_376.t2 a_928_5966.t9 a_4342_376.t3 VSS nfet_06v0 ad=0.44p pd=2.88u as=0.44p ps=2.88u w=1u l=1u
X32 a_354_13766.t3 a_354_13766.t2 VDD.t32 VDD pfet_06v0 ad=0.88p pd=4.88u as=0.88p ps=4.88u w=2u l=1u
X33 a_4702_13882.t1 a_354_13766.t12 a_4402_13882.t0 VDD pfet_06v0 ad=4.4p pd=20.88u as=2.5p ps=10.5u w=10u l=1u
X34 a_12718_13882.t1 a_54_13766.t2 VDD.t40 VDD pfet_06v0 ad=2.5p pd=10.5u as=4.4p ps=20.88u w=10u l=1u
X35 a_6838_376.t1 a_8074_14766.t4 VDD.t28 VDD pfet_06v0 ad=1.65p pd=5.66u as=2.2p ps=10.88u w=5u l=1u
X36 OUT.t1 a_948_11486.t7 VDD.t12 VDD pfet_06v0 ad=0.22p pd=1.88u as=0.22p ps=1.88u w=0.5u l=1u
X37 a_14_332.t1 a_14_332.t0 VSS.t10 VSS nfet_06v0 ad=0.44p pd=2.88u as=0.44p ps=2.88u w=1u l=1u
X38 a_4702_13882.t3 a_354_13766.t11 a_5514_13882.t0 VDD pfet_06v0 ad=4.4p pd=20.88u as=2.5p ps=10.5u w=10u l=1u
X39 a_928_5966.t3 a_12168_7346.t0 VSS.t0 ppolyf_u_3k r_width=1u r_length=55.56u
X40 OUT.t5 a_9346_376.t3 VSS.t26 VSS nfet_06v0 ad=0.44p pd=2.88u as=0.44p ps=2.88u w=1u l=1u
X41 a_928_5966.t4 a_12168_10106.t1 VSS.t0 ppolyf_u_3k r_width=1u r_length=55.56u
X42 a_5074_376.t1 a_746_332.t3 VSS.t15 VSS nfet_06v0 ad=1.25p pd=5.5u as=2.2p ps=10.88u w=5u l=1u
X43 a_9346_376.t0 a_14_332.t5 a_928_5966.t0 VSS nfet_06v0 ad=0.825p pd=3.16u as=0.825p ps=3.16u w=2.5u l=1u
X44 a_254_13882.t0 a_54_13766.t7 VDD.t4 VDD pfet_06v0 ad=2.5p pd=10.5u as=4.4p ps=20.88u w=10u l=1u
X45 a_7394_332.t2 a_8738_14766.t4 a_8074_14766.t2 VDD pfet_06v0 ad=2.2p pd=10.88u as=1.65p ps=5.66u w=5u l=1u
X46 a_11274_13882.t0 a_11074_13766.t2 VDD.t19 VDD pfet_06v0 ad=2.5p pd=10.5u as=4.4p ps=20.88u w=10u l=1u
X47 a_948_11936.t0 a_16366_11486.t0 VSS.t8 ppolyf_u_3k r_width=1u r_length=76.45u
X48 a_948_11486.t2 a_16366_11486.t1 VSS.t8 ppolyf_u_3k r_width=1u r_length=76.45u
X49 a_946_376.t1 a_746_332.t5 VSS.t37 VSS nfet_06v0 ad=1.25p pd=5.5u as=2.2p ps=10.88u w=5u l=1u
X50 a_7438_15682.t0 a_928_5966.t11 a_4702_13882.t0 VDD pfet_06v0 ad=0.44p pd=2.88u as=0.44p ps=2.88u w=1u l=1u
X51 a_10410_376.t1 a_746_332.t2 VSS.t17 VSS nfet_06v0 ad=1.25p pd=5.5u as=2.2p ps=10.88u w=5u l=1u
X52 a_4402_13882.t1 a_54_13766.t4 VDD.t23 VDD pfet_06v0 ad=2.5p pd=10.5u as=4.4p ps=20.88u w=10u l=1u
X53 a_354_13766.t1 a_354_13766.t0 a_3010_376.t0 VSS nfet_06v0 ad=0.44p pd=2.88u as=0.25p ps=1.5u w=1u l=1u
X54 a_5514_13882.t1 a_54_13766.t3 VDD.t36 VDD pfet_06v0 ad=2.5p pd=10.5u as=4.4p ps=20.88u w=10u l=1u
X55 a_948_11486.t0 a_354_13766.t9 a_6106_376.t1 VDD pfet_06v0 ad=1.65p pd=5.66u as=1.65p ps=5.66u w=5u l=1u
X56 a_928_10556.t1 a_12168_10106.t0 VSS.t0 ppolyf_u_3k r_width=1u r_length=55.56u
X57 a_928_7796.t0 a_12168_7346.t1 VSS.t0 ppolyf_u_3k r_width=1u r_length=55.56u
X58 a_7394_332.t0 a_14_332.t6 a_7438_15682.t2 VSS nfet_06v0 ad=0.825p pd=3.16u as=0.825p ps=3.16u w=2.5u l=1u
X59 OUT.t3 a_948_11486.t6 VDD.t16 VDD pfet_06v0 ad=0.22p pd=1.88u as=0.22p ps=1.88u w=0.5u l=1u
X60 a_928_10556.t0 a_12168_11006.t0 VSS.t0 ppolyf_u_3k r_width=1u r_length=55.56u
X61 a_928_7796.t1 a_12168_8246.t0 VSS.t0 ppolyf_u_3k r_width=1u r_length=55.56u
X62 a_8738_14766.t0 a_14_332.t4 a_10410_376.t0 VSS nfet_06v0 ad=2.2p pd=10.88u as=1.25p ps=5.5u w=5u l=1u
X63 a_746_332.t0 a_14_332.t9 a_946_376.t0 VSS nfet_06v0 ad=2.2p pd=10.88u as=1.25p ps=5.5u w=5u l=1u
X64 a_7438_15682.t1 a_7394_332.t4 VSS.t35 VSS nfet_06v0 ad=0.825p pd=3.16u as=1.1p ps=5.88u w=2.5u l=1u
X65 a_928_5966.t2 a_12168_8726.t0 VSS.t0 ppolyf_u_3k r_width=1u r_length=55.56u
X66 a_948_12836.t1 a_16366_12386.t1 VSS.t8 ppolyf_u_3k r_width=1u r_length=76.45u
X67 a_3010_376.t1 a_354_13766.t4 VSS.t28 VSS nfet_06v0 ad=0.25p pd=1.5u as=0.44p ps=2.88u w=1u l=1u
X68 a_948_11936.t1 a_16366_12386.t0 VSS.t8 ppolyf_u_3k r_width=1u r_length=76.45u
X69 a_746_332.t1 a_354_13766.t14 a_1366_13882.t1 VDD pfet_06v0 ad=4.4p pd=20.88u as=2.5p ps=10.5u w=10u l=1u
X70 a_14_332.t2 a_354_13766.t15 a_254_13882.t1 VDD pfet_06v0 ad=4.4p pd=20.88u as=2.5p ps=10.5u w=10u l=1u
X71 a_928_5966.t6 a_928_5966.t5 a_4702_13882.t2 VDD pfet_06v0 ad=0.484p pd=3.08u as=0.484p ps=3.08u w=1.1u l=1u
R0 OUT.n3 OUT.t0 40.9509
R1 OUT.n5 OUT.t3 40.7677
R2 OUT.n4 OUT.t2 40.7677
R3 OUT OUT.t1 36.2677
R4 OUT.n2 OUT.t4 34.0563
R5 OUT.n2 OUT.t7 14.5655
R6 OUT.n1 OUT.t5 11.9355
R7 OUT.n1 OUT.t6 9.18093
R8 OUT.n8 OUT.n7 5.4005
R9 OUT.n7 OUT.n6 5.333
R10 OUT.n3 OUT.n2 4.5005
R11 OUT.n7 OUT.n0 4.5005
R12 OUT OUT.n9 4.5005
R13 OUT.n8 OUT.n1 1.24764
R14 OUT.n9 OUT.n0 1.15443
R15 OUT.n4 OUT.n3 1.05157
R16 OUT.n6 OUT.n5 1.03871
R17 OUT.n6 OUT.n4 0.196571
R18 OUT.n5 OUT.n0 0.0833947
R19 OUT.n9 OUT.n8 0.0691842
R20 VDD VDD 312.875
R21 VDD VDD 303.892
R22 VDD VDD 303.892
R23 VDD VDD 303.892
R24 VDD VDD 303.892
R25 VDD VDD 303.892
R26 VDD.n46 VDD 161.678
R27 VDD.n60 VDD 161.678
R28 VDD.n30 VDD 152.696
R29 VDD.n31 VDD 152.696
R30 VDD.n45 VDD 152.696
R31 VDD.n61 VDD 152.696
R32 VDD.n89 VDD 152.696
R33 VDD VDD.n88 152.696
R34 VDD.n76 VDD 152.696
R35 VDD VDD.n30 151.198
R36 VDD.n31 VDD 151.198
R37 VDD VDD.n45 151.198
R38 VDD.n46 VDD 151.198
R39 VDD VDD.n60 151.198
R40 VDD VDD.n61 151.198
R41 VDD.n89 VDD 151.198
R42 VDD.n88 VDD 151.198
R43 VDD.n76 VDD 151.198
R44 VDD VDD 124.252
R45 VDD VDD 124.252
R46 VDD VDD 124.252
R47 VDD VDD 124.252
R48 VDD VDD 124.252
R49 VDD VDD 112.275
R50 VDD VDD 112.275
R51 VDD VDD 112.275
R52 VDD VDD 112.275
R53 VDD VDD 112.275
R54 VDD VDD 112.275
R55 VDD VDD 112.275
R56 VDD.n30 VDD.n29 12.6005
R57 VDD.n32 VDD.n31 12.6005
R58 VDD.n45 VDD.n44 12.6005
R59 VDD.n47 VDD.n46 12.6005
R60 VDD.n60 VDD.n59 12.6005
R61 VDD.n61 VDD.n4 12.6005
R62 VDD.n90 VDD.n89 12.6005
R63 VDD.n88 VDD.n87 12.6005
R64 VDD.n77 VDD.n76 12.6005
R65 VDD.n20 VDD.t7 9.29792
R66 VDD.n17 VDD.t12 9.28167
R67 VDD.n23 VDD.t16 9.28167
R68 VDD.n21 VDD.t14 9.28167
R69 VDD.n80 VDD.n79 9.0005
R70 VDD.n81 VDD.n73 9.0005
R71 VDD.n83 VDD.n82 9.0005
R72 VDD.n84 VDD.n63 9.0005
R73 VDD.n86 VDD.n85 9.0005
R74 VDD.n72 VDD.n71 9.0005
R75 VDD.n70 VDD.n64 9.0005
R76 VDD.n69 VDD.n68 9.0005
R77 VDD.n67 VDD.n66 9.0005
R78 VDD.n9 VDD.n7 9.0005
R79 VDD.n92 VDD.n91 9.0005
R80 VDD.n93 VDD.n6 9.0005
R81 VDD.n95 VDD.n94 9.0005
R82 VDD.n96 VDD.n5 9.0005
R83 VDD.n98 VDD.n97 9.0005
R84 VDD.n100 VDD.n99 9.0005
R85 VDD.n101 VDD.n3 9.0005
R86 VDD.n103 VDD.n102 9.0005
R87 VDD.n105 VDD.n104 9.0005
R88 VDD.n2 VDD.n0 9.0005
R89 VDD.n58 VDD.n57 9.0005
R90 VDD.n56 VDD.n55 9.0005
R91 VDD.n54 VDD.n11 9.0005
R92 VDD.n53 VDD.n52 9.0005
R93 VDD.n51 VDD.n12 9.0005
R94 VDD.n50 VDD.n49 9.0005
R95 VDD.n14 VDD.n13 9.0005
R96 VDD.n43 VDD.n42 9.0005
R97 VDD.n41 VDD.n15 9.0005
R98 VDD.n40 VDD.n39 9.0005
R99 VDD.n37 VDD.n16 9.0005
R100 VDD.n36 VDD.n35 9.0005
R101 VDD.n34 VDD.n33 9.0005
R102 VDD.n19 VDD.n18 9.0005
R103 VDD.n24 VDD.n22 9.0005
R104 VDD.n26 VDD.n25 9.0005
R105 VDD.n28 VDD.n27 9.0005
R106 VDD.n27 VDD.n20 3.38619
R107 VDD.n79 VDD.n78 3.23511
R108 VDD.n74 VDD.t32 2.82475
R109 VDD.n78 VDD.t4 2.14376
R110 VDD.n75 VDD.t10 1.96744
R111 VDD.n62 VDD.t21 1.96744
R112 VDD.n65 VDD.t23 1.96744
R113 VDD.n8 VDD.t36 1.96744
R114 VDD.n48 VDD.t19 1.96744
R115 VDD.n38 VDD.t40 1.96744
R116 VDD.n1 VDD.t28 1.8449
R117 VDD.n10 VDD.t38 1.8449
R118 VDD.n78 VDD.n77 0.25569
R119 VDD.n27 VDD.n26 0.2005
R120 VDD.n26 VDD.n22 0.2005
R121 VDD.n22 VDD.n18 0.2005
R122 VDD.n34 VDD.n18 0.2005
R123 VDD.n35 VDD.n34 0.2005
R124 VDD.n35 VDD.n16 0.2005
R125 VDD.n40 VDD.n16 0.2005
R126 VDD.n41 VDD.n40 0.2005
R127 VDD.n42 VDD.n41 0.2005
R128 VDD.n42 VDD.n13 0.2005
R129 VDD.n50 VDD.n13 0.2005
R130 VDD.n51 VDD.n50 0.2005
R131 VDD.n52 VDD.n51 0.2005
R132 VDD.n52 VDD.n11 0.2005
R133 VDD.n56 VDD.n11 0.2005
R134 VDD.n57 VDD.n56 0.2005
R135 VDD.n57 VDD.n2 0.2005
R136 VDD.n104 VDD.n2 0.2005
R137 VDD.n104 VDD.n103 0.2005
R138 VDD.n103 VDD.n3 0.2005
R139 VDD.n99 VDD.n3 0.2005
R140 VDD.n99 VDD.n98 0.2005
R141 VDD.n98 VDD.n5 0.2005
R142 VDD.n94 VDD.n5 0.2005
R143 VDD.n94 VDD.n93 0.2005
R144 VDD.n93 VDD.n92 0.2005
R145 VDD.n92 VDD.n7 0.2005
R146 VDD.n67 VDD.n7 0.2005
R147 VDD.n68 VDD.n67 0.2005
R148 VDD.n68 VDD.n64 0.2005
R149 VDD.n72 VDD.n64 0.2005
R150 VDD.n85 VDD.n72 0.2005
R151 VDD.n85 VDD.n84 0.2005
R152 VDD.n84 VDD.n83 0.2005
R153 VDD.n83 VDD.n73 0.2005
R154 VDD.n79 VDD.n73 0.2005
R155 VDD.n25 VDD.n24 0.2005
R156 VDD.n37 VDD.n36 0.2005
R157 VDD.n39 VDD.n37 0.2005
R158 VDD.n43 VDD.n14 0.2005
R159 VDD.n49 VDD.n14 0.2005
R160 VDD.n53 VDD.n12 0.2005
R161 VDD.n54 VDD.n53 0.2005
R162 VDD.n55 VDD.n54 0.2005
R163 VDD.n58 VDD.n0 0.2005
R164 VDD.n102 VDD.n101 0.2005
R165 VDD.n101 VDD.n100 0.2005
R166 VDD.n97 VDD.n96 0.2005
R167 VDD.n96 VDD.n95 0.2005
R168 VDD.n95 VDD.n6 0.2005
R169 VDD.n66 VDD.n9 0.2005
R170 VDD.n70 VDD.n69 0.2005
R171 VDD.n71 VDD.n70 0.2005
R172 VDD.n86 VDD.n63 0.2005
R173 VDD.n82 VDD.n81 0.2005
R174 VDD.n81 VDD.n80 0.2005
R175 VDD.n33 VDD.n17 0.174
R176 VDD.n24 VDD.n23 0.168
R177 VDD.n28 VDD.n21 0.162
R178 VDD.n105 VDD.n1 0.152
R179 VDD.n44 VDD.n43 0.1515
R180 VDD.n82 VDD.n74 0.151
R181 VDD.n90 VDD.n9 0.1495
R182 VDD VDD.n0 0.1385
R183 VDD.n48 VDD.n47 0.132
R184 VDD.n59 VDD.n10 0.132
R185 VDD.n8 VDD.n6 0.132
R186 VDD.n39 VDD.n38 0.13
R187 VDD.n29 VDD.n28 0.1255
R188 VDD.n87 VDD.n62 0.12
R189 VDD.n77 VDD.n75 0.12
R190 VDD.n33 VDD.n32 0.1135
R191 VDD.n69 VDD.n65 0.113
R192 VDD.n97 VDD.n4 0.1115
R193 VDD.n29 VDD.n20 0.10461
R194 VDD.n100 VDD.n4 0.0895
R195 VDD.n66 VDD.n65 0.088
R196 VDD.n32 VDD.n19 0.0875
R197 VDD.n38 VDD.n15 0.071
R198 VDD.n91 VDD.n8 0.069
R199 VDD.n59 VDD.n58 0.0675
R200 VDD VDD.n105 0.0625
R201 VDD.n49 VDD.n48 0.052
R202 VDD.n91 VDD.n90 0.0515
R203 VDD.n74 VDD.n63 0.05
R204 VDD.n44 VDD.n15 0.0495
R205 VDD.n102 VDD.n1 0.049
R206 VDD.n71 VDD.n62 0.044
R207 VDD.n25 VDD.n21 0.039
R208 VDD.n87 VDD.n86 0.0375
R209 VDD.n23 VDD.n19 0.033
R210 VDD.n36 VDD.n17 0.027
R211 VDD.n47 VDD.n12 0.0175
R212 VDD.n80 VDD.n75 0.006
R213 VDD.n55 VDD.n10 0.002
R214 VSS.n18 VSS 209.175
R215 VSS VSS 180.849
R216 VSS VSS 180.849
R217 VSS VSS 175.107
R218 VSS VSS 175.107
R219 VSS VSS 175.107
R220 VSS VSS.n16 88.0323
R221 VSS.n37 VSS 88.0323
R222 VSS.n67 VSS 88.0323
R223 VSS VSS.n66 88.0323
R224 VSS.n54 VSS 88.0323
R225 VSS.n16 VSS 87.0754
R226 VSS VSS.n37 87.0754
R227 VSS VSS.n38 87.0754
R228 VSS VSS.n39 87.0754
R229 VSS.n67 VSS 87.0754
R230 VSS.n66 VSS 87.0754
R231 VSS.n54 VSS 87.0754
R232 VSS VSS 79.4205
R233 VSS VSS 79.4205
R234 VSS VSS 79.4205
R235 VSS VSS 79.4205
R236 VSS VSS 79.4205
R237 VSS VSS 71.7656
R238 VSS VSS 71.7656
R239 VSS VSS 71.7656
R240 VSS VSS 71.7656
R241 VSS VSS 71.7656
R242 VSS VSS 71.7656
R243 VSS VSS 71.7656
R244 VSS.n39 VSS.t0 57.891
R245 VSS.n38 VSS.t8 47.6047
R246 VSS.t8 VSS 46.1693
R247 VSS.t0 VSS 30.1418
R248 VSS.n16 VSS.n15 10.4005
R249 VSS.n37 VSS.n36 10.4005
R250 VSS.n38 VSS.n0 10.4005
R251 VSS.n39 VSS.n4 10.4005
R252 VSS.n68 VSS.n67 10.4005
R253 VSS.n66 VSS.n65 10.4005
R254 VSS.n55 VSS.n54 10.4005
R255 VSS.n33 VSS.n11 9.0005
R256 VSS.n32 VSS.n31 9.0005
R257 VSS.n29 VSS.n2 9.0005
R258 VSS.n85 VSS.n84 9.0005
R259 VSS.n83 VSS.n1 9.0005
R260 VSS.n82 VSS.n81 9.0005
R261 VSS.n79 VSS.n3 9.0005
R262 VSS.n78 VSS.n77 9.0005
R263 VSS.n76 VSS.n75 9.0005
R264 VSS.n74 VSS.n5 9.0005
R265 VSS.n73 VSS.n72 9.0005
R266 VSS.n71 VSS.n6 9.0005
R267 VSS.n70 VSS.n69 9.0005
R268 VSS.n9 VSS.n7 9.0005
R269 VSS.n44 VSS.n43 9.0005
R270 VSS.n46 VSS.n42 9.0005
R271 VSS.n49 VSS.n48 9.0005
R272 VSS.n50 VSS.n40 9.0005
R273 VSS.n64 VSS.n63 9.0005
R274 VSS.n62 VSS.n41 9.0005
R275 VSS.n61 VSS.n60 9.0005
R276 VSS.n59 VSS.n51 9.0005
R277 VSS.n58 VSS.n57 9.0005
R278 VSS.n20 VSS.n19 9.0005
R279 VSS.n21 VSS.n14 9.0005
R280 VSS.n23 VSS.n22 9.0005
R281 VSS.n25 VSS.n24 9.0005
R282 VSS.n26 VSS.n12 9.0005
R283 VSS.n28 VSS.n27 9.0005
R284 VSS.n35 VSS.n34 9.0005
R285 VSS.n56 VSS.t10 5.3806
R286 VSS.n17 VSS.t26 5.28916
R287 VSS.n47 VSS.t28 5.28916
R288 VSS.n52 VSS.t2 5.28916
R289 VSS.n57 VSS.n56 4.71005
R290 VSS.n30 VSS.t30 2.58836
R291 VSS.n80 VSS.t35 2.58836
R292 VSS.n13 VSS.t33 1.91886
R293 VSS.n10 VSS.t17 1.91886
R294 VSS.n8 VSS.t15 1.91886
R295 VSS.n45 VSS.t19 1.91886
R296 VSS.n53 VSS.t37 1.91886
R297 VSS.n19 VSS.n18 1.63426
R298 VSS.n18 VSS.n17 0.388546
R299 VSS.n19 VSS.n14 0.2005
R300 VSS.n23 VSS.n14 0.2005
R301 VSS.n24 VSS.n23 0.2005
R302 VSS.n24 VSS.n12 0.2005
R303 VSS.n28 VSS.n12 0.2005
R304 VSS.n34 VSS.n28 0.2005
R305 VSS.n34 VSS.n33 0.2005
R306 VSS.n33 VSS.n32 0.2005
R307 VSS.n32 VSS.n2 0.2005
R308 VSS.n84 VSS.n2 0.2005
R309 VSS.n84 VSS.n83 0.2005
R310 VSS.n83 VSS.n82 0.2005
R311 VSS.n82 VSS.n3 0.2005
R312 VSS.n77 VSS.n3 0.2005
R313 VSS.n77 VSS.n76 0.2005
R314 VSS.n76 VSS.n5 0.2005
R315 VSS.n72 VSS.n5 0.2005
R316 VSS.n72 VSS.n71 0.2005
R317 VSS.n71 VSS.n70 0.2005
R318 VSS.n70 VSS.n7 0.2005
R319 VSS.n43 VSS.n7 0.2005
R320 VSS.n43 VSS.n42 0.2005
R321 VSS.n49 VSS.n42 0.2005
R322 VSS.n50 VSS.n49 0.2005
R323 VSS.n63 VSS.n50 0.2005
R324 VSS.n63 VSS.n62 0.2005
R325 VSS.n62 VSS.n61 0.2005
R326 VSS.n61 VSS.n51 0.2005
R327 VSS.n57 VSS.n51 0.2005
R328 VSS.n21 VSS.n20 0.2005
R329 VSS.n22 VSS.n21 0.2005
R330 VSS.n26 VSS.n25 0.2005
R331 VSS.n27 VSS.n26 0.2005
R332 VSS.n35 VSS.n11 0.2005
R333 VSS.n31 VSS.n11 0.2005
R334 VSS.n85 VSS.n1 0.2005
R335 VSS.n81 VSS.n1 0.2005
R336 VSS.n79 VSS.n78 0.2005
R337 VSS.n75 VSS.n74 0.2005
R338 VSS.n74 VSS.n73 0.2005
R339 VSS.n73 VSS.n6 0.2005
R340 VSS.n44 VSS.n9 0.2005
R341 VSS.n48 VSS.n46 0.2005
R342 VSS.n64 VSS.n41 0.2005
R343 VSS.n60 VSS.n59 0.2005
R344 VSS.n59 VSS.n58 0.2005
R345 VSS.n48 VSS.n47 0.184
R346 VSS.n31 VSS.n30 0.182
R347 VSS.n56 VSS.n55 0.174777
R348 VSS.n78 VSS.n4 0.1695
R349 VSS.n22 VSS.n13 0.156
R350 VSS.n8 VSS.n6 0.152
R351 VSS.n68 VSS.n9 0.1495
R352 VSS.n46 VSS.n45 0.133
R353 VSS.n65 VSS.n64 0.1175
R354 VSS.n80 VSS.n79 0.109
R355 VSS.n60 VSS.n52 0.101
R356 VSS.n17 VSS.n15 0.1
R357 VSS.n36 VSS.n10 0.1
R358 VSS.n52 VSS.n41 0.1
R359 VSS.n55 VSS.n53 0.1
R360 VSS.n29 VSS.n0 0.0935
R361 VSS.n81 VSS.n80 0.092
R362 VSS.n27 VSS.n10 0.084
R363 VSS.n65 VSS.n40 0.0835
R364 VSS.n45 VSS.n44 0.068
R365 VSS VSS.n85 0.0625
R366 VSS.n69 VSS.n68 0.0515
R367 VSS.n69 VSS.n8 0.049
R368 VSS VSS.n0 0.0455
R369 VSS.n25 VSS.n13 0.045
R370 VSS.n75 VSS.n4 0.0315
R371 VSS.n20 VSS.n15 0.0275
R372 VSS.n30 VSS.n29 0.019
R373 VSS.n36 VSS.n35 0.0175
R374 VSS.n47 VSS.n40 0.017
R375 VSS.n58 VSS.n53 0.016
R376 a_11466_376.t0 a_11466_376.t1 0.6305
R377 a_10410_376.t0 a_10410_376.t1 0.6305
R378 a_5074_376.t0 a_5074_376.t1 0.6305
R379 a_4342_376.t0 a_4342_376.n1 12.2624
R380 a_4342_376.n1 a_4342_376.t3 13.4066
R381 a_4342_376.n1 a_4342_376.n0 0.601571
R382 a_4342_376.n0 a_4342_376.t2 8.95471
R383 a_4342_376.n0 a_4342_376.t1 7.32828
R384 a_4042_376.t0 a_4042_376.t1 0.6305
R385 a_3010_376.t0 a_3010_376.t1 3.1505
R386 a_1978_376.t0 a_1978_376.t1 3.1505
R387 a_946_376.t0 a_946_376.t1 0.6305
R388 a_11266_332.t0 a_11266_332.n0 0.4163
R389 a_11266_332.n0 a_11266_332.t1 0.4163
R390 a_11266_332.n0 a_11266_332.t2 48.8669
R391 a_12168_5966.t0 a_12168_5966.t1 15.2227
R392 a_928_6416.t0 a_928_6416.t1 15.2227
R393 a_12168_7346.t0 a_12168_7346.t1 15.2227
R394 a_928_7796.t0 a_928_7796.t1 15.2227
R395 a_12168_8726.t0 a_12168_8726.t1 15.2227
R396 a_928_9176.t0 a_928_9176.t1 15.2227
R397 a_12168_10106.t0 a_12168_10106.t1 15.2227
R398 a_928_10556.t0 a_928_10556.t1 15.2227
R399 a_16366_11486.t0 a_16366_11486.t1 15.2227
R400 a_948_11936.t0 a_948_11936.t1 15.2227
R401 a_16366_12386.t0 a_16366_12386.t1 15.2227
R402 a_948_12836.t0 a_948_12836.t1 15.2227
R403 a_8058_332.t2 a_8058_332.n2 7.32828
R404 a_8058_332.n2 a_8058_332.t0 30.6625
R405 a_8058_332.n2 a_8058_332.n0 0.239964
R406 a_8058_332.n0 a_8058_332.n1 3.85764
R407 a_8058_332.n1 a_8058_332.t4 24.8563
R408 a_8058_332.n1 a_8058_332.t3 22.6063
R409 a_8058_332.n0 a_8058_332.t1 30.753
R410 a_12718_13882.t0 a_12718_13882.t1 0.3505
R411 a_11274_13882.t0 a_11274_13882.t1 0.3505
R412 a_9346_376.t0 a_9346_376.n0 0.8321
R413 a_9346_376.n0 a_9346_376.t1 0.8321
R414 a_9346_376.n0 a_9346_376.n1 19.1368
R415 a_9346_376.n1 a_9346_376.t3 21.517
R416 a_9346_376.n1 a_9346_376.t2 30.792
R417 a_6106_376.t0 a_6106_376.n0 13.2268
R418 a_6106_376.n0 a_6106_376.n1 44.3883
R419 a_6106_376.n1 a_6106_376.t2 0.4625
R420 a_6106_376.n1 a_6106_376.t1 0.4625
R421 a_6106_376.n0 a_6106_376.t3 9.18093
R422 a_7394_332.t0 a_7394_332.n0 0.8321
R423 a_7394_332.n0 a_7394_332.t1 0.8321
R424 a_7394_332.n0 a_7394_332.n2 18.1888
R425 a_7394_332.n2 a_7394_332.n1 1.38264
R426 a_7394_332.n1 a_7394_332.t2 30.1972
R427 a_7394_332.n1 a_7394_332.t3 23.6719
R428 a_7394_332.n2 a_7394_332.t4 24.4123
R429 a_6838_376.t2 a_6838_376.n0 54.066
R430 a_6838_376.n0 a_6838_376.t1 0.4625
R431 a_6838_376.n0 a_6838_376.t0 0.4625
R432 a_7438_15682.t0 a_7438_15682.n0 53.0652
R433 a_7438_15682.n0 a_7438_15682.t1 0.8321
R434 a_7438_15682.n0 a_7438_15682.t2 0.8321
R435 a_5514_13882.t0 a_5514_13882.t1 0.3505
R436 a_4702_13882.t0 a_4702_13882.n0 36.706
R437 a_4702_13882.n0 a_4702_13882.n1 0.730143
R438 a_4702_13882.n1 a_4702_13882.t1 30.7128
R439 a_4702_13882.n1 a_4702_13882.t3 28.9578
R440 a_4702_13882.n0 a_4702_13882.t2 35.2399
R441 a_4402_13882.t0 a_4402_13882.t1 0.3505
R442 a_3290_13882.t0 a_3290_13882.t1 0.3505
R443 a_746_332.t0 a_746_332.n3 7.07002
R444 a_746_332.n3 a_746_332.n0 0.643357
R445 a_746_332.n0 a_746_332.n1 3.51532
R446 a_746_332.n1 a_746_332.n2 1.62693
R447 a_746_332.n2 a_746_332.t2 39.0383
R448 a_746_332.n2 a_746_332.t3 30.4947
R449 a_746_332.n1 a_746_332.t4 30.4947
R450 a_746_332.n0 a_746_332.t1 29.4744
R451 a_746_332.n3 a_746_332.t5 31.2164
R452 a_1366_13882.t0 a_1366_13882.t1 0.3505
R453 a_14_332.t1 a_14_332.n7 11.7458
R454 a_14_332.n7 a_14_332.n0 0.514786
R455 a_14_332.n0 a_14_332.n1 0.808893
R456 a_14_332.n1 a_14_332.n2 4.94407
R457 a_14_332.n2 a_14_332.n3 1.62693
R458 a_14_332.n3 a_14_332.n4 4.06979
R459 a_14_332.n4 a_14_332.n5 2.2505
R460 a_14_332.n5 a_14_332.n6 2.1605
R461 a_14_332.n6 a_14_332.t3 31.9015
R462 a_14_332.n6 a_14_332.t4 30.2365
R463 a_14_332.n5 a_14_332.t5 22.0897
R464 a_14_332.n4 a_14_332.t6 22.0897
R465 a_14_332.n3 a_14_332.t7 30.2365
R466 a_14_332.n2 a_14_332.t8 30.2365
R467 a_14_332.n1 a_14_332.t9 30.2365
R468 a_14_332.n0 a_14_332.t2 29.7326
R469 a_14_332.n7 a_14_332.t0 17.4412
R470 a_254_13882.t0 a_254_13882.t1 0.3505
R471 a_948_11486.t2 a_948_11486.n5 48.1203
R472 a_948_11486.n5 a_948_11486.n1 0.331571
R473 a_948_11486.n1 a_948_11486.n2 5.68175
R474 a_948_11486.n2 a_948_11486.n3 1.27336
R475 a_948_11486.n3 a_948_11486.n4 1.27336
R476 a_948_11486.n4 a_948_11486.t4 40.6404
R477 a_948_11486.n4 a_948_11486.t5 39.3676
R478 a_948_11486.n3 a_948_11486.t6 39.3676
R479 a_948_11486.n2 a_948_11486.t7 39.3676
R480 a_948_11486.n1 a_948_11486.n0 39.0119
R481 a_948_11486.n0 a_948_11486.t0 0.4625
R482 a_948_11486.n0 a_948_11486.t3 0.4625
R483 a_948_11486.n5 a_948_11486.t1 9.77828
R484 a_11074_13766.n0 a_11074_13766.t1 0.2315
R485 a_11074_13766.t0 a_11074_13766.n0 0.2315
R486 a_11074_13766.n0 a_11074_13766.t2 109.971
R487 a_8738_14766.t0 a_8738_14766.n2 8.87785
R488 a_8738_14766.n2 a_8738_14766.n1 1.61889
R489 a_8738_14766.n1 a_8738_14766.t2 27.906
R490 a_8738_14766.n1 a_8738_14766.t1 69.2921
R491 a_8738_14766.n2 a_8738_14766.n0 0.677107
R492 a_8738_14766.n0 a_8738_14766.t4 55.3772
R493 a_8738_14766.n0 a_8738_14766.t3 52.9987
R494 a_8074_14766.t0 a_8074_14766.n2 10.267
R495 a_8074_14766.n2 a_8074_14766.n1 0.527643
R496 a_8074_14766.n1 a_8074_14766.t3 54.8303
R497 a_8074_14766.n1 a_8074_14766.n0 38.2372
R498 a_8074_14766.n0 a_8074_14766.t1 0.4625
R499 a_8074_14766.n0 a_8074_14766.t2 0.4625
R500 a_8074_14766.n2 a_8074_14766.t4 53.4707
R501 a_928_5966.t2 a_928_5966.n0 24.0227
R502 a_928_5966.n0 a_928_5966.n1 0.991
R503 a_928_5966.n1 a_928_5966.n3 1.3065
R504 a_928_5966.n4 a_928_5966.n7 0.6305
R505 a_928_5966.n3 a_928_5966.n11 3.09941
R506 a_928_5966.n12 a_928_5966.n10 4.5005
R507 a_928_5966.n11 a_928_5966.n8 4.68866
R508 a_928_5966.n11 a_928_5966.n12 0.170842
R509 a_928_5966.n12 a_928_5966.t8 9.60183
R510 a_928_5966.n10 a_928_5966.n9 21.2497
R511 a_928_5966.n9 a_928_5966.t1 0.8321
R512 a_928_5966.n9 a_928_5966.t0 0.8321
R513 a_928_5966.n10 a_928_5966.t6 35.1713
R514 a_928_5966.n8 a_928_5966.t11 42.1177
R515 a_928_5966.n8 a_928_5966.t9 17.9689
R516 a_928_5966.n7 a_928_5966.n2 1.9805
R517 a_928_5966.n7 a_928_5966.n6 9.9965
R518 a_928_5966.n6 a_928_5966.n5 0.636929
R519 a_928_5966.n5 a_928_5966.t5 41.3915
R520 a_928_5966.n4 a_928_5966.n5 9.9965
R521 a_928_5966.n6 a_928_5966.t10 18.2797
R522 a_928_5966.n3 a_928_5966.n4 0.236497
R523 a_928_5966.n7 a_928_5966.t7 24.0227
R524 a_928_5966.n1 a_928_5966.n2 0.239966
R525 a_928_5966.n2 a_928_5966.t3 24.0227
R526 a_928_5966.n0 a_928_5966.t4 26.0028
R527 a_354_13766.t1 a_354_13766.n13 14.3285
R528 a_354_13766.n13 a_354_13766.n7 0.1805
R529 a_354_13766.n7 a_354_13766.n8 1.72175
R530 a_354_13766.n8 a_354_13766.n9 1.7555
R531 a_354_13766.n9 a_354_13766.n10 4.4555
R532 a_354_13766.n10 a_354_13766.n11 2.37907
R533 a_354_13766.n11 a_354_13766.n12 2.32764
R534 a_354_13766.n12 a_354_13766.t7 71.0642
R535 a_354_13766.n12 a_354_13766.t8 68.7756
R536 a_354_13766.n11 a_354_13766.t9 52.4821
R537 a_354_13766.n10 a_354_13766.t10 52.4821
R538 a_354_13766.n9 a_354_13766.t11 68.7756
R539 a_354_13766.n8 a_354_13766.t12 68.7756
R540 a_354_13766.n7 a_354_13766.t13 68.7756
R541 a_354_13766.n13 a_354_13766.n0 0.230321
R542 a_354_13766.n0 a_354_13766.n1 0.460143
R543 a_354_13766.n1 a_354_13766.n2 0.55175
R544 a_354_13766.n2 a_354_13766.n3 0.239964
R545 a_354_13766.n3 a_354_13766.n4 0.289786
R546 a_354_13766.n4 a_354_13766.n5 0.4505
R547 a_354_13766.n5 a_354_13766.n6 0.469786
R548 a_354_13766.n6 a_354_13766.t15 70.5306
R549 a_354_13766.n6 a_354_13766.t14 68.7756
R550 a_354_13766.n5 a_354_13766.t6 19.7843
R551 a_354_13766.n4 a_354_13766.t5 19.7843
R552 a_354_13766.n3 a_354_13766.t2 42.706
R553 a_354_13766.n2 a_354_13766.t3 31.1385
R554 a_354_13766.n1 a_354_13766.t4 19.7843
R555 a_354_13766.n0 a_354_13766.t0 19.7843
R556 a_54_13766.t0 a_54_13766.n5 14.0702
R557 a_54_13766.n5 a_54_13766.n1 1.19943
R558 a_54_13766.n1 a_54_13766.n2 0.845857
R559 a_54_13766.n2 a_54_13766.n3 1.00175
R560 a_54_13766.n3 a_54_13766.n4 1.7555
R561 a_54_13766.n4 a_54_13766.t2 80.5796
R562 a_54_13766.n4 a_54_13766.t3 69.0339
R563 a_54_13766.n3 a_54_13766.t4 69.0339
R564 a_54_13766.n2 a_54_13766.t1 27.4083
R565 a_54_13766.n1 a_54_13766.t5 69.1139
R566 a_54_13766.n5 a_54_13766.n0 1.70568
R567 a_54_13766.n0 a_54_13766.t7 70.7889
R568 a_54_13766.n0 a_54_13766.t6 69.0339
C0 OUT VDD 2.04653f
C1 OUT VSS 24.07431f
C2 VDD VSS 0.13949p
C3 a_54_13766.t0 VSS 0.34116f
C4 a_54_13766.t6 VSS 2.2232f
C5 a_54_13766.n0 VSS 4.89257f
C6 a_54_13766.t7 VSS 2.28292f
C7 a_54_13766.t5 VSS 2.22299f
C8 a_54_13766.n1 VSS 2.42539f
C9 a_54_13766.t1 VSS 2.88105f
C10 a_54_13766.n2 VSS 1.28209f
C11 a_54_13766.t4 VSS 2.2232f
C12 a_54_13766.n3 VSS 2.48483f
C13 a_54_13766.t3 VSS 2.2232f
C14 a_54_13766.n4 VSS 6.13436f
C15 a_54_13766.t2 VSS 2.68583f
C16 a_54_13766.n5 VSS 0.54708f
C17 a_354_13766.t1 VSS 0.52281f
C18 a_354_13766.t0 VSS 0.64902f
C19 a_354_13766.n0 VSS 0.74732f
C20 a_354_13766.t4 VSS 0.64902f
C21 a_354_13766.n1 VSS 0.78692f
C22 a_354_13766.t3 VSS 2.58846f
C23 a_354_13766.n2 VSS 2.03667f
C24 a_354_13766.t2 VSS 2.2168f
C25 a_354_13766.n3 VSS 2.64663f
C26 a_354_13766.t5 VSS 0.64902f
C27 a_354_13766.n4 VSS 0.75346f
C28 a_354_13766.t6 VSS 0.64902f
C29 a_354_13766.n5 VSS 0.77563f
C30 a_354_13766.t14 VSS 3.25422f
C31 a_354_13766.n6 VSS 6.98682f
C32 a_354_13766.t15 VSS 3.34166f
C33 a_354_13766.t13 VSS 3.25422f
C34 a_354_13766.n7 VSS 3.52069f
C35 a_354_13766.t12 VSS 3.25422f
C36 a_354_13766.n8 VSS 3.71473f
C37 a_354_13766.t11 VSS 3.25422f
C38 a_354_13766.n9 VSS 4.05152f
C39 a_354_13766.t10 VSS 2.5333f
C40 a_354_13766.n10 VSS 3.76028f
C41 a_354_13766.t9 VSS 2.5333f
C42 a_354_13766.n11 VSS 3.49813f
C43 a_354_13766.t8 VSS 3.25422f
C44 a_354_13766.n12 VSS 7.31933f
C45 a_354_13766.t7 VSS 3.3695f
C46 a_354_13766.n13 VSS 0.519f
C47 a_928_5966.t2 VSS 0.20965f
C48 a_928_5966.t4 VSS 0.2672f
C49 a_928_5966.n0 VSS 1.67622f
C50 a_928_5966.t3 VSS 0.20965f
C51 a_928_5966.n1 VSS 0.2919f
C52 a_928_5966.n2 VSS 0.87836f
C53 a_928_5966.t7 VSS 0.20965f
C54 a_928_5966.n3 VSS 0.74433f
C55 a_928_5966.n4 VSS 0.55003f
C56 a_928_5966.t10 VSS 0.18758f
C57 a_928_5966.n5 VSS 1.08422f
C58 a_928_5966.t5 VSS 0.78413f
C59 a_928_5966.n6 VSS 0.36732f
C60 a_928_5966.n7 VSS 1.17493f
C61 a_928_5966.t9 VSS 0.17782f
C62 a_928_5966.t11 VSS 0.80819f
C63 a_928_5966.n8 VSS 1.15089f
C64 a_928_5966.t6 VSS 0.83512f
C65 a_928_5966.t1 VSS 0.04015f
C66 a_928_5966.t0 VSS 0.04015f
C67 a_928_5966.n9 VSS 0.32602f
C68 a_928_5966.n10 VSS 1.19371f
C69 a_928_5966.n11 VSS 0.39236f
C70 a_928_5966.n12 VSS 0.43362f
C71 a_928_5966.t8 VSS 19.7199f
C72 a_8074_14766.t0 VSS 0.89565f
C73 a_8074_14766.t4 VSS 3.43679f
C74 a_8074_14766.t1 VSS 0.30857f
C75 a_8074_14766.t2 VSS 0.30857f
C76 a_8074_14766.n0 VSS 3.95781f
C77 a_8074_14766.n1 VSS 7.56482f
C78 a_8074_14766.t3 VSS 3.54214f
C79 a_8074_14766.n2 VSS 4.48371f
C80 a_8738_14766.t0 VSS 1.07763f
C81 a_8738_14766.t3 VSS 2.93227f
C82 a_8738_14766.n0 VSS 7.39286f
C83 a_8738_14766.t4 VSS 3.09272f
C84 a_8738_14766.t1 VSS 3.74868f
C85 a_8738_14766.n1 VSS 6.02142f
C86 a_8738_14766.t2 VSS 4.87787f
C87 a_8738_14766.n2 VSS 0.56913f
C88 a_11074_13766.t0 VSS 0.45209f
C89 a_11074_13766.n0 VSS 7.85064f
C90 a_11074_13766.t2 VSS 5.35293f
C91 a_11074_13766.t1 VSS 0.45209f
C92 a_948_11486.t2 VSS 3.74693f
C93 a_948_11486.t1 VSS 0.71061f
C94 a_948_11486.t0 VSS 0.27176f
C95 a_948_11486.t3 VSS 0.27176f
C96 a_948_11486.n0 VSS 3.55787f
C97 a_948_11486.n1 VSS 3.6835f
C98 a_948_11486.t7 VSS 2.61251f
C99 a_948_11486.n2 VSS 3.89267f
C100 a_948_11486.t6 VSS 2.61251f
C101 a_948_11486.n3 VSS 3.26019f
C102 a_948_11486.t5 VSS 2.61251f
C103 a_948_11486.n4 VSS 6.25387f
C104 a_948_11486.t4 VSS 2.70931f
C105 a_948_11486.n5 VSS 6.1115f
C106 a_254_13882.t0 VSS 0.06564f
C107 a_254_13882.t1 VSS 0.06564f
C108 a_14_332.t1 VSS 0.20502f
C109 a_14_332.t0 VSS 0.31671f
C110 a_14_332.t2 VSS 2.91386f
C111 a_14_332.n0 VSS 1.31851f
C112 a_14_332.t9 VSS 0.80692f
C113 a_14_332.n1 VSS 0.81006f
C114 a_14_332.t8 VSS 0.80692f
C115 a_14_332.n2 VSS 0.87626f
C116 a_14_332.t7 VSS 0.80692f
C117 a_14_332.n3 VSS 0.80551f
C118 a_14_332.t6 VSS 0.49096f
C119 a_14_332.n4 VSS 0.81429f
C120 a_14_332.t5 VSS 0.49096f
C121 a_14_332.n5 VSS 0.6598f
C122 a_14_332.t4 VSS 0.80692f
C123 a_14_332.n6 VSS 1.11537f
C124 a_14_332.t3 VSS 0.83232f
C125 a_14_332.n7 VSS 0.51434f
C126 a_1366_13882.t0 VSS 0.06196f
C127 a_1366_13882.t1 VSS 0.06196f
C128 a_746_332.t0 VSS 0.61628f
C129 a_746_332.t5 VSS 1.03445f
C130 a_746_332.t1 VSS 3.64048f
C131 a_746_332.n0 VSS 1.92647f
C132 a_746_332.t4 VSS 1.02193f
C133 a_746_332.n1 VSS 0.98177f
C134 a_746_332.t3 VSS 1.02193f
C135 a_746_332.n2 VSS 2.53679f
C136 a_746_332.t2 VSS 1.31445f
C137 a_746_332.n3 VSS 0.7605f
C138 a_3290_13882.t0 VSS 0.06196f
C139 a_3290_13882.t1 VSS 0.06196f
C140 a_4402_13882.t0 VSS 0.06196f
C141 a_4402_13882.t1 VSS 0.06196f
C142 a_4702_13882.t0 VSS 2.868f
C143 a_4702_13882.t2 VSS 2.80408f
C144 a_4702_13882.n0 VSS 5.55761f
C145 a_4702_13882.t3 VSS 5.02959f
C146 a_4702_13882.n1 VSS 4.58414f
C147 a_4702_13882.t1 VSS 5.16175f
C148 a_5514_13882.t0 VSS 0.06352f
C149 a_5514_13882.t1 VSS 0.06352f
C150 a_7438_15682.t0 VSS 4.47325f
C151 a_7438_15682.t1 VSS 0.16115f
C152 a_7438_15682.t2 VSS 0.16115f
C153 a_7438_15682.n0 VSS 3.51465f
C154 a_6838_376.t2 VSS 4.8658f
C155 a_6838_376.t1 VSS 0.39736f
C156 a_6838_376.t0 VSS 0.39736f
C157 a_6838_376.n0 VSS 6.70282f
C158 a_7394_332.t0 VSS 0.1253f
C159 a_7394_332.n0 VSS 0.8931f
C160 a_7394_332.t4 VSS 0.91902f
C161 a_7394_332.t3 VSS 0.89389f
C162 a_7394_332.n1 VSS 2.90956f
C163 a_7394_332.t2 VSS 3.59353f
C164 a_7394_332.n2 VSS 1.57855f
C165 a_7394_332.t1 VSS 0.1253f
C166 a_6106_376.t0 VSS 0.27125f
C167 a_6106_376.n0 VSS 2.52253f
C168 a_6106_376.t3 VSS 12.0007f
C169 a_6106_376.t2 VSS 0.14967f
C170 a_6106_376.t1 VSS 0.14967f
C171 a_6106_376.n1 VSS 2.19901f
C172 a_9346_376.t0 VSS 0.1456f
C173 a_9346_376.n0 VSS 1.04624f
C174 a_9346_376.t2 VSS 4.24423f
C175 a_9346_376.n1 VSS 4.89856f
C176 a_9346_376.t3 VSS 0.84852f
C177 a_9346_376.t1 VSS 0.1456f
C178 a_11274_13882.t0 VSS 0.07008f
C179 a_11274_13882.t1 VSS 0.07008f
C180 a_12718_13882.t0 VSS 0.06556f
C181 a_12718_13882.t1 VSS 0.06556f
C182 a_8058_332.t2 VSS 0.72115f
C183 a_8058_332.t1 VSS 1.16037f
C184 a_8058_332.n0 VSS 1.01554f
C185 a_8058_332.t3 VSS 0.71958f
C186 a_8058_332.n1 VSS 1.86283f
C187 a_8058_332.t4 VSS 0.78746f
C188 a_8058_332.t0 VSS 4.16471f
C189 a_8058_332.n2 VSS 2.07168f
C190 a_948_12836.t0 VSS 0.1081f
C191 a_948_12836.t1 VSS 0.1081f
C192 a_16366_12386.t0 VSS 0.29425f
C193 a_16366_12386.t1 VSS 0.29425f
C194 a_948_11936.t0 VSS 0.1092f
C195 a_948_11936.t1 VSS 0.1092f
C196 a_16366_11486.t0 VSS 0.27986f
C197 a_16366_11486.t1 VSS 0.27986f
C198 a_928_10556.t0 VSS 0.1073f
C199 a_928_10556.t1 VSS 0.1073f
C200 a_12168_11006.t0 VSS 0.08478f
C201 a_12168_10106.t0 VSS 0.12833f
C202 a_12168_10106.t1 VSS 0.12833f
C203 a_928_9176.t0 VSS 0.10947f
C204 a_928_9176.t1 VSS 0.10947f
C205 a_12168_9626.t0 VSS 0.10157f
C206 a_12168_8726.t0 VSS 0.12833f
C207 a_12168_8726.t1 VSS 0.12833f
C208 a_928_7796.t0 VSS 0.10947f
C209 a_928_7796.t1 VSS 0.10947f
C210 a_12168_8246.t0 VSS 0.10157f
C211 a_12168_7346.t0 VSS 0.12833f
C212 a_12168_7346.t1 VSS 0.12833f
C213 a_928_6416.t0 VSS 0.10947f
C214 a_928_6416.t1 VSS 0.10947f
C215 a_12168_6866.t0 VSS 0.10157f
C216 a_12168_5966.t0 VSS 0.11994f
C217 a_12168_5966.t1 VSS 0.11994f
C218 a_11266_332.t0 VSS 0.12032f
C219 a_11266_332.n0 VSS 1.1129f
C220 a_11266_332.t2 VSS 0.8887f
C221 a_11266_332.t1 VSS 0.12032f
C222 a_946_376.t0 VSS 0.01645f
C223 a_946_376.t1 VSS 0.01645f
C224 a_4042_376.t0 VSS 0.0204f
C225 a_4042_376.t1 VSS 0.0204f
C226 a_4342_376.t0 VSS 0.39016f
C227 a_4342_376.t1 VSS 0.8558f
C228 a_4342_376.n0 VSS 0.74461f
C229 a_4342_376.t2 VSS 0.92325f
C230 a_4342_376.t3 VSS 0.43208f
C231 a_4342_376.n1 VSS 1.00961f
C232 a_5074_376.t0 VSS 0.0204f
C233 a_5074_376.t1 VSS 0.0204f
C234 a_10410_376.t0 VSS 0.02434f
C235 a_10410_376.t1 VSS 0.02434f
C236 a_11466_376.t0 VSS 0.02526f
C237 a_11466_376.t1 VSS 0.02526f
C238 VDD.n0 VSS 0.03328f
C239 VDD.t28 VSS 0.03751f
C240 VDD.n1 VSS 0.03319f
C241 VDD.n2 VSS 0.03908f
C242 VDD.n3 VSS 0.03908f
C243 VDD.n4 VSS 0.01532f
C244 VDD.n5 VSS 0.03908f
C245 VDD.n6 VSS 0.03268f
C246 VDD.n7 VSS 0.03908f
C247 VDD.t36 VSS 0.07652f
C248 VDD.n8 VSS 0.04148f
C249 VDD.n9 VSS 0.03431f
C250 VDD VSS 0.53051f
C251 VDD.t38 VSS 0.03751f
C252 VDD.n10 VSS 0.02692f
C253 VDD.n11 VSS 0.03908f
C254 VDD.n12 VSS 0.02196f
C255 VDD.n13 VSS 0.03908f
C256 VDD.n14 VSS 0.03908f
C257 VDD.t19 VSS 0.07652f
C258 VDD VSS 0.49162f
C259 VDD.n15 VSS 0.01284f
C260 VDD.n16 VSS 0.03908f
C261 VDD.n17 VSS 0.02472f
C262 VDD.n18 VSS 0.03908f
C263 VDD.n19 VSS 0.01284f
C264 VDD VSS 0.84715f
C265 VDD.n20 VSS 0.13106f
C266 VDD.n21 VSS 0.02472f
C267 VDD.n22 VSS 0.03908f
C268 VDD.n23 VSS 0.02472f
C269 VDD.n24 VSS 0.03604f
C270 VDD.n25 VSS 0.02398f
C271 VDD.n26 VSS 0.03908f
C272 VDD.n27 VSS 0.16224f
C273 VDD.n28 VSS 0.02847f
C274 VDD.n29 VSS 0.01891f
C275 VDD.n30 VSS 0.56144f
C276 VDD VSS 0.84437f
C277 VDD VSS 0.84715f
C278 VDD VSS 0.77215f
C279 VDD VSS 0.84437f
C280 VDD.n31 VSS 0.56144f
C281 VDD.n32 VSS 0.01532f
C282 VDD.n33 VSS 0.02847f
C283 VDD.n34 VSS 0.03908f
C284 VDD.n35 VSS 0.03908f
C285 VDD.n36 VSS 0.02285f
C286 VDD.n37 VSS 0.03908f
C287 VDD.t40 VSS 0.07652f
C288 VDD.n38 VSS 0.04148f
C289 VDD.n39 VSS 0.03249f
C290 VDD.n40 VSS 0.03908f
C291 VDD.n41 VSS 0.03908f
C292 VDD.n42 VSS 0.03908f
C293 VDD.n43 VSS 0.0345f
C294 VDD.n44 VSS 0.01532f
C295 VDD.n45 VSS 0.56144f
C296 VDD VSS 0.51107f
C297 VDD VSS 0.43885f
C298 VDD VSS 0.50829f
C299 VDD VSS 0.46107f
C300 VDD VSS 0.51107f
C301 VDD.n46 VSS 0.57811f
C302 VDD.n47 VSS 0.0105f
C303 VDD.n48 VSS 0.03989f
C304 VDD.n49 VSS 0.02519f
C305 VDD.n50 VSS 0.03908f
C306 VDD.n51 VSS 0.03908f
C307 VDD.n52 VSS 0.03908f
C308 VDD.n53 VSS 0.03908f
C309 VDD.n54 VSS 0.03908f
C310 VDD.n55 VSS 0.02051f
C311 VDD.n56 VSS 0.03908f
C312 VDD.n57 VSS 0.03908f
C313 VDD.n58 VSS 0.02664f
C314 VDD.n59 VSS 0.01518f
C315 VDD.n60 VSS 0.57811f
C316 VDD VSS 0.51107f
C317 VDD VSS 0.46107f
C318 VDD VSS 0.81104f
C319 VDD VSS 0.86381f
C320 VDD.n61 VSS 0.56144f
C321 VDD VSS 0.84437f
C322 VDD VSS 0.77215f
C323 VDD VSS 0.49162f
C324 VDD VSS 0.84437f
C325 VDD.t21 VSS 0.07652f
C326 VDD.n62 VSS 0.03801f
C327 VDD.n63 VSS 0.025f
C328 VDD.n64 VSS 0.03908f
C329 VDD.t23 VSS 0.07652f
C330 VDD.n65 VSS 0.04148f
C331 VDD.n66 VSS 0.02856f
C332 VDD.n67 VSS 0.03908f
C333 VDD.n68 VSS 0.03908f
C334 VDD.n69 VSS 0.0309f
C335 VDD.n70 VSS 0.03908f
C336 VDD.n71 VSS 0.02444f
C337 VDD.n72 VSS 0.03908f
C338 VDD.n73 VSS 0.03908f
C339 VDD.t32 VSS 0.01426f
C340 VDD.n74 VSS 0.02805f
C341 VDD.t10 VSS 0.07652f
C342 VDD.n75 VSS 0.03446f
C343 VDD.t4 VSS 0.08251f
C344 VDD VSS 0.77215f
C345 VDD VSS 0.49162f
C346 VDD VSS 0.77215f
C347 VDD VSS 0.48884f
C348 VDD.n76 VSS 0.56144f
C349 VDD.n77 VSS 0.04127f
C350 VDD.n78 VSS 0.09786f
C351 VDD.n79 VSS 0.14199f
C352 VDD.n80 VSS 0.02089f
C353 VDD.n81 VSS 0.03908f
C354 VDD.n82 VSS 0.03445f
C355 VDD.n83 VSS 0.03908f
C356 VDD.n84 VSS 0.03908f
C357 VDD.n85 VSS 0.03908f
C358 VDD.n86 VSS 0.02384f
C359 VDD.n87 VSS 0.01125f
C360 VDD.n88 VSS 0.56144f
C361 VDD VSS 0.49162f
C362 VDD VSS 0.77215f
C363 VDD VSS 0.77215f
C364 VDD VSS 0.48884f
C365 VDD.n89 VSS 0.56144f
C366 VDD.n90 VSS 0.01532f
C367 VDD.n91 VSS 0.01284f
C368 VDD.n92 VSS 0.03908f
C369 VDD.n93 VSS 0.03908f
C370 VDD.n94 VSS 0.03908f
C371 VDD.n95 VSS 0.03908f
C372 VDD.n96 VSS 0.03908f
C373 VDD.n97 VSS 0.03076f
C374 VDD.n98 VSS 0.03908f
C375 VDD.n99 VSS 0.03908f
C376 VDD.n100 VSS 0.0287f
C377 VDD.n101 VSS 0.03908f
C378 VDD.n102 VSS 0.02491f
C379 VDD.n103 VSS 0.03908f
C380 VDD.n104 VSS 0.03908f
C381 VDD.n105 VSS 0.02164f
C382 OUT.t1 VSS 0.55663f
C383 OUT.n0 VSS 0.0534f
C384 OUT.t5 VSS 0.09714f
C385 OUT.t6 VSS 5.74005f
C386 OUT.n1 VSS 0.17581f
C387 OUT.t0 VSS 0.65759f
C388 OUT.t4 VSS 0.48917f
C389 OUT.t7 VSS 20.6929f
C390 OUT.n2 VSS 2.08071f
C391 OUT.n3 VSS 0.85102f
C392 OUT.t2 VSS 0.65401f
C393 OUT.n4 VSS 0.83779f
C394 OUT.t3 VSS 0.65401f
C395 OUT.n5 VSS 0.8329f
C396 OUT.n6 VSS 0.06475f
C397 OUT.n7 VSS 0.25731f
C398 OUT.n8 VSS 0.06864f
C399 OUT.n9 VSS 0.05149f
.ends
