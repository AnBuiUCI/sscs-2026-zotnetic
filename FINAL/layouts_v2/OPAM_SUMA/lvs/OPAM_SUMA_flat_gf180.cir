* Extracted by KLayout with GF180MCU LVS runset on : 29/08/2026 18:10

.SUBCKT OPAM_SUMA OUT A1|A2|B1|B2 VDD VSS
M$1 \$656 \$16 VDD VDD pfet_06v0 L=1U W=10U AS=4.4P AD=2.5P PS=20.88U PD=10.5U
M$2 \$14 \$20 \$656 VDD pfet_06v0 L=1U W=10U AS=2.5P AD=4.4P PS=10.5U PD=20.88U
M$3 \$640 \$16 VDD VDD pfet_06v0 L=1U W=10U AS=4.4P AD=2.5P PS=20.88U PD=10.5U
M$4 \$8 \$20 \$640 VDD pfet_06v0 L=1U W=10U AS=2.5P AD=4.4P PS=10.5U PD=20.88U
M$5 \$702 \$16 VDD VDD pfet_06v0 L=1U W=10U AS=4.4P AD=2.5P PS=20.88U PD=10.5U
M$6 \$94 \$20 \$702 VDD pfet_06v0 L=1U W=10U AS=2.5P AD=4.4P PS=10.5U PD=20.88U
M$7 \$690 \$16 VDD VDD pfet_06v0 L=1U W=10U AS=4.4P AD=2.5P PS=20.88U PD=10.5U
M$8 \$94 \$20 \$690 VDD pfet_06v0 L=1U W=10U AS=2.5P AD=4.4P PS=10.5U PD=20.88U
M$9 \$728 \$156 VDD VDD pfet_06v0 L=1U W=10U AS=4.4P AD=2.5P PS=20.88U PD=10.5U
M$10 \$156 \$20 \$728 VDD pfet_06v0 L=1U W=10U AS=2.5P AD=3.3P PS=10.5U
+ PD=10.66U
M$11 \$42 \$42 \$156 VDD pfet_06v0 L=1U W=10U AS=3.3P AD=4.4P PS=10.66U
+ PD=20.88U
M$12 \$743 \$16 VDD VDD pfet_06v0 L=1U W=10U AS=4.4P AD=2.5P PS=20.88U PD=10.5U
M$13 \$48 \$20 \$743 VDD pfet_06v0 L=1U W=10U AS=2.5P AD=4.4P PS=10.5U PD=20.88U
M$14 \$665 \$16 VDD VDD pfet_06v0 L=1U W=10U AS=4.4P AD=2.5P PS=20.88U PD=10.5U
M$15 \$16 \$20 \$665 VDD pfet_06v0 L=1U W=10U AS=2.5P AD=4.4P PS=10.5U PD=20.88U
M$16 \$17 \$20 VSS VSS nfet_06v0 L=1U W=1U AS=0.44P AD=0.25P PS=2.88U PD=1.5U
M$17 \$20 \$20 \$17 VSS nfet_06v0 L=1U W=1U AS=0.25P AD=0.44P PS=1.5U PD=2.88U
M$18 \$34 \$32 VSS VSS nfet_06v0 L=1U W=2.5U AS=1.1P AD=0.825P PS=5.88U PD=3.16U
M$19 \$37 \$8 \$34 VSS nfet_06v0 L=1U W=2.5U AS=0.825P AD=1.1P PS=3.16U PD=5.88U
M$20 \$13 \$20 VSS VSS nfet_06v0 L=1U W=1U AS=0.44P AD=0.25P PS=2.88U PD=1.5U
M$21 \$16 \$20 \$13 VSS nfet_06v0 L=1U W=1U AS=0.25P AD=0.44P PS=1.5U PD=2.88U
M$22 \$11 \$14 VSS VSS nfet_06v0 L=1U W=5U AS=2.2P AD=1.25P PS=10.88U PD=5.5U
M$23 \$14 \$8 \$11 VSS nfet_06v0 L=1U W=5U AS=1.25P AD=2.2P PS=5.5U PD=10.88U
M$24 \$23 \$14 VSS VSS nfet_06v0 L=1U W=5U AS=2.2P AD=1.25P PS=10.88U PD=5.5U
M$25 \$21 \$8 \$23 VSS nfet_06v0 L=1U W=5U AS=1.25P AD=2.2P PS=5.5U PD=10.88U
M$26 \$47 \$44 VSS VSS nfet_06v0 L=1U W=5U AS=2.2P AD=1.25P PS=10.88U PD=5.5U
M$27 \$44 \$8 \$47 VSS nfet_06v0 L=1U W=5U AS=1.25P AD=1.65P PS=5.5U PD=5.66U
M$28 \$48 \$48 \$44 VSS nfet_06v0 L=1U W=5U AS=1.65P AD=2.2P PS=5.66U PD=10.88U
M$29 \$24 \$14 VSS VSS nfet_06v0 L=1U W=5U AS=2.2P AD=1.25P PS=10.88U PD=5.5U
M$30 \$21 \$8 \$24 VSS nfet_06v0 L=1U W=5U AS=1.25P AD=2.2P PS=5.5U PD=10.88U
M$31 \$39 \$14 VSS VSS nfet_06v0 L=1U W=5U AS=2.2P AD=1.25P PS=10.88U PD=5.5U
M$32 \$42 \$8 \$39 VSS nfet_06v0 L=1U W=5U AS=1.25P AD=2.2P PS=5.5U PD=10.88U
M$33 \$30 \$32 VSS VSS nfet_06v0 L=1U W=2.5U AS=1.1P AD=0.825P PS=5.88U PD=3.16U
M$34 \$32 \$8 \$30 VSS nfet_06v0 L=1U W=2.5U AS=0.825P AD=1.1P PS=3.16U PD=5.88U
C$35 \$74 OUT 4e-13 cap_mim_2f0fF A=200P P=66U
C$36 OUT \$34 4e-13 cap_mim_2f0fF A=200P P=66U
M$37 VSS A1|A2|B1|B2 VSS VSS nfet_06v0 L=2U W=2U AS=0.88P AD=0.88P PS=4.88U
+ PD=4.88U
M$38 VSS A1|A2|B1|B2 VSS VSS nfet_06v0 L=2U W=2U AS=0.88P AD=0.88P PS=4.88U
+ PD=4.88U
M$39 VSS A1|A2|B1|B2 VSS VSS nfet_06v0 L=2U W=2U AS=0.88P AD=0.88P PS=4.88U
+ PD=4.88U
M$40 VSS A1|A2|B1|B2 VSS VSS nfet_06v0 L=2U W=2U AS=0.88P AD=0.88P PS=4.88U
+ PD=4.88U
M$41 \$77 \$48 \$37 VSS nfet_06v0 L=1U W=2U AS=0.88P AD=0.88P PS=4.88U PD=4.88U
M$42 \$222 \$48 \$32 VSS nfet_06v0 L=1U W=2U AS=0.88P AD=0.88P PS=4.88U PD=4.88U
M$43 OUT \$37 VSS VSS nfet_06v0 L=1U W=1U AS=0.44P AD=0.44P PS=2.88U PD=2.88U
M$44 \$74 \$34 \$21 VSS nfet_06v0 L=1U W=7.5U AS=3.3P AD=3.3P PS=15.88U
+ PD=15.88U
M$45 \$164 \$34 \$21 VSS nfet_06v0 L=1U W=8.5U AS=3.74P AD=3.74P PS=17.88U
+ PD=17.88U
M$46 \$8 \$8 VSS VSS nfet_06v0 L=1U W=1U AS=0.44P AD=0.44P PS=2.88U PD=2.88U
M$47 \$222 \$20 \$164 VDD pfet_06v0 L=1U W=10U AS=4.4P AD=4.4P PS=20.88U
+ PD=20.88U
M$48 \$30 \$34 \$94 VDD pfet_06v0 L=1U W=0.5U AS=0.22P AD=0.22P PS=1.88U
+ PD=1.88U
M$49 \$34 \$34 \$94 VDD pfet_06v0 L=1U W=0.55U AS=0.242P AD=0.242P PS=1.98U
+ PD=1.98U
M$50 \$20 \$20 VDD VDD pfet_06v0 L=1U W=2U AS=0.88P AD=0.88P PS=4.88U PD=4.88U
M$51 \$37 \$42 \$77 VDD pfet_06v0 L=1U W=4U AS=1.76P AD=1.76P PS=8.88U PD=8.88U
M$52 \$32 \$42 \$222 VDD pfet_06v0 L=1U W=4U AS=1.76P AD=1.76P PS=8.88U PD=8.88U
M$53 \$74 \$222 VDD VDD pfet_06v0 L=1U W=5U AS=2.2P AD=2.2P PS=10.88U PD=10.88U
M$54 \$164 \$222 VDD VDD pfet_06v0 L=1U W=5U AS=2.2P AD=2.2P PS=10.88U PD=10.88U
M$55 OUT \$77 VDD VDD pfet_06v0 L=1U W=1U AS=0.44P AD=0.44P PS=2.88U PD=2.88U
M$56 OUT \$77 VDD VDD pfet_06v0 L=1U W=1U AS=0.44P AD=0.44P PS=2.88U PD=2.88U
M$57 OUT \$77 VDD VDD pfet_06v0 L=1U W=1U AS=0.44P AD=0.44P PS=2.88U PD=2.88U
M$58 OUT \$77 VDD VDD pfet_06v0 L=1U W=1U AS=0.44P AD=0.44P PS=2.88U PD=2.88U
M$59 \$77 \$20 \$74 VDD pfet_06v0 L=1U W=10U AS=4.4P AD=4.4P PS=20.88U PD=20.88U
R$60 \$34 \$I375 VSS 55560 ppolyf_u_1k L=55.56U W=1U
R$61 \$I376 \$I375 VSS 55560 ppolyf_u_1k L=55.56U W=1U
R$62 \$I376 A1|A2|B1|B2 VSS 55560 ppolyf_u_1k L=55.56U W=1U
R$63 \$34 \$I377 VSS 55560 ppolyf_u_1k L=55.56U W=1U
R$64 \$I378 \$I377 VSS 55560 ppolyf_u_1k L=55.56U W=1U
R$65 \$I378 A1|A2|B1|B2 VSS 55560 ppolyf_u_1k L=55.56U W=1U
R$66 \$34 \$I379 VSS 55560 ppolyf_u_1k L=55.56U W=1U
R$67 \$I380 \$I379 VSS 55560 ppolyf_u_1k L=55.56U W=1U
R$68 \$I380 A1|A2|B1|B2 VSS 55560 ppolyf_u_1k L=55.56U W=1U
R$69 \$34 \$I381 VSS 55560 ppolyf_u_1k L=55.56U W=1U
R$70 \$I382 \$I381 VSS 55560 ppolyf_u_1k L=55.56U W=1U
R$71 \$I382 A1|A2|B1|B2 VSS 55560 ppolyf_u_1k L=55.56U W=1U
R$72 \$638 \$I383 VSS 76450 ppolyf_u_1k L=76.45U W=1U
R$73 \$I384 \$I383 VSS 76450 ppolyf_u_1k L=76.45U W=1U
R$74 \$I384 \$I385 VSS 76450 ppolyf_u_1k L=76.45U W=1U
R$75 \$I386 \$I385 VSS 76450 ppolyf_u_1k L=76.45U W=1U
R$76 \$I386 OUT VSS 76450 ppolyf_u_1k L=76.45U W=1U
.ENDS OPAM_SUMA
