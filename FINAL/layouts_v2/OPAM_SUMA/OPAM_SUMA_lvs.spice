* fuente: /foss/designs/a_zonetic2026/XSCHEM_v2/simulation/OPAM_SUMA.sch/OPAM_SUMA.spice
* leida via enlace: /foss/designs/a_zonetic2026/spice_blocks/OPAM_SUMA.spice
* fecha de la fuente: 2026-08-29 17:59   sha1: 6880809c9c
* generado por flatten_spice.py — NO editar a mano
* netlist plana generada por flatten_spice.py (top: OPAM_SUMA)
* 57 MOSFETs; nets fusionadas por V=0: ninguna
* nombres: los del esquematico; solo llevan la ruta de instancias (Mx1_M4) los -2 que chocaban
* m -> fingers: ninguno
* para LVS: cada dedo, un transistor en paralelo
.subckt OPAM_SUMA A1 A2 B1 B2 OUT VDD VSS
M4 xamp_x1_net3 xamp_net3 VDD VDD pfet_06v0 L=1.0u W=10.0u
M5 xamp_net2 xamp_net4 xamp_x1_net3 VDD pfet_06v0 L=1.0u W=10.0u
M6 xamp_net2 xamp_net2 VSS VSS nfet_06v0 L=1.0u W=1.0u
M7 xamp_x1_net2 xamp_net3 VDD VDD pfet_06v0 L=1.0u W=10.0u
M8 xamp_net1 xamp_net4 xamp_x1_net2 VDD pfet_06v0 L=1.0u W=10.0u
M9 xamp_net1 xamp_net2 xamp_x1_net1 VSS nfet_06v0 L=1.0u W=5.0u
M10 xamp_x1_net1 xamp_net1 VSS VSS nfet_06v0 L=1.0u W=5.0u
M1 xamp_net4 xamp_net4 VDD VDD pfet_06v0 L=1.0u W=2u
M2 xamp_x1_net4 xamp_net3 VDD VDD pfet_06v0 L=1.0u W=10.0u
M3 xamp_net3 xamp_net4 xamp_x1_net4 VDD pfet_06v0 L=1.0u W=10.0u
M47 xamp_x1_net5 xamp_net4 VSS VSS nfet_06v0 L=1.0u W=1.0u
M48 xamp_x1_net6 xamp_net4 VSS VSS nfet_06v0 L=1.0u W=1.0u
M49 xamp_net4 xamp_net4 xamp_x1_net6 VSS nfet_06v0 L=1.0u W=1.0u
M50 xamp_net3 xamp_net4 xamp_x1_net5 VSS nfet_06v0 L=1.0u W=1.0u
M11 xamp_x2_net2 xamp_net3 VDD VDD pfet_06v0 L=1.0u W=10.0u
M12 xamp_x2_net7 xamp_net4 xamp_x2_net2 VDD pfet_06v0 L=1.0u W=10.0u
M13 xamp_x2_net18 xamp_net3 VDD VDD pfet_06v0 L=1.0u W=10.0u
M14 xamp_x2_net7 xamp_net4 xamp_x2_net18 VDD pfet_06v0 L=1.0u W=10.0u
M15 xamp_x2_net5 NSP xamp_x2_net7 VDD pfet_06v0 L=1.0u W=0.55u
M16 xamp_x2_net4 NSN xamp_x2_net7 VDD pfet_06v0 L=1.0u W=0.5u
M17 xamp_x2_net8 xamp_net2 xamp_x2_net1 VSS nfet_06v0 L=1.0u W=5.0u
M18 xamp_x2_net1 xamp_net1 VSS VSS nfet_06v0 L=1.0u W=5.0u
M19 xamp_x2_net8 xamp_net2 xamp_x2_net19 VSS nfet_06v0 L=1.0u W=5.0u
M20 xamp_x2_net19 xamp_net1 VSS VSS nfet_06v0 L=1.0u W=5.0u
M21 xamp_x2_net6 NSP xamp_x2_net8 VSS nfet_06v0 L=1.0u W=7.5u
M22 xamp_x2_net3 NSN xamp_x2_net8 VSS nfet_06v0 L=1.0u W=8.5u
M29 xamp_x2_net9 xamp_net4 xamp_x2_net3 VDD pfet_06v0 L=1.0u W=10u
M30 xamp_x2_G_OUT_P xamp_net4 xamp_x2_net6 VDD pfet_06v0 L=1.0u W=10u
M31 xamp_x2_net3 xamp_x2_net9 VDD VDD pfet_06v0 L=1.0u W=5u
M35 xamp_x2_net6 xamp_x2_net9 VDD VDD pfet_06v0 L=1.0u W=5u
M32 xamp_x2_net10 xamp_x2_net20 xamp_x2_net9 VDD pfet_06v0 L=1.0u W=4.0u
M33 xamp_x2_net21 xamp_x2_net20 xamp_x2_G_OUT_P VDD pfet_06v0 L=1.0u W=4.0u
M23 xamp_x2_net10 xamp_net2 xamp_x2_net4 VSS nfet_06v0 L=1.0u W=2.5u
M24 xamp_x2_net21 xamp_net2 xamp_x2_net5 VSS nfet_06v0 L=1.0u W=2.5u
M25 xamp_x2_net4 xamp_x2_net10 VSS VSS nfet_06v0 L=1.0u W=2.5u
M26 xamp_x2_net5 xamp_x2_net10 VSS VSS nfet_06v0 L=1.0u W=2.5u
M27 xamp_x2_net9 xamp_x2_net11 xamp_x2_net10 VSS nfet_06v0 L=1.0u W=2.0u
M28 xamp_x2_G_OUT_P xamp_x2_net11 xamp_x2_net21 VSS nfet_06v0 L=1.0u W=2.0u
M34 xamp_x2_net12 xamp_x2_net13 VDD VDD pfet_06v0 L=1.0u W=10.0u
M36 xamp_x2_net13 xamp_net4 xamp_x2_net12 VDD pfet_06v0 L=1.0u W=10.0u
M37 xamp_x2_net20 xamp_x2_net20 xamp_x2_net13 VDD pfet_06v0 L=1.0u W=10.0u
M38 xamp_x2_net20 xamp_net2 xamp_x2_net14 VSS nfet_06v0 L=1.0u W=5.0u
M39 xamp_x2_net14 xamp_net1 VSS VSS nfet_06v0 L=1.0u W=5.0u
M45 xamp_x2_net15 xamp_net3 VDD VDD pfet_06v0 L=1.0u W=10.0u
M46 xamp_x2_net11 xamp_net4 xamp_x2_net15 VDD pfet_06v0 L=1.0u W=10.0u
M40 xamp_x2_net11 xamp_x2_net11 xamp_x2_net17 VSS nfet_06v0 L=1.0u W=5.0u
M41 xamp_x2_net17 xamp_net2 xamp_x2_net16 VSS nfet_06v0 L=1.0u W=5.0u
M42 xamp_x2_net16 xamp_x2_net17 VSS VSS nfet_06v0 L=1.0u W=5.0u
M43_m1 OUT xamp_x2_G_OUT_P VDD VDD pfet_06v0 L=1.0u W=1.0u
M43_m2 OUT xamp_x2_G_OUT_P VDD VDD pfet_06v0 L=1.0u W=1.0u
M43_m3 OUT xamp_x2_G_OUT_P VDD VDD pfet_06v0 L=1.0u W=1.0u
M43_m4 OUT xamp_x2_G_OUT_P VDD VDD pfet_06v0 L=1.0u W=1.0u
M44 OUT xamp_x2_net21 VSS VSS nfet_06v0 L=1.0u W=1.0u
MXxmcA1 VSS A1 VSS VSS nfet_06v0 L=2u W=2u
MXxmcA2 VSS A2 VSS VSS nfet_06v0 L=2u W=2u
MXxmcB1 VSS B1 VSS VSS nfet_06v0 L=2u W=2u
MXxmcB2 VSS B2 VSS VSS nfet_06v0 L=2u W=2u
* condensadores: elemento 'C' con W/L en METROS, no 'X' con c_width/c_length.
*   El deck de KLayout los lee con un delegate (custom_classes.lvs, SubcircuitModelsReader#element)
*   que SOLO actua si el elemento empieza por 'C', y de ahi saca A=W*L*1e12 y P=2*(W+L)*1e6.
*   Escrito como 'X...' se leeria como llamada a subcircuito y no emparejaria con nada.
C3 xamp_x2_net6 OUT cap_mim_2f0fF W=8e-06 L=2.5e-05
C1 OUT xamp_x2_net5 cap_mim_2f0fF W=8e-06 L=2.5e-05
* resistencias: elemento 'R' con W/L/S en METROS, no 'X' con r_width/r_length.
*   Mismo motivo que los condensadores: el delegate del deck (custom_classes.lvs,
*   SubcircuitModelsReader#element) solo entra por la primera letra, y para 'R' de tres
*   nodos monta un DeviceClassResistorWithBulk con los terminales A, B, W.
*   El deck hace W=W*PAR*1e6 y L=L*S*1e6, o sea que la 'S' MULTIPLICA el largo.
*   Aun asi la serie se escribe TRAMO A TRAMO, no con un 'S=5': el layout dibuja
*   `s` cuerpos de poly encadenados por metal1 y las dos herramientas los extraen
*   como `s` dispositivos. Juntarlos en uno exige la reduccion en serie, y netgen no
*   la aplica aqui porque lee la resistencia de tres nodos como si tuviera dos y le
*   pone de modelo el nodo de sustrato: la clase le sale 'VSS' y su setup no la
*   reconoce. Escribiendo los tramos, las dos partes cuentan lo mismo y no hace falta.
RFB_xamp_x2_1 xamp_x2_G_OUT_P RFB_xamp_x2$1 VSS ppolyf_u_1k W=1e-06 L=7.645e-05 R=76450
RFB_xamp_x2_2 RFB_xamp_x2$1 RFB_xamp_x2$2 VSS ppolyf_u_1k W=1e-06 L=7.645e-05 R=76450
RFB_xamp_x2_3 RFB_xamp_x2$2 RFB_xamp_x2$3 VSS ppolyf_u_1k W=1e-06 L=7.645e-05 R=76450
RFB_xamp_x2_4 RFB_xamp_x2$3 RFB_xamp_x2$4 VSS ppolyf_u_1k W=1e-06 L=7.645e-05 R=76450
RFB_xamp_x2_5 RFB_xamp_x2$4 OUT VSS ppolyf_u_1k W=1e-06 L=7.645e-05 R=76450
RA1_1 NSP RA1$1 VSS ppolyf_u_3k W=1e-06 L=5.556e-05 R=166680
RA1_2 RA1$1 RA1$2 VSS ppolyf_u_3k W=1e-06 L=5.556e-05 R=166680
RA1_3 RA1$2 A1 VSS ppolyf_u_3k W=1e-06 L=5.556e-05 R=166680
RA2_1 NSP RA2$1 VSS ppolyf_u_3k W=1e-06 L=5.556e-05 R=166680
RA2_2 RA2$1 RA2$2 VSS ppolyf_u_3k W=1e-06 L=5.556e-05 R=166680
RA2_3 RA2$2 A2 VSS ppolyf_u_3k W=1e-06 L=5.556e-05 R=166680
RB1_1 NSN RB1$1 VSS ppolyf_u_3k W=1e-06 L=5.556e-05 R=166680
RB1_2 RB1$1 RB1$2 VSS ppolyf_u_3k W=1e-06 L=5.556e-05 R=166680
RB1_3 RB1$2 B1 VSS ppolyf_u_3k W=1e-06 L=5.556e-05 R=166680
RB2_1 NSN RB2$1 VSS ppolyf_u_3k W=1e-06 L=5.556e-05 R=166680
RB2_2 RB2$1 RB2$2 VSS ppolyf_u_3k W=1e-06 L=5.556e-05 R=166680
RB2_3 RB2$2 B2 VSS ppolyf_u_3k W=1e-06 L=5.556e-05 R=166680
.ends
