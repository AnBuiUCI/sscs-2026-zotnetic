* Nodos de bulk atados: 2 de pozo n -> VDD, 1 de sustrato -> VSS.
*   magic no extrae los taps de este layout y los dejaba flotando;
*   la conexion si existe (el LVS de KLayout da 'match uniquely').
*   Quien detecta un tap que falte de verdad es el LVS, no esto.
* NGSPICE file created from OPAM.ext - technology: gf180mcuD

.subckt OPAM_V2 VSS VDD OUT INP INN
X0 a_3566_332# a_314_332# a_3290_3908# VSS nfet_06v0 ad=0.825p pd=3.16u as=0.825p ps=3.16u w=2.5u l=1u
X1 a_10922_3908# a_54_3792# VDD VDD pfet_06v0 ad=2.5p pd=10.5u as=4.4p ps=20.88u w=10u l=1u
X2 a_354_3792# a_354_3792# VDD VDD pfet_06v0 ad=0.88p pd=4.88u as=0.88p ps=4.88u w=2u l=1u
X3 OUT a_5518_376# VSS VSS nfet_06v0 ad=0.44p pd=2.88u as=0.44p ps=2.88u w=1u l=1u
X4 a_554_3908# a_354_3792# a_254_3908# VDD pfet_06v0 ad=4.4p pd=20.88u as=2.5p ps=10.5u w=10u l=1u
X5 a_7054_3792# a_354_3792# a_7254_3908# VDD pfet_06v0 ad=3.3p pd=10.66u as=2.5p ps=10.5u w=10u l=1u
X6 a_5518_376# a_314_332# a_2478_3908# VSS nfet_06v0 ad=0.825p pd=3.16u as=0.825p ps=3.16u w=2.5u l=1u
X7 a_4694_4792# a_314_332# a_6582_376# VSS nfet_06v0 ad=2.2p pd=10.88u as=1.25p ps=5.5u w=5u l=1u
X8 a_2478_3908# INP a_554_3908# VDD pfet_06v0 ad=4.4p pd=20.88u as=4.4p ps=20.88u w=10u l=1u
X9 a_2278_376# INP a_514_376# VSS nfet_06v0 ad=2.2p pd=10.88u as=2.2p ps=10.88u w=5u l=1u
X10 a_514_376# a_314_332# a_214_376# VSS nfet_06v0 ad=2.2p pd=10.88u as=1.25p ps=5.5u w=5u l=1u
X11 a_4230_332# a_4230_332# a_7438_332# VSS nfet_06v0 ad=2.2p pd=10.88u as=1.65p ps=5.66u w=5u l=1u
X12 a_314_332# a_314_332# VSS VSS nfet_06v0 ad=0.44p pd=2.88u as=0.44p ps=2.88u w=1u l=1u
X13 a_1366_3908# a_54_3792# VDD VDD pfet_06v0 ad=2.5p pd=10.5u as=4.4p ps=20.88u w=10u l=1u
X14 a_3290_3908# a_3566_332# VSS VSS nfet_06v0 ad=0.825p pd=3.16u as=1.1p ps=5.88u w=2.5u l=1u
X15 a_9810_3908# a_54_3792# VDD VDD pfet_06v0 ad=2.5p pd=10.5u as=4.4p ps=20.88u w=10u l=1u
X16 a_2478_3908# a_3566_332# VSS VSS nfet_06v0 ad=0.825p pd=3.16u as=1.1p ps=5.88u w=2.5u l=1u
X17 a_3566_332# a_4694_4792# a_4030_4792# VDD pfet_06v0 ad=2.2p pd=10.88u as=1.65p ps=5.66u w=5u l=1u
X18 OUT a_5850_376# VDD VDD pfet_06v0 ad=0.308p pd=2.28u as=0.308p ps=2.28u w=0.7u l=20u
X19 a_12530_376# a_354_3792# VSS VSS nfet_06v0 ad=0.25p pd=1.5u as=0.44p ps=2.88u w=1u l=1u
X20 a_254_3908# a_54_3792# VDD VDD pfet_06v0 ad=2.5p pd=10.5u as=4.4p ps=20.88u w=10u l=1u
X21 a_12846_3908# a_54_3792# VDD VDD pfet_06v0 ad=2.5p pd=10.5u as=4.4p ps=20.88u w=10u l=1u
X22 a_214_376# a_14_332# VSS VSS nfet_06v0 ad=1.25p pd=5.5u as=2.2p ps=10.88u w=5u l=1u
X23 a_10466_376# a_14_332# VSS VSS nfet_06v0 ad=1.25p pd=5.5u as=2.2p ps=10.88u w=5u l=1u
X24 OUT a_2278_376# cap_mim_2f0_m4m5_noshield c_width=20u c_length=10u
X25 a_4030_4792# a_354_3792# a_3010_376# VDD pfet_06v0 ad=1.65p pd=5.66u as=1.65p ps=5.66u w=5u l=1u
X26 a_8698_3908# a_54_3792# VDD VDD pfet_06v0 ad=2.5p pd=10.5u as=4.4p ps=20.88u w=10u l=1u
X27 a_354_3792# a_354_3792# a_12530_376# VSS nfet_06v0 ad=0.44p pd=2.88u as=0.25p ps=1.5u w=1u l=1u
X28 a_554_3908# a_354_3792# a_1366_3908# VDD pfet_06v0 ad=4.4p pd=20.88u as=2.5p ps=10.5u w=10u l=1u
X29 a_5518_376# a_4694_4792# a_5850_376# VDD pfet_06v0 ad=2.2p pd=10.88u as=1.65p ps=5.66u w=5u l=1u
X30 a_5850_376# a_354_3792# a_2278_376# VDD pfet_06v0 ad=1.65p pd=5.66u as=1.65p ps=5.66u w=5u l=1u
X31 a_14_332# a_314_332# a_10466_376# VSS nfet_06v0 ad=2.2p pd=10.88u as=1.25p ps=5.5u w=5u l=1u
X32 a_3010_376# a_4030_4792# VDD VDD pfet_06v0 ad=1.65p pd=5.66u as=2.2p ps=10.88u w=5u l=1u
X33 a_314_332# a_354_3792# a_9810_3908# VDD pfet_06v0 ad=4.4p pd=20.88u as=2.5p ps=10.5u w=10u l=1u
X34 a_14_332# a_354_3792# a_10922_3908# VDD pfet_06v0 ad=4.4p pd=20.88u as=2.5p ps=10.5u w=10u l=1u
X35 a_4030_4792# a_4230_332# a_3566_332# VSS nfet_06v0 ad=1.1p pd=5.88u as=0.825p ps=3.16u w=2.5u l=1u
X36 a_2278_376# a_4030_4792# VDD VDD pfet_06v0 ad=1.65p pd=5.66u as=2.2p ps=10.88u w=5u l=1u
X37 a_5850_376# a_4230_332# a_5518_376# VSS nfet_06v0 ad=1.1p pd=5.88u as=0.825p ps=3.16u w=2.5u l=1u
X38 a_54_3792# a_354_3792# a_12846_3908# VDD pfet_06v0 ad=4.4p pd=20.88u as=2.5p ps=10.5u w=10u l=1u
X39 a_7638_376# a_7438_332# VSS VSS nfet_06v0 ad=1.25p pd=5.5u as=2.2p ps=10.88u w=5u l=1u
X40 a_7254_3908# a_7054_3792# VDD VDD pfet_06v0 ad=2.5p pd=10.5u as=4.4p ps=20.88u w=10u l=1u
X41 a_4230_332# a_354_3792# a_8698_3908# VDD pfet_06v0 ad=4.4p pd=20.88u as=2.5p ps=10.5u w=10u l=1u
X42 a_1246_376# a_14_332# VSS VSS nfet_06v0 ad=1.25p pd=5.5u as=2.2p ps=10.88u w=5u l=1u
X43 a_11498_376# a_354_3792# VSS VSS nfet_06v0 ad=0.25p pd=1.5u as=0.44p ps=2.88u w=1u l=1u
X44 a_2478_3908# OUT cap_mim_2f0_m4m5_noshield c_width=20u c_length=10u
X45 a_3010_376# INN a_514_376# VSS nfet_06v0 ad=2.2p pd=10.88u as=2.2p ps=10.88u w=5u l=1u
X46 a_7438_332# a_314_332# a_7638_376# VSS nfet_06v0 ad=1.65p pd=5.66u as=1.25p ps=5.5u w=5u l=1u
X47 a_4694_4792# a_4694_4792# a_7054_3792# VDD pfet_06v0 ad=4.4p pd=20.88u as=3.3p ps=10.66u w=10u l=1u
X48 a_514_376# a_314_332# a_1246_376# VSS nfet_06v0 ad=2.2p pd=10.88u as=1.25p ps=5.5u w=5u l=1u
X49 a_6582_376# a_14_332# VSS VSS nfet_06v0 ad=1.25p pd=5.5u as=2.2p ps=10.88u w=5u l=1u
X50 a_54_3792# a_354_3792# a_11498_376# VSS nfet_06v0 ad=0.44p pd=2.88u as=0.25p ps=1.5u w=1u l=1u
X51 a_3290_3908# INN a_554_3908# VDD pfet_06v0 ad=4.4p pd=20.88u as=4.4p ps=20.88u w=10u l=1u
C0 VSS a_6582_376# 0.04423f
C1 VSS a_3566_332# 0.26021f
C2 a_2278_376# a_5850_376# 0.51865f
C3 a_354_3792# a_3010_376# 0.66505f
C4 a_54_3792# a_5850_376# 0.05225f
C5 OUT a_2478_3908# 3.54344f
C6 a_4230_332# a_8698_3908# 0.05253f
C7 OUT a_3566_332# 0.139f
C8 a_14_332# a_5850_376# 0.24474f
C9 VDD a_5850_376# 5.30728f
C10 a_7054_3792# a_5518_376# 0.11305f
C11 a_4030_4792# a_4230_332# 0.65231f
C12 VDD a_2278_376# 0.52121f
C13 INN VDD 0.28859f
C14 VSS a_4230_332# 0.21242f
C15 VDD a_2478_3908# 0.21943f
C16 a_54_3792# VDD 1.95096f
C17 VDD a_3566_332# 0.11208f
C18 a_254_3908# VDD 0.07875f
C19 VDD a_14_332# 0.33364f
C20 a_4694_4792# a_2278_376# 0.76514f
C21 OUT a_4230_332# 0.09341f
C22 VSS a_214_376# 0.04686f
C23 a_54_3792# a_4694_4792# 0.12337f
C24 a_3290_3908# a_314_332# 0.64363f
C25 a_554_3908# a_3290_3908# 0.39604f
C26 a_14_332# a_4694_4792# 0.80272f
C27 a_354_3792# a_12846_3908# 0.01143f
C28 VSS a_5850_376# 0.20165f
C29 VDD a_4230_332# 0.38177f
C30 a_354_3792# a_314_332# 0.46626f
C31 VDD a_4030_4792# 1.29073f
C32 a_554_3908# a_354_3792# 0.98807f
C33 OUT a_5850_376# 5.21785f
C34 a_7438_332# a_314_332# 0.4567f
C35 a_3290_3908# a_354_3792# 0.03114f
C36 VDD INP 0.28223f
C37 a_5518_376# a_2478_3908# 0.23404f
C38 OUT a_7254_3908# 0.02043f
C39 VSS a_1246_376# 0.04308f
C40 VDD a_1366_3908# 0.07139f
C41 a_4030_4792# a_4694_4792# 0.87468f
C42 a_5518_376# a_3566_332# 0.08035f
C43 VDD a_5850_376# 1.47352f
C44 a_3010_376# a_2278_376# 0.58867f
C45 VSS a_4694_4792# 0.21959f
C46 VDD OUT 0.91914f
C47 INN a_3010_376# 0.87445f
C48 a_54_3792# a_3010_376# 0.01932f
C49 a_514_376# a_2278_376# 0.43204f
C50 VDD a_7254_3908# 0.07139f
C51 INN a_514_376# 0.37101f
C52 a_14_332# a_3010_376# 0.11279f
C53 OUT a_4694_4792# 0.29362f
C54 VDD VDD 6.64328f
C55 a_5518_376# a_4230_332# 1.11183f
C56 a_514_376# a_14_332# 0.1643f
C57 a_7054_3792# a_4230_332# 0.298f
C58 VDD a_4694_4792# 0.38804f
C59 VDD a_9810_3908# 0.07525f
C60 a_3010_376# a_4030_4792# 1.26915f
C61 a_5518_376# a_5850_376# 0.35734f
C62 VSS a_3010_376# 0.08317f
C63 INP a_3010_376# 0.01622f
C64 a_54_3792# a_12846_3908# 0.05253f
C65 a_7054_3792# a_5850_376# 0.09061f
C66 VSS a_514_376# 0.38678f
C67 INP a_514_376# 0.44241f
C68 a_3566_332# a_2478_3908# 1.20083f
C69 a_314_332# a_2278_376# 0.07919f
C70 a_554_3908# a_2278_376# 0.0192f
C71 INN a_314_332# 0.04514f
C72 a_554_3908# INN 0.93141f
C73 a_7054_3792# a_7254_3908# 0.06557f
C74 a_54_3792# a_314_332# 0.13909f
C75 OUT a_3010_376# 0.1094f
C76 VDD a_5518_376# 0.38783f
C77 a_554_3908# a_54_3792# 0.28924f
C78 a_3290_3908# a_2278_376# 0.07165f
C79 INN a_3290_3908# 0.76461f
C80 a_7054_3792# VDD 0.45674f
C81 a_54_3792# a_3290_3908# 0.02585f
C82 a_14_332# a_314_332# 1.36918f
C83 a_554_3908# a_14_332# 1.12044f
C84 VDD a_3010_376# 0.23844f
C85 a_4694_4792# a_5518_376# 0.94229f
C86 a_4230_332# a_2478_3908# 0.11003f
C87 a_3290_3908# a_14_332# 0.0291f
C88 a_7638_376# a_7438_332# 0.03308f
C89 a_7054_3792# a_4694_4792# 1.33225f
C90 a_354_3792# a_2278_376# 0.79156f
C91 a_4230_332# a_3566_332# 0.90083f
C92 INN a_354_3792# 0.04335f
C93 a_7438_332# a_2278_376# 0.01319f
C94 a_54_3792# a_354_3792# 7.91034f
C95 a_4030_4792# a_314_332# 0.03311f
C96 a_354_3792# a_14_332# 1.29438f
C97 VDD a_354_3792# 0.01215f
C98 VSS a_314_332# 0.83385f
C99 a_5850_376# a_2478_3908# 0.38838f
C100 INP a_314_332# 0.0457f
C101 a_3290_3908# a_4030_4792# 0.10325f
C102 OUT a_12846_3908# 0.01079f
C103 a_554_3908# INP 0.86203f
C104 VSS a_3290_3908# 0.13237f
C105 OUT a_314_332# 0.27991f
C106 a_554_3908# OUT 0.01647f
C107 VDD a_12846_3908# 0.07139f
C108 VDD a_2478_3908# 0.60751f
C109 a_354_3792# a_4030_4792# 0.79764f
C110 a_3290_3908# OUT 0.04938f
C111 VDD a_3566_332# 0.40746f
C112 VSS a_354_3792# 0.30903f
C113 INP a_354_3792# 0.04562f
C114 VDD a_314_332# 0.38035f
C115 a_4230_332# a_5850_376# 0.87726f
C116 a_554_3908# VDD 0.62473f
C117 a_4694_4792# a_2478_3908# 0.01138f
C118 VSS a_7438_332# 0.2942f
C119 a_3290_3908# VDD 0.0997f
C120 a_4694_4792# a_3566_332# 1.03626f
C121 a_6582_376# a_4694_4792# 0.02626f
C122 a_354_3792# OUT 1.11791f
C123 VDD a_4230_332# 0.29945f
C124 a_7438_332# OUT 0.03375f
C125 VDD a_354_3792# 1.41852f
C126 INN a_2278_376# 0.12167f
C127 a_14_332# a_10922_3908# 0.05253f
C128 a_4694_4792# a_4230_332# 0.4347f
C129 a_54_3792# a_2278_376# 0.06857f
C130 a_54_3792# INN 0.02535f
C131 a_14_332# a_2278_376# 0.13669f
C132 INN a_14_332# 0.14865f
C133 VDD a_5850_376# 0.21377f
C134 a_54_3792# a_14_332# 0.88217f
C135 a_54_3792# VDD 0.01719f
C136 a_314_332# a_5518_376# 0.44675f
C137 a_3010_376# a_2478_3908# 0.04332f
C138 a_514_376# a_2478_3908# 0.12252f
C139 a_3010_376# a_3566_332# 0.07696f
C140 a_4694_4792# a_5850_376# 1.04724f
C141 VSS a_7638_376# 0.04308f
C142 a_4030_4792# a_2278_376# 0.86809f
C143 a_54_3792# a_4030_4792# 0.66654f
C144 VSS a_2278_376# 0.03734f
C145 a_354_3792# a_5518_376# 0.04062f
C146 INP a_2278_376# 0.83849f
C147 VDD a_4694_4792# 1.39289f
C148 INN VSS 0.05097f
C149 INN INP 0.19706f
C150 a_54_3792# VSS 0.06475f
C151 OUT a_10922_3908# 0.01079f
C152 a_7054_3792# a_354_3792# 0.58302f
C153 a_54_3792# INP 0.02433f
C154 a_14_332# a_4030_4792# 0.29641f
C155 a_7054_3792# a_7438_332# 0.09222f
C156 VSS a_14_332# 0.81995f
C157 VSS VDD 0.16288f
C158 OUT a_2278_376# 1.91585f
C159 INP a_14_332# 0.06427f
C160 INN OUT 0.0365f
C161 a_12846_3908# a_2478_3908# 0.01345f
C162 a_54_3792# OUT 0.50729f
C163 VDD a_10922_3908# 0.07139f
C164 a_514_376# a_214_376# 0.02626f
C165 a_14_332# OUT 0.68286f
C166 VDD OUT 1.05931f
C167 VDD a_2278_376# 0.28934f
C168 a_314_332# a_2478_3908# 1.01636f
C169 INN VDD 0.05252f
C170 a_554_3908# a_2478_3908# 0.71615f
C171 a_54_3792# VDD 1.99713f
C172 a_314_332# a_3566_332# 0.56154f
C173 a_3290_3908# a_2478_3908# 0.27674f
C174 VSS a_4030_4792# 0.07998f
C175 a_554_3908# a_254_3908# 0.05253f
C176 VDD a_14_332# 0.2292f
C177 VSS a_12530_376# 0.01198f
C178 VDD VDD 2.30841f
C179 a_3290_3908# a_3566_332# 0.68593f
C180 VSS INP 0.05143f
C181 VDD a_3010_376# 0.21985f
C182 OUT a_4030_4792# 0.36123f
C183 a_354_3792# a_2478_3908# 0.8163f
C184 a_14_332# a_10466_376# 0.02626f
C185 a_314_332# a_4230_332# 0.37165f
C186 VSS OUT 0.11046f
C187 a_514_376# a_1246_376# 0.02626f
C188 INP OUT 0.01161f
C189 a_7438_332# a_2478_3908# 0.04624f
C190 a_354_3792# a_3566_332# 0.0297f
C191 VDD a_8698_3908# 0.07599f
C192 VDD a_4030_4792# 0.37405f
C193 a_5518_376# a_2278_376# 0.26073f
C194 VSS VDD 0.14018f
C195 INP VDD 0.0535f
C196 a_7054_3792# a_2278_376# 0.1198f
C197 a_54_3792# a_5518_376# 0.61699f
C198 a_554_3908# a_1366_3908# 0.05253f
C199 a_54_3792# a_7054_3792# 0.06349f
C200 a_314_332# a_5850_376# 1.87783f
C201 a_354_3792# a_4230_332# 0.46454f
C202 a_14_332# a_5518_376# 1.37659f
C203 VDD OUT 4.98005f
C204 VSS a_10466_376# 0.04308f
C205 a_7438_332# a_4230_332# 0.63645f
C206 a_7054_3792# a_14_332# 0.0803f
C207 VDD a_314_332# 0.29774f
C208 a_554_3908# VDD 1.17326f
C209 VDD a_3290_3908# 0.34323f
C210 a_354_3792# a_5850_376# 0.79439f
C211 a_514_376# a_3010_376# 0.20156f
C212 a_4030_4792# a_5518_376# 0.0628f
C213 a_4694_4792# a_314_332# 0.35538f
C214 a_7438_332# a_5850_376# 0.2727f
C215 VSS a_5518_376# 0.11234f
C216 a_10922_3908# a_2478_3908# 0.01345f
C217 a_314_332# a_9810_3908# 0.05253f
C218 VDD a_354_3792# 4.68521f
C219 a_2278_376# a_2478_3908# 0.35971f
C220 INN a_2478_3908# 0.20145f
C221 OUT a_5518_376# 0.8823f
C222 a_54_3792# a_2478_3908# 0.60286f
C223 a_2278_376# a_3566_332# 0.22849f
C224 a_7054_3792# OUT 0.31067f
C225 a_354_3792# a_4694_4792# 0.26104f
C226 a_54_3792# a_3566_332# 0.02092f
C227 a_14_332# a_2478_3908# 0.29664f
C228 VDD a_2478_3908# 0.19187f
C229 a_7438_332# a_4694_4792# 0.05726f
C230 VDD a_5518_376# 0.20807f
C231 VSS a_11498_376# 0.0134f
C232 a_14_332# a_3566_332# 0.02909f
C233 a_7054_3792# VDD 0.49182f
C234 a_2278_376# a_4230_332# 0.81055f
C235 a_3010_376# a_314_332# 0.03403f
C236 a_54_3792# a_4230_332# 0.13907f
C237 a_514_376# a_314_332# 1.60282f
C238 a_3290_3908# a_3010_376# 0.1926f
C239 a_554_3908# a_514_376# 0.05754f
C240 a_4030_4792# a_2478_3908# 0.03568f
C241 a_14_332# a_4230_332# 0.14452f
C242 VSS a_2478_3908# 0.24147f
C243 INP a_2478_3908# 0.80553f
C244 a_4030_4792# a_3566_332# 0.59122f
C245 VSS VSS 13.3305f
C246 OUT VSS 5.2134f
C247 VDD VSS 9.29207f
C248 INN VSS 0.94663f
C249 INP VSS 1.00601f
C250 a_514_376# VSS 1.20213f
C251 a_7438_332# VSS 0.78158f
C252 a_14_332# VSS 4.7828f
C253 a_314_332# VSS 5.48081f
C254 a_4230_332# VSS 2.53471f
C255 a_5518_376# VSS 1.67743f
C256 a_5850_376# VSS 1.83106f
C257 a_2278_376# VSS 2.17716f
C258 a_3566_332# VSS 1.81908f
C259 a_3010_376# VSS 0.697f
C260 a_3290_3908# VSS 0.67898f
C261 a_2478_3908# VSS 4.61948f
C262 a_554_3908# VSS 1.07776f
C263 a_7054_3792# VSS 0.90502f
C264 a_4694_4792# VSS 1.49743f
C265 a_4030_4792# VSS 0.9734f
C266 a_354_3792# VSS 5.95051f
C267 a_54_3792# VSS 2.70615f
C268 VDD VSS 22.3137f
C269 VDD VSS 0.10985p
.ends
