* Nodos de bulk atados: 2 de pozo n -> VDD, 1 de sustrato -> VSS.
*   magic no extrae los taps de este layout y los dejaba flotando;
*   la conexion si existe (el LVS de KLayout da 'match uniquely').
*   Quien detecta un tap que falte de verdad es el LVS, no esto.
* NGSPICE file created from OPAM.ext - technology: gf180mcuD

.subckt OPAM VSS VDD OUT INN INP
X0 a_4218_332# a_4218_332# a_7402_332# VSS nfet_06v0 ad=2.2p pd=10.88u as=1.65p ps=5.66u w=5u l=1u
X1 a_1366_3776# a_54_3660# VDD VDD pfet_06v0 ad=2.5p pd=10.5u as=4.4p ps=20.88u w=10u l=1u
X2 a_3914_4660# a_354_3660# a_3010_376# VDD pfet_06v0 ad=1.65p pd=5.66u as=1.65p ps=5.66u w=5u l=1u
X3 a_14_332# a_354_3660# a_10758_3776# VDD pfet_06v0 ad=4.4p pd=20.88u as=2.5p ps=10.5u w=10u l=1u
X4 a_6890_3660# a_354_3660# a_7090_3776# VDD pfet_06v0 ad=3.3p pd=10.66u as=2.5p ps=10.5u w=10u l=1u
X5 a_354_3660# a_354_3660# VDD VDD pfet_06v0 ad=0.88p pd=4.88u as=0.88p ps=4.88u w=2u l=1u
X6 a_2278_376# INP a_514_376# VSS nfet_06v0 ad=2.2p pd=10.88u as=2.2p ps=10.88u w=5u l=1u
X7 a_2478_3776# a_3554_332# VSS VSS nfet_06v0 ad=0.825p pd=3.16u as=1.1p ps=5.88u w=2.5u l=1u
X8 a_9646_3776# a_54_3660# VDD VDD pfet_06v0 ad=2.5p pd=10.5u as=4.4p ps=20.88u w=10u l=1u
X9 a_10430_376# a_14_332# VSS VSS nfet_06v0 ad=1.25p pd=5.5u as=2.2p ps=10.88u w=5u l=1u
X10 a_514_376# a_314_332# a_214_376# VSS nfet_06v0 ad=2.2p pd=10.88u as=1.25p ps=5.5u w=5u l=1u
X11 a_3290_3776# a_3554_332# VSS VSS nfet_06v0 ad=0.825p pd=3.16u as=1.1p ps=5.88u w=2.5u l=1u
X12 a_254_3776# a_54_3660# VDD VDD pfet_06v0 ad=2.5p pd=10.5u as=4.4p ps=20.88u w=10u l=1u
X13 a_14_332# a_314_332# a_10430_376# VSS nfet_06v0 ad=2.2p pd=10.88u as=1.25p ps=5.5u w=5u l=1u
X14 OUT a_2278_376# cap_mim_2f0_m4m5_noshield c_width=20u c_length=10u
X15 a_554_3776# a_354_3660# a_1366_3776# VDD pfet_06v0 ad=4.4p pd=20.88u as=2.5p ps=10.5u w=10u l=1u
X16 a_8534_3776# a_54_3660# VDD VDD pfet_06v0 ad=2.5p pd=10.5u as=4.4p ps=20.88u w=10u l=1u
X17 a_314_332# a_354_3660# a_9646_3776# VDD pfet_06v0 ad=4.4p pd=20.88u as=2.5p ps=10.5u w=10u l=1u
X18 a_214_376# a_14_332# VSS VSS nfet_06v0 ad=1.25p pd=5.5u as=2.2p ps=10.88u w=5u l=1u
X19 a_7602_376# a_7402_332# VSS VSS nfet_06v0 ad=1.25p pd=5.5u as=2.2p ps=10.88u w=5u l=1u
X20 OUT a_5494_376# VSS VSS nfet_06v0 ad=0.44p pd=2.88u as=0.44p ps=2.88u w=1u l=1u
X21 a_7090_3776# a_6890_3660# VDD VDD pfet_06v0 ad=2.5p pd=10.5u as=4.4p ps=20.88u w=10u l=1u
X22 a_5826_376# a_4218_332# a_5494_376# VSS nfet_06v0 ad=1.1p pd=5.88u as=0.825p ps=3.16u w=2.5u l=1u
X23 OUT a_5826_376# VDD VDD pfet_06v0 ad=0.308p pd=2.28u as=0.308p ps=2.28u w=0.7u l=20u
X24 a_11462_376# a_354_3660# VSS VSS nfet_06v0 ad=0.25p pd=1.5u as=0.44p ps=2.88u w=1u l=1u
X25 a_12682_3776# a_54_3660# VDD VDD pfet_06v0 ad=2.5p pd=10.5u as=4.4p ps=20.88u w=10u l=1u
X26 a_7402_332# a_314_332# a_7602_376# VSS nfet_06v0 ad=1.65p pd=5.66u as=1.25p ps=5.5u w=5u l=1u
X27 a_3914_4660# a_4218_332# a_3554_332# VSS nfet_06v0 ad=1.1p pd=5.88u as=0.825p ps=3.16u w=2.5u l=1u
X28 a_5494_376# a_314_332# a_2478_3776# VSS nfet_06v0 ad=0.825p pd=3.16u as=0.825p ps=3.16u w=2.5u l=1u
X29 a_5826_376# a_354_3660# a_2278_376# VDD pfet_06v0 ad=1.65p pd=5.66u as=1.65p ps=5.66u w=5u l=1u
X30 a_4218_332# a_354_3660# a_8534_3776# VDD pfet_06v0 ad=4.4p pd=20.88u as=2.5p ps=10.5u w=10u l=1u
X31 a_54_3660# a_354_3660# a_11462_376# VSS nfet_06v0 ad=0.44p pd=2.88u as=0.25p ps=1.5u w=1u l=1u
X32 a_3290_3776# INN a_554_3776# VDD pfet_06v0 ad=4.4p pd=20.88u as=4.4p ps=20.88u w=10u l=1u
X33 a_2278_376# a_3914_4660# VDD VDD pfet_06v0 ad=1.65p pd=5.66u as=2.2p ps=10.88u w=5u l=1u
X34 a_4578_4660# a_4578_4660# a_6890_3660# VDD pfet_06v0 ad=4.4p pd=20.88u as=3.3p ps=10.66u w=10u l=1u
X35 a_314_332# a_314_332# VSS VSS nfet_06v0 ad=0.44p pd=2.88u as=0.44p ps=2.88u w=1u l=1u
X36 a_2478_3776# OUT cap_mim_2f0_m4m5_noshield c_width=20u c_length=10u
X37 a_6558_376# a_14_332# VSS VSS nfet_06v0 ad=1.25p pd=5.5u as=2.2p ps=10.88u w=5u l=1u
X38 a_5494_376# a_4578_4660# a_5826_376# VDD pfet_06v0 ad=2.2p pd=10.88u as=1.65p ps=5.66u w=5u l=1u
X39 a_1246_376# a_14_332# VSS VSS nfet_06v0 ad=1.25p pd=5.5u as=2.2p ps=10.88u w=5u l=1u
X40 a_554_3776# a_354_3660# a_254_3776# VDD pfet_06v0 ad=4.4p pd=20.88u as=2.5p ps=10.5u w=10u l=1u
X41 a_12982_3776# a_354_3660# a_12682_3776# VDD pfet_06v0 ad=4.4p pd=20.88u as=2.5p ps=10.5u w=10u l=1u
X42 a_10758_3776# a_54_3660# VDD VDD pfet_06v0 ad=2.5p pd=10.5u as=4.4p ps=20.88u w=10u l=1u
X43 a_3010_376# INN a_514_376# VSS nfet_06v0 ad=2.2p pd=10.88u as=2.2p ps=10.88u w=5u l=1u
X44 a_12494_376# a_354_3660# VSS VSS nfet_06v0 ad=0.25p pd=1.5u as=0.44p ps=2.88u w=1u l=1u
X45 a_2478_3776# INP a_554_3776# VDD pfet_06v0 ad=4.4p pd=20.88u as=4.4p ps=20.88u w=10u l=1u
X46 a_3010_376# a_3914_4660# VDD VDD pfet_06v0 ad=1.65p pd=5.66u as=2.2p ps=10.88u w=5u l=1u
X47 a_514_376# a_314_332# a_1246_376# VSS nfet_06v0 ad=2.2p pd=10.88u as=1.25p ps=5.5u w=5u l=1u
X48 a_3554_332# a_314_332# a_3290_3776# VSS nfet_06v0 ad=0.825p pd=3.16u as=0.825p ps=3.16u w=2.5u l=1u
X49 a_4578_4660# a_314_332# a_6558_376# VSS nfet_06v0 ad=2.2p pd=10.88u as=1.25p ps=5.5u w=5u l=1u
X50 a_3554_332# a_4578_4660# a_3914_4660# VDD pfet_06v0 ad=2.2p pd=10.88u as=1.65p ps=5.66u w=5u l=1u
X51 a_354_3660# a_354_3660# a_12494_376# VSS nfet_06v0 ad=0.44p pd=2.88u as=0.25p ps=1.5u w=1u l=1u
C0 a_14_332# a_4218_332# 0.12997f
C1 a_3914_4660# VDD 0.38297f
C2 a_514_376# a_2278_376# 0.44482f
C3 a_2478_3776# a_3554_332# 1.20361f
C4 a_4578_4660# a_6890_3660# 1.08148f
C5 a_514_376# INN 0.42585f
C6 a_10758_3776# OUT 0.01039f
C7 a_54_3660# INP 0.02302f
C8 a_3290_3776# VSS 0.13156f
C9 a_5494_376# a_2478_3776# 0.26623f
C10 a_354_3660# a_4578_4660# 0.26092f
C11 VDD a_12982_3776# 0.23769f
C12 a_3914_4660# a_54_3660# 0.07513f
C13 a_5826_376# VDD 1.48047f
C14 a_12682_3776# a_12982_3776# 0.05253f
C15 VSS a_10430_376# 0.04308f
C16 a_3554_332# VDD 0.1192f
C17 a_4578_4660# OUT 0.22138f
C18 a_554_3776# a_2278_376# 0.11204f
C19 a_3914_4660# a_4218_332# 1.3524f
C20 a_2478_3776# a_314_332# 0.75572f
C21 a_554_3776# INN 0.53561f
C22 a_54_3660# a_12982_3776# -13.4425f
C23 a_5826_376# a_54_3660# 0.27235f
C24 a_554_3776# a_254_3776# 0.05253f
C25 a_3290_3776# a_3010_376# 0.12604f
C26 a_6890_3660# a_7402_332# 0.05719f
C27 a_4578_4660# a_6558_376# 0.02626f
C28 a_2478_3776# a_2278_376# 0.52687f
C29 a_5494_376# VDD 0.21888f
C30 a_2478_3776# INN 0.22825f
C31 a_54_3660# a_3554_332# 0.0257f
C32 a_554_3776# VDD 1.17619f
C33 a_5826_376# a_4218_332# 1.01649f
C34 a_2478_3776# VDD 0.69121f
C35 a_4578_4660# VSS 0.22163f
C36 a_314_332# VDD 0.38053f
C37 a_4218_332# a_3554_332# 0.63468f
C38 a_5494_376# a_54_3660# 0.02659f
C39 a_354_3660# a_14_332# 1.06898f
C40 a_2278_376# VDD 0.33849f
C41 OUT a_7402_332# 0.03131f
C42 VDD INN 0.0527f
C43 a_254_3776# VDD 0.07875f
C44 a_5494_376# a_4218_332# 0.78681f
C45 a_14_332# OUT 0.40929f
C46 a_54_3660# a_314_332# 0.14889f
C47 a_554_3776# a_514_376# 0.05021f
C48 VDD VDD 6.55138f
C49 a_54_3660# a_2278_376# 0.45932f
C50 a_554_3776# a_1366_3776# 0.05253f
C51 a_54_3660# INN 0.02517f
C52 a_354_3660# INP 0.047f
C53 a_2478_3776# a_514_376# 0.10847f
C54 a_4218_332# a_314_332# 0.24244f
C55 VSS a_7402_332# 0.29779f
C56 a_3914_4660# a_354_3660# 0.80085f
C57 a_54_3660# VDD 1.89524f
C58 a_4218_332# a_2278_376# 0.69024f
C59 OUT INP 0.03287f
C60 VSS a_1246_376# 0.04308f
C61 a_5826_376# a_6890_3660# 0.11401f
C62 a_14_332# VSS 0.85435f
C63 a_5826_376# VDD 5.31447f
C64 a_3914_4660# OUT 0.39086f
C65 a_4218_332# VDD 0.30348f
C66 a_354_3660# a_12982_3776# 0.24224f
C67 a_5826_376# a_354_3660# 0.81249f
C68 a_554_3776# a_2478_3776# 0.67609f
C69 a_1366_3776# VDD 0.07139f
C70 a_214_376# a_514_376# 0.02626f
C71 a_354_3660# a_3554_332# 0.02969f
C72 a_5494_376# a_6890_3660# 0.08455f
C73 OUT a_12982_3776# 0.01497f
C74 VSS INP 0.05143f
C75 a_5826_376# OUT 3.99993f
C76 a_14_332# a_3010_376# 0.03024f
C77 a_3914_4660# VSS 0.08185f
C78 a_3554_332# OUT 0.15466f
C79 a_5494_376# a_354_3660# 0.03005f
C80 a_554_3776# VDD 0.62485f
C81 a_6890_3660# a_2278_376# 0.05008f
C82 a_2478_3776# VDD 0.22648f
C83 a_5494_376# OUT 0.71822f
C84 a_5826_376# VSS 0.2009f
C85 a_354_3660# a_314_332# 0.46747f
C86 a_12682_3776# a_2478_3776# 0.01597f
C87 VSS a_7602_376# 0.04308f
C88 a_554_3776# a_54_3660# 1.2023f
C89 a_354_3660# a_2278_376# 0.77526f
C90 VSS a_3554_332# 0.25847f
C91 a_6890_3660# VDD 0.45594f
C92 a_3914_4660# a_3010_376# 1.42309f
C93 a_354_3660# INN 0.04324f
C94 a_314_332# OUT 1.04645f
C95 VSS a_11462_376# 0.01425f
C96 a_54_3660# a_2478_3776# 0.61007f
C97 a_2278_376# OUT 1.65989f
C98 a_354_3660# VDD 4.67362f
C99 a_5494_376# VSS 0.11775f
C100 OUT INN 0.19732f
C101 a_12682_3776# VDD 0.07746f
C102 a_2478_3776# a_4218_332# 0.08225f
C103 VDD OUT 1.15988f
C104 a_3010_376# a_3554_332# 0.35265f
C105 VSS a_314_332# 0.79676f
C106 a_54_3660# VDD 1.77158f
C107 VSS a_2278_376# 0.03209f
C108 VSS INN 0.051f
C109 a_4218_332# VDD 0.38261f
C110 a_3290_3776# a_14_332# 0.03032f
C111 a_3010_376# a_314_332# 0.0247f
C112 a_514_376# OUT 0.02519f
C113 a_9646_3776# a_314_332# 0.05253f
C114 a_54_3660# a_4218_332# 0.43136f
C115 a_3010_376# a_2278_376# 0.13225f
C116 a_14_332# a_10430_376# 0.0329f
C117 a_3010_376# INN 0.84258f
C118 a_2478_3776# a_6890_3660# 0.02006f
C119 a_10758_3776# a_14_332# 0.05253f
C120 a_554_3776# a_354_3660# 0.98996f
C121 VDD a_2478_3776# 0.21785f
C122 a_3010_376# VDD 0.2171f
C123 VSS a_514_376# 0.3867f
C124 a_354_3660# a_2478_3776# 0.83164f
C125 a_3290_3776# a_3914_4660# 0.15024f
C126 a_4578_4660# a_7402_332# 0.59438f
C127 a_554_3776# OUT 0.1619f
C128 a_6890_3660# VDD 0.49132f
C129 a_14_332# a_4578_4660# 0.0643f
C130 a_2478_3776# OUT 3.10967f
C131 VDD VDD 2.24292f
C132 a_354_3660# VDD 1.42318f
C133 a_3010_376# a_514_376# 0.20156f
C134 a_12682_3776# a_354_3660# 0.01006f
C135 a_3290_3776# a_3554_332# 0.74671f
C136 a_54_3660# a_6890_3660# 0.06823f
C137 VDD a_54_3660# 0.01216f
C138 OUT VDD 5.06364f
C139 a_2478_3776# VSS 0.13372f
C140 a_12682_3776# OUT 0.01039f
C141 a_54_3660# a_354_3660# 7.47453f
C142 a_4218_332# a_6890_3660# 0.28532f
C143 a_3914_4660# a_4578_4660# 1.12179f
C144 a_14_332# a_7402_332# 0.09039f
C145 a_8534_3776# VDD 0.07139f
C146 a_54_3660# OUT 0.4475f
C147 a_354_3660# a_4218_332# 0.46845f
C148 a_3290_3776# a_314_332# 0.67108f
C149 VSS VDD 0.14509f
C150 a_5826_376# a_4578_4660# 1.14253f
C151 a_7090_3776# VDD 0.07672f
C152 a_2478_3776# a_3010_376# 0.13537f
C153 a_3290_3776# a_2278_376# 0.063f
C154 a_3290_3776# INN 0.7651f
C155 a_4218_332# OUT 0.07371f
C156 a_214_376# VSS 0.04686f
C157 a_4578_4660# a_3554_332# 1.13225f
C158 a_54_3660# VSS 0.06319f
C159 a_3290_3776# VDD 0.31853f
C160 a_14_332# INP 0.04089f
C161 a_8534_3776# a_4218_332# 0.05253f
C162 a_5494_376# a_4578_4660# 2.05403f
C163 a_3914_4660# a_14_332# 0.02844f
C164 a_3010_376# VDD 0.23043f
C165 a_4218_332# VSS 0.21047f
C166 a_9646_3776# VDD 0.07139f
C167 a_5826_376# a_7402_332# 0.26535f
C168 a_7602_376# a_7402_332# 0.03311f
C169 a_4578_4660# a_314_332# 1.64543f
C170 a_354_3660# a_6890_3660# 0.58684f
C171 a_54_3660# a_3010_376# 0.02404f
C172 a_5826_376# a_14_332# 0.09663f
C173 a_4578_4660# a_2278_376# 0.11141f
C174 VDD a_354_3660# 0.0145f
C175 a_14_332# a_3554_332# 0.09486f
C176 a_6890_3660# OUT 0.04904f
C177 a_5494_376# a_7402_332# 0.05501f
C178 a_4218_332# a_3010_376# 0.17985f
C179 a_4578_4660# VDD 1.39362f
C180 VDD OUT 1.05177f
C181 a_5494_376# a_14_332# 0.06753f
C182 a_354_3660# OUT 1.16871f
C183 a_314_332# a_7402_332# 0.48561f
C184 a_3290_3776# a_554_3776# 0.39604f
C185 a_7090_3776# a_6890_3660# 0.06563f
C186 a_14_332# a_314_332# 5.03976f
C187 a_3914_4660# a_3554_332# 0.74918f
C188 VDD VSS 0.16386f
C189 a_3290_3776# a_2478_3776# 0.25372f
C190 a_14_332# a_2278_376# 0.0473f
C191 a_354_3660# VSS 0.31041f
C192 a_14_332# INN 0.04262f
C193 a_14_332# VDD 0.32779f
C194 a_10758_3776# a_2478_3776# 0.01597f
C195 VSS OUT 0.14946f
C196 a_314_332# INP 0.02167f
C197 a_3290_3776# VDD 0.11911f
C198 a_2278_376# INP 1.1373f
C199 a_3914_4660# a_314_332# 0.02993f
C200 VSS a_6558_376# 0.04308f
C201 INN INP 0.01418f
C202 a_5826_376# a_5494_376# 1.4768f
C203 a_354_3660# a_3010_376# 0.65118f
C204 a_3914_4660# a_2278_376# 1.11431f
C205 a_3914_4660# INN 0.01219f
C206 a_3290_3776# a_54_3660# 0.02563f
C207 VDD INP 0.28864f
C208 a_10758_3776# VDD 0.07139f
C209 a_2478_3776# a_4578_4660# 0.32745f
C210 a_3010_376# OUT 0.17222f
C211 a_5826_376# a_314_332# 0.07992f
C212 a_514_376# a_1246_376# 0.02626f
C213 a_14_332# a_514_376# 0.21437f
C214 a_3914_4660# VDD 1.26526f
C215 a_5826_376# a_2278_376# 0.436f
C216 a_3554_332# a_314_332# 0.57859f
C217 a_3554_332# a_2278_376# 0.07609f
C218 VDD a_12982_3776# 0.0828f
C219 a_4578_4660# VDD 0.37831f
C220 a_5826_376# VDD 0.21735f
C221 a_5494_376# a_314_332# 0.67629f
C222 VSS a_12494_376# 0.01198f
C223 a_3010_376# VSS 0.08504f
C224 a_514_376# INP 0.47302f
C225 a_3554_332# VDD 0.39995f
C226 a_5494_376# a_2278_376# 0.04474f
C227 a_2478_3776# a_7402_332# 0.02624f
C228 a_54_3660# a_4578_4660# 0.1353f
C229 a_2478_3776# a_14_332# 0.16267f
C230 a_5494_376# VDD 0.38031f
C231 a_314_332# a_2278_376# 0.03997f
C232 a_314_332# INN 0.02421f
C233 a_4218_332# a_4578_4660# 0.17652f
C234 a_554_3776# INP 1.05205f
C235 a_2278_376# INN 0.46093f
C236 a_314_332# VDD 0.29827f
C237 a_2478_3776# INP 0.60568f
C238 a_14_332# VDD 0.23279f
C239 a_2278_376# VDD 0.50999f
C240 VDD INN 0.2874f
C241 a_3290_3776# a_354_3660# 0.03098f
C242 a_3914_4660# a_2478_3776# 0.05633f
C243 a_54_3660# a_14_332# 0.11128f
C244 a_3290_3776# OUT 0.13685f
C245 a_4218_332# a_7402_332# 0.79838f
C246 VDD INP 0.05355f
C247 a_2478_3776# a_12982_3776# 0.03177f
C248 a_5826_376# a_2478_3776# 0.891f
C249 a_514_376# a_314_332# 1.66621f
C250 VSS VSS 13.1872f
C251 OUT VSS 5.86011f
C252 VDD VSS 9.16789f
C253 INN VSS 0.98927f
C254 INP VSS 0.96709f
C255 a_514_376# VSS 1.34986f
C256 a_7402_332# VSS 0.89074f
C257 a_12982_3776# VSS 0.0756f
C258 a_14_332# VSS 3.92427f
C259 a_314_332# VSS 4.64952f
C260 a_4218_332# VSS 2.7302f
C261 a_5494_376# VSS 1.39003f
C262 a_5826_376# VSS 1.82066f
C263 a_2278_376# VSS 2.2045f
C264 a_3554_332# VSS 1.79187f
C265 a_3010_376# VSS 0.64186f
C266 a_3290_3776# VSS 0.60313f
C267 a_2478_3776# VSS 3.61289f
C268 a_554_3776# VSS 0.68167f
C269 a_6890_3660# VSS 0.64605f
C270 a_4578_4660# VSS 1.42196f
C271 a_3914_4660# VSS 1.08703f
C272 a_354_3660# VSS 5.72112f
C273 a_54_3660# VSS 2.80789f
C274 VDD VSS 21.8235f
C275 VDD VSS 0.10854p
.ends
