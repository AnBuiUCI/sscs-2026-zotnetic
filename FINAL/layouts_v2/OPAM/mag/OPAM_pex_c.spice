* Nodos de bulk atados: 2 de pozo n -> VDD, 1 de sustrato -> VSS.
*   magic no extrae los taps de este layout y los dejaba flotando;
*   la conexion si existe (el LVS de KLayout da 'match uniquely').
*   Quien detecta un tap que falte de verdad es el LVS, no esto.
* NGSPICE file created from OPAM.ext - technology: gf180mcuD

.subckt OPAM VSS VDD OUT INN INP
X0 a_4218_332# a_4218_332# a_7402_332# VSS nfet_06v0 ad=2.2p pd=10.88u as=1.65p ps=5.66u w=5u l=1u
X1 a_1366_3776# a_54_3660# VDD VDD pfet_06v0 ad=2.5p pd=10.5u as=4.4p ps=20.88u w=10u l=1u
X2 a_3914_4660# a_354_3660# a_3010_376# VDD pfet_06v0 ad=1.65p pd=5.66u as=1.65p ps=5.66u w=5u l=1u
X3 a_14_332# a_354_3660# a_10758_3776# VDD pfet_06v0 ad=4.4p pd=20.88u as=2.5p ps=10.5u w=10u l=1u
X4 a_6890_3660# a_354_3660# a_7090_3776# VDD pfet_06v0 ad=3.3p pd=10.66u as=2.5p ps=10.5u w=10u l=1u
X5 a_354_3660# a_354_3660# VDD VDD pfet_06v0 ad=0.88p pd=4.88u as=0.88p ps=4.88u w=2u l=1u
X6 a_2278_376# INP a_514_376# VSS nfet_06v0 ad=2.2p pd=10.88u as=2.2p ps=10.88u w=5u l=1u
X7 a_2478_3776# a_3554_332# VSS VSS nfet_06v0 ad=0.825p pd=3.16u as=1.1p ps=5.88u w=2.5u l=1u
X8 a_9646_3776# a_54_3660# VDD VDD pfet_06v0 ad=2.5p pd=10.5u as=4.4p ps=20.88u w=10u l=1u
X9 a_10430_376# a_14_332# VSS VSS nfet_06v0 ad=1.25p pd=5.5u as=2.2p ps=10.88u w=5u l=1u
X10 a_514_376# a_314_332# a_214_376# VSS nfet_06v0 ad=2.2p pd=10.88u as=1.25p ps=5.5u w=5u l=1u
X11 a_3290_3776# a_3554_332# VSS VSS nfet_06v0 ad=0.825p pd=3.16u as=1.1p ps=5.88u w=2.5u l=1u
X12 a_254_3776# a_54_3660# VDD VDD pfet_06v0 ad=2.5p pd=10.5u as=4.4p ps=20.88u w=10u l=1u
X13 a_14_332# a_314_332# a_10430_376# VSS nfet_06v0 ad=2.2p pd=10.88u as=1.25p ps=5.5u w=5u l=1u
X14 OUT a_2278_376# cap_mim_2f0_m4m5_noshield c_width=20u c_length=10u
X15 a_554_3776# a_354_3660# a_1366_3776# VDD pfet_06v0 ad=4.4p pd=20.88u as=2.5p ps=10.5u w=10u l=1u
X16 a_8534_3776# a_54_3660# VDD VDD pfet_06v0 ad=2.5p pd=10.5u as=4.4p ps=20.88u w=10u l=1u
X17 a_314_332# a_354_3660# a_9646_3776# VDD pfet_06v0 ad=4.4p pd=20.88u as=2.5p ps=10.5u w=10u l=1u
X18 a_214_376# a_14_332# VSS VSS nfet_06v0 ad=1.25p pd=5.5u as=2.2p ps=10.88u w=5u l=1u
X19 a_7602_376# a_7402_332# VSS VSS nfet_06v0 ad=1.25p pd=5.5u as=2.2p ps=10.88u w=5u l=1u
X20 OUT a_5494_376# VSS VSS nfet_06v0 ad=0.44p pd=2.88u as=0.44p ps=2.88u w=1u l=1u
X21 a_7090_3776# a_6890_3660# VDD VDD pfet_06v0 ad=2.5p pd=10.5u as=4.4p ps=20.88u w=10u l=1u
X22 a_5826_376# a_4218_332# a_5494_376# VSS nfet_06v0 ad=1.1p pd=5.88u as=0.825p ps=3.16u w=2.5u l=1u
X23 OUT a_5826_376# VDD VDD pfet_06v0 ad=0.308p pd=2.28u as=0.308p ps=2.28u w=0.7u l=20u
X24 a_11462_376# a_354_3660# VSS VSS nfet_06v0 ad=0.25p pd=1.5u as=0.44p ps=2.88u w=1u l=1u
X25 a_12682_3776# a_54_3660# VDD VDD pfet_06v0 ad=2.5p pd=10.5u as=4.4p ps=20.88u w=10u l=1u
X26 a_7402_332# a_314_332# a_7602_376# VSS nfet_06v0 ad=1.65p pd=5.66u as=1.25p ps=5.5u w=5u l=1u
X27 a_3914_4660# a_4218_332# a_3554_332# VSS nfet_06v0 ad=1.1p pd=5.88u as=0.825p ps=3.16u w=2.5u l=1u
X28 a_5494_376# a_314_332# a_2478_3776# VSS nfet_06v0 ad=0.825p pd=3.16u as=0.825p ps=3.16u w=2.5u l=1u
X29 a_5826_376# a_354_3660# a_2278_376# VDD pfet_06v0 ad=1.65p pd=5.66u as=1.65p ps=5.66u w=5u l=1u
X30 a_4218_332# a_354_3660# a_8534_3776# VDD pfet_06v0 ad=4.4p pd=20.88u as=2.5p ps=10.5u w=10u l=1u
X31 a_54_3660# a_354_3660# a_11462_376# VSS nfet_06v0 ad=0.44p pd=2.88u as=0.25p ps=1.5u w=1u l=1u
X32 a_3290_3776# INN a_554_3776# VDD pfet_06v0 ad=4.4p pd=20.88u as=4.4p ps=20.88u w=10u l=1u
X33 a_2278_376# a_3914_4660# VDD VDD pfet_06v0 ad=1.65p pd=5.66u as=2.2p ps=10.88u w=5u l=1u
X34 a_4578_4660# a_4578_4660# a_6890_3660# VDD pfet_06v0 ad=4.4p pd=20.88u as=3.3p ps=10.66u w=10u l=1u
X35 a_314_332# a_314_332# VSS VSS nfet_06v0 ad=0.44p pd=2.88u as=0.44p ps=2.88u w=1u l=1u
X36 a_2478_3776# OUT cap_mim_2f0_m4m5_noshield c_width=20u c_length=10u
X37 a_6558_376# a_14_332# VSS VSS nfet_06v0 ad=1.25p pd=5.5u as=2.2p ps=10.88u w=5u l=1u
X38 a_5494_376# a_4578_4660# a_5826_376# VDD pfet_06v0 ad=2.2p pd=10.88u as=1.65p ps=5.66u w=5u l=1u
X39 a_1246_376# a_14_332# VSS VSS nfet_06v0 ad=1.25p pd=5.5u as=2.2p ps=10.88u w=5u l=1u
X40 a_554_3776# a_354_3660# a_254_3776# VDD pfet_06v0 ad=4.4p pd=20.88u as=2.5p ps=10.5u w=10u l=1u
X41 a_54_3660# a_354_3660# a_12682_3776# VDD pfet_06v0 ad=4.4p pd=20.88u as=2.5p ps=10.5u w=10u l=1u
X42 a_10758_3776# a_54_3660# VDD VDD pfet_06v0 ad=2.5p pd=10.5u as=4.4p ps=20.88u w=10u l=1u
X43 a_3010_376# INN a_514_376# VSS nfet_06v0 ad=2.2p pd=10.88u as=2.2p ps=10.88u w=5u l=1u
X44 a_12494_376# a_354_3660# VSS VSS nfet_06v0 ad=0.25p pd=1.5u as=0.44p ps=2.88u w=1u l=1u
X45 a_2478_3776# INP a_554_3776# VDD pfet_06v0 ad=4.4p pd=20.88u as=4.4p ps=20.88u w=10u l=1u
X46 a_3010_376# a_3914_4660# VDD VDD pfet_06v0 ad=1.65p pd=5.66u as=2.2p ps=10.88u w=5u l=1u
X47 a_514_376# a_314_332# a_1246_376# VSS nfet_06v0 ad=2.2p pd=10.88u as=1.25p ps=5.5u w=5u l=1u
X48 a_3554_332# a_314_332# a_3290_3776# VSS nfet_06v0 ad=0.825p pd=3.16u as=0.825p ps=3.16u w=2.5u l=1u
X49 a_4578_4660# a_314_332# a_6558_376# VSS nfet_06v0 ad=2.2p pd=10.88u as=1.25p ps=5.5u w=5u l=1u
X50 a_3554_332# a_4578_4660# a_3914_4660# VDD pfet_06v0 ad=2.2p pd=10.88u as=1.65p ps=5.66u w=5u l=1u
X51 a_354_3660# a_354_3660# a_12494_376# VSS nfet_06v0 ad=0.44p pd=2.88u as=0.25p ps=1.5u w=1u l=1u
C0 OUT a_5826_376# 3.99996f
C1 a_354_3660# a_3010_376# 0.65118f
C2 INP INN 0.02499f
C3 a_4578_4660# VDD 1.39362f
C4 a_7402_332# a_5826_376# 0.26535f
C5 INP VDD 0.05355f
C6 a_354_3660# a_5826_376# 0.81239f
C7 a_5494_376# a_314_332# 0.67629f
C8 a_2278_376# a_14_332# 0.0473f
C9 OUT a_314_332# 1.04645f
C10 a_2478_3776# a_2278_376# 0.52681f
C11 a_3914_4660# a_314_332# 0.02993f
C12 a_3554_332# a_2278_376# 0.07609f
C13 a_7402_332# a_314_332# 0.48561f
C14 a_354_3660# a_314_332# 0.46747f
C15 INN a_3010_376# 0.81445f
C16 VDD a_3010_376# 0.23043f
C17 INP VSS 0.05143f
C18 a_6890_3660# a_5826_376# 0.11401f
C19 OUT a_3290_3776# 0.13685f
C20 VDD OUT 1.05177f
C21 VDD a_5826_376# 1.48047f
C22 VDD a_1366_3776# 0.07139f
C23 a_3914_4660# a_3290_3776# 0.15024f
C24 a_4578_4660# a_2278_376# 0.11141f
C25 a_514_376# a_2278_376# 0.44478f
C26 a_54_3660# a_12682_3776# 0.05253f
C27 a_4578_4660# a_6558_376# 0.02626f
C28 a_4218_332# a_5494_376# 0.78681f
C29 a_354_3660# a_3290_3776# 0.03098f
C30 a_314_332# a_9646_3776# 0.05253f
C31 VDD a_354_3660# 0.0144f
C32 OUT a_4218_332# 0.07371f
C33 a_3914_4660# a_4218_332# 1.3524f
C34 INN a_314_332# 0.02256f
C35 a_54_3660# a_5494_376# 0.02659f
C36 OUT a_54_3660# 0.4606f
C37 VSS a_3010_376# 0.08504f
C38 VDD a_314_332# 0.38053f
C39 a_3914_4660# a_54_3660# 0.07513f
C40 a_7402_332# a_4218_332# 0.79838f
C41 a_354_3660# a_4218_332# 0.46845f
C42 VSS a_10430_376# 0.04308f
C43 VSS a_5826_376# 0.2009f
C44 a_54_3660# a_354_3660# 7.65551f
C45 a_2478_3776# a_14_332# 0.16267f
C46 VDD a_5494_376# 0.38031f
C47 a_3554_332# a_14_332# 0.09486f
C48 a_7402_332# a_7602_376# 0.03311f
C49 INN a_3290_3776# 0.7635f
C50 OUT VDD 1.16103f
C51 a_2478_3776# a_3554_332# 1.20361f
C52 a_6890_3660# a_7090_3776# 0.06563f
C53 OUT a_10758_3776# 0.01039f
C54 a_3914_4660# VDD 1.26526f
C55 VDD a_3290_3776# 0.11911f
C56 a_554_3776# INP 1.05626f
C57 VDD VDD 2.24292f
C58 VDD a_7090_3776# 0.07672f
C59 VSS a_314_332# 0.79676f
C60 a_6890_3660# a_4218_332# 0.28532f
C61 a_354_3660# VDD 4.66559f
C62 a_514_376# a_214_376# 0.02626f
C63 VDD a_4218_332# 0.38261f
C64 a_54_3660# a_6890_3660# 0.06823f
C65 a_4578_4660# a_14_332# 0.0643f
C66 a_2478_3776# a_4578_4660# 0.32745f
C67 INN a_54_3660# 0.02353f
C68 a_514_376# a_14_332# 0.21437f
C69 VSS a_1246_376# 0.04308f
C70 a_54_3660# VDD 2.0054f
C71 a_3554_332# a_4578_4660# 1.13225f
C72 a_2478_3776# a_514_376# 0.10847f
C73 VSS a_3290_3776# 0.13156f
C74 VDD VSS 0.16386f
C75 a_2278_376# a_5494_376# 0.04474f
C76 a_6890_3660# VDD 0.45594f
C77 VDD a_254_3776# 0.07875f
C78 OUT a_2278_376# 1.65989f
C79 a_554_3776# a_1366_3776# 0.05253f
C80 INN VDD 0.27977f
C81 a_3914_4660# a_2278_376# 1.11431f
C82 VDD VDD 6.55409f
C83 VSS a_4218_332# 0.21047f
C84 VDD a_10758_3776# 0.07139f
C85 a_354_3660# a_2278_376# 0.77526f
C86 a_54_3660# VSS 0.06319f
C87 VSS a_7602_376# 0.04308f
C88 a_2278_376# a_6890_3660# 0.05008f
C89 INN a_2278_376# 0.3878f
C90 a_554_3776# a_3290_3776# 0.39604f
C91 VDD a_2278_376# 0.33849f
C92 INP a_314_332# 0.02169f
C93 a_2478_3776# a_12682_3776# 0.01597f
C94 a_4218_332# a_8534_3776# 0.05253f
C95 a_14_332# a_5494_376# 0.06753f
C96 a_2478_3776# a_5494_376# 0.26623f
C97 OUT a_14_332# 0.40929f
C98 a_2478_3776# OUT 3.10967f
C99 a_3914_4660# a_14_332# 0.02844f
C100 a_2478_3776# a_3914_4660# 0.05633f
C101 OUT a_3554_332# 0.15466f
C102 a_554_3776# a_54_3660# 1.2023f
C103 a_3914_4660# a_3554_332# 0.74918f
C104 a_7402_332# a_14_332# 0.09039f
C105 a_354_3660# a_14_332# 1.06898f
C106 a_2478_3776# a_7402_332# 0.02624f
C107 a_2478_3776# a_354_3660# 0.82373f
C108 VSS a_2278_376# 0.03209f
C109 a_354_3660# a_3554_332# 0.02969f
C110 a_314_332# a_3010_376# 0.0247f
C111 a_554_3776# a_254_3776# 0.05253f
C112 a_4578_4660# a_5494_376# 2.05403f
C113 VSS a_6558_376# 0.04308f
C114 a_314_332# a_5826_376# 0.07992f
C115 OUT a_4578_4660# 0.22138f
C116 a_554_3776# VDD 1.17619f
C117 a_3914_4660# a_4578_4660# 1.12179f
C118 OUT a_514_376# 0.02519f
C119 INP a_54_3660# 0.02472f
C120 a_4578_4660# a_7402_332# 0.59438f
C121 a_354_3660# a_4578_4660# 0.26092f
C122 INN a_14_332# 0.04151f
C123 a_2478_3776# a_6890_3660# 0.02006f
C124 a_3290_3776# a_3010_376# 0.12604f
C125 a_2478_3776# INN 0.22102f
C126 VDD a_14_332# 0.23279f
C127 a_2478_3776# VDD 0.22722f
C128 VDD a_5826_376# 5.31447f
C129 VDD a_3554_332# 0.1192f
C130 a_4218_332# a_3010_376# 0.17985f
C131 INP VDD 0.29359f
C132 VSS a_214_376# 0.04686f
C133 a_4218_332# a_5826_376# 1.01649f
C134 a_54_3660# a_3010_376# 0.02404f
C135 a_4578_4660# a_6890_3660# 1.08148f
C136 a_554_3776# a_2278_376# 0.11196f
C137 a_54_3660# a_5826_376# 0.27133f
C138 a_314_332# a_3290_3776# 0.67108f
C139 VDD a_4578_4660# 0.37831f
C140 INN a_514_376# 0.42559f
C141 VSS a_14_332# 0.85435f
C142 a_2478_3776# VSS 0.13372f
C143 a_3554_332# VSS 0.25847f
C144 VDD a_3010_376# 0.2171f
C145 a_4218_332# a_314_332# 0.24244f
C146 VDD a_5826_376# 0.21774f
C147 a_54_3660# a_314_332# 0.14889f
C148 OUT a_12682_3776# 0.01039f
C149 INP a_2278_376# 1.15121f
C150 VSS a_4578_4660# 0.22163f
C151 OUT a_5494_376# 0.71822f
C152 a_354_3660# a_12682_3776# 0.01006f
C153 VSS a_514_376# 0.3867f
C154 a_3914_4660# OUT 0.39086f
C155 VDD a_314_332# 0.29827f
C156 a_7402_332# a_5494_376# 0.05501f
C157 a_354_3660# a_5494_376# 0.03005f
C158 a_54_3660# a_3290_3776# 0.02563f
C159 VDD a_54_3660# 0.01764f
C160 OUT a_7402_332# 0.03131f
C161 OUT a_354_3660# 1.16825f
C162 a_3914_4660# a_354_3660# 0.80085f
C163 a_2278_376# a_3010_376# 0.13228f
C164 a_2478_3776# a_554_3776# 0.67609f
C165 a_54_3660# a_4218_332# 0.43136f
C166 a_2278_376# a_5826_376# 0.436f
C167 VDD a_3290_3776# 0.31853f
C168 VDD a_12682_3776# 0.07746f
C169 a_6890_3660# a_5494_376# 0.08455f
C170 OUT a_6890_3660# 0.04904f
C171 OUT INN 0.1658f
C172 VDD a_5494_376# 0.21888f
C173 VDD a_4218_332# 0.30348f
C174 a_3914_4660# INN 0.01219f
C175 INP a_14_332# 0.04091f
C176 OUT VDD 5.06373f
C177 a_2278_376# a_314_332# 0.03997f
C178 a_2478_3776# INP 0.6056f
C179 a_3914_4660# VDD 0.38297f
C180 a_7402_332# a_6890_3660# 0.05719f
C181 a_354_3660# a_6890_3660# 0.58684f
C182 a_54_3660# VDD 1.96276f
C183 INN a_354_3660# 0.0421f
C184 a_554_3776# a_514_376# 0.05021f
C185 VDD a_354_3660# 1.42317f
C186 VSS a_11462_376# 0.01425f
C187 a_2278_376# a_3290_3776# 0.063f
C188 VSS a_5494_376# 0.11775f
C189 a_14_332# a_3010_376# 0.03024f
C190 OUT VSS 0.14946f
C191 a_2478_3776# a_3010_376# 0.13537f
C192 a_3914_4660# VSS 0.08185f
C193 INP a_514_376# 0.47311f
C194 VDD a_9646_3776# 0.07139f
C195 a_10430_376# a_14_332# 0.0329f
C196 a_14_332# a_5826_376# 0.09663f
C197 a_3554_332# a_3010_376# 0.35265f
C198 a_2478_3776# a_5826_376# 0.89162f
C199 a_2278_376# a_4218_332# 0.69024f
C200 VDD a_6890_3660# 0.49132f
C201 VSS a_7402_332# 0.29779f
C202 a_354_3660# VSS 0.31041f
C203 INN VDD 0.0527f
C204 a_54_3660# a_2278_376# 0.45932f
C205 a_14_332# a_314_332# 5.03976f
C206 a_2478_3776# a_314_332# 0.75572f
C207 a_514_376# a_3010_376# 0.20156f
C208 a_4578_4660# a_5826_376# 1.14253f
C209 a_3554_332# a_314_332# 0.57859f
C210 a_2278_376# VDD 0.50999f
C211 INN VSS 0.051f
C212 VDD VSS 0.14509f
C213 a_14_332# a_3290_3776# 0.03032f
C214 a_554_3776# OUT 0.1619f
C215 a_2478_3776# a_3290_3776# 0.25372f
C216 a_2478_3776# VDD 0.21785f
C217 a_4578_4660# a_314_332# 1.64543f
C218 a_3554_332# a_3290_3776# 0.74671f
C219 a_514_376# a_314_332# 1.66621f
C220 a_554_3776# a_354_3660# 0.98996f
C221 a_14_332# a_4218_332# 0.12997f
C222 a_2478_3776# a_4218_332# 0.08225f
C223 a_3554_332# a_4218_332# 0.63468f
C224 a_54_3660# a_14_332# 0.11128f
C225 a_2478_3776# a_54_3660# 0.6354f
C226 OUT INP 0.04137f
C227 a_514_376# a_1246_376# 0.02626f
C228 a_54_3660# a_3554_332# 0.0257f
C229 INP a_354_3660# 0.04786f
C230 VSS a_12494_376# 0.01198f
C231 a_4578_4660# a_4218_332# 0.17652f
C232 a_554_3776# INN 0.5318f
C233 VDD a_8534_3776# 0.07139f
C234 VDD a_14_332# 0.32779f
C235 a_2478_3776# VDD 0.69385f
C236 a_14_332# a_10758_3776# 0.05253f
C237 a_2478_3776# a_10758_3776# 0.01597f
C238 a_554_3776# VDD 0.62485f
C239 a_54_3660# a_4578_4660# 0.1353f
C240 a_3554_332# VDD 0.39995f
C241 OUT a_3010_376# 0.17226f
C242 a_3914_4660# a_3010_376# 1.42309f
C243 a_5494_376# a_5826_376# 1.4768f
C244 VSS VSS 13.1872f
C245 OUT VSS 5.86411f
C246 VDD VSS 9.16885f
C247 INN VSS 0.90304f
C248 INP VSS 0.97973f
C249 a_514_376# VSS 1.34986f
C250 a_7402_332# VSS 0.89074f
C251 a_14_332# VSS 3.92427f
C252 a_314_332# VSS 4.64952f
C253 a_4218_332# VSS 2.7302f
C254 a_5494_376# VSS 1.39003f
C255 a_5826_376# VSS 1.82214f
C256 a_2278_376# VSS 2.2059f
C257 a_3554_332# VSS 1.79187f
C258 a_3010_376# VSS 0.64186f
C259 a_3290_3776# VSS 0.60313f
C260 a_2478_3776# VSS 3.61367f
C261 a_554_3776# VSS 0.68167f
C262 a_6890_3660# VSS 0.64605f
C263 a_4578_4660# VSS 1.42196f
C264 a_3914_4660# VSS 1.08703f
C265 a_354_3660# VSS 5.70704f
C266 a_54_3660# VSS 2.86792f
C267 VDD VSS 21.8235f
C268 VDD VSS 0.10854p
.ends
