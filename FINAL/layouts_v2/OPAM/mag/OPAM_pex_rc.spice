* Nodos de bulk atados: 27 de pozo n -> VDD, 27 de sustrato -> VSS.
*   magic no extrae los taps de este layout y los dejaba flotando;
*   la conexion si existe (el LVS de KLayout da 'match uniquely').
*   Quien detecta un tap que falte de verdad es el LVS, no esto.
* NGSPICE file created from OPAM.ext - technology: gf180mcuD

.subckt OPAM VSS VDD OUT INP INN
X0 a_3566_332.t1 a_314_332.t7 a_3290_3908.t2 VSS nfet_06v0 ad=0.825p pd=3.16u as=0.825p ps=3.16u w=2.5u l=1u
X1 a_10922_3908.t0 a_54_3792.t3 VDD.t10 VDD pfet_06v0 ad=2.5p pd=10.5u as=4.4p ps=20.88u w=10u l=1u
X2 a_354_3792.t1 a_354_3792.t0 VDD.t4 VDD pfet_06v0 ad=0.88p pd=4.88u as=0.88p ps=4.88u w=2u l=1u
X3 OUT.t1 a_5518_376.t3 VSS.t8 VSS nfet_06v0 ad=0.44p pd=2.88u as=0.44p ps=2.88u w=1u l=1u
X4 a_554_3908.t2 a_354_3792.t15 a_254_3908.t1 VDD pfet_06v0 ad=4.4p pd=20.88u as=2.5p ps=10.5u w=10u l=1u
X5 a_7054_3792.t1 a_354_3792.t11 a_7254_3908.t0 VDD pfet_06v0 ad=3.3p pd=10.66u as=2.5p ps=10.5u w=10u l=1u
X6 a_5518_376.t1 a_314_332.t6 a_2478_3908.t1 VSS nfet_06v0 ad=0.825p pd=3.16u as=0.825p ps=3.16u w=2.5u l=1u
X7 a_4694_4792.t0 a_314_332.t5 a_6582_376.t0 VSS nfet_06v0 ad=2.2p pd=10.88u as=1.25p ps=5.5u w=5u l=1u
X8 a_2478_3908.t2 INP.t1 a_554_3908.t3 VDD pfet_06v0 ad=4.4p pd=20.88u as=4.4p ps=20.88u w=10u l=1u
X9 a_2278_376.t3 INP.t0 a_514_376.t1 VSS nfet_06v0 ad=2.2p pd=10.88u as=2.2p ps=10.88u w=5u l=1u
X10 a_514_376.t3 a_314_332.t9 a_214_376.t1 VSS nfet_06v0 ad=2.2p pd=10.88u as=1.25p ps=5.5u w=5u l=1u
X11 a_4230_332.t1 a_4230_332.t0 a_7438_332.t1 VSS nfet_06v0 ad=2.2p pd=10.88u as=1.65p ps=5.66u w=5u l=1u
X12 a_314_332.t1 a_314_332.t0 VSS.t2 VSS nfet_06v0 ad=0.44p pd=2.88u as=0.44p ps=2.88u w=1u l=1u
X13 a_1366_3908.t0 a_54_3792.t6 VDD.t0 VDD pfet_06v0 ad=2.5p pd=10.5u as=4.4p ps=20.88u w=10u l=1u
X14 a_3290_3908.t0 a_3566_332.t4 VSS.t10 VSS nfet_06v0 ad=0.825p pd=3.16u as=1.1p ps=5.88u w=2.5u l=1u
X15 a_9810_3908.t0 a_54_3792.t4 VDD.t8 VDD pfet_06v0 ad=2.5p pd=10.5u as=4.4p ps=20.88u w=10u l=1u
X16 a_2478_3908.t0 a_3566_332.t3 VSS.t9 VSS nfet_06v0 ad=0.825p pd=3.16u as=1.1p ps=5.88u w=2.5u l=1u
X17 a_3566_332.t2 a_4694_4792.t4 a_4030_4792.t2 VDD pfet_06v0 ad=2.2p pd=10.88u as=1.65p ps=5.66u w=5u l=1u
X18 OUT.t0 a_5850_376.t3 VDD.t2 VDD pfet_06v0 ad=0.308p pd=2.28u as=0.308p ps=2.28u w=0.7u l=20u
X19 a_12530_376.t0 a_354_3792.t4 VSS.t5 VSS nfet_06v0 ad=0.25p pd=1.5u as=0.44p ps=2.88u w=1u l=1u
X20 a_254_3908.t0 a_54_3792.t7 VDD.t1 VDD pfet_06v0 ad=2.5p pd=10.5u as=4.4p ps=20.88u w=10u l=1u
X21 a_12846_3908.t1 a_54_3792.t2 VDD.t9 VDD pfet_06v0 ad=2.5p pd=10.5u as=4.4p ps=20.88u w=10u l=1u
X22 a_214_376.t0 a_14_332.t5 VSS.t1 VSS nfet_06v0 ad=1.25p pd=5.5u as=2.2p ps=10.88u w=5u l=1u
X23 a_10466_376.t0 a_14_332.t2 VSS.t3 VSS nfet_06v0 ad=1.25p pd=5.5u as=2.2p ps=10.88u w=5u l=1u
X24 OUT.t3 a_2278_376.t2 cap_mim_2f0_m4m5_noshield c_width=20u c_length=10u
X25 a_4030_4792.t1 a_354_3792.t13 a_3010_376.t2 VDD pfet_06v0 ad=1.65p pd=5.66u as=1.65p ps=5.66u w=5u l=1u
X26 a_8698_3908.t0 a_54_3792.t5 VDD.t3 VDD pfet_06v0 ad=2.5p pd=10.5u as=4.4p ps=20.88u w=10u l=1u
X27 a_354_3792.t3 a_354_3792.t2 a_12530_376.t1 VSS nfet_06v0 ad=0.44p pd=2.88u as=0.25p ps=1.5u w=1u l=1u
X28 a_554_3908.t1 a_354_3792.t14 a_1366_3908.t1 VDD pfet_06v0 ad=4.4p pd=20.88u as=2.5p ps=10.5u w=10u l=1u
X29 a_5518_376.t2 a_4694_4792.t3 a_5850_376.t2 VDD pfet_06v0 ad=2.2p pd=10.88u as=1.65p ps=5.66u w=5u l=1u
X30 a_5850_376.t1 a_354_3792.t12 a_2278_376.t1 VDD pfet_06v0 ad=1.65p pd=5.66u as=1.65p ps=5.66u w=5u l=1u
X31 a_14_332.t1 a_314_332.t3 a_10466_376.t1 VSS nfet_06v0 ad=2.2p pd=10.88u as=1.25p ps=5.5u w=5u l=1u
X32 a_3010_376.t0 a_4030_4792.t4 VDD.t5 VDD pfet_06v0 ad=1.65p pd=5.66u as=2.2p ps=10.88u w=5u l=1u
X33 a_314_332.t2 a_354_3792.t9 a_9810_3908.t1 VDD pfet_06v0 ad=4.4p pd=20.88u as=2.5p ps=10.5u w=10u l=1u
X34 a_14_332.t0 a_354_3792.t8 a_10922_3908.t1 VDD pfet_06v0 ad=4.4p pd=20.88u as=2.5p ps=10.5u w=10u l=1u
X35 a_4030_4792.t0 a_4230_332.t4 a_3566_332.t0 VSS nfet_06v0 ad=1.1p pd=5.88u as=0.825p ps=3.16u w=2.5u l=1u
X36 a_2278_376.t0 a_4030_4792.t3 VDD.t6 VDD pfet_06v0 ad=1.65p pd=5.66u as=2.2p ps=10.88u w=5u l=1u
X37 a_5850_376.t0 a_4230_332.t3 a_5518_376.t0 VSS nfet_06v0 ad=1.1p pd=5.88u as=0.825p ps=3.16u w=2.5u l=1u
X38 a_54_3792.t1 a_354_3792.t7 a_12846_3908.t0 VDD pfet_06v0 ad=4.4p pd=20.88u as=2.5p ps=10.5u w=10u l=1u
X39 a_7638_376.t1 a_7438_332.t2 VSS.t6 VSS nfet_06v0 ad=1.25p pd=5.5u as=2.2p ps=10.88u w=5u l=1u
X40 a_7254_3908.t1 a_7054_3792.t2 VDD.t7 VDD pfet_06v0 ad=2.5p pd=10.5u as=4.4p ps=20.88u w=10u l=1u
X41 a_4230_332.t2 a_354_3792.t10 a_8698_3908.t1 VDD pfet_06v0 ad=4.4p pd=20.88u as=2.5p ps=10.5u w=10u l=1u
X42 a_1246_376.t0 a_14_332.t4 VSS.t7 VSS nfet_06v0 ad=1.25p pd=5.5u as=2.2p ps=10.88u w=5u l=1u
X43 a_11498_376.t0 a_354_3792.t6 VSS.t0 VSS nfet_06v0 ad=0.25p pd=1.5u as=0.44p ps=2.88u w=1u l=1u
X44 a_2478_3908.t3 OUT.t2 cap_mim_2f0_m4m5_noshield c_width=20u c_length=10u
X45 a_3010_376.t1 INN.t0 a_514_376.t0 VSS nfet_06v0 ad=2.2p pd=10.88u as=2.2p ps=10.88u w=5u l=1u
X46 a_7438_332.t0 a_314_332.t4 a_7638_376.t0 VSS nfet_06v0 ad=1.65p pd=5.66u as=1.25p ps=5.5u w=5u l=1u
X47 a_4694_4792.t2 a_4694_4792.t1 a_7054_3792.t0 VDD pfet_06v0 ad=4.4p pd=20.88u as=3.3p ps=10.66u w=10u l=1u
X48 a_514_376.t2 a_314_332.t8 a_1246_376.t1 VSS nfet_06v0 ad=2.2p pd=10.88u as=1.25p ps=5.5u w=5u l=1u
X49 a_6582_376.t1 a_14_332.t3 VSS.t4 VSS nfet_06v0 ad=1.25p pd=5.5u as=2.2p ps=10.88u w=5u l=1u
X50 a_54_3792.t0 a_354_3792.t5 a_11498_376.t1 VSS nfet_06v0 ad=0.44p pd=2.88u as=0.25p ps=1.5u w=1u l=1u
X51 a_3290_3908.t1 INN.t1 a_554_3908.t0 VDD pfet_06v0 ad=4.4p pd=20.88u as=4.4p ps=20.88u w=10u l=1u
R0 VSS.n38 VSS.n35 9.0005
R1 VSS.n40 VSS.n39 9.0005
R2 VSS.n41 VSS.n34 9.0005
R3 VSS.n43 VSS.n42 9.0005
R4 VSS.n44 VSS.n32 9.0005
R5 VSS.n46 VSS.n45 9.0005
R6 VSS.n47 VSS.n31 9.0005
R7 VSS.n49 VSS.n48 9.0005
R8 VSS.n50 VSS.n29 9.0005
R9 VSS.n52 VSS.n51 9.0005
R10 VSS.n53 VSS.n28 9.0005
R11 VSS.n55 VSS.n54 9.0005
R12 VSS.n56 VSS.n26 9.0005
R13 VSS.n58 VSS.n57 9.0005
R14 VSS.n59 VSS.n1 9.0005
R15 VSS.n61 VSS.n60 9.0005
R16 VSS.n25 VSS.n0 9.0005
R17 VSS.n24 VSS.n23 9.0005
R18 VSS.n22 VSS.n2 9.0005
R19 VSS.n21 VSS.n20 9.0005
R20 VSS.n19 VSS.n18 9.0005
R21 VSS.n16 VSS.n4 9.0005
R22 VSS.n15 VSS.n14 9.0005
R23 VSS.n13 VSS.n12 9.0005
R24 VSS.n11 VSS.n6 9.0005
R25 VSS.n10 VSS.n9 9.0005
R26 VSS.n8 VSS.t5 5.38136
R27 VSS.n7 VSS.t0 5.28916
R28 VSS.n17 VSS.t2 5.28916
R29 VSS.n3 VSS.t8 5.28916
R30 VSS.n36 VSS.n35 3.22882
R31 VSS.n30 VSS.t9 2.58836
R32 VSS.n33 VSS.t10 2.58836
R33 VSS.n36 VSS.t1 2.10811
R34 VSS.n5 VSS.t3 1.91886
R35 VSS.n62 VSS.t6 1.91886
R36 VSS.n27 VSS.t4 1.91886
R37 VSS.n37 VSS.t7 1.91886
R38 VSS.n9 VSS.n8 1.72616
R39 VSS.n8 VSS.n7 0.413223
R40 VSS.n37 VSS.n36 0.32148
R41 VSS.n9 VSS.n6 0.2005
R42 VSS.n13 VSS.n6 0.2005
R43 VSS.n14 VSS.n13 0.2005
R44 VSS.n14 VSS.n4 0.2005
R45 VSS.n19 VSS.n4 0.2005
R46 VSS.n20 VSS.n19 0.2005
R47 VSS.n20 VSS.n2 0.2005
R48 VSS.n24 VSS.n2 0.2005
R49 VSS.n25 VSS.n24 0.2005
R50 VSS.n60 VSS.n25 0.2005
R51 VSS.n60 VSS.n59 0.2005
R52 VSS.n59 VSS.n58 0.2005
R53 VSS.n58 VSS.n26 0.2005
R54 VSS.n54 VSS.n26 0.2005
R55 VSS.n54 VSS.n53 0.2005
R56 VSS.n53 VSS.n52 0.2005
R57 VSS.n52 VSS.n29 0.2005
R58 VSS.n48 VSS.n29 0.2005
R59 VSS.n48 VSS.n47 0.2005
R60 VSS.n47 VSS.n46 0.2005
R61 VSS.n46 VSS.n32 0.2005
R62 VSS.n42 VSS.n32 0.2005
R63 VSS.n42 VSS.n41 0.2005
R64 VSS.n41 VSS.n40 0.2005
R65 VSS.n40 VSS.n35 0.2005
R66 VSS.n11 VSS.n10 0.2005
R67 VSS.n12 VSS.n11 0.2005
R68 VSS.n16 VSS.n15 0.2005
R69 VSS.n22 VSS.n21 0.2005
R70 VSS.n23 VSS.n22 0.2005
R71 VSS.n23 VSS.n0 0.2005
R72 VSS.n61 VSS.n1 0.2005
R73 VSS.n57 VSS.n56 0.2005
R74 VSS.n56 VSS.n55 0.2005
R75 VSS.n55 VSS.n28 0.2005
R76 VSS.n51 VSS.n50 0.2005
R77 VSS.n50 VSS.n49 0.2005
R78 VSS.n49 VSS.n31 0.2005
R79 VSS.n45 VSS.n44 0.2005
R80 VSS.n44 VSS.n43 0.2005
R81 VSS.n43 VSS.n34 0.2005
R82 VSS.n39 VSS.n34 0.2005
R83 VSS.n39 VSS.n38 0.2005
R84 VSS.n27 VSS.n1 0.198
R85 VSS.n45 VSS.n33 0.195
R86 VSS.n18 VSS.n3 0.188
R87 VSS.n18 VSS.n17 0.179
R88 VSS.n15 VSS.n5 0.145
R89 VSS.n62 VSS.n61 0.131
R90 VSS.n51 VSS.n30 0.105
R91 VSS.n30 VSS.n28 0.096
R92 VSS.n38 VSS.n37 0.066
R93 VSS.n10 VSS.n7 0.061
R94 VSS.n12 VSS.n5 0.056
R95 VSS VSS.n62 0.055
R96 VSS.n17 VSS.n16 0.022
R97 VSS VSS.n0 0.0155
R98 VSS.n21 VSS.n3 0.013
R99 VSS.n33 VSS.n31 0.006
R100 VSS.n57 VSS.n27 0.003
R101 OUT.n0 OUT.t3 15.5647
R102 OUT OUT.t0 13.0454
R103 OUT.n0 OUT.t1 12.452
R104 OUT.n1 OUT.t2 9.27911
R105 OUT.n1 OUT.n0 7.50564
R106 OUT OUT.n1 4.81068
R107 VDD.n9 VDD.t2 17.88
R108 VDD.n44 VDD.n41 9.0005
R109 VDD.n46 VDD.n45 9.0005
R110 VDD.n47 VDD.n40 9.0005
R111 VDD.n49 VDD.n48 9.0005
R112 VDD.n50 VDD.n39 9.0005
R113 VDD.n52 VDD.n51 9.0005
R114 VDD.n53 VDD.n38 9.0005
R115 VDD.n55 VDD.n54 9.0005
R116 VDD.n57 VDD.n56 9.0005
R117 VDD.n58 VDD.n35 9.0005
R118 VDD.n60 VDD.n59 9.0005
R119 VDD.n61 VDD.n34 9.0005
R120 VDD.n63 VDD.n62 9.0005
R121 VDD.n64 VDD.n33 9.0005
R122 VDD.n66 VDD.n65 9.0005
R123 VDD.n68 VDD.n67 9.0005
R124 VDD.n32 VDD.n0 9.0005
R125 VDD.n31 VDD.n30 9.0005
R126 VDD.n29 VDD.n2 9.0005
R127 VDD.n27 VDD.n26 9.0005
R128 VDD.n25 VDD.n3 9.0005
R129 VDD.n24 VDD.n23 9.0005
R130 VDD.n21 VDD.n4 9.0005
R131 VDD.n20 VDD.n19 9.0005
R132 VDD.n18 VDD.n17 9.0005
R133 VDD.n16 VDD.n6 9.0005
R134 VDD.n15 VDD.n14 9.0005
R135 VDD.n13 VDD.n12 9.0005
R136 VDD.n11 VDD.n8 9.0005
R137 VDD.n44 VDD.n43 3.23511
R138 VDD.n7 VDD.t4 2.82475
R139 VDD.n43 VDD.t1 2.14376
R140 VDD.n42 VDD.t0 1.96744
R141 VDD.n1 VDD.t7 1.96744
R142 VDD.n28 VDD.t3 1.96744
R143 VDD.n22 VDD.t8 1.96744
R144 VDD.n5 VDD.t10 1.96744
R145 VDD.n10 VDD.t9 1.96744
R146 VDD.n9 VDD.n8 1.8627
R147 VDD.n37 VDD.t5 1.8449
R148 VDD.n36 VDD.t6 1.8449
R149 VDD.n10 VDD.n9 0.445868
R150 VDD.n43 VDD.n42 0.37519
R151 VDD.n13 VDD.n8 0.2005
R152 VDD.n14 VDD.n13 0.2005
R153 VDD.n14 VDD.n6 0.2005
R154 VDD.n18 VDD.n6 0.2005
R155 VDD.n19 VDD.n18 0.2005
R156 VDD.n19 VDD.n4 0.2005
R157 VDD.n24 VDD.n4 0.2005
R158 VDD.n25 VDD.n24 0.2005
R159 VDD.n26 VDD.n25 0.2005
R160 VDD.n26 VDD.n2 0.2005
R161 VDD.n31 VDD.n2 0.2005
R162 VDD.n32 VDD.n31 0.2005
R163 VDD.n67 VDD.n32 0.2005
R164 VDD.n67 VDD.n66 0.2005
R165 VDD.n66 VDD.n33 0.2005
R166 VDD.n62 VDD.n33 0.2005
R167 VDD.n62 VDD.n61 0.2005
R168 VDD.n61 VDD.n60 0.2005
R169 VDD.n60 VDD.n35 0.2005
R170 VDD.n56 VDD.n35 0.2005
R171 VDD.n56 VDD.n55 0.2005
R172 VDD.n55 VDD.n38 0.2005
R173 VDD.n51 VDD.n38 0.2005
R174 VDD.n51 VDD.n50 0.2005
R175 VDD.n50 VDD.n49 0.2005
R176 VDD.n49 VDD.n40 0.2005
R177 VDD.n45 VDD.n40 0.2005
R178 VDD.n45 VDD.n44 0.2005
R179 VDD.n12 VDD.n11 0.2005
R180 VDD.n16 VDD.n15 0.2005
R181 VDD.n17 VDD.n16 0.2005
R182 VDD.n21 VDD.n20 0.2005
R183 VDD.n23 VDD.n3 0.2005
R184 VDD.n27 VDD.n3 0.2005
R185 VDD.n30 VDD.n29 0.2005
R186 VDD.n30 VDD.n0 0.2005
R187 VDD.n65 VDD.n64 0.2005
R188 VDD.n64 VDD.n63 0.2005
R189 VDD.n63 VDD.n34 0.2005
R190 VDD.n59 VDD.n58 0.2005
R191 VDD.n58 VDD.n57 0.2005
R192 VDD.n54 VDD.n53 0.2005
R193 VDD.n53 VDD.n52 0.2005
R194 VDD.n52 VDD.n39 0.2005
R195 VDD.n48 VDD.n39 0.2005
R196 VDD.n48 VDD.n47 0.2005
R197 VDD.n47 VDD.n46 0.2005
R198 VDD.n46 VDD.n41 0.2005
R199 VDD.n59 VDD.n36 0.189
R200 VDD VDD.n68 0.1855
R201 VDD.n22 VDD.n21 0.184
R202 VDD.n57 VDD.n37 0.174
R203 VDD.n20 VDD.n5 0.173
R204 VDD.n28 VDD.n27 0.14
R205 VDD.n65 VDD.n1 0.139
R206 VDD.n11 VDD.n10 0.135
R207 VDD.n15 VDD.n7 0.129
R208 VDD.n12 VDD.n7 0.072
R209 VDD.n68 VDD.n1 0.062
R210 VDD.n29 VDD.n28 0.061
R211 VDD.n17 VDD.n5 0.028
R212 VDD.n54 VDD.n37 0.027
R213 VDD.n23 VDD.n22 0.017
R214 VDD VDD.n0 0.0155
R215 VDD.n36 VDD.n34 0.012
R216 VDD.n42 VDD.n41 0.006
R217 INN INN.t1 45.536
R218 INN INN.t0 36.9394
R219 INP INP.t1 45.7943
R220 INP INP.t0 36.5625
R221 a_12530_376.t0 a_12530_376.t1 3.1505
R222 a_11498_376.t0 a_11498_376.t1 3.1505
R223 a_10466_376.t0 a_10466_376.t1 0.6305
R224 a_7638_376.t0 a_7638_376.t1 0.6305
R225 a_6582_376.t0 a_6582_376.t1 0.6305
R226 a_1246_376.t0 a_1246_376.t1 0.6305
R227 a_514_376.t0 a_514_376.n0 8.21431
R228 a_514_376.n0 a_514_376.n1 0.601571
R229 a_514_376.n1 a_514_376.t3 8.69645
R230 a_514_376.n1 a_514_376.t2 7.07002
R231 a_514_376.n0 a_514_376.t1 7.07002
R232 a_214_376.t0 a_214_376.t1 0.6305
R233 a_7438_332.n0 a_7438_332.t2 47.4245
R234 a_7438_332.t0 a_7438_332.n0 0.4163
R235 a_7438_332.n0 a_7438_332.t1 0.4163
R236 a_12846_3908.t0 a_12846_3908.t1 0.3505
R237 a_14_332.t1 a_14_332.n3 9.13611
R238 a_14_332.n3 a_14_332.t0 8.59464
R239 a_14_332.n3 a_14_332.n0 0.722107
R240 a_14_332.n0 a_14_332.n1 6.2105
R241 a_14_332.n1 a_14_332.n2 8.54407
R242 a_14_332.n2 a_14_332.t5 34.1873
R243 a_14_332.n2 a_14_332.t4 32.5608
R244 a_14_332.n1 a_14_332.t3 32.5608
R245 a_14_332.n0 a_14_332.t2 32.5608
R246 a_10922_3908.t0 a_10922_3908.t1 0.3505
R247 a_314_332.t1 a_314_332.n7 11.7458
R248 a_314_332.n7 a_314_332.n6 0.572643
R249 a_314_332.n6 a_314_332.t3 30.987
R250 a_314_332.n6 a_314_332.t2 10.2183
R251 a_314_332.n7 a_314_332.n0 0.239964
R252 a_314_332.n0 a_314_332.n1 2.85479
R253 a_314_332.n1 a_314_332.n2 1.6655
R254 a_314_332.n2 a_314_332.n3 2.1605
R255 a_314_332.n3 a_314_332.n4 2.2505
R256 a_314_332.n4 a_314_332.n5 4.06979
R257 a_314_332.n5 a_314_332.t9 31.8629
R258 a_314_332.n5 a_314_332.t8 30.2365
R259 a_314_332.n4 a_314_332.t7 22.0897
R260 a_314_332.n3 a_314_332.t6 22.0897
R261 a_314_332.n2 a_314_332.t5 30.2365
R262 a_314_332.n1 a_314_332.t4 30.2365
R263 a_314_332.n0 a_314_332.t0 17.2017
R264 a_9810_3908.t0 a_9810_3908.t1 0.3505
R265 a_4230_332.t1 a_4230_332.n2 7.84481
R266 a_4230_332.n2 a_4230_332.t2 10.3231
R267 a_4230_332.n2 a_4230_332.n0 0.239964
R268 a_4230_332.n0 a_4230_332.n1 3.85764
R269 a_4230_332.n1 a_4230_332.t4 25.3728
R270 a_4230_332.n1 a_4230_332.t3 23.1228
R271 a_4230_332.n0 a_4230_332.t0 31.2695
R272 a_8698_3908.t0 a_8698_3908.t1 0.3505
R273 a_7254_3908.t0 a_7254_3908.t1 0.3505
R274 a_5518_376.n0 a_5518_376.n1 20.6858
R275 a_5518_376.n0 a_5518_376.t1 0.8321
R276 a_5518_376.t0 a_5518_376.n0 0.8321
R277 a_5518_376.n1 a_5518_376.t3 23.6334
R278 a_5518_376.n1 a_5518_376.t2 9.46983
R279 a_5850_376.t0 a_5850_376.n1 9.06456
R280 a_5850_376.n1 a_5850_376.t3 20.1748
R281 a_5850_376.n1 a_5850_376.n0 20.3767
R282 a_5850_376.n0 a_5850_376.t1 0.4625
R283 a_5850_376.n0 a_5850_376.t2 0.4625
R284 a_2278_376.n0 a_2278_376.n1 19.5904
R285 a_2278_376.t0 a_2278_376.n0 0.4625
R286 a_2278_376.n0 a_2278_376.t1 0.4625
R287 a_2278_376.n1 a_2278_376.t3 13.3713
R288 a_2278_376.n1 a_2278_376.t2 9.0005
R289 a_3566_332.n0 a_3566_332.n2 17.4637
R290 a_3566_332.n0 a_3566_332.t1 0.8321
R291 a_3566_332.t0 a_3566_332.n0 0.8321
R292 a_3566_332.n2 a_3566_332.n1 1.24764
R293 a_3566_332.n1 a_3566_332.t3 23.0445
R294 a_3566_332.n1 a_3566_332.t2 11.2777
R295 a_3566_332.n2 a_3566_332.t4 23.6376
R296 a_3010_376.n0 a_3010_376.t1 29.3741
R297 a_3010_376.t0 a_3010_376.n0 0.4625
R298 a_3010_376.n0 a_3010_376.t2 0.4625
R299 a_3290_3908.n0 a_3290_3908.t1 27.6395
R300 a_3290_3908.t0 a_3290_3908.n0 0.8321
R301 a_3290_3908.n0 a_3290_3908.t2 0.8321
R302 a_2478_3908.n0 a_2478_3908.n1 21.0401
R303 a_2478_3908.t0 a_2478_3908.n0 0.8321
R304 a_2478_3908.n0 a_2478_3908.t1 0.8321
R305 a_2478_3908.n1 a_2478_3908.t2 10.1485
R306 a_2478_3908.n1 a_2478_3908.t3 16.5927
R307 a_1366_3908.t0 a_1366_3908.t1 0.3505
R308 a_554_3908.t0 a_554_3908.n0 9.42505
R309 a_554_3908.n0 a_554_3908.n1 0.730143
R310 a_554_3908.n1 a_554_3908.t2 9.90719
R311 a_554_3908.n1 a_554_3908.t1 8.15219
R312 a_554_3908.n0 a_554_3908.t3 8.15219
R313 a_254_3908.t0 a_254_3908.t1 0.3505
R314 a_7054_3792.n0 a_7054_3792.t2 70.1066
R315 a_7054_3792.n0 a_7054_3792.t1 0.2315
R316 a_7054_3792.t0 a_7054_3792.n0 0.2315
R317 a_4694_4792.t0 a_4694_4792.n2 8.36133
R318 a_4694_4792.n2 a_4694_4792.n1 1.31032
R319 a_4694_4792.n1 a_4694_4792.t2 8.90817
R320 a_4694_4792.n1 a_4694_4792.t1 50.2943
R321 a_4694_4792.n2 a_4694_4792.n0 0.985679
R322 a_4694_4792.n0 a_4694_4792.t4 36.418
R323 a_4694_4792.n0 a_4694_4792.t3 34.0008
R324 a_4030_4792.t0 a_4030_4792.n2 11.3
R325 a_4030_4792.n2 a_4030_4792.n1 0.1805
R326 a_4030_4792.n1 a_4030_4792.t3 34.3215
R327 a_4030_4792.n1 a_4030_4792.n0 17.7941
R328 a_4030_4792.n0 a_4030_4792.t1 0.4625
R329 a_4030_4792.n0 a_4030_4792.t2 0.4625
R330 a_4030_4792.n2 a_4030_4792.t4 33.2704
R331 a_354_3792.t3 a_354_3792.n13 15.1032
R332 a_354_3792.n13 a_354_3792.t7 48.6906
R333 a_354_3792.n13 a_354_3792.n0 0.363714
R334 a_354_3792.n0 a_354_3792.n1 0.32675
R335 a_354_3792.n1 a_354_3792.n2 0.493893
R336 a_354_3792.n2 a_354_3792.n3 0.239964
R337 a_354_3792.n3 a_354_3792.n4 0.347643
R338 a_354_3792.n4 a_354_3792.n5 0.4505
R339 a_354_3792.n5 a_354_3792.n6 0.411929
R340 a_354_3792.n6 a_354_3792.n7 1.7555
R341 a_354_3792.n7 a_354_3792.n8 1.7555
R342 a_354_3792.n8 a_354_3792.n9 2.28907
R343 a_354_3792.n9 a_354_3792.n10 2.32764
R344 a_354_3792.n10 a_354_3792.n11 2.41764
R345 a_354_3792.n11 a_354_3792.n12 4.62264
R346 a_354_3792.n12 a_354_3792.t15 50.2415
R347 a_354_3792.n12 a_354_3792.t14 48.4865
R348 a_354_3792.n11 a_354_3792.t13 32.193
R349 a_354_3792.n10 a_354_3792.t12 32.193
R350 a_354_3792.n9 a_354_3792.t11 48.4865
R351 a_354_3792.n8 a_354_3792.t10 48.4865
R352 a_354_3792.n7 a_354_3792.t9 48.4865
R353 a_354_3792.n6 a_354_3792.t8 48.4865
R354 a_354_3792.n5 a_354_3792.t6 20.5591
R355 a_354_3792.n4 a_354_3792.t5 20.5591
R356 a_354_3792.n3 a_354_3792.t0 22.4169
R357 a_354_3792.n2 a_354_3792.t1 10.8493
R358 a_354_3792.n1 a_354_3792.t4 20.5591
R359 a_354_3792.n0 a_354_3792.t2 20.6391
R360 a_54_3792.t0 a_54_3792.n5 14.845
R361 a_54_3792.n5 a_54_3792.n4 1.39711
R362 a_54_3792.n4 a_54_3792.t1 7.82468
R363 a_54_3792.n4 a_54_3792.t2 48.7447
R364 a_54_3792.n5 a_54_3792.n0 1.64782
R365 a_54_3792.n0 a_54_3792.n1 1.7555
R366 a_54_3792.n1 a_54_3792.n2 1.7555
R367 a_54_3792.n2 a_54_3792.n3 11.7519
R368 a_54_3792.n3 a_54_3792.t7 50.4997
R369 a_54_3792.n3 a_54_3792.t6 48.7447
R370 a_54_3792.n2 a_54_3792.t5 48.7447
R371 a_54_3792.n1 a_54_3792.t4 48.7447
R372 a_54_3792.n0 a_54_3792.t3 48.7447
R373 VDD VDD 1935.38
R374 VDD VDD 151.946
R375 VDD VDD 112.275
R376 VDD VDD 303.892
R377 VDD VDD 112.275
R378 VDD VDD 303.892
R379 VDD VDD 303.892
R380 VDD VDD 351.796
R381 VDD VDD 124.252
R382 VDD VDD 124.252
R383 VDD VDD 321.856
R384 VDD VDD 124.252
R385 VDD VDD 124.252
R386 VDD VDD 312.875
R387 VDD VDD 112.275
R388 VDD VDD 124.252
R389 VDD VDD 303.892
R390 VDD VDD 112.275
R391 VDD VDD 303.892
R392 VDD VDD 112.275
R393 VDD VDD 303.892
R394 VDD VDD 112.275
R395 VDD VDD 303.892
R396 VDD VDD 303.892
R397 VDD VDD 112.275
R398 VSS VSS 329.32
R399 VSS VSS 269.935
R400 VSS VSS 658.639
R401 VSS VSS 269.935
R402 VSS VSS 658.639
R403 VSS VSS 658.639
R404 VSS VSS 680.234
R405 VSS VSS 298.728
R406 VSS VSS 298.728
R407 VSS VSS 680.234
R408 VSS VSS 298.728
R409 VSS VSS 298.728
R410 VSS VSS 658.639
R411 VSS VSS 269.935
R412 VSS VSS 680.234
R413 VSS VSS 269.935
R414 VSS VSS 298.728
R415 VSS VSS 658.639
R416 VSS VSS 658.639
R417 VSS VSS 658.639
R418 VSS VSS 269.935
R419 VSS VSS 658.639
R420 VSS VSS 269.935
R421 VSS VSS 658.639
R422 VSS VSS 269.935
C0 OUT INN 0.0365f
C1 VDD INP 0.0535f
C2 VSS INN 0.05097f
C3 VDD INN 0.05252f
C4 INP INN 0.19706f
C5 VSS OUT 0.11046f
C6 VDD OUT 4.98005f
C7 VSS VDD 0.14018f
C8 INP OUT 0.01161f
C9 VSS INP 0.05143f
C10 VSS 0 13.33953f
C11 OUT 0 5.30653f
C12 VDD 0 9.41035f
C13 INN 0 2.52107f
C14 INP 0 2.4038f
C15 VDD 0 0.33648f
C16 VDD 0 0.58511f
C17 VDD 0 0.92159f
C18 VDD 0 0.92159f
C19 VDD 0 0.92159f
C20 VDD 0 1.34592f
C21 VDD 0 1.452f
C22 VDD 0 1.05419f
C23 VDD 0 0.5503f
C24 VDD 0 0.98789f
C25 VDD 0 0.98789f
C26 VDD 0 0.5503f
C27 VDD 0 0.968f
C28 VDD 0 0.94148f
C29 VDD 0 0.52378f
C30 VDD 0 0.94811f
C31 VDD 0 0.92159f
C32 VDD 0 0.92159f
C33 VDD 0 0.92159f
C34 VDD 0 0.92159f
C35 VDD 0 0.92159f
C36 VDD 0 0.92159f
C37 VDD 0 1.34592f
C38 VDD 0 0.92159f
C39 VDD 0 0.92159f
C40 VDD 0 1.80639f
C41 VDD 0 7.2527f
C42 a_54_3792.t0 0 0.32839f
C43 a_54_3792.t3 0 1.33568f
C44 a_54_3792.n0 0 0.77347f
C45 a_54_3792.t4 0 1.33568f
C46 a_54_3792.n1 0 0.78118f
C47 a_54_3792.t5 0 1.33568f
C48 a_54_3792.n2 0 1.49683f
C49 a_54_3792.t6 0 1.33568f
C50 a_54_3792.n3 0 2.1358f
C51 a_54_3792.t7 0 1.35868f
C52 a_54_3792.t2 0 1.33568f
C53 a_54_3792.n4 0 0.84316f
C54 a_54_3792.t1 0 1.35926f
C55 a_54_3792.n5 0 0.51549f
C56 a_354_3792.t3 0 0.3404f
C57 a_354_3792.t2 0 0.40758f
C58 a_354_3792.n0 0 0.47794f
C59 a_354_3792.t4 0 0.40814f
C60 a_354_3792.n1 0 0.48669f
C61 a_354_3792.t1 0 0.46382f
C62 a_354_3792.n2 0 0.25894f
C63 a_354_3792.t0 0 0.44672f
C64 a_354_3792.n3 0 0.42268f
C65 a_354_3792.t5 0 0.40814f
C66 a_354_3792.n4 0 0.48508f
C67 a_354_3792.t6 0 0.40814f
C68 a_354_3792.n5 0 0.48968f
C69 a_354_3792.t8 0 1.32963f
C70 a_354_3792.n6 0 0.66442f
C71 a_354_3792.t9 0 1.32963f
C72 a_354_3792.n7 0 0.76053f
C73 a_354_3792.t10 0 1.32963f
C74 a_354_3792.n8 0 0.79869f
C75 a_354_3792.t11 0 1.32963f
C76 a_354_3792.n9 0 0.83962f
C77 a_354_3792.t12 0 0.76241f
C78 a_354_3792.n10 0 0.78376f
C79 a_354_3792.t13 0 0.76241f
C80 a_354_3792.n11 0 0.94792f
C81 a_354_3792.t14 0 1.32963f
C82 a_354_3792.n12 0 1.58464f
C83 a_354_3792.t15 0 1.35204f
C84 a_354_3792.t7 0 1.33185f
C85 a_354_3792.n13 0 0.87881f
C86 a_4030_4792.t0 0 0.76612f
C87 a_4030_4792.t4 0 1.33641f
C88 a_4030_4792.n0 0 1.40374f
C89 a_4030_4792.t1 0 0.23061f
C90 a_4030_4792.t2 0 0.23061f
C91 a_4030_4792.n1 0 1.70081f
C92 a_4030_4792.t3 0 1.36943f
C93 a_4030_4792.n2 0 1.32233f
C94 a_4694_4792.t0 0 0.6929f
C95 a_4694_4792.t3 0 1.08944f
C96 a_4694_4792.n0 0 2.02602f
C97 a_4694_4792.t4 0 1.15604f
C98 a_4694_4792.t1 0 1.8315f
C99 a_4694_4792.n1 0 1.26102f
C100 a_4694_4792.t2 0 1.95151f
C101 a_4694_4792.n2 0 0.36356f
C102 a_7054_3792.t0 0 0.24232f
C103 a_7054_3792.n0 0 2.1041f
C104 a_7054_3792.t2 0 1.51492f
C105 a_7054_3792.t1 0 0.24232f
C106 a_254_3908.t0 0 0.06843f
C107 a_254_3908.t1 0 0.06843f
C108 a_554_3908.t0 0 1.55533f
C109 a_554_3908.t3 0 1.51974f
C110 a_554_3908.n0 0 0.5406f
C111 a_554_3908.t1 0 1.51974f
C112 a_554_3908.n1 0 0.597f
C113 a_554_3908.t2 0 1.57299f
C114 a_1366_3908.t0 0 0.06556f
C115 a_1366_3908.t1 0 0.06556f
C116 a_2478_3908.t0 0 0.01119f
C117 a_2478_3908.n0 0 0.08842f
C118 a_2478_3908.n1 0 0.24454f
C119 a_2478_3908.t3 0 11.5251f
C120 a_2478_3908.t2 0 0.25213f
C121 a_2478_3908.t1 0 0.01119f
C122 a_3290_3908.t0 0 0.09975f
C123 a_3290_3908.n0 0 0.92518f
C124 a_3290_3908.t1 0 2.73554f
C125 a_3290_3908.t2 0 0.09975f
C126 a_3010_376.t0 0 0.2658f
C127 a_3010_376.n0 0 2.21368f
C128 a_3010_376.t1 0 2.02183f
C129 a_3010_376.t2 0 0.2658f
C130 a_3566_332.t0 0 0.1101f
C131 a_3566_332.n0 0 0.73663f
C132 a_3566_332.t4 0 0.76487f
C133 a_3566_332.t2 0 1.56724f
C134 a_3566_332.n1 0 1.10623f
C135 a_3566_332.t3 0 0.74896f
C136 a_3566_332.n2 0 1.21902f
C137 a_3566_332.t1 0 0.1101f
C138 a_2278_376.t0 0 0.10322f
C139 a_2278_376.n0 0 0.67989f
C140 a_2278_376.n1 0 0.85017f
C141 a_2278_376.t2 0 7.61187f
C142 a_2278_376.t3 0 0.5259f
C143 a_2278_376.t1 0 0.10322f
C144 a_5850_376.t0 0 0.58233f
C145 a_5850_376.n0 0 1.74701f
C146 a_5850_376.t1 0 0.25451f
C147 a_5850_376.t2 0 0.25451f
C148 a_5850_376.n1 0 3.63304f
C149 a_5850_376.t3 0 12.4707f
C150 a_5518_376.t0 0 0.13767f
C151 a_5518_376.n0 0 1.1237f
C152 a_5518_376.t2 0 1.74042f
C153 a_5518_376.n1 0 3.11229f
C154 a_5518_376.t3 0 0.98633f
C155 a_5518_376.t1 0 0.13767f
C156 a_7254_3908.t0 0 0.08861f
C157 a_7254_3908.t1 0 0.08861f
C158 a_8698_3908.t0 0 0.07349f
C159 a_8698_3908.t1 0 0.07349f
C160 a_4230_332.t1 0 0.64199f
C161 a_4230_332.t0 0 0.97882f
C162 a_4230_332.n0 0 0.89088f
C163 a_4230_332.t3 0 0.61824f
C164 a_4230_332.n1 0 1.62994f
C165 a_4230_332.t4 0 0.67729f
C166 a_4230_332.t2 0 2.00569f
C167 a_4230_332.n2 0 0.5643f
C168 a_9810_3908.t0 0 0.06947f
C169 a_9810_3908.t1 0 0.06947f
C170 a_314_332.t1 0 0.18113f
C171 a_314_332.t0 0 0.27624f
C172 a_314_332.n0 0 0.45673f
C173 a_314_332.t4 0 0.71287f
C174 a_314_332.n1 0 0.62753f
C175 a_314_332.t5 0 0.71287f
C176 a_314_332.n2 0 0.5779f
C177 a_314_332.t6 0 0.43374f
C178 a_314_332.n3 0 0.5829f
C179 a_314_332.t7 0 0.43374f
C180 a_314_332.n4 0 0.71939f
C181 a_314_332.t8 0 0.71287f
C182 a_314_332.n5 0 1.11699f
C183 a_314_332.t9 0 0.73468f
C184 a_314_332.t2 0 1.54743f
C185 a_314_332.n6 0 0.6648f
C186 a_314_332.t3 0 0.7217f
C187 a_314_332.n7 0 0.20297f
C188 a_10922_3908.t0 0 0.07768f
C189 a_10922_3908.t1 0 0.07768f
C190 a_14_332.t1 0 0.61989f
C191 a_14_332.t2 0 0.84933f
C192 a_14_332.n0 0 1.0623f
C193 a_14_332.t3 0 0.84933f
C194 a_14_332.n1 0 1.67766f
C195 a_14_332.t4 0 0.84933f
C196 a_14_332.n2 0 1.93807f
C197 a_14_332.t5 0 0.88035f
C198 a_14_332.t0 0 1.555f
C199 a_14_332.n3 0 0.45961f
C200 a_12846_3908.t0 0 0.0798f
C201 a_12846_3908.t1 0 0.0798f
C202 a_7438_332.t0 0 0.11081f
C203 a_7438_332.n0 0 0.94855f
C204 a_7438_332.t2 0 0.7725f
C205 a_7438_332.t1 0 0.11081f
C206 a_214_376.t0 0 0.0366f
C207 a_214_376.t1 0 0.0366f
C208 a_514_376.t0 0 0.70205f
C209 a_514_376.t1 0 0.66909f
C210 a_514_376.n0 0 0.49664f
C211 a_514_376.t2 0 0.66909f
C212 a_514_376.n1 0 0.58177f
C213 a_514_376.t3 0 0.72329f
C214 a_1246_376.t0 0 0.03799f
C215 a_1246_376.t1 0 0.03799f
C216 a_6582_376.t0 0 0.04461f
C217 a_6582_376.t1 0 0.04461f
C218 a_7638_376.t0 0 0.04557f
C219 a_7638_376.t1 0 0.04557f
C220 a_10466_376.t0 0 0.041f
C221 a_10466_376.t1 0 0.041f
C222 a_11498_376.t0 0 0.01017f
C223 a_11498_376.t1 0 0.01017f
C224 INP.t1 0 1.42654f
C225 INP.t0 0 0.91714f
C226 INN.t1 0 1.55823f
C227 INN.t0 0 1.02291f
C228 VDD.n0 0 0.13767f
C229 VDD.t7 0 0.4837f
C230 VDD.n1 0 0.26187f
C231 VDD.n2 0 0.24708f
C232 VDD.t3 0 0.4837f
C233 VDD.n3 0 0.24708f
C234 VDD.n4 0 0.24708f
C235 VDD.t8 0 0.4837f
C236 VDD.t10 0 0.4837f
C237 VDD.n5 0 0.26025f
C238 VDD.n6 0 0.24708f
C239 VDD.t4 0 0.09017f
C240 VDD.n7 0 0.17733f
C241 VDD.n8 0 1.43153f
C242 VDD.t9 0 0.4837f
C243 VDD.t2 0 0.41394f
C244 VDD.n9 0 0.71285f
C245 VDD.n10 0 0.59978f
C246 VDD.n11 0 0.20274f
C247 VDD.n12 0 0.17108f
C248 VDD.n13 0 0.24708f
C249 VDD.n14 0 0.24708f
C250 VDD.n15 0 0.20479f
C251 VDD.n16 0 0.24708f
C252 VDD.n17 0 0.14506f
C253 VDD.n18 0 0.24708f
C254 VDD.n19 0 0.24708f
C255 VDD.n20 0 0.22645f
C256 VDD.n21 0 0.23732f
C257 VDD.n22 0 0.26219f
C258 VDD.n23 0 0.13855f
C259 VDD.n24 0 0.24708f
C260 VDD.n25 0 0.24708f
C261 VDD.n26 0 0.24708f
C262 VDD.n27 0 0.2113f
C263 VDD.n28 0 0.26219f
C264 VDD.n29 0 0.16013f
C265 VDD.n30 0 0.24522f
C266 VDD.n31 0 0.24708f
C267 VDD.n32 0 0.24708f
C268 VDD.n33 0 0.24708f
C269 VDD.n34 0 0.1356f
C270 VDD.n35 0 0.24708f
C271 VDD.t6 0 0.2371f
C272 VDD.n36 0 0.20829f
C273 VDD.t5 0 0.2371f
C274 VDD.n37 0 0.20979f
C275 VDD.n38 0 0.24708f
C276 VDD.n39 0 0.24194f
C277 VDD.n40 0 0.24708f
C278 VDD.n41 0 0.13205f
C279 VDD.t1 0 0.52159f
C280 VDD.t0 0 0.4837f
C281 VDD.n42 0 0.40583f
C282 VDD.n43 0 0.7067f
C283 VDD.n44 0 0.89761f
C284 VDD.n45 0 0.24708f
C285 VDD.n46 0 0.24708f
C286 VDD.n47 0 0.24708f
C287 VDD.n48 0 0.24708f
C288 VDD.n49 0 0.24708f
C289 VDD.n50 0 0.24708f
C290 VDD.n51 0 0.24708f
C291 VDD.n52 0 0.24591f
C292 VDD.n53 0 0.24708f
C293 VDD.n54 0 0.14447f
C294 VDD.n55 0 0.24708f
C295 VDD.n56 0 0.24708f
C296 VDD.n57 0 0.23141f
C297 VDD.n58 0 0.24708f
C298 VDD.n59 0 0.23548f
C299 VDD.n60 0 0.24708f
C300 VDD.n61 0 0.24708f
C301 VDD.n62 0 0.24708f
C302 VDD.n63 0 0.24708f
C303 VDD.n64 0 0.24708f
C304 VDD.n65 0 0.20472f
C305 VDD.n66 0 0.24708f
C306 VDD.n67 0 0.24708f
C307 VDD.n68 0 0.1563f
C308 OUT.t0 0 0.06531f
C309 OUT.t1 0 0.05745f
C310 OUT.t3 0 18.8635f
C311 OUT.n0 0 0.44636f
C312 OUT.t2 0 2.84785f
C313 OUT.n1 0 0.34819f
C314 VSS.n0 0 0.03025f
C315 VSS.t6 0 0.07941f
C316 VSS.n1 0 0.05396f
C317 VSS.n2 0 0.05429f
C318 VSS.t8 0 0.01113f
C319 VSS.n3 0 0.0449f
C320 VSS.n4 0 0.05429f
C321 VSS.t2 0 0.01113f
C322 VSS.t3 0 0.07941f
C323 VSS.n5 0 0.07076f
C324 VSS.n6 0 0.05429f
C325 VSS.t0 0 0.01113f
C326 VSS.n7 0 0.08965f
C327 VSS.t5 0 0.02001f
C328 VSS.n8 0 0.61161f
C329 VSS.n9 0 0.44771f
C330 VSS.n10 0 0.03616f
C331 VSS.n11 0 0.05429f
C332 VSS.n12 0 0.03551f
C333 VSS.n13 0 0.05429f
C334 VSS.n14 0 0.05429f
C335 VSS.n15 0 0.04708f
C336 VSS.n16 0 0.03109f
C337 VSS.n17 0 0.0449f
C338 VSS.n18 0 0.04987f
C339 VSS.n19 0 0.05429f
C340 VSS.n20 0 0.05429f
C341 VSS.n21 0 0.02992f
C342 VSS.n22 0 0.05429f
C343 VSS.n23 0 0.05429f
C344 VSS.n24 0 0.05429f
C345 VSS.n25 0 0.05429f
C346 VSS.n26 0 0.05429f
C347 VSS.t4 0 0.07941f
C348 VSS.n27 0 0.07076f
C349 VSS.n28 0 0.04071f
C350 VSS.n29 0 0.05429f
C351 VSS.t9 0 0.03283f
C352 VSS.n30 0 0.05851f
C353 VSS.n31 0 0.02901f
C354 VSS.n32 0 0.05429f
C355 VSS.t10 0 0.03283f
C356 VSS.n33 0 0.05851f
C357 VSS.n34 0 0.05429f
C358 VSS.n35 0 0.19714f
C359 VSS.t7 0 0.07941f
C360 VSS.t1 0 0.08941f
C361 VSS.n36 0 0.15608f
C362 VSS.n37 0 0.10666f
C363 VSS.n38 0 0.03681f
C364 VSS.n39 0 0.05429f
C365 VSS.n40 0 0.05429f
C366 VSS.n41 0 0.05429f
C367 VSS.n42 0 0.05429f
C368 VSS.n43 0 0.05429f
C369 VSS.n44 0 0.05429f
C370 VSS.n45 0 0.05357f
C371 VSS.n46 0 0.05429f
C372 VSS.n47 0 0.05429f
C373 VSS.n48 0 0.05429f
C374 VSS.n49 0 0.05429f
C375 VSS.n50 0 0.05429f
C376 VSS.n51 0 0.04188f
C377 VSS.n52 0 0.05429f
C378 VSS.n53 0 0.05429f
C379 VSS.n54 0 0.05429f
C380 VSS.n55 0 0.05429f
C381 VSS.n56 0 0.05429f
C382 VSS.n57 0 0.02862f
C383 VSS.n58 0 0.05429f
C384 VSS.n59 0 0.05429f
C385 VSS.n60 0 0.05429f
C386 VSS.n61 0 0.04526f
C387 VSS.n62 0 0.06881f
.ends
