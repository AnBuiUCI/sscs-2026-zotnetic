* Extracted by KLayout with GF180MCU LVS runset on : 29/08/2026 10:32

.SUBCKT OPAM OUT VDD INN INP VSS
M$1 \$653 \$46 VDD VDD pfet_06v0 L=1U W=10U AS=4.4P AD=2.5P PS=20.88U PD=10.5U
M$2 \$11 \$40 \$653 VDD pfet_06v0 L=1U W=10U AS=2.5P AD=4.4P PS=10.5U PD=20.88U
M$3 \$91 \$19 VDD VDD pfet_06v0 L=1U W=5U AS=2.2P AD=1.65P PS=10.88U PD=5.66U
M$4 \$19 \$40 \$91 VDD pfet_06v0 L=1U W=5U AS=1.65P AD=1.65P PS=5.66U PD=5.66U
M$5 \$22 \$36 \$19 VDD pfet_06v0 L=1U W=5U AS=1.65P AD=2.2P PS=5.66U PD=10.88U
M$6 \$83 \$19 VDD VDD pfet_06v0 L=1U W=5U AS=2.2P AD=1.65P PS=10.88U PD=5.66U
M$7 \$30 \$40 \$83 VDD pfet_06v0 L=1U W=5U AS=1.65P AD=1.65P PS=5.66U PD=5.66U
M$8 \$25 \$36 \$30 VDD pfet_06v0 L=1U W=5U AS=1.65P AD=2.2P PS=5.66U PD=10.88U
M$9 \$640 \$46 VDD VDD pfet_06v0 L=1U W=10U AS=4.4P AD=2.5P PS=20.88U PD=10.5U
M$10 \$208 \$40 \$640 VDD pfet_06v0 L=1U W=10U AS=2.5P AD=4.4P PS=10.5U
+ PD=20.88U
M$11 \$645 \$46 VDD VDD pfet_06v0 L=1U W=10U AS=4.4P AD=2.5P PS=20.88U PD=10.5U
M$12 \$7 \$40 \$645 VDD pfet_06v0 L=1U W=10U AS=2.5P AD=4.4P PS=10.5U PD=20.88U
M$13 \$639 \$46 VDD VDD pfet_06v0 L=1U W=10U AS=4.4P AD=2.5P PS=20.88U PD=10.5U
M$14 \$208 \$40 \$639 VDD pfet_06v0 L=1U W=10U AS=2.5P AD=4.4P PS=10.5U
+ PD=20.88U
M$15 \$637 \$46 VDD VDD pfet_06v0 L=1U W=10U AS=4.4P AD=2.5P PS=20.88U PD=10.5U
M$16 \$634 \$40 \$637 VDD pfet_06v0 L=1U W=10U AS=2.5P AD=4.4P PS=10.5U
+ PD=20.88U
M$17 \$681 \$105 VDD VDD pfet_06v0 L=1U W=10U AS=4.4P AD=2.5P PS=20.88U PD=10.5U
M$18 \$105 \$40 \$681 VDD pfet_06v0 L=1U W=10U AS=2.5P AD=3.3P PS=10.5U
+ PD=10.66U
M$19 \$36 \$36 \$105 VDD pfet_06v0 L=1U W=10U AS=3.3P AD=4.4P PS=10.66U
+ PD=20.88U
M$20 \$654 \$46 VDD VDD pfet_06v0 L=1U W=10U AS=4.4P AD=2.5P PS=20.88U PD=10.5U
M$21 \$39 \$40 \$654 VDD pfet_06v0 L=1U W=10U AS=2.5P AD=4.4P PS=10.5U PD=20.88U
M$22 \$53 \$7 VSS VSS nfet_06v0 L=1U W=5U AS=2.2P AD=1.25P PS=10.88U PD=5.5U
M$23 \$7 \$11 \$53 VSS nfet_06v0 L=1U W=5U AS=1.25P AD=2.2P PS=5.5U PD=10.88U
M$24 \$57 \$40 VSS VSS nfet_06v0 L=1U W=1U AS=0.44P AD=0.25P PS=2.88U PD=1.5U
M$25 \$46 \$40 \$57 VSS nfet_06v0 L=1U W=1U AS=0.25P AD=0.44P PS=1.5U PD=2.88U
M$26 \$17 \$22 VSS VSS nfet_06v0 L=1U W=2.5U AS=1.1P AD=0.825P PS=5.88U PD=3.16U
M$27 \$22 \$11 \$17 VSS nfet_06v0 L=1U W=2.5U AS=0.825P AD=0.825P PS=3.16U
+ PD=3.16U
M$28 \$19 \$39 \$22 VSS nfet_06v0 L=1U W=2.5U AS=0.825P AD=1.1P PS=3.16U
+ PD=5.88U
M$29 \$45 \$40 VSS VSS nfet_06v0 L=1U W=1U AS=0.44P AD=0.25P PS=2.88U PD=1.5U
M$30 \$40 \$40 \$45 VSS nfet_06v0 L=1U W=1U AS=0.25P AD=0.44P PS=1.5U PD=2.88U
M$31 \$31 \$7 VSS VSS nfet_06v0 L=1U W=5U AS=2.2P AD=1.25P PS=10.88U PD=5.5U
M$32 \$36 \$11 \$31 VSS nfet_06v0 L=1U W=5U AS=1.25P AD=2.2P PS=5.5U PD=10.88U
M$33 \$9 \$7 VSS VSS nfet_06v0 L=1U W=5U AS=2.2P AD=1.25P PS=10.88U PD=5.5U
M$34 \$10 \$11 \$9 VSS nfet_06v0 L=1U W=5U AS=1.25P AD=2.2P PS=5.5U PD=10.88U
M$35 \$28 \$22 VSS VSS nfet_06v0 L=1U W=2.5U AS=1.1P AD=0.825P PS=5.88U PD=3.16U
M$36 \$25 \$11 \$28 VSS nfet_06v0 L=1U W=2.5U AS=0.825P AD=0.825P PS=3.16U
+ PD=3.16U
M$37 \$30 \$39 \$25 VSS nfet_06v0 L=1U W=2.5U AS=0.825P AD=1.1P PS=3.16U
+ PD=5.88U
M$38 \$15 \$7 VSS VSS nfet_06v0 L=1U W=5U AS=2.2P AD=1.25P PS=10.88U PD=5.5U
M$39 \$10 \$11 \$15 VSS nfet_06v0 L=1U W=5U AS=1.25P AD=2.2P PS=5.5U PD=10.88U
M$40 \$38 \$42 VSS VSS nfet_06v0 L=1U W=5U AS=2.2P AD=1.25P PS=10.88U PD=5.5U
M$41 \$42 \$11 \$38 VSS nfet_06v0 L=1U W=5U AS=1.25P AD=1.65P PS=5.5U PD=5.66U
M$42 \$39 \$39 \$42 VSS nfet_06v0 L=1U W=5U AS=1.65P AD=2.2P PS=5.66U PD=10.88U
C$43 \$83 OUT 4e-13 cap_mim_2f0fF A=200P P=60U
C$44 OUT \$28 4e-13 cap_mim_2f0fF A=200P P=60U
M$45 OUT \$25 VSS VSS nfet_06v0 L=1U W=1U AS=0.44P AD=0.44P PS=2.88U PD=2.88U
M$46 \$11 \$11 VSS VSS nfet_06v0 L=1U W=1U AS=0.44P AD=0.44P PS=2.88U PD=2.88U
M$47 \$91 INN \$10 VSS nfet_06v0 L=1U W=5U AS=2.2P AD=2.2P PS=10.88U PD=10.88U
M$48 \$83 INP \$10 VSS nfet_06v0 L=1U W=5U AS=2.2P AD=2.2P PS=10.88U PD=10.88U
M$49 \$17 INN \$208 VDD pfet_06v0 L=1U W=10U AS=4.4P AD=4.4P PS=20.88U PD=20.88U
M$50 \$28 INP \$208 VDD pfet_06v0 L=1U W=10U AS=4.4P AD=4.4P PS=20.88U PD=20.88U
M$51 \$40 \$40 VDD VDD pfet_06v0 L=1U W=2U AS=0.88P AD=0.88P PS=4.88U PD=4.88U
M$52 OUT \$30 VDD VDD pfet_06v0 L=20U W=0.7U AS=0.308P AD=0.308P PS=2.28U
+ PD=2.28U
.ENDS OPAM
