* Extracted by KLayout with GF180MCU LVS runset on : 29/08/2026 18:10

.SUBCKT OPAM OUT VDD INN INP VSS
M$1 \$653 \$47 VDD VDD pfet_06v0 L=1U W=10U AS=4.4P AD=2.5P PS=20.88U PD=10.5U
M$2 \$9 \$37 \$653 VDD pfet_06v0 L=1U W=10U AS=2.5P AD=4.4P PS=10.5U PD=20.88U
M$3 \$92 \$21 VDD VDD pfet_06v0 L=1U W=5U AS=2.2P AD=1.65P PS=10.88U PD=5.66U
M$4 \$21 \$37 \$92 VDD pfet_06v0 L=1U W=5U AS=1.65P AD=1.65P PS=5.66U PD=5.66U
M$5 \$22 \$33 \$21 VDD pfet_06v0 L=1U W=5U AS=1.65P AD=2.2P PS=5.66U PD=10.88U
M$6 \$83 \$21 VDD VDD pfet_06v0 L=1U W=5U AS=2.2P AD=1.65P PS=10.88U PD=5.66U
M$7 \$32 \$37 \$83 VDD pfet_06v0 L=1U W=5U AS=1.65P AD=1.65P PS=5.66U PD=5.66U
M$8 \$25 \$33 \$32 VDD pfet_06v0 L=1U W=5U AS=1.65P AD=2.2P PS=5.66U PD=10.88U
M$9 \$640 \$47 VDD VDD pfet_06v0 L=1U W=10U AS=4.4P AD=2.5P PS=20.88U PD=10.5U
M$10 \$208 \$37 \$640 VDD pfet_06v0 L=1U W=10U AS=2.5P AD=4.4P PS=10.5U
+ PD=20.88U
M$11 \$645 \$47 VDD VDD pfet_06v0 L=1U W=10U AS=4.4P AD=2.5P PS=20.88U PD=10.5U
M$12 \$8 \$37 \$645 VDD pfet_06v0 L=1U W=10U AS=2.5P AD=4.4P PS=10.5U PD=20.88U
M$13 \$639 \$47 VDD VDD pfet_06v0 L=1U W=10U AS=4.4P AD=2.5P PS=20.88U PD=10.5U
M$14 \$208 \$37 \$639 VDD pfet_06v0 L=1U W=10U AS=2.5P AD=4.4P PS=10.5U
+ PD=20.88U
M$15 \$637 \$47 VDD VDD pfet_06v0 L=1U W=10U AS=4.4P AD=2.5P PS=20.88U PD=10.5U
M$16 \$47 \$37 \$637 VDD pfet_06v0 L=1U W=10U AS=2.5P AD=4.4P PS=10.5U PD=20.88U
M$17 \$681 \$105 VDD VDD pfet_06v0 L=1U W=10U AS=4.4P AD=2.5P PS=20.88U PD=10.5U
M$18 \$105 \$37 \$681 VDD pfet_06v0 L=1U W=10U AS=2.5P AD=3.3P PS=10.5U
+ PD=10.66U
M$19 \$33 \$33 \$105 VDD pfet_06v0 L=1U W=10U AS=3.3P AD=4.4P PS=10.66U
+ PD=20.88U
M$20 \$654 \$47 VDD VDD pfet_06v0 L=1U W=10U AS=4.4P AD=2.5P PS=20.88U PD=10.5U
M$21 \$43 \$37 \$654 VDD pfet_06v0 L=1U W=10U AS=2.5P AD=4.4P PS=10.5U PD=20.88U
M$22 \$56 \$8 VSS VSS nfet_06v0 L=1U W=5U AS=2.2P AD=1.25P PS=10.88U PD=5.5U
M$23 \$8 \$9 \$56 VSS nfet_06v0 L=1U W=5U AS=1.25P AD=2.2P PS=5.5U PD=10.88U
M$24 \$50 \$37 VSS VSS nfet_06v0 L=1U W=1U AS=0.44P AD=0.25P PS=2.88U PD=1.5U
M$25 \$47 \$37 \$50 VSS nfet_06v0 L=1U W=1U AS=0.25P AD=0.44P PS=1.5U PD=2.88U
M$26 \$18 \$22 VSS VSS nfet_06v0 L=1U W=2.5U AS=1.1P AD=0.825P PS=5.88U PD=3.16U
M$27 \$22 \$9 \$18 VSS nfet_06v0 L=1U W=2.5U AS=0.825P AD=0.825P PS=3.16U
+ PD=3.16U
M$28 \$21 \$43 \$22 VSS nfet_06v0 L=1U W=2.5U AS=0.825P AD=1.1P PS=3.16U
+ PD=5.88U
M$29 \$44 \$37 VSS VSS nfet_06v0 L=1U W=1U AS=0.44P AD=0.25P PS=2.88U PD=1.5U
M$30 \$37 \$37 \$44 VSS nfet_06v0 L=1U W=1U AS=0.25P AD=0.44P PS=1.5U PD=2.88U
M$31 \$35 \$8 VSS VSS nfet_06v0 L=1U W=5U AS=2.2P AD=1.25P PS=10.88U PD=5.5U
M$32 \$33 \$9 \$35 VSS nfet_06v0 L=1U W=5U AS=1.25P AD=2.2P PS=5.5U PD=10.88U
M$33 \$10 \$8 VSS VSS nfet_06v0 L=1U W=5U AS=2.2P AD=1.25P PS=10.88U PD=5.5U
M$34 \$11 \$9 \$10 VSS nfet_06v0 L=1U W=5U AS=1.25P AD=2.2P PS=5.5U PD=10.88U
M$35 \$28 \$22 VSS VSS nfet_06v0 L=1U W=2.5U AS=1.1P AD=0.825P PS=5.88U PD=3.16U
M$36 \$25 \$9 \$28 VSS nfet_06v0 L=1U W=2.5U AS=0.825P AD=0.825P PS=3.16U
+ PD=3.16U
M$37 \$32 \$43 \$25 VSS nfet_06v0 L=1U W=2.5U AS=0.825P AD=1.1P PS=3.16U
+ PD=5.88U
M$38 \$15 \$8 VSS VSS nfet_06v0 L=1U W=5U AS=2.2P AD=1.25P PS=10.88U PD=5.5U
M$39 \$11 \$9 \$15 VSS nfet_06v0 L=1U W=5U AS=1.25P AD=2.2P PS=5.5U PD=10.88U
M$40 \$36 \$40 VSS VSS nfet_06v0 L=1U W=5U AS=2.2P AD=1.25P PS=10.88U PD=5.5U
M$41 \$40 \$9 \$36 VSS nfet_06v0 L=1U W=5U AS=1.25P AD=1.65P PS=5.5U PD=5.66U
M$42 \$43 \$43 \$40 VSS nfet_06v0 L=1U W=5U AS=1.65P AD=2.2P PS=5.66U PD=10.88U
C$43 \$83 OUT 4e-13 cap_mim_2f0fF A=200P P=60U
C$44 OUT \$28 4e-13 cap_mim_2f0fF A=200P P=60U
M$45 \$9 \$9 VSS VSS nfet_06v0 L=1U W=1U AS=0.44P AD=0.44P PS=2.88U PD=2.88U
M$46 OUT \$25 VSS VSS nfet_06v0 L=1U W=1U AS=0.44P AD=0.44P PS=2.88U PD=2.88U
M$47 \$92 INN \$11 VSS nfet_06v0 L=1U W=5U AS=2.2P AD=2.2P PS=10.88U PD=10.88U
M$48 \$83 INP \$11 VSS nfet_06v0 L=1U W=5U AS=2.2P AD=2.2P PS=10.88U PD=10.88U
M$49 \$18 INN \$208 VDD pfet_06v0 L=1U W=10U AS=4.4P AD=4.4P PS=20.88U PD=20.88U
M$50 \$28 INP \$208 VDD pfet_06v0 L=1U W=10U AS=4.4P AD=4.4P PS=20.88U PD=20.88U
M$51 \$37 \$37 VDD VDD pfet_06v0 L=1U W=2U AS=0.88P AD=0.88P PS=4.88U PD=4.88U
M$52 OUT \$32 VDD VDD pfet_06v0 L=20U W=0.7U AS=0.308P AD=0.308P PS=2.28U
+ PD=2.28U
.ENDS OPAM
