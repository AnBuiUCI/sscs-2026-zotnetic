* Extracted by KLayout with GF180MCU LVS runset on : 29/08/2026 22:04

.SUBCKT io_secondary_5p0 to_gate ASIG5V VDD VSS
D$1 to_gate VDD diode_pd2nw_06v0 A=100P P=40U
D$2 to_gate VDD diode_pd2nw_06v0 A=100P P=40U
D$3 to_gate VDD diode_pd2nw_06v0 A=100P P=40U
D$4 to_gate VDD diode_pd2nw_06v0 A=100P P=40U
D$5 VSS to_gate diode_nd2ps_06v0 A=100P P=40U
D$6 VSS to_gate diode_nd2ps_06v0 A=100P P=40U
D$7 VSS to_gate diode_nd2ps_06v0 A=100P P=40U
D$8 VSS to_gate diode_nd2ps_06v0 A=100P P=40U
R$9 to_gate ASIG5V VDD 87.5 ppolyf_u L=10U W=40U
.ENDS io_secondary_5p0
