* Nodos de bulk atados: 1 de pozo n -> VDD, 1 de sustrato -> VSS.
*   magic no extrae los taps de este layout y los dejaba flotando;
*   la conexion si existe (el LVS de KLayout da 'match uniquely').
*   Quien detecta un tap que falte de verdad es el LVS, no esto.
* NGSPICE file created from COMP.ext - technology: gf180mcuD

.subckt COMP VSS VDD OUT INP INN
X0 a_4714_3916# INP a_6158_3846# VDD pfet_06v0 ad=4.4p pd=20.88u as=2.6p ps=10.52u w=10u l=1u
X1 a_5718_446# a_8390_4846# VDD VDD pfet_06v0 ad=1.3p pd=5.52u as=2.2p ps=10.88u w=5u l=1u
X2 a_14_332# a_354_3800# a_254_3916# VDD pfet_06v0 ad=4.4p pd=20.88u as=2.5p ps=10.5u w=10u l=1u
X3 a_4714_3916# a_354_3800# a_4414_3916# VDD pfet_06v0 ad=3.3p pd=10.66u as=2.5p ps=10.5u w=10u l=1u
X4 a_5718_446# INP a_4354_376# VSS nfet_06v0 ad=1.3p pd=5.52u as=2.2p ps=10.88u w=5u l=1u
X5 a_9054_446# a_13870_4800# a_9506_4846# VDD pfet_06v0 ad=2.2p pd=10.88u as=2.2p ps=10.88u w=5u l=1u
X6 a_16114_376# a_15914_332# VSS VSS nfet_06v0 ad=1.25p pd=5.5u as=2.2p ps=10.88u w=5u l=1u
X7 OUT a_9054_446# VSS VSS nfet_06v0 ad=2.2p pd=10.88u as=1.3p ps=5.52u w=5u l=1u
X8 a_6830_446# a_8390_4846# VDD VDD pfet_06v0 ad=1.3p pd=5.52u as=2.2p ps=10.88u w=5u l=1u
X9 a_13870_4800# a_13870_4800# a_15506_3800# VDD pfet_06v0 ad=4.4p pd=20.88u as=3.3p ps=10.66u w=10u l=1u
X10 a_6158_3846# a_7942_446# VSS VSS nfet_06v0 ad=0.65p pd=3.02u as=1.1p ps=5.88u w=2.5u l=1u
X11 a_6158_3846# INP a_4714_3916# VDD pfet_06v0 ad=2.6p pd=10.52u as=4.4p ps=20.88u w=10u l=1u
X12 a_54_3800# a_354_3800# a_1978_376# VSS nfet_06v0 ad=0.44p pd=2.88u as=0.25p ps=1.5u w=1u l=1u
X13 a_4354_376# a_14_332# a_4054_376# VSS nfet_06v0 ad=1.65p pd=5.66u as=1.25p ps=5.5u w=5u l=1u
X14 a_7942_446# a_14_332# a_7274_3846# VSS nfet_06v0 ad=0.65p pd=3.02u as=1.1p ps=5.88u w=2.5u l=1u
X15 a_9506_4846# a_354_3800# a_5718_446# VDD pfet_06v0 ad=1.3p pd=5.52u as=2.2p ps=10.88u w=5u l=1u
X16 a_6830_446# a_8390_4846# VDD VDD pfet_06v0 ad=1.3p pd=5.52u as=1.3p ps=5.52u w=5u l=1u
X17 a_13406_332# a_354_3800# a_17150_3916# VDD pfet_06v0 ad=4.4p pd=20.88u as=2.5p ps=10.5u w=10u l=1u
X18 OUT a_9506_4846# VDD VDD pfet_06v0 ad=2.6p pd=10.52u as=4.4p ps=20.88u w=10u l=1u
X19 a_13870_4800# a_14_332# a_15070_376# VSS nfet_06v0 ad=2.2p pd=10.88u as=1.25p ps=5.5u w=5u l=1u
X20 a_54_3800# a_354_3800# a_3290_3916# VDD pfet_06v0 ad=4.4p pd=20.88u as=2.5p ps=10.5u w=10u l=1u
X21 a_7274_3846# a_7942_446# VSS VSS nfet_06v0 ad=0.65p pd=3.02u as=1.1p ps=5.88u w=2.5u l=1u
X22 VSS a_9054_446# OUT VSS nfet_06v0 ad=1.3p pd=5.52u as=1.3p ps=5.52u w=5u l=1u
X23 a_1366_3916# a_54_3800# VDD VDD pfet_06v0 ad=2.5p pd=10.5u as=4.4p ps=20.88u w=10u l=1u
X24 a_1978_376# a_354_3800# VSS VSS nfet_06v0 ad=0.25p pd=1.5u as=0.44p ps=2.88u w=1u l=1u
X25 a_6158_3846# a_14_332# a_9054_446# VSS nfet_06v0 ad=1.1p pd=5.88u as=0.65p ps=3.02u w=2.5u l=1u
X26 VSS a_7942_446# a_6158_3846# VSS nfet_06v0 ad=1.1p pd=5.88u as=0.65p ps=3.02u w=2.5u l=1u
X27 OUT a_5718_446# cap_mim_2f0_m4m5_noshield c_width=20u c_length=10u
X28 a_354_3800# a_354_3800# VDD VDD pfet_06v0 ad=0.88p pd=4.88u as=0.88p ps=4.88u w=2u l=1u
X29 a_4054_376# a_746_332# VSS VSS nfet_06v0 ad=1.25p pd=5.5u as=2.2p ps=10.88u w=5u l=1u
X30 VDD a_8390_4846# a_6830_446# VDD pfet_06v0 ad=1.3p pd=5.52u as=1.3p ps=5.52u w=5u l=1u
X31 VDD a_8390_4846# a_5718_446# VDD pfet_06v0 ad=2.2p pd=10.88u as=1.3p ps=5.52u w=5u l=1u
X32 a_15070_376# a_746_332# VSS VSS nfet_06v0 ad=1.25p pd=5.5u as=2.2p ps=10.88u w=5u l=1u
X33 a_4354_376# INN a_6830_446# VSS nfet_06v0 ad=2.2p pd=10.88u as=1.3p ps=5.52u w=5u l=1u
X34 VSS a_7942_446# a_7274_3846# VSS nfet_06v0 ad=1.1p pd=5.88u as=0.65p ps=3.02u w=2.5u l=1u
X35 VDD a_9506_4846# OUT VDD pfet_06v0 ad=2.6p pd=10.52u as=2.6p ps=10.52u w=10u l=1u
X36 a_254_3916# a_54_3800# VDD VDD pfet_06v0 ad=2.5p pd=10.5u as=4.4p ps=20.88u w=10u l=1u
X37 VDD a_8390_4846# a_6830_446# VDD pfet_06v0 ad=2.2p pd=10.88u as=1.3p ps=5.52u w=5u l=1u
X38 a_14_332# a_14_332# VSS VSS nfet_06v0 ad=0.44p pd=2.88u as=0.44p ps=2.88u w=1u l=1u
X39 a_6158_3846# a_7942_446# VSS VSS nfet_06v0 ad=0.65p pd=3.02u as=0.65p ps=3.02u w=2.5u l=1u
X40 a_7942_446# a_13870_4800# a_8390_4846# VDD pfet_06v0 ad=2.2p pd=10.88u as=2.2p ps=10.88u w=5u l=1u
X41 OUT a_9054_446# VSS VSS nfet_06v0 ad=1.3p pd=5.52u as=2.2p ps=10.88u w=5u l=1u
X42 VDD a_54_3800# a_5046_3916# VDD pfet_06v0 ad=4.4p pd=20.88u as=2.5p ps=10.5u w=10u l=1u
X43 a_746_332# a_354_3800# a_1366_3916# VDD pfet_06v0 ad=4.4p pd=20.88u as=2.5p ps=10.5u w=10u l=1u
X44 VDD a_8390_4846# a_5718_446# VDD pfet_06v0 ad=1.3p pd=5.52u as=1.3p ps=5.52u w=5u l=1u
X45 a_7274_3846# a_7942_446# VSS VSS nfet_06v0 ad=0.65p pd=3.02u as=0.65p ps=3.02u w=2.5u l=1u
X46 a_7274_3846# INN a_4714_3916# VDD pfet_06v0 ad=2.6p pd=10.52u as=4.4p ps=20.88u w=10u l=1u
X47 a_6830_446# INN a_4354_376# VSS nfet_06v0 ad=1.3p pd=5.52u as=2.2p ps=10.88u w=5u l=1u
X48 a_8390_4846# a_354_3800# a_6830_446# VDD pfet_06v0 ad=1.3p pd=5.52u as=2.2p ps=10.88u w=5u l=1u
X49 a_17150_3916# a_54_3800# VDD VDD pfet_06v0 ad=2.5p pd=10.5u as=4.4p ps=20.88u w=10u l=1u
X50 a_946_376# a_746_332# VSS VSS nfet_06v0 ad=1.25p pd=5.5u as=2.2p ps=10.88u w=5u l=1u
X51 a_13406_332# a_13406_332# a_15914_332# VSS nfet_06v0 ad=2.2p pd=10.88u as=1.65p ps=5.66u w=5u l=1u
X52 a_15706_3916# a_15506_3800# VDD VDD pfet_06v0 ad=2.5p pd=10.5u as=4.4p ps=20.88u w=10u l=1u
X53 a_8390_4846# a_13406_332# a_7942_446# VSS nfet_06v0 ad=1.1p pd=5.88u as=1.1p ps=5.88u w=2.5u l=1u
X54 a_6158_3846# OUT cap_mim_2f0_m4m5_noshield c_width=20u c_length=10u
X55 a_5718_446# a_354_3800# a_9506_4846# VDD pfet_06v0 ad=2.2p pd=10.88u as=1.3p ps=5.52u w=5u l=1u
X56 a_354_3800# a_354_3800# a_3010_376# VSS nfet_06v0 ad=0.44p pd=2.88u as=0.25p ps=1.5u w=1u l=1u
X57 a_7274_3846# a_14_332# a_7942_446# VSS nfet_06v0 ad=1.1p pd=5.88u as=0.65p ps=3.02u w=2.5u l=1u
X58 a_9054_446# a_14_332# a_6158_3846# VSS nfet_06v0 ad=0.65p pd=3.02u as=1.1p ps=5.88u w=2.5u l=1u
X59 VSS a_7942_446# a_7274_3846# VSS nfet_06v0 ad=0.65p pd=3.02u as=0.65p ps=3.02u w=2.5u l=1u
X60 a_4414_3916# a_54_3800# VDD VDD pfet_06v0 ad=2.5p pd=10.5u as=4.4p ps=20.88u w=10u l=1u
X61 a_5718_446# a_8390_4846# VDD VDD pfet_06v0 ad=1.3p pd=5.52u as=1.3p ps=5.52u w=5u l=1u
X62 a_746_332# a_14_332# a_946_376# VSS nfet_06v0 ad=2.2p pd=10.88u as=1.25p ps=5.5u w=5u l=1u
X63 a_4714_3916# INN a_7274_3846# VDD pfet_06v0 ad=4.4p pd=20.88u as=2.6p ps=10.52u w=10u l=1u
X64 a_4686_376# a_14_332# a_4354_376# VSS nfet_06v0 ad=1.25p pd=5.5u as=1.65p ps=5.66u w=5u l=1u
X65 a_4354_376# INP a_5718_446# VSS nfet_06v0 ad=2.2p pd=10.88u as=1.3p ps=5.52u w=5u l=1u
X66 a_6830_446# a_354_3800# a_8390_4846# VDD pfet_06v0 ad=2.2p pd=10.88u as=1.3p ps=5.52u w=5u l=1u
X67 a_3010_376# a_354_3800# VSS VSS nfet_06v0 ad=0.25p pd=1.5u as=0.44p ps=2.88u w=1u l=1u
X68 a_5046_3916# a_354_3800# a_4714_3916# VDD pfet_06v0 ad=2.5p pd=10.5u as=3.3p ps=10.66u w=10u l=1u
X69 a_15506_3800# a_354_3800# a_15706_3916# VDD pfet_06v0 ad=3.3p pd=10.66u as=2.5p ps=10.5u w=10u l=1u
X70 VSS a_7942_446# a_6158_3846# VSS nfet_06v0 ad=0.65p pd=3.02u as=0.65p ps=3.02u w=2.5u l=1u
X71 a_9506_4846# a_13406_332# a_9054_446# VSS nfet_06v0 ad=1.1p pd=5.88u as=1.1p ps=5.88u w=2.5u l=1u
X72 a_15914_332# a_14_332# a_16114_376# VSS nfet_06v0 ad=1.65p pd=5.66u as=1.25p ps=5.5u w=5u l=1u
X73 a_3290_3916# a_54_3800# VDD VDD pfet_06v0 ad=2.5p pd=10.5u as=4.4p ps=20.88u w=10u l=1u
X74 OUT a_9506_4846# VDD VDD pfet_06v0 ad=4.4p pd=20.88u as=2.6p ps=10.52u w=10u l=1u
X75 VSS a_746_332# a_4686_376# VSS nfet_06v0 ad=2.2p pd=10.88u as=1.25p ps=5.5u w=5u l=1u
C0 a_16114_376# a_15914_332# 0.03311f
C1 VSS a_15070_376# 0.04949f
C2 a_9506_4846# VDD 1.93576f
C3 a_354_3800# a_6830_446# 1.22222f
C4 a_54_3800# a_4354_376# 0.01445f
C5 VSS a_4354_376# 0.64174f
C6 VDD a_6830_446# 2.21585f
C7 a_13870_4800# a_15070_376# 0.02626f
C8 a_54_3800# a_6830_446# 0.04834f
C9 VSS a_6830_446# 0.04524f
C10 VDD a_5046_3916# 0.07856f
C11 a_5718_446# a_7942_446# 1.9125f
C12 VDD INN 0.62568f
C13 a_746_332# a_6158_3846# 2.51462f
C14 a_6158_3846# a_15914_332# 0.03437f
C15 a_9506_4846# a_8390_4846# 0.18771f
C16 VDD a_254_3916# 0.07875f
C17 a_7942_446# a_9054_446# 0.21293f
C18 a_9506_4846# a_15506_3800# 0.04496f
C19 VDD a_13406_332# 0.28907f
C20 a_4686_376# a_4354_376# 0.03377f
C21 a_7274_3846# INN 1.6193f
C22 a_746_332# a_4714_3916# 0.01194f
C23 a_7942_446# a_354_3800# 0.02967f
C24 a_8390_4846# a_13406_332# 0.84403f
C25 a_17150_3916# OUT 0.0112f
C26 VDD a_7942_446# 0.02617f
C27 a_15506_3800# a_13406_332# 0.12617f
C28 a_7942_446# a_54_3800# 0.10873f
C29 a_746_332# OUT 0.26784f
C30 a_15914_332# OUT 0.14634f
C31 VDD a_3290_3916# 0.07139f
C32 a_7942_446# VSS 2.42435f
C33 a_3290_3916# a_54_3800# 0.05253f
C34 a_14_332# a_6158_3846# 0.7877f
C35 a_746_332# INP 0.03664f
C36 a_7942_446# a_13870_4800# 0.91619f
C37 a_5718_446# a_354_3800# 1.45702f
C38 VDD a_6830_446# 1.17914f
C39 VDD a_5718_446# 2.11239f
C40 a_5718_446# a_54_3800# 3.18307f
C41 a_9054_446# a_354_3800# 0.02924f
C42 a_5718_446# VSS 0.04493f
C43 VDD a_9054_446# 0.21297f
C44 a_7274_3846# a_6830_446# 2.50204f
C45 a_9054_446# a_54_3800# 0.02141f
C46 a_5718_446# a_13870_4800# 0.01032f
C47 a_9054_446# VSS 1.61375f
C48 a_8390_4846# a_6830_446# 3.92117f
C49 a_9506_4846# a_746_332# 0.07715f
C50 a_13870_4800# a_9054_446# 0.90748f
C51 a_14_332# OUT 0.50668f
C52 VDD a_354_3800# 1.67656f
C53 a_14_332# INP 0.05779f
C54 a_54_3800# a_354_3800# 9.4793f
C55 VSS a_354_3800# 0.42608f
C56 a_746_332# INN 0.03269f
C57 VDD a_54_3800# 2.06599f
C58 a_946_376# a_746_332# 0.02626f
C59 VDD a_7942_446# 0.397f
C60 a_17150_3916# a_13406_332# 0.05253f
C61 VSS a_54_3800# 0.06656f
C62 a_4054_376# a_4354_376# 0.03336f
C63 a_13870_4800# a_354_3800# 0.16936f
C64 a_746_332# a_13406_332# 0.04723f
C65 a_15914_332# a_13406_332# 0.53511f
C66 VDD a_13870_4800# 0.39397f
C67 a_13870_4800# a_54_3800# 1.06513f
C68 a_7942_446# a_7274_3846# 1.74765f
C69 a_13870_4800# VSS 0.2213f
C70 a_15706_3916# OUT 0.01091f
C71 a_8390_4846# a_7942_446# 0.88069f
C72 VDD a_5718_446# 1.4818f
C73 a_9506_4846# a_14_332# 0.02925f
C74 VSS a_4686_376# 0.04817f
C75 VDD a_9054_446# 0.39591f
C76 a_5718_446# a_7274_3846# 0.04323f
C77 a_16114_376# OUT 0.01043f
C78 a_14_332# INN 0.05974f
C79 a_5718_446# a_8390_4846# 2.32948f
C80 a_746_332# a_4354_376# 1.05f
C81 a_9054_446# a_7274_3846# 0.03112f
C82 a_6158_3846# a_4714_3916# 3.20708f
C83 a_14_332# a_13406_332# 0.10485f
C84 a_746_332# a_6830_446# 0.02258f
C85 a_8390_4846# a_9054_446# 2.0122f
C86 VDD a_354_3800# 6.20925f
C87 a_15506_3800# a_9054_446# 0.15703f
C88 VDD VDD 9.00726f
C89 a_6158_3846# OUT 3.06355f
C90 VDD a_54_3800# 2.20874f
C91 a_7274_3846# a_354_3800# 0.03361f
C92 INP a_6158_3846# 1.52827f
C93 VDD a_7274_3846# 0.07133f
C94 a_8390_4846# a_354_3800# 1.06111f
C95 VDD a_13870_4800# 1.46812f
C96 a_54_3800# a_7274_3846# 0.02264f
C97 VDD a_8390_4846# 3.63767f
C98 VSS a_7274_3846# 1.36034f
C99 a_15506_3800# a_354_3800# 0.61675f
C100 a_8390_4846# a_54_3800# 0.09774f
C101 a_4714_3916# OUT 0.68719f
C102 VDD a_1366_3916# 0.07139f
C103 a_8390_4846# VSS 0.02524f
C104 VDD a_15506_3800# 0.48806f
C105 a_14_332# a_4354_376# 0.70495f
C106 a_15506_3800# a_54_3800# 0.0567f
C107 INP a_4714_3916# 2.41623f
C108 a_8390_4846# a_13870_4800# 0.80162f
C109 a_14_332# a_6830_446# 0.08683f
C110 a_7942_446# a_746_332# 0.10196f
C111 a_13870_4800# a_15506_3800# 1.373f
C112 a_9506_4846# a_6158_3846# 0.45217f
C113 INP OUT 0.20691f
C114 a_14_332# a_254_3916# 0.05253f
C115 a_5718_446# a_746_332# 0.07472f
C116 a_6158_3846# INN 0.43853f
C117 a_4054_376# VSS 0.04308f
C118 a_9054_446# a_746_332# 0.14241f
C119 a_9054_446# a_15914_332# 0.04493f
C120 a_6158_3846# a_13406_332# 0.46952f
C121 a_3010_376# VSS 0.01317f
C122 VDD a_7274_3846# 0.39308f
C123 a_9506_4846# OUT 2.11468f
C124 a_14_332# a_7942_446# 0.75459f
C125 a_4714_3916# INN 2.03297f
C126 VDD a_8390_4846# 4.20563f
C127 a_746_332# a_354_3800# 1.63813f
C128 VDD a_17150_3916# 0.07151f
C129 VDD a_15506_3800# 0.49115f
C130 VDD a_746_332# 0.22681f
C131 INN OUT 0.07564f
C132 a_746_332# a_54_3800# 0.25605f
C133 a_746_332# VSS 0.81565f
C134 VSS a_15914_332# 0.29741f
C135 a_5718_446# a_14_332# 0.09585f
C136 INP INN 0.0444f
C137 a_13406_332# OUT 0.16391f
C138 a_6158_3846# a_4354_376# 0.06025f
C139 a_13870_4800# a_746_332# 0.04348f
C140 a_13870_4800# a_15914_332# 0.05116f
C141 a_14_332# a_9054_446# 0.69849f
C142 a_4414_3916# a_4714_3916# 0.06563f
C143 a_6158_3846# a_6830_446# 0.11964f
C144 a_4714_3916# a_4354_376# 0.10701f
C145 a_4414_3916# OUT 0.0318f
C146 a_14_332# a_354_3800# 0.63947f
C147 a_4714_3916# a_6830_446# 0.01157f
C148 a_15070_376# OUT 0.01043f
C149 VDD a_14_332# 0.38035f
C150 a_14_332# a_54_3800# 0.19761f
C151 a_4714_3916# a_5046_3916# 0.06575f
C152 a_4354_376# OUT 0.09254f
C153 a_14_332# VSS 0.97809f
C154 a_9506_4846# a_13406_332# 2.50155f
C155 a_6830_446# OUT 0.04477f
C156 INP a_4354_376# 1.45405f
C157 a_14_332# a_13870_4800# 0.38177f
C158 a_5046_3916# OUT 0.0318f
C159 a_7942_446# a_6158_3846# 1.59903f
C160 VDD a_746_332# 0.34319f
C161 a_746_332# a_7274_3846# 0.04949f
C162 VDD a_15706_3916# 0.07139f
C163 a_8390_4846# a_746_332# 0.09845f
C164 a_5718_446# a_6158_3846# 0.20788f
C165 a_1366_3916# a_746_332# 0.05253f
C166 a_15506_3800# a_15914_332# 0.09168f
C167 a_9054_446# a_6158_3846# 1.24544f
C168 a_9506_4846# a_6830_446# 0.03319f
C169 a_7942_446# OUT 0.16479f
C170 a_3290_3916# OUT 0.0318f
C171 a_16114_376# VSS 0.04346f
C172 a_4354_376# INN 0.93697f
C173 a_5718_446# a_4714_3916# 0.31157f
C174 VDD a_14_332# 0.31241f
C175 a_6830_446# INN 1.13615f
C176 a_6158_3846# a_354_3800# 0.48892f
C177 a_14_332# a_7274_3846# 0.73384f
C178 a_5718_446# OUT 1.47396f
C179 VDD a_6158_3846# 0.19274f
C180 a_6158_3846# a_54_3800# 0.27412f
C181 a_8390_4846# a_14_332# 0.02982f
C182 VSS a_6158_3846# 1.23165f
C183 a_5718_446# INP 1.59355f
C184 a_9054_446# OUT 1.33775f
C185 a_14_332# a_15506_3800# 0.07597f
C186 a_13870_4800# a_6158_3846# 0.36656f
C187 a_4714_3916# a_354_3800# 1.11492f
C188 a_9506_4846# a_7942_446# 1.05586f
C189 VDD a_4714_3916# 0.76904f
C190 a_54_3800# a_4714_3916# 0.40959f
C191 a_354_3800# OUT 1.1395f
C192 VDD OUT 1.53578f
C193 a_4354_376# a_6830_446# 1.29732f
C194 a_54_3800# OUT 0.58072f
C195 INP a_354_3800# 0.03537f
C196 a_9506_4846# a_5718_446# 1.33703f
C197 VSS OUT 0.80572f
C198 a_7942_446# a_13406_332# 1.12085f
C199 VDD INP 0.19732f
C200 INP a_54_3800# 0.03241f
C201 a_15706_3916# a_15506_3800# 0.06563f
C202 a_9506_4846# a_9054_446# 3.27561f
C203 a_13870_4800# OUT 0.10585f
C204 INP VSS 0.12362f
C205 a_5718_446# INN 0.08792f
C206 VDD a_6158_3846# 0.81522f
C207 a_9506_4846# a_354_3800# 0.99019f
C208 a_9054_446# a_13406_332# 0.96468f
C209 VDD a_9506_4846# 2.51314f
C210 a_6158_3846# a_7274_3846# 1.46906f
C211 a_9506_4846# a_54_3800# 0.04631f
C212 a_14_332# a_746_332# 6.47023f
C213 a_14_332# a_15914_332# 0.61534f
C214 a_9506_4846# VSS 0.14423f
C215 a_8390_4846# a_6158_3846# 0.1901f
C216 VDD a_4714_3916# 1.16223f
C217 a_354_3800# INN 0.03761f
C218 a_7942_446# a_6830_446# 0.27542f
C219 a_15506_3800# a_6158_3846# 0.33788f
C220 a_9506_4846# a_13870_4800# 0.87086f
C221 VDD INN 0.20529f
C222 a_54_3800# INN 0.02393f
C223 a_7274_3846# a_4714_3916# 2.48536f
C224 a_13406_332# a_354_3800# 0.49054f
C225 VSS INN 0.1249f
C226 VDD OUT 1.39371f
C227 a_946_376# VSS 0.04308f
C228 VDD a_13406_332# 0.47484f
C229 a_5718_446# a_4354_376# 1.69219f
C230 a_54_3800# a_13406_332# 0.15217f
C231 VSS a_13406_332# 0.40408f
C232 VDD INP 0.62595f
C233 a_5718_446# a_6830_446# 0.14266f
C234 a_7274_3846# OUT 0.07654f
C235 a_13870_4800# a_13406_332# 0.45221f
C236 a_8390_4846# OUT 0.04647f
C237 a_9054_446# a_6830_446# 0.05089f
C238 a_1978_376# VSS 0.01198f
C239 a_15506_3800# OUT 0.08308f
C240 VDD a_4414_3916# 0.07139f
C241 VSS VSS 17.366f
C242 OUT VSS 9.31117f
C243 INN VSS 1.36418f
C244 VDD VSS 9.72822f
C245 INP VSS 1.32247f
C246 a_15914_332# VSS 0.74573f
C247 a_4354_376# VSS 1.44847f
C248 a_13406_332# VSS 2.65361f
C249 a_9054_446# VSS 3.3396f
C250 a_7942_446# VSS 5.71721f
C251 a_5718_446# VSS 2.89722f
C252 a_6830_446# VSS 1.50489f
C253 a_7274_3846# VSS 1.76718f
C254 a_6158_3846# VSS 3.78125f
C255 a_9506_4846# VSS 2.06318f
C256 a_15506_3800# VSS 0.92513f
C257 a_13870_4800# VSS 1.06248f
C258 a_8390_4846# VSS 2.13955f
C259 a_4714_3916# VSS 1.39745f
C260 a_746_332# VSS 3.42466f
C261 a_14_332# VSS 7.48193f
C262 a_354_3800# VSS 5.89864f
C263 a_54_3800# VSS 2.79881f
C264 VDD VSS 0.15981p
.ends
