* Nodos de bulk atados: 1 de pozo n -> VDD, 1 de sustrato -> VSS.
*   magic no extrae los taps de este layout y los dejaba flotando;
*   la conexion si existe (el LVS de KLayout da 'match uniquely').
*   Quien detecta un tap que falte de verdad es el LVS, no esto.
* NGSPICE file created from COMP.ext - technology: gf180mcuD

.subckt COMP VSS VDD OUT INP INN
X0 a_5730_446# a_8402_4846# VDD VDD pfet_06v0 ad=1.3p pd=5.52u as=1.3p ps=5.52u w=5u l=1u
X1 a_9518_4846# a_13418_332# a_9066_446# VSS nfet_06v0 ad=1.1p pd=5.88u as=1.1p ps=5.88u w=2.5u l=1u
X2 a_15536_3800# a_354_3800# a_15736_3916# VDD pfet_06v0 ad=3.3p pd=10.66u as=2.5p ps=10.5u w=10u l=1u
X3 VSS a_7954_446# a_6170_3846# VSS nfet_06v0 ad=0.65p pd=3.02u as=0.65p ps=3.02u w=2.5u l=1u
X4 a_14_332# a_354_3800# a_254_3916# VDD pfet_06v0 ad=4.4p pd=20.88u as=2.5p ps=10.5u w=10u l=1u
X5 VSS a_746_332# a_4698_376# VSS nfet_06v0 ad=2.2p pd=10.88u as=1.25p ps=5.5u w=5u l=1u
X6 a_5058_3916# a_354_3800# a_4726_3916# VDD pfet_06v0 ad=2.5p pd=10.5u as=3.3p ps=10.66u w=10u l=1u
X7 a_5730_446# INP a_4366_376# VSS nfet_06v0 ad=1.3p pd=5.52u as=2.2p ps=10.88u w=5u l=1u
X8 a_7954_446# a_13888_4800# a_8402_4846# VDD pfet_06v0 ad=2.2p pd=10.88u as=2.2p ps=10.88u w=5u l=1u
X9 a_54_3800# a_354_3800# a_1978_376# VSS nfet_06v0 ad=0.44p pd=2.88u as=0.25p ps=1.5u w=1u l=1u
X10 a_15938_332# a_14_332# a_16138_376# VSS nfet_06v0 ad=1.65p pd=5.66u as=1.25p ps=5.5u w=5u l=1u
X11 a_4726_3916# INP a_6170_3846# VDD pfet_06v0 ad=4.4p pd=20.88u as=2.6p ps=10.52u w=10u l=1u
X12 a_6170_3846# OUT cap_mim_2f0_m4m5_noshield c_width=20u c_length=10u
X13 a_13888_4800# a_13888_4800# a_15536_3800# VDD pfet_06v0 ad=4.4p pd=20.88u as=3.3p ps=10.66u w=10u l=1u
X14 OUT a_5730_446# cap_mim_2f0_m4m5_noshield c_width=20u c_length=10u
X15 a_54_3800# a_354_3800# a_3290_3916# VDD pfet_06v0 ad=4.4p pd=20.88u as=2.5p ps=10.5u w=10u l=1u
X16 a_4726_3916# a_354_3800# a_4426_3916# VDD pfet_06v0 ad=3.3p pd=10.66u as=2.5p ps=10.5u w=10u l=1u
X17 a_5730_446# a_8402_4846# VDD VDD pfet_06v0 ad=1.3p pd=5.52u as=2.2p ps=10.88u w=5u l=1u
X18 a_4366_376# a_14_332# a_4066_376# VSS nfet_06v0 ad=1.65p pd=5.66u as=1.25p ps=5.5u w=5u l=1u
X19 a_7954_446# a_14_332# a_7286_3846# VSS nfet_06v0 ad=0.65p pd=3.02u as=1.1p ps=5.88u w=2.5u l=1u
X20 a_6170_3846# a_7954_446# VSS VSS nfet_06v0 ad=0.65p pd=3.02u as=1.1p ps=5.88u w=2.5u l=1u
X21 a_1366_3916# a_54_3800# VDD VDD pfet_06v0 ad=2.5p pd=10.5u as=4.4p ps=20.88u w=10u l=1u
X22 a_4726_3916# INN a_7286_3846# VDD pfet_06v0 ad=4.4p pd=20.88u as=2.6p ps=10.52u w=10u l=1u
X23 a_1978_376# a_354_3800# VSS VSS nfet_06v0 ad=0.25p pd=1.5u as=0.44p ps=2.88u w=1u l=1u
X24 a_16138_376# a_15938_332# VSS VSS nfet_06v0 ad=1.25p pd=5.5u as=2.2p ps=10.88u w=5u l=1u
X25 a_354_3800# a_354_3800# VDD VDD pfet_06v0 ad=0.88p pd=4.88u as=0.88p ps=4.88u w=2u l=1u
X26 a_6842_446# a_8402_4846# VDD VDD pfet_06v0 ad=1.3p pd=5.52u as=2.2p ps=10.88u w=5u l=1u
X27 OUT a_9518_4846# VDD VDD pfet_06v0 ad=2.6p pd=10.52u as=4.4p ps=20.88u w=10u l=1u
X28 a_13418_332# a_354_3800# a_17180_3916# VDD pfet_06v0 ad=4.4p pd=20.88u as=2.5p ps=10.5u w=10u l=1u
X29 a_6170_3846# a_14_332# a_9066_446# VSS nfet_06v0 ad=1.1p pd=5.88u as=0.65p ps=3.02u w=2.5u l=1u
X30 a_13888_4800# a_14_332# a_15082_376# VSS nfet_06v0 ad=2.2p pd=10.88u as=1.25p ps=5.5u w=5u l=1u
X31 a_7286_3846# a_7954_446# VSS VSS nfet_06v0 ad=0.65p pd=3.02u as=1.1p ps=5.88u w=2.5u l=1u
X32 a_9518_4846# a_354_3800# a_5730_446# VDD pfet_06v0 ad=1.3p pd=5.52u as=2.2p ps=10.88u w=5u l=1u
X33 a_6842_446# a_8402_4846# VDD VDD pfet_06v0 ad=1.3p pd=5.52u as=1.3p ps=5.52u w=5u l=1u
X34 a_4066_376# a_746_332# VSS VSS nfet_06v0 ad=1.25p pd=5.5u as=2.2p ps=10.88u w=5u l=1u
X35 a_254_3916# a_54_3800# VDD VDD pfet_06v0 ad=2.5p pd=10.5u as=4.4p ps=20.88u w=10u l=1u
X36 a_14_332# a_14_332# VSS VSS nfet_06v0 ad=0.44p pd=2.88u as=0.44p ps=2.88u w=1u l=1u
X37 VSS a_7954_446# a_7286_3846# VSS nfet_06v0 ad=1.1p pd=5.88u as=0.65p ps=3.02u w=2.5u l=1u
X38 a_15082_376# a_746_332# VSS VSS nfet_06v0 ad=1.25p pd=5.5u as=2.2p ps=10.88u w=5u l=1u
X39 a_4366_376# INN a_6842_446# VSS nfet_06v0 ad=2.2p pd=10.88u as=1.3p ps=5.52u w=5u l=1u
X40 OUT a_9066_446# VSS VSS nfet_06v0 ad=2.2p pd=10.88u as=1.3p ps=5.52u w=5u l=1u
X41 a_746_332# a_354_3800# a_1366_3916# VDD pfet_06v0 ad=4.4p pd=20.88u as=2.5p ps=10.5u w=10u l=1u
X42 a_8402_4846# a_354_3800# a_6842_446# VDD pfet_06v0 ad=1.3p pd=5.52u as=2.2p ps=10.88u w=5u l=1u
X43 VDD a_8402_4846# a_6842_446# VDD pfet_06v0 ad=1.3p pd=5.52u as=1.3p ps=5.52u w=5u l=1u
X44 VDD a_9518_4846# OUT VDD pfet_06v0 ad=2.6p pd=10.52u as=2.6p ps=10.52u w=10u l=1u
X45 a_6170_3846# INP a_4726_3916# VDD pfet_06v0 ad=2.6p pd=10.52u as=4.4p ps=20.88u w=10u l=1u
X46 a_946_376# a_746_332# VSS VSS nfet_06v0 ad=1.25p pd=5.5u as=2.2p ps=10.88u w=5u l=1u
X47 VSS a_7954_446# a_6170_3846# VSS nfet_06v0 ad=1.1p pd=5.88u as=0.65p ps=3.02u w=2.5u l=1u
X48 VDD a_8402_4846# a_6842_446# VDD pfet_06v0 ad=2.2p pd=10.88u as=1.3p ps=5.52u w=5u l=1u
X49 a_6842_446# INN a_4366_376# VSS nfet_06v0 ad=1.3p pd=5.52u as=2.2p ps=10.88u w=5u l=1u
X50 a_7286_3846# a_7954_446# VSS VSS nfet_06v0 ad=0.65p pd=3.02u as=0.65p ps=3.02u w=2.5u l=1u
X51 VDD a_54_3800# a_5058_3916# VDD pfet_06v0 ad=4.4p pd=20.88u as=2.5p ps=10.5u w=10u l=1u
X52 a_17180_3916# a_54_3800# VDD VDD pfet_06v0 ad=2.5p pd=10.5u as=4.4p ps=20.88u w=10u l=1u
X53 a_354_3800# a_354_3800# a_3010_376# VSS nfet_06v0 ad=0.44p pd=2.88u as=0.25p ps=1.5u w=1u l=1u
X54 VSS a_9066_446# OUT VSS nfet_06v0 ad=1.3p pd=5.52u as=1.3p ps=5.52u w=5u l=1u
X55 VDD a_8402_4846# a_5730_446# VDD pfet_06v0 ad=1.3p pd=5.52u as=1.3p ps=5.52u w=5u l=1u
X56 a_9066_446# a_13888_4800# a_9518_4846# VDD pfet_06v0 ad=2.2p pd=10.88u as=2.2p ps=10.88u w=5u l=1u
X57 a_15736_3916# a_15536_3800# VDD VDD pfet_06v0 ad=2.5p pd=10.5u as=4.4p ps=20.88u w=10u l=1u
X58 a_7286_3846# INN a_4726_3916# VDD pfet_06v0 ad=2.6p pd=10.52u as=4.4p ps=20.88u w=10u l=1u
X59 a_8402_4846# a_13418_332# a_7954_446# VSS nfet_06v0 ad=1.1p pd=5.88u as=1.1p ps=5.88u w=2.5u l=1u
X60 a_13418_332# a_13418_332# a_15938_332# VSS nfet_06v0 ad=2.2p pd=10.88u as=1.65p ps=5.66u w=5u l=1u
X61 a_6842_446# a_354_3800# a_8402_4846# VDD pfet_06v0 ad=2.2p pd=10.88u as=1.3p ps=5.52u w=5u l=1u
X62 OUT a_9518_4846# VDD VDD pfet_06v0 ad=4.4p pd=20.88u as=2.6p ps=10.52u w=10u l=1u
X63 a_746_332# a_14_332# a_946_376# VSS nfet_06v0 ad=2.2p pd=10.88u as=1.25p ps=5.5u w=5u l=1u
X64 a_7286_3846# a_14_332# a_7954_446# VSS nfet_06v0 ad=1.1p pd=5.88u as=0.65p ps=3.02u w=2.5u l=1u
X65 a_9066_446# a_14_332# a_6170_3846# VSS nfet_06v0 ad=0.65p pd=3.02u as=1.1p ps=5.88u w=2.5u l=1u
X66 VDD a_8402_4846# a_5730_446# VDD pfet_06v0 ad=2.2p pd=10.88u as=1.3p ps=5.52u w=5u l=1u
X67 a_6170_3846# a_7954_446# VSS VSS nfet_06v0 ad=0.65p pd=3.02u as=0.65p ps=3.02u w=2.5u l=1u
X68 a_3010_376# a_354_3800# VSS VSS nfet_06v0 ad=0.25p pd=1.5u as=0.44p ps=2.88u w=1u l=1u
X69 VSS a_7954_446# a_7286_3846# VSS nfet_06v0 ad=0.65p pd=3.02u as=0.65p ps=3.02u w=2.5u l=1u
X70 a_5730_446# a_354_3800# a_9518_4846# VDD pfet_06v0 ad=2.2p pd=10.88u as=1.3p ps=5.52u w=5u l=1u
X71 OUT a_9066_446# VSS VSS nfet_06v0 ad=1.3p pd=5.52u as=2.2p ps=10.88u w=5u l=1u
X72 a_4698_376# a_14_332# a_4366_376# VSS nfet_06v0 ad=1.25p pd=5.5u as=1.65p ps=5.66u w=5u l=1u
X73 a_4366_376# INP a_5730_446# VSS nfet_06v0 ad=2.2p pd=10.88u as=1.3p ps=5.52u w=5u l=1u
X74 a_3290_3916# a_54_3800# VDD VDD pfet_06v0 ad=2.5p pd=10.5u as=4.4p ps=20.88u w=10u l=1u
X75 a_4426_3916# a_54_3800# VDD VDD pfet_06v0 ad=2.5p pd=10.5u as=4.4p ps=20.88u w=10u l=1u
C0 a_7954_446# OUT 0.16421f
C1 a_3290_3916# OUT 0.0318f
C2 a_16138_376# VSS 0.04346f
C3 a_4366_376# INN 0.93767f
C4 a_5730_446# a_4726_3916# 0.3116f
C5 VDD a_14_332# 0.31241f
C6 a_6842_446# INN 1.13868f
C7 a_6170_3846# a_354_3800# 0.48929f
C8 a_14_332# a_7286_3846# 0.73384f
C9 a_5730_446# OUT 1.47382f
C10 VDD a_6170_3846# 0.19363f
C11 a_6170_3846# a_54_3800# 0.27431f
C12 a_8402_4846# a_14_332# 0.02983f
C13 VSS a_6170_3846# 1.23196f
C14 a_5730_446# INP 1.59731f
C15 a_9066_446# OUT 1.33434f
C16 a_14_332# a_15536_3800# 0.0748f
C17 a_13888_4800# a_6170_3846# 0.36754f
C18 a_4726_3916# a_354_3800# 1.11468f
C19 a_9518_4846# a_7954_446# 1.05586f
C20 VDD a_4726_3916# 0.76802f
C21 a_54_3800# a_4726_3916# 0.40897f
C22 a_354_3800# OUT 1.1374f
C23 VDD OUT 1.53779f
C24 a_4366_376# a_6842_446# 1.29732f
C25 a_54_3800# OUT 0.57863f
C26 INP a_354_3800# 0.0356f
C27 a_9518_4846# a_5730_446# 1.33702f
C28 VSS OUT 0.8079f
C29 a_7954_446# a_13418_332# 1.12308f
C30 VDD INP 0.19726f
C31 INP a_54_3800# 0.0327f
C32 a_15736_3916# a_15536_3800# 0.06557f
C33 a_9518_4846# a_9066_446# 3.27992f
C34 a_13888_4800# OUT 0.10549f
C35 INP VSS 0.12324f
C36 a_5730_446# INN 0.08778f
C37 VDD a_6170_3846# 0.81573f
C38 a_9518_4846# a_354_3800# 0.99019f
C39 a_9066_446# a_13418_332# 0.96574f
C40 VDD a_9518_4846# 2.51485f
C41 a_6170_3846# a_7286_3846# 1.46906f
C42 a_9518_4846# a_54_3800# 0.04631f
C43 a_14_332# a_746_332# 6.47472f
C44 a_14_332# a_15938_332# 0.61078f
C45 a_9518_4846# VSS 0.14366f
C46 a_8402_4846# a_6170_3846# 0.18993f
C47 VDD a_4726_3916# 1.16288f
C48 a_7954_446# a_6842_446# 0.27542f
C49 a_354_3800# INN 0.03782f
C50 a_15536_3800# a_6170_3846# 0.33897f
C51 a_9518_4846# a_13888_4800# 0.87121f
C52 VDD INN 0.20399f
C53 a_54_3800# INN 0.02419f
C54 a_7286_3846# a_4726_3916# 2.48536f
C55 a_13418_332# a_354_3800# 0.49054f
C56 VSS INN 0.12498f
C57 VDD OUT 1.39494f
C58 a_946_376# VSS 0.04308f
C59 VDD a_13418_332# 0.4749f
C60 a_5730_446# a_4366_376# 1.69219f
C61 a_54_3800# a_13418_332# 0.15217f
C62 VSS a_13418_332# 0.40498f
C63 VDD INP 0.62711f
C64 a_5730_446# a_6842_446# 0.14266f
C65 a_7286_3846# OUT 0.07654f
C66 a_13888_4800# a_13418_332# 0.4547f
C67 a_8402_4846# OUT 0.04622f
C68 a_9066_446# a_6842_446# 0.05089f
C69 a_1978_376# VSS 0.01198f
C70 a_15536_3800# OUT 0.08311f
C71 VDD a_4426_3916# 0.07139f
C72 a_16138_376# a_15938_332# 0.03308f
C73 VSS a_15082_376# 0.0485f
C74 a_9518_4846# VDD 1.93576f
C75 a_354_3800# a_6842_446# 1.22222f
C76 a_54_3800# a_4366_376# 0.01445f
C77 VSS a_4366_376# 0.64182f
C78 VDD a_6842_446# 2.21585f
C79 a_13888_4800# a_15082_376# 0.02626f
C80 a_54_3800# a_6842_446# 0.04834f
C81 VSS a_6842_446# 0.04524f
C82 VDD a_5058_3916# 0.07875f
C83 a_5730_446# a_7954_446# 1.9125f
C84 VDD INN 0.62683f
C85 a_746_332# a_6170_3846# 2.51388f
C86 a_6170_3846# a_15938_332# 0.0342f
C87 a_9518_4846# a_8402_4846# 0.18781f
C88 VDD a_254_3916# 0.07875f
C89 a_7954_446# a_9066_446# 0.21292f
C90 a_9518_4846# a_15536_3800# 0.04532f
C91 VDD a_13418_332# 0.28907f
C92 a_4698_376# a_4366_376# 0.03381f
C93 a_7286_3846# INN 1.61855f
C94 a_746_332# a_4726_3916# 0.01209f
C95 a_7954_446# a_354_3800# 0.02967f
C96 a_8402_4846# a_13418_332# 0.84288f
C97 VDD a_7954_446# 0.02616f
C98 a_17180_3916# OUT 0.0112f
C99 a_15536_3800# a_13418_332# 0.12778f
C100 a_7954_446# a_54_3800# 0.10982f
C101 a_746_332# OUT 0.26648f
C102 a_15938_332# OUT 0.14664f
C103 VDD a_3290_3916# 0.07139f
C104 a_7954_446# VSS 2.42373f
C105 a_3290_3916# a_54_3800# 0.05253f
C106 a_14_332# a_6170_3846# 0.78872f
C107 a_746_332# INP 0.04106f
C108 a_7954_446# a_13888_4800# 0.91619f
C109 a_5730_446# a_354_3800# 1.45724f
C110 VDD a_6842_446# 1.17914f
C111 VDD a_5730_446# 2.11076f
C112 a_5730_446# a_54_3800# 3.18335f
C113 a_9066_446# a_354_3800# 0.02926f
C114 a_5730_446# VSS 0.04493f
C115 VDD a_9066_446# 0.20795f
C116 a_7286_3846# a_6842_446# 2.50204f
C117 a_9066_446# a_54_3800# 0.02143f
C118 a_5730_446# a_13888_4800# 0.01019f
C119 a_9066_446# VSS 1.61122f
C120 a_8402_4846# a_6842_446# 3.92117f
C121 a_9518_4846# a_746_332# 0.07714f
C122 a_14_332# OUT 0.50686f
C123 a_13888_4800# a_9066_446# 0.9086f
C124 VDD a_354_3800# 1.68023f
C125 a_14_332# INP 0.06003f
C126 a_54_3800# a_354_3800# 9.49042f
C127 VSS a_354_3800# 0.42225f
C128 a_746_332# INN 0.0368f
C129 VDD a_54_3800# 2.06078f
C130 a_946_376# a_746_332# 0.02626f
C131 VDD a_7954_446# 0.397f
C132 a_17180_3916# a_13418_332# 0.05253f
C133 VSS a_54_3800# 0.06656f
C134 a_13888_4800# a_354_3800# 0.16929f
C135 a_4066_376# a_4366_376# 0.03333f
C136 a_746_332# a_13418_332# 0.04723f
C137 a_15938_332# a_13418_332# 0.54135f
C138 VDD a_13888_4800# 0.38956f
C139 a_13888_4800# a_54_3800# 1.06952f
C140 a_7954_446# a_7286_3846# 1.74765f
C141 a_13888_4800# VSS 0.21779f
C142 a_15736_3916# OUT 0.01091f
C143 a_8402_4846# a_7954_446# 0.88054f
C144 VDD a_5730_446# 1.48608f
C145 a_9518_4846# a_14_332# 0.02925f
C146 VSS a_4698_376# 0.04719f
C147 VDD a_9066_446# 0.39941f
C148 a_5730_446# a_7286_3846# 0.04323f
C149 a_16138_376# OUT 0.01043f
C150 a_14_332# INN 0.06183f
C151 a_5730_446# a_8402_4846# 2.32292f
C152 a_746_332# a_4366_376# 1.0489f
C153 a_9066_446# a_7286_3846# 0.03112f
C154 a_6170_3846# a_4726_3916# 3.20709f
C155 a_14_332# a_13418_332# 0.10485f
C156 a_746_332# a_6842_446# 0.02258f
C157 a_8402_4846# a_9066_446# 2.01578f
C158 VDD a_354_3800# 6.21286f
C159 a_15536_3800# a_9066_446# 0.15643f
C160 VDD VDD 9.02313f
C161 a_6170_3846# OUT 3.06765f
C162 VDD a_54_3800# 2.21277f
C163 a_7286_3846# a_354_3800# 0.03361f
C164 INP a_6170_3846# 1.52801f
C165 VDD a_7286_3846# 0.07133f
C166 a_8402_4846# a_354_3800# 1.06116f
C167 VDD a_13888_4800# 1.4685f
C168 a_54_3800# a_7286_3846# 0.02264f
C169 VDD a_8402_4846# 3.63928f
C170 VSS a_7286_3846# 1.36051f
C171 a_15536_3800# a_354_3800# 0.61271f
C172 a_8402_4846# a_54_3800# 0.09779f
C173 a_4726_3916# OUT 0.6872f
C174 VDD a_1366_3916# 0.07139f
C175 a_8402_4846# VSS 0.02524f
C176 VDD a_15536_3800# 0.48488f
C177 a_15536_3800# a_54_3800# 0.05675f
C178 a_14_332# a_4366_376# 0.70518f
C179 INP a_4726_3916# 2.42142f
C180 a_8402_4846# a_13888_4800# 0.8016f
C181 a_14_332# a_6842_446# 0.08683f
C182 a_7954_446# a_746_332# 0.10196f
C183 a_13888_4800# a_15536_3800# 1.32222f
C184 a_9518_4846# a_6170_3846# 0.45111f
C185 INP OUT 0.20861f
C186 a_14_332# a_254_3916# 0.05253f
C187 a_5730_446# a_746_332# 0.07438f
C188 a_6170_3846# INN 0.44687f
C189 a_4066_376# VSS 0.04308f
C190 a_9066_446# a_746_332# 0.14216f
C191 a_9066_446# a_15938_332# 0.04452f
C192 a_6170_3846# a_13418_332# 0.4686f
C193 a_3010_376# VSS 0.01317f
C194 VDD a_7286_3846# 0.39308f
C195 a_9518_4846# OUT 2.11631f
C196 a_14_332# a_7954_446# 0.75459f
C197 a_4726_3916# INN 2.04034f
C198 VDD a_8402_4846# 4.20842f
C199 a_746_332# a_354_3800# 1.63698f
C200 VDD a_15536_3800# 0.49172f
C201 VDD a_17180_3916# 0.07151f
C202 VDD a_746_332# 0.22681f
C203 INN OUT 0.07645f
C204 a_746_332# a_54_3800# 0.25658f
C205 a_746_332# VSS 0.81675f
C206 VSS a_15938_332# 0.29504f
C207 a_5730_446# a_14_332# 0.0951f
C208 INP INN 0.03931f
C209 a_13418_332# OUT 0.16466f
C210 a_6170_3846# a_4366_376# 0.06025f
C211 a_13888_4800# a_746_332# 0.04348f
C212 a_13888_4800# a_15938_332# 0.04995f
C213 a_14_332# a_9066_446# 0.69967f
C214 a_4426_3916# a_4726_3916# 0.06557f
C215 a_6170_3846# a_6842_446# 0.11964f
C216 a_4726_3916# a_4366_376# 0.10647f
C217 a_4426_3916# OUT 0.0318f
C218 a_14_332# a_354_3800# 0.6395f
C219 a_4726_3916# a_6842_446# 0.01157f
C220 a_15082_376# OUT 0.01043f
C221 VDD a_14_332# 0.38035f
C222 a_14_332# a_54_3800# 0.19761f
C223 a_4726_3916# a_5058_3916# 0.06582f
C224 a_4366_376# OUT 0.09253f
C225 a_14_332# VSS 0.97942f
C226 a_9518_4846# a_13418_332# 2.50621f
C227 a_6842_446# OUT 0.04477f
C228 INP a_4366_376# 1.46531f
C229 a_14_332# a_13888_4800# 0.3818f
C230 a_5058_3916# OUT 0.0318f
C231 a_7954_446# a_6170_3846# 1.59858f
C232 VDD a_746_332# 0.34318f
C233 a_746_332# a_7286_3846# 0.04949f
C234 VDD a_15736_3916# 0.07139f
C235 a_8402_4846# a_746_332# 0.09901f
C236 a_5730_446# a_6170_3846# 0.20779f
C237 a_1366_3916# a_746_332# 0.05253f
C238 a_15536_3800# a_15938_332# 0.08842f
C239 a_9066_446# a_6170_3846# 1.2468f
C240 a_9518_4846# a_6842_446# 0.03319f
C241 VSS VSS 17.3938f
C242 OUT VSS 9.45883f
C243 INN VSS 1.39287f
C244 VDD VSS 9.74041f
C245 INP VSS 1.35426f
C246 a_15938_332# VSS 0.7478f
C247 a_4366_376# VSS 1.44838f
C248 a_13418_332# VSS 2.65511f
C249 a_9066_446# VSS 3.33976f
C250 a_7954_446# VSS 5.71858f
C251 a_5730_446# VSS 2.89783f
C252 a_6842_446# VSS 1.50489f
C253 a_7286_3846# VSS 1.76698f
C254 a_6170_3846# VSS 3.78128f
C255 a_9518_4846# VSS 2.06812f
C256 a_15536_3800# VSS 0.93296f
C257 a_13888_4800# VSS 1.07232f
C258 a_8402_4846# VSS 2.14317f
C259 a_4726_3916# VSS 1.39729f
C260 a_746_332# VSS 3.42723f
C261 a_14_332# VSS 7.48857f
C262 a_354_3800# VSS 5.90473f
C263 a_54_3800# VSS 2.8022f
C264 VDD VSS 0.16006p
.ends
