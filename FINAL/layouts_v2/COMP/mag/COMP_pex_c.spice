* Nodos de bulk atados: 1 de pozo n -> VDD, 1 de sustrato -> VSS.
*   magic no extrae los taps de este layout y los dejaba flotando;
*   la conexion si existe (el LVS de KLayout da 'match uniquely').
*   Quien detecta un tap que falte de verdad es el LVS, no esto.
* NGSPICE file created from COMP.ext - technology: gf180mcuD

.subckt COMP VSS VDD OUT INP INN
X0 a_4714_3916# INP a_6158_3846# VDD pfet_06v0 ad=4.4p pd=20.88u as=2.6p ps=10.52u w=10u l=1u
X1 a_5718_446# a_8390_4846# VDD VDD pfet_06v0 ad=1.3p pd=5.52u as=2.2p ps=10.88u w=5u l=1u
X2 a_14_332# a_354_3800# a_254_3916# VDD pfet_06v0 ad=4.4p pd=20.88u as=2.5p ps=10.5u w=10u l=1u
X3 a_4714_3916# a_354_3800# a_4414_3916# VDD pfet_06v0 ad=3.3p pd=10.66u as=2.5p ps=10.5u w=10u l=1u
X4 a_5718_446# INP a_4354_376# VSS nfet_06v0 ad=1.3p pd=5.52u as=2.2p ps=10.88u w=5u l=1u
X5 a_17156_3916# a_54_3800# VDD VDD pfet_06v0 ad=2.5p pd=10.5u as=4.4p ps=20.88u w=10u l=1u
X6 a_16114_376# a_15914_332# VSS VSS nfet_06v0 ad=1.25p pd=5.5u as=2.2p ps=10.88u w=5u l=1u
X7 OUT a_9054_446# VSS VSS nfet_06v0 ad=2.2p pd=10.88u as=1.3p ps=5.52u w=5u l=1u
X8 a_6830_446# a_8390_4846# VDD VDD pfet_06v0 ad=1.3p pd=5.52u as=2.2p ps=10.88u w=5u l=1u
X9 a_6158_3846# a_7942_446# VSS VSS nfet_06v0 ad=0.65p pd=3.02u as=1.1p ps=5.88u w=2.5u l=1u
X10 a_6158_3846# INP a_4714_3916# VDD pfet_06v0 ad=2.6p pd=10.52u as=4.4p ps=20.88u w=10u l=1u
X11 a_54_3800# a_354_3800# a_1978_376# VSS nfet_06v0 ad=0.44p pd=2.88u as=0.25p ps=1.5u w=1u l=1u
X12 a_4354_376# a_14_332# a_4054_376# VSS nfet_06v0 ad=1.65p pd=5.66u as=1.25p ps=5.5u w=5u l=1u
X13 a_7942_446# a_14_332# a_7274_3846# VSS nfet_06v0 ad=0.65p pd=3.02u as=1.1p ps=5.88u w=2.5u l=1u
X14 VDD a_9506_4846# OUT VDD pfet_06v0 ad=2.6p pd=10.52u as=2.6p ps=10.52u w=10u l=1u
X15 a_9506_4846# a_354_3800# a_5718_446# VDD pfet_06v0 ad=1.3p pd=5.52u as=2.2p ps=10.88u w=5u l=1u
X16 a_6830_446# a_8390_4846# VDD VDD pfet_06v0 ad=1.3p pd=5.52u as=1.3p ps=5.52u w=5u l=1u
X17 a_13876_4800# a_14_332# a_15070_376# VSS nfet_06v0 ad=2.2p pd=10.88u as=1.25p ps=5.5u w=5u l=1u
X18 a_54_3800# a_354_3800# a_3290_3916# VDD pfet_06v0 ad=4.4p pd=20.88u as=2.5p ps=10.5u w=10u l=1u
X19 a_7274_3846# a_7942_446# VSS VSS nfet_06v0 ad=0.65p pd=3.02u as=1.1p ps=5.88u w=2.5u l=1u
X20 VSS a_9054_446# OUT VSS nfet_06v0 ad=1.3p pd=5.52u as=1.3p ps=5.52u w=5u l=1u
X21 a_1366_3916# a_54_3800# VDD VDD pfet_06v0 ad=2.5p pd=10.5u as=4.4p ps=20.88u w=10u l=1u
X22 a_1978_376# a_354_3800# VSS VSS nfet_06v0 ad=0.25p pd=1.5u as=0.44p ps=2.88u w=1u l=1u
X23 a_6158_3846# a_14_332# a_9054_446# VSS nfet_06v0 ad=1.1p pd=5.88u as=0.65p ps=3.02u w=2.5u l=1u
X24 VSS a_7942_446# a_6158_3846# VSS nfet_06v0 ad=1.1p pd=5.88u as=0.65p ps=3.02u w=2.5u l=1u
X25 OUT a_5718_446# cap_mim_2f0_m4m5_noshield c_width=20u c_length=10u
X26 a_354_3800# a_354_3800# VDD VDD pfet_06v0 ad=0.88p pd=4.88u as=0.88p ps=4.88u w=2u l=1u
X27 a_4054_376# a_746_332# VSS VSS nfet_06v0 ad=1.25p pd=5.5u as=2.2p ps=10.88u w=5u l=1u
X28 VDD a_8390_4846# a_6830_446# VDD pfet_06v0 ad=1.3p pd=5.52u as=1.3p ps=5.52u w=5u l=1u
X29 VDD a_8390_4846# a_5718_446# VDD pfet_06v0 ad=2.2p pd=10.88u as=1.3p ps=5.52u w=5u l=1u
X30 a_15712_3916# a_15512_3800# VDD VDD pfet_06v0 ad=2.5p pd=10.5u as=4.4p ps=20.88u w=10u l=1u
X31 a_15070_376# a_746_332# VSS VSS nfet_06v0 ad=1.25p pd=5.5u as=2.2p ps=10.88u w=5u l=1u
X32 a_4354_376# INN a_6830_446# VSS nfet_06v0 ad=2.2p pd=10.88u as=1.3p ps=5.52u w=5u l=1u
X33 VSS a_7942_446# a_7274_3846# VSS nfet_06v0 ad=1.1p pd=5.88u as=0.65p ps=3.02u w=2.5u l=1u
X34 OUT a_9506_4846# VDD VDD pfet_06v0 ad=4.4p pd=20.88u as=2.6p ps=10.52u w=10u l=1u
X35 a_254_3916# a_54_3800# VDD VDD pfet_06v0 ad=2.5p pd=10.5u as=4.4p ps=20.88u w=10u l=1u
X36 VDD a_8390_4846# a_6830_446# VDD pfet_06v0 ad=2.2p pd=10.88u as=1.3p ps=5.52u w=5u l=1u
X37 a_14_332# a_14_332# VSS VSS nfet_06v0 ad=0.44p pd=2.88u as=0.44p ps=2.88u w=1u l=1u
X38 a_6158_3846# a_7942_446# VSS VSS nfet_06v0 ad=0.65p pd=3.02u as=0.65p ps=3.02u w=2.5u l=1u
X39 OUT a_9054_446# VSS VSS nfet_06v0 ad=1.3p pd=5.52u as=2.2p ps=10.88u w=5u l=1u
X40 VDD a_54_3800# a_5046_3916# VDD pfet_06v0 ad=4.4p pd=20.88u as=2.5p ps=10.5u w=10u l=1u
X41 a_746_332# a_354_3800# a_1366_3916# VDD pfet_06v0 ad=4.4p pd=20.88u as=2.5p ps=10.5u w=10u l=1u
X42 VDD a_8390_4846# a_5718_446# VDD pfet_06v0 ad=1.3p pd=5.52u as=1.3p ps=5.52u w=5u l=1u
X43 a_9054_446# a_13876_4800# a_9506_4846# VDD pfet_06v0 ad=2.2p pd=10.88u as=2.2p ps=10.88u w=5u l=1u
X44 a_7274_3846# a_7942_446# VSS VSS nfet_06v0 ad=0.65p pd=3.02u as=0.65p ps=3.02u w=2.5u l=1u
X45 a_7274_3846# INN a_4714_3916# VDD pfet_06v0 ad=2.6p pd=10.52u as=4.4p ps=20.88u w=10u l=1u
X46 a_6830_446# INN a_4354_376# VSS nfet_06v0 ad=1.3p pd=5.52u as=2.2p ps=10.88u w=5u l=1u
X47 a_8390_4846# a_354_3800# a_6830_446# VDD pfet_06v0 ad=1.3p pd=5.52u as=2.2p ps=10.88u w=5u l=1u
X48 a_15512_3800# a_354_3800# a_15712_3916# VDD pfet_06v0 ad=3.3p pd=10.66u as=2.5p ps=10.5u w=10u l=1u
X49 a_946_376# a_746_332# VSS VSS nfet_06v0 ad=1.25p pd=5.5u as=2.2p ps=10.88u w=5u l=1u
X50 a_13406_332# a_13406_332# a_15914_332# VSS nfet_06v0 ad=2.2p pd=10.88u as=1.65p ps=5.66u w=5u l=1u
X51 OUT a_9506_4846# VDD VDD pfet_06v0 ad=2.6p pd=10.52u as=4.4p ps=20.88u w=10u l=1u
X52 a_13406_332# a_354_3800# a_17156_3916# VDD pfet_06v0 ad=4.4p pd=20.88u as=2.5p ps=10.5u w=10u l=1u
X53 a_8390_4846# a_13406_332# a_7942_446# VSS nfet_06v0 ad=1.1p pd=5.88u as=1.1p ps=5.88u w=2.5u l=1u
X54 a_5718_446# a_354_3800# a_9506_4846# VDD pfet_06v0 ad=2.2p pd=10.88u as=1.3p ps=5.52u w=5u l=1u
X55 a_354_3800# a_354_3800# a_3010_376# VSS nfet_06v0 ad=0.44p pd=2.88u as=0.25p ps=1.5u w=1u l=1u
X56 a_7274_3846# a_14_332# a_7942_446# VSS nfet_06v0 ad=1.1p pd=5.88u as=0.65p ps=3.02u w=2.5u l=1u
X57 a_9054_446# a_14_332# a_6158_3846# VSS nfet_06v0 ad=0.65p pd=3.02u as=1.1p ps=5.88u w=2.5u l=1u
X58 VSS a_7942_446# a_7274_3846# VSS nfet_06v0 ad=0.65p pd=3.02u as=0.65p ps=3.02u w=2.5u l=1u
X59 a_4414_3916# a_54_3800# VDD VDD pfet_06v0 ad=2.5p pd=10.5u as=4.4p ps=20.88u w=10u l=1u
X60 a_6158_3846# OUT cap_mim_2f0_m4m5_noshield c_width=20u c_length=10u
X61 a_5718_446# a_8390_4846# VDD VDD pfet_06v0 ad=1.3p pd=5.52u as=1.3p ps=5.52u w=5u l=1u
X62 a_746_332# a_14_332# a_946_376# VSS nfet_06v0 ad=2.2p pd=10.88u as=1.25p ps=5.5u w=5u l=1u
X63 a_4714_3916# INN a_7274_3846# VDD pfet_06v0 ad=4.4p pd=20.88u as=2.6p ps=10.52u w=10u l=1u
X64 a_13876_4800# a_13876_4800# a_15512_3800# VDD pfet_06v0 ad=4.4p pd=20.88u as=3.3p ps=10.66u w=10u l=1u
X65 a_4686_376# a_14_332# a_4354_376# VSS nfet_06v0 ad=1.25p pd=5.5u as=1.65p ps=5.66u w=5u l=1u
X66 a_4354_376# INP a_5718_446# VSS nfet_06v0 ad=2.2p pd=10.88u as=1.3p ps=5.52u w=5u l=1u
X67 a_6830_446# a_354_3800# a_8390_4846# VDD pfet_06v0 ad=2.2p pd=10.88u as=1.3p ps=5.52u w=5u l=1u
X68 a_3010_376# a_354_3800# VSS VSS nfet_06v0 ad=0.25p pd=1.5u as=0.44p ps=2.88u w=1u l=1u
X69 a_5046_3916# a_354_3800# a_4714_3916# VDD pfet_06v0 ad=2.5p pd=10.5u as=3.3p ps=10.66u w=10u l=1u
X70 VSS a_7942_446# a_6158_3846# VSS nfet_06v0 ad=0.65p pd=3.02u as=0.65p ps=3.02u w=2.5u l=1u
X71 a_9506_4846# a_13406_332# a_9054_446# VSS nfet_06v0 ad=1.1p pd=5.88u as=1.1p ps=5.88u w=2.5u l=1u
X72 a_15914_332# a_14_332# a_16114_376# VSS nfet_06v0 ad=1.65p pd=5.66u as=1.25p ps=5.5u w=5u l=1u
X73 a_3290_3916# a_54_3800# VDD VDD pfet_06v0 ad=2.5p pd=10.5u as=4.4p ps=20.88u w=10u l=1u
X74 a_7942_446# a_13876_4800# a_8390_4846# VDD pfet_06v0 ad=2.2p pd=10.88u as=2.2p ps=10.88u w=5u l=1u
X75 VSS a_746_332# a_4686_376# VSS nfet_06v0 ad=2.2p pd=10.88u as=1.25p ps=5.5u w=5u l=1u
C0 a_9054_446# a_6158_3846# 1.24525f
C1 a_9506_4846# a_6830_446# 0.03319f
C2 a_7942_446# OUT 0.16492f
C3 a_3290_3916# OUT 0.0318f
C4 a_16114_376# VSS 0.04346f
C5 a_4354_376# INN 0.93769f
C6 a_5718_446# a_4714_3916# 0.31157f
C7 VDD a_14_332# 0.31241f
C8 a_6830_446# INN 1.13939f
C9 a_6158_3846# a_354_3800# 0.48922f
C10 a_14_332# a_7274_3846# 0.73384f
C11 a_5718_446# OUT 1.47393f
C12 VDD a_6158_3846# 0.19244f
C13 a_6158_3846# a_54_3800# 0.27428f
C14 a_8390_4846# a_14_332# 0.02983f
C15 VSS a_6158_3846# 1.23165f
C16 a_5718_446# INP 1.59971f
C17 a_9054_446# OUT 1.33696f
C18 a_14_332# a_15512_3800# 0.07495f
C19 a_13876_4800# a_6158_3846# 0.36694f
C20 a_4714_3916# a_354_3800# 1.11492f
C21 a_9506_4846# a_7942_446# 1.05586f
C22 VDD a_4714_3916# 0.76904f
C23 a_54_3800# a_4714_3916# 0.40959f
C24 a_354_3800# OUT 1.13952f
C25 VDD OUT 1.53637f
C26 a_4354_376# a_6830_446# 1.29732f
C27 a_54_3800# OUT 0.58072f
C28 INP a_354_3800# 0.03565f
C29 a_9506_4846# a_5718_446# 1.33702f
C30 VSS OUT 0.80576f
C31 a_7942_446# a_13406_332# 1.12308f
C32 VDD INP 0.19732f
C33 INP a_54_3800# 0.03277f
C34 a_15712_3916# a_15512_3800# 0.06563f
C35 a_13876_4800# OUT 0.10611f
C36 a_9506_4846# a_9054_446# 3.27547f
C37 INP VSS 0.12362f
C38 a_5718_446# INN 0.0885f
C39 VDD a_6158_3846# 0.81564f
C40 a_9506_4846# a_354_3800# 0.99019f
C41 a_9054_446# a_13406_332# 0.96576f
C42 VDD a_9506_4846# 2.51346f
C43 a_6158_3846# a_7274_3846# 1.46906f
C44 a_9506_4846# a_54_3800# 0.04631f
C45 a_14_332# a_746_332# 6.47023f
C46 a_14_332# a_15914_332# 0.61534f
C47 a_9506_4846# VSS 0.14423f
C48 a_8390_4846# a_6158_3846# 0.19023f
C49 VDD a_4714_3916# 1.16223f
C50 a_7942_446# a_6830_446# 0.27542f
C51 a_354_3800# INN 0.03787f
C52 a_15512_3800# a_6158_3846# 0.338f
C53 a_9506_4846# a_13876_4800# 0.87096f
C54 VDD INN 0.20529f
C55 a_54_3800# INN 0.02426f
C56 a_7274_3846# a_4714_3916# 2.48536f
C57 a_13406_332# a_354_3800# 0.49054f
C58 VSS INN 0.1249f
C59 VDD OUT 1.3939f
C60 a_946_376# VSS 0.04308f
C61 VDD a_13406_332# 0.47533f
C62 a_5718_446# a_4354_376# 1.69219f
C63 a_54_3800# a_13406_332# 0.15217f
C64 VSS a_13406_332# 0.40408f
C65 VDD INP 0.6275f
C66 a_5718_446# a_6830_446# 0.14266f
C67 a_7274_3846# OUT 0.07654f
C68 a_13876_4800# a_13406_332# 0.45232f
C69 a_8390_4846# OUT 0.04653f
C70 a_9054_446# a_6830_446# 0.05089f
C71 a_1978_376# VSS 0.01198f
C72 a_15512_3800# OUT 0.08305f
C73 VDD a_4414_3916# 0.07139f
C74 a_16114_376# a_15914_332# 0.03311f
C75 VSS a_15070_376# 0.04949f
C76 a_9506_4846# VDD 1.93576f
C77 a_354_3800# a_6830_446# 1.22222f
C78 a_54_3800# a_4354_376# 0.01445f
C79 VSS a_4354_376# 0.64174f
C80 VDD a_6830_446# 2.21585f
C81 a_13876_4800# a_15070_376# 0.02626f
C82 a_54_3800# a_6830_446# 0.04834f
C83 VSS a_6830_446# 0.04524f
C84 VDD a_5046_3916# 0.07856f
C85 a_5718_446# a_7942_446# 1.9125f
C86 VDD INN 0.62724f
C87 a_746_332# a_6158_3846# 2.51443f
C88 a_6158_3846# a_15914_332# 0.03416f
C89 a_9506_4846# a_8390_4846# 0.18781f
C90 VDD a_254_3916# 0.07875f
C91 a_7942_446# a_9054_446# 0.21292f
C92 a_9506_4846# a_15512_3800# 0.04507f
C93 VDD a_13406_332# 0.28907f
C94 a_4686_376# a_4354_376# 0.03377f
C95 a_7274_3846# INN 1.61879f
C96 a_746_332# a_4714_3916# 0.01194f
C97 a_7942_446# a_354_3800# 0.02967f
C98 a_8390_4846# a_13406_332# 0.84288f
C99 VDD a_7942_446# 0.02616f
C100 a_17156_3916# OUT 0.0112f
C101 a_15512_3800# a_13406_332# 0.12709f
C102 a_7942_446# a_54_3800# 0.10982f
C103 a_746_332# OUT 0.26773f
C104 a_15914_332# OUT 0.14634f
C105 VDD a_3290_3916# 0.07139f
C106 a_7942_446# VSS 2.42435f
C107 a_3290_3916# a_54_3800# 0.05253f
C108 a_14_332# a_6158_3846# 0.78797f
C109 a_746_332# INP 0.04106f
C110 a_7942_446# a_13876_4800# 0.91619f
C111 a_5718_446# a_354_3800# 1.45706f
C112 VDD a_6830_446# 1.17914f
C113 VDD a_5718_446# 2.11239f
C114 a_5718_446# a_54_3800# 3.18311f
C115 a_9054_446# a_354_3800# 0.02924f
C116 a_5718_446# VSS 0.04493f
C117 VDD a_9054_446# 0.21297f
C118 a_7274_3846# a_6830_446# 2.50204f
C119 a_9054_446# a_54_3800# 0.02141f
C120 a_5718_446# a_13876_4800# 0.01019f
C121 a_9054_446# VSS 1.61375f
C122 a_8390_4846# a_6830_446# 3.92117f
C123 a_9506_4846# a_746_332# 0.07714f
C124 a_13876_4800# a_9054_446# 0.90836f
C125 a_14_332# OUT 0.50653f
C126 VDD a_354_3800# 1.67656f
C127 a_14_332# INP 0.06003f
C128 a_54_3800# a_354_3800# 9.48152f
C129 VSS a_354_3800# 0.42608f
C130 a_746_332# INN 0.0368f
C131 VDD a_54_3800# 2.06599f
C132 a_946_376# a_746_332# 0.02626f
C133 VDD a_7942_446# 0.397f
C134 a_17156_3916# a_13406_332# 0.05253f
C135 VSS a_54_3800# 0.06656f
C136 a_13876_4800# a_354_3800# 0.16936f
C137 a_4054_376# a_4354_376# 0.03336f
C138 a_746_332# a_13406_332# 0.04723f
C139 a_15914_332# a_13406_332# 0.53512f
C140 VDD a_13876_4800# 0.39252f
C141 a_13876_4800# a_54_3800# 1.06513f
C142 a_7942_446# a_7274_3846# 1.74765f
C143 a_13876_4800# VSS 0.2213f
C144 a_15712_3916# OUT 0.01091f
C145 a_8390_4846# a_7942_446# 0.88054f
C146 VDD a_5718_446# 1.48454f
C147 a_9506_4846# a_14_332# 0.02925f
C148 VSS a_4686_376# 0.04817f
C149 VDD a_9054_446# 0.39578f
C150 a_5718_446# a_7274_3846# 0.04323f
C151 a_16114_376# OUT 0.01043f
C152 a_14_332# INN 0.06183f
C153 a_5718_446# a_8390_4846# 2.32292f
C154 a_746_332# a_4354_376# 1.05f
C155 a_9054_446# a_7274_3846# 0.03112f
C156 a_6158_3846# a_4714_3916# 3.20708f
C157 a_14_332# a_13406_332# 0.10485f
C158 a_746_332# a_6830_446# 0.02258f
C159 a_8390_4846# a_9054_446# 2.01578f
C160 VDD a_354_3800# 6.20991f
C161 a_15512_3800# a_9054_446# 0.15714f
C162 VDD VDD 9.00865f
C163 a_6158_3846# OUT 3.06443f
C164 VDD a_54_3800# 2.20874f
C165 a_7274_3846# a_354_3800# 0.03361f
C166 INP a_6158_3846# 1.52826f
C167 VDD a_7274_3846# 0.07133f
C168 a_8390_4846# a_354_3800# 1.06116f
C169 VDD a_13876_4800# 1.46832f
C170 a_54_3800# a_7274_3846# 0.02264f
C171 VDD a_8390_4846# 3.63815f
C172 VSS a_7274_3846# 1.36034f
C173 a_15512_3800# a_354_3800# 0.61675f
C174 a_8390_4846# a_54_3800# 0.09779f
C175 a_4714_3916# OUT 0.68719f
C176 VDD a_1366_3916# 0.07139f
C177 a_8390_4846# VSS 0.02524f
C178 VDD a_15512_3800# 0.48745f
C179 a_15512_3800# a_54_3800# 0.0567f
C180 a_14_332# a_4354_376# 0.70495f
C181 INP a_4714_3916# 2.44292f
C182 a_8390_4846# a_13876_4800# 0.8016f
C183 a_14_332# a_6830_446# 0.08683f
C184 a_7942_446# a_746_332# 0.10196f
C185 a_13876_4800# a_15512_3800# 1.35141f
C186 a_9506_4846# a_6158_3846# 0.45154f
C187 INP OUT 0.21257f
C188 a_14_332# a_254_3916# 0.05253f
C189 a_5718_446# a_746_332# 0.07472f
C190 a_6158_3846# INN 0.44921f
C191 a_4054_376# VSS 0.04308f
C192 a_9054_446# a_746_332# 0.14216f
C193 a_9054_446# a_15914_332# 0.04451f
C194 a_6158_3846# a_13406_332# 0.46925f
C195 a_3010_376# VSS 0.01317f
C196 VDD a_7274_3846# 0.39308f
C197 a_9506_4846# OUT 2.11582f
C198 a_14_332# a_7942_446# 0.75459f
C199 a_4714_3916# INN 2.05093f
C200 VDD a_8390_4846# 4.20842f
C201 a_746_332# a_354_3800# 1.63812f
C202 VDD a_15512_3800# 0.49115f
C203 VDD a_17156_3916# 0.07151f
C204 VDD a_746_332# 0.22681f
C205 INN OUT 0.07869f
C206 a_746_332# a_54_3800# 0.25605f
C207 a_746_332# VSS 0.81565f
C208 VSS a_15914_332# 0.29741f
C209 a_5718_446# a_14_332# 0.09585f
C210 INP INN 0.04421f
C211 a_13406_332# OUT 0.16396f
C212 a_6158_3846# a_4354_376# 0.06025f
C213 a_13876_4800# a_746_332# 0.04348f
C214 a_13876_4800# a_15914_332# 0.05121f
C215 a_14_332# a_9054_446# 0.69884f
C216 a_4414_3916# a_4714_3916# 0.06563f
C217 a_6158_3846# a_6830_446# 0.11964f
C218 a_4714_3916# a_4354_376# 0.10701f
C219 a_4414_3916# OUT 0.0318f
C220 a_14_332# a_354_3800# 0.63947f
C221 a_4714_3916# a_6830_446# 0.01157f
C222 a_15070_376# OUT 0.01043f
C223 VDD a_14_332# 0.38035f
C224 a_14_332# a_54_3800# 0.19761f
C225 a_4714_3916# a_5046_3916# 0.06575f
C226 a_4354_376# OUT 0.09254f
C227 a_14_332# VSS 0.97809f
C228 a_9506_4846# a_13406_332# 2.50177f
C229 a_6830_446# OUT 0.04477f
C230 INP a_4354_376# 1.4653f
C231 a_14_332# a_13876_4800# 0.38177f
C232 a_5046_3916# OUT 0.0318f
C233 a_7942_446# a_6158_3846# 1.59921f
C234 VDD a_746_332# 0.34318f
C235 a_746_332# a_7274_3846# 0.04949f
C236 VDD a_15712_3916# 0.07139f
C237 a_8390_4846# a_746_332# 0.09901f
C238 a_5718_446# a_6158_3846# 0.20786f
C239 a_1366_3916# a_746_332# 0.05253f
C240 a_15512_3800# a_15914_332# 0.09005f
C241 VSS VSS 17.3708f
C242 OUT VSS 9.43421f
C243 INN VSS 1.40552f
C244 VDD VSS 9.73052f
C245 INP VSS 1.3674f
C246 a_15914_332# VSS 0.74594f
C247 a_4354_376# VSS 1.44847f
C248 a_13406_332# VSS 2.65507f
C249 a_9054_446# VSS 3.338f
C250 a_7942_446# VSS 5.71774f
C251 a_5718_446# VSS 2.89704f
C252 a_6830_446# VSS 1.50489f
C253 a_7274_3846# VSS 1.76718f
C254 a_6158_3846# VSS 3.78132f
C255 a_9506_4846# VSS 2.06635f
C256 a_15512_3800# VSS 0.92729f
C257 a_13876_4800# VSS 1.06435f
C258 a_8390_4846# VSS 2.14317f
C259 a_4714_3916# VSS 1.39745f
C260 a_746_332# VSS 3.42442f
C261 a_14_332# VSS 7.48227f
C262 a_354_3800# VSS 5.89917f
C263 a_54_3800# VSS 2.7992f
C264 VDD VSS 0.15986p
.ends
