* Nodos de bulk atados: 38 de pozo n -> VDD, 39 de sustrato -> VSS.
*   magic no extrae los taps de este layout y los dejaba flotando;
*   la conexion si existe (el LVS de KLayout da 'match uniquely').
*   Quien detecta un tap que falte de verdad es el LVS, no esto.
* NGSPICE file created from COMP.ext - technology: gf180mcuD

.subckt COMP VSS VDD OUT INP INN
X0 a_4714_3916.t1 INP.t2 a_6158_3846.t1 VDD pfet_06v0 ad=4.4p pd=20.88u as=2.6p ps=10.52u w=10u l=1u
X1 a_5718_446.t6 a_8390_4846.t7 VDD.t12 VDD pfet_06v0 ad=1.3p pd=5.52u as=2.2p ps=10.88u w=5u l=1u
X2 a_14_332.t2 a_354_3800.t17 a_254_3916.t1 VDD pfet_06v0 ad=4.4p pd=20.88u as=2.5p ps=10.5u w=10u l=1u
X3 a_4714_3916.t5 a_354_3800.t14 a_4414_3916.t1 VDD pfet_06v0 ad=3.3p pd=10.66u as=2.5p ps=10.5u w=10u l=1u
X4 a_5718_446.t1 INP.t1 a_4354_376.t1 VSS nfet_06v0 ad=1.3p pd=5.52u as=2.2p ps=10.88u w=5u l=1u
X5 a_9054_446.t0 a_13870_4800.t3 a_9506_4846.t1 VDD pfet_06v0 ad=2.2p pd=10.88u as=2.2p ps=10.88u w=5u l=1u
X6 a_16114_376.t1 a_15914_332.t2 VSS.t12 VSS nfet_06v0 ad=1.25p pd=5.5u as=2.2p ps=10.88u w=5u l=1u
X7 OUT.t0 a_9054_446.t4 VSS.t5 VSS nfet_06v0 ad=2.2p pd=10.88u as=1.3p ps=5.52u w=5u l=1u
X8 a_6830_446.t7 a_8390_4846.t11 VDD.t14 VDD pfet_06v0 ad=1.3p pd=5.52u as=2.2p ps=10.88u w=5u l=1u
X9 a_13870_4800.t1 a_13870_4800.t0 a_15506_3800.t1 VDD pfet_06v0 ad=4.4p pd=20.88u as=3.3p ps=10.66u w=10u l=1u
X10 a_6158_3846.t2 a_7942_446.t7 VSS.t3 VSS nfet_06v0 ad=0.65p pd=3.02u as=1.1p ps=5.88u w=2.5u l=1u
X11 a_6158_3846.t0 INP.t3 a_4714_3916.t0 VDD pfet_06v0 ad=2.6p pd=10.52u as=4.4p ps=20.88u w=10u l=1u
X12 a_54_3800.t0 a_354_3800.t5 a_1978_376.t0 VSS nfet_06v0 ad=0.44p pd=2.88u as=0.25p ps=1.5u w=1u l=1u
X13 a_4354_376.t5 a_14_332.t10 a_4054_376.t1 VSS nfet_06v0 ad=1.65p pd=5.66u as=1.25p ps=5.5u w=5u l=1u
X14 a_7942_446.t1 a_14_332.t8 a_7274_3846.t1 VSS nfet_06v0 ad=0.65p pd=3.02u as=1.1p ps=5.88u w=2.5u l=1u
X15 a_9506_4846.t2 a_354_3800.t10 a_5718_446.t3 VDD pfet_06v0 ad=1.3p pd=5.52u as=2.2p ps=10.88u w=5u l=1u
X16 a_6830_446.t4 a_8390_4846.t9 VDD.t10 VDD pfet_06v0 ad=1.3p pd=5.52u as=1.3p ps=5.52u w=5u l=1u
X17 a_13406_332.t0 a_354_3800.t7 a_17150_3916.t1 VDD pfet_06v0 ad=4.4p pd=20.88u as=2.5p ps=10.5u w=10u l=1u
X18 OUT.t6 a_9506_4846.t6 VDD.t18 VDD pfet_06v0 ad=2.6p pd=10.52u as=4.4p ps=20.88u w=10u l=1u
X19 a_13870_4800.t2 a_14_332.t4 a_15070_376.t0 VSS nfet_06v0 ad=2.2p pd=10.88u as=1.25p ps=5.5u w=5u l=1u
X20 a_54_3800.t1 a_354_3800.t15 a_3290_3916.t1 VDD pfet_06v0 ad=4.4p pd=20.88u as=2.5p ps=10.5u w=10u l=1u
X21 a_7274_3846.t2 a_7942_446.t11 VSS.t17 VSS nfet_06v0 ad=0.65p pd=3.02u as=1.1p ps=5.88u w=2.5u l=1u
X22 VSS.t15 a_9054_446.t5 OUT.t5 VSS nfet_06v0 ad=1.3p pd=5.52u as=1.3p ps=5.52u w=5u l=1u
X23 a_1366_3916.t1 a_54_3800.t6 VDD.t6 VDD pfet_06v0 ad=2.5p pd=10.5u as=4.4p ps=20.88u w=10u l=1u
X24 a_1978_376.t1 a_354_3800.t6 VSS.t14 VSS nfet_06v0 ad=0.25p pd=1.5u as=0.44p ps=2.88u w=1u l=1u
X25 a_6158_3846.t6 a_14_332.t5 a_9054_446.t1 VSS nfet_06v0 ad=1.1p pd=5.88u as=0.65p ps=3.02u w=2.5u l=1u
X26 VSS.t18 a_7942_446.t4 a_6158_3846.t5 VSS nfet_06v0 ad=1.1p pd=5.88u as=0.65p ps=3.02u w=2.5u l=1u
X27 OUT.t7 a_5718_446.t4 cap_mim_2f0_m4m5_noshield c_width=20u c_length=10u
X28 a_354_3800.t1 a_354_3800.t0 VDD.t2 VDD pfet_06v0 ad=0.88p pd=4.88u as=0.88p ps=4.88u w=2u l=1u
X29 a_4054_376.t0 a_746_332.t4 VSS.t1 VSS nfet_06v0 ad=1.25p pd=5.5u as=2.2p ps=10.88u w=5u l=1u
X30 VDD.t13 a_8390_4846.t10 a_6830_446.t6 VDD pfet_06v0 ad=1.3p pd=5.52u as=1.3p ps=5.52u w=5u l=1u
X31 VDD.t15 a_8390_4846.t4 a_5718_446.t7 VDD pfet_06v0 ad=2.2p pd=10.88u as=1.3p ps=5.52u w=5u l=1u
X32 a_15070_376.t1 a_746_332.t2 VSS.t13 VSS nfet_06v0 ad=1.25p pd=5.5u as=2.2p ps=10.88u w=5u l=1u
X33 a_4354_376.t3 INN.t0 a_6830_446.t2 VSS nfet_06v0 ad=2.2p pd=10.88u as=1.3p ps=5.52u w=5u l=1u
X34 VSS.t4 a_7942_446.t8 a_7274_3846.t5 VSS nfet_06v0 ad=1.1p pd=5.88u as=0.65p ps=3.02u w=2.5u l=1u
X35 VDD.t5 a_9506_4846.t5 OUT.t3 VDD pfet_06v0 ad=2.6p pd=10.52u as=2.6p ps=10.52u w=10u l=1u
X36 a_254_3916.t0 a_54_3800.t7 VDD.t3 VDD pfet_06v0 ad=2.5p pd=10.5u as=4.4p ps=20.88u w=10u l=1u
X37 VDD.t9 a_8390_4846.t8 a_6830_446.t3 VDD pfet_06v0 ad=2.2p pd=10.88u as=1.3p ps=5.52u w=5u l=1u
X38 a_14_332.t1 a_14_332.t0 VSS.t0 VSS nfet_06v0 ad=0.44p pd=2.88u as=0.44p ps=2.88u w=1u l=1u
X39 a_6158_3846.t4 a_7942_446.t5 VSS.t11 VSS nfet_06v0 ad=0.65p pd=3.02u as=0.65p ps=3.02u w=2.5u l=1u
X40 a_7942_446.t2 a_13870_4800.t4 a_8390_4846.t1 VDD pfet_06v0 ad=2.2p pd=10.88u as=2.2p ps=10.88u w=5u l=1u
X41 OUT.t1 a_9054_446.t6 VSS.t8 VSS nfet_06v0 ad=1.3p pd=5.52u as=2.2p ps=10.88u w=5u l=1u
X42 VDD.t17 a_54_3800.t3 a_5046_3916.t1 VDD pfet_06v0 ad=4.4p pd=20.88u as=2.5p ps=10.5u w=10u l=1u
X43 a_746_332.t0 a_354_3800.t16 a_1366_3916.t0 VDD pfet_06v0 ad=4.4p pd=20.88u as=2.5p ps=10.5u w=10u l=1u
X44 VDD.t11 a_8390_4846.t6 a_5718_446.t5 VDD pfet_06v0 ad=1.3p pd=5.52u as=1.3p ps=5.52u w=5u l=1u
X45 a_7274_3846.t4 a_7942_446.t9 VSS.t9 VSS nfet_06v0 ad=0.65p pd=3.02u as=0.65p ps=3.02u w=2.5u l=1u
X46 a_7274_3846.t6 INN.t3 a_4714_3916.t3 VDD pfet_06v0 ad=2.6p pd=10.52u as=4.4p ps=20.88u w=10u l=1u
X47 a_6830_446.t1 INN.t1 a_4354_376.t2 VSS nfet_06v0 ad=1.3p pd=5.52u as=2.2p ps=10.88u w=5u l=1u
X48 a_8390_4846.t0 a_354_3800.t12 a_6830_446.t0 VDD pfet_06v0 ad=1.3p pd=5.52u as=2.2p ps=10.88u w=5u l=1u
X49 a_17150_3916.t0 a_54_3800.t2 VDD.t8 VDD pfet_06v0 ad=2.5p pd=10.5u as=4.4p ps=20.88u w=10u l=1u
X50 a_946_376.t1 a_746_332.t5 VSS.t16 VSS nfet_06v0 ad=1.25p pd=5.5u as=2.2p ps=10.88u w=5u l=1u
X51 a_13406_332.t2 a_13406_332.t1 a_15914_332.t1 VSS nfet_06v0 ad=2.2p pd=10.88u as=1.65p ps=5.66u w=5u l=1u
X52 a_15706_3916.t1 a_15506_3800.t2 VDD.t7 VDD pfet_06v0 ad=2.5p pd=10.5u as=4.4p ps=20.88u w=10u l=1u
X53 a_8390_4846.t3 a_13406_332.t4 a_7942_446.t3 VSS nfet_06v0 ad=1.1p pd=5.88u as=1.1p ps=5.88u w=2.5u l=1u
X54 a_6158_3846.t8 OUT.t4 cap_mim_2f0_m4m5_noshield c_width=20u c_length=10u
X55 a_5718_446.t0 a_354_3800.t9 a_9506_4846.t0 VDD pfet_06v0 ad=2.2p pd=10.88u as=1.3p ps=5.52u w=5u l=1u
X56 a_354_3800.t3 a_354_3800.t2 a_3010_376.t0 VSS nfet_06v0 ad=0.44p pd=2.88u as=0.25p ps=1.5u w=1u l=1u
X57 a_7274_3846.t0 a_14_332.t7 a_7942_446.t0 VSS nfet_06v0 ad=1.1p pd=5.88u as=0.65p ps=3.02u w=2.5u l=1u
X58 a_9054_446.t3 a_14_332.t6 a_6158_3846.t7 VSS nfet_06v0 ad=0.65p pd=3.02u as=1.1p ps=5.88u w=2.5u l=1u
X59 VSS.t10 a_7942_446.t10 a_7274_3846.t3 VSS nfet_06v0 ad=0.65p pd=3.02u as=0.65p ps=3.02u w=2.5u l=1u
X60 a_4414_3916.t0 a_54_3800.t4 VDD.t0 VDD pfet_06v0 ad=2.5p pd=10.5u as=4.4p ps=20.88u w=10u l=1u
X61 a_5718_446.t8 a_8390_4846.t5 VDD.t16 VDD pfet_06v0 ad=1.3p pd=5.52u as=1.3p ps=5.52u w=5u l=1u
X62 a_746_332.t1 a_14_332.t11 a_946_376.t0 VSS nfet_06v0 ad=2.2p pd=10.88u as=1.25p ps=5.5u w=5u l=1u
X63 a_4714_3916.t4 INN.t2 a_7274_3846.t7 VDD pfet_06v0 ad=4.4p pd=20.88u as=2.6p ps=10.52u w=10u l=1u
X64 a_4686_376.t1 a_14_332.t9 a_4354_376.t4 VSS nfet_06v0 ad=1.25p pd=5.5u as=1.65p ps=5.66u w=5u l=1u
X65 a_4354_376.t0 INP.t0 a_5718_446.t2 VSS nfet_06v0 ad=2.2p pd=10.88u as=1.3p ps=5.52u w=5u l=1u
X66 a_6830_446.t5 a_354_3800.t11 a_8390_4846.t2 VDD pfet_06v0 ad=2.2p pd=10.88u as=1.3p ps=5.52u w=5u l=1u
X67 a_3010_376.t1 a_354_3800.t4 VSS.t7 VSS nfet_06v0 ad=0.25p pd=1.5u as=0.44p ps=2.88u w=1u l=1u
X68 a_5046_3916.t0 a_354_3800.t13 a_4714_3916.t2 VDD pfet_06v0 ad=2.5p pd=10.5u as=3.3p ps=10.66u w=10u l=1u
X69 a_15506_3800.t0 a_354_3800.t8 a_15706_3916.t0 VDD pfet_06v0 ad=3.3p pd=10.66u as=2.5p ps=10.5u w=10u l=1u
X70 VSS.t2 a_7942_446.t6 a_6158_3846.t3 VSS nfet_06v0 ad=0.65p pd=3.02u as=0.65p ps=3.02u w=2.5u l=1u
X71 a_9506_4846.t3 a_13406_332.t3 a_9054_446.t2 VSS nfet_06v0 ad=1.1p pd=5.88u as=1.1p ps=5.88u w=2.5u l=1u
X72 a_15914_332.t0 a_14_332.t3 a_16114_376.t0 VSS nfet_06v0 ad=1.65p pd=5.66u as=1.25p ps=5.5u w=5u l=1u
X73 a_3290_3916.t0 a_54_3800.t5 VDD.t1 VDD pfet_06v0 ad=2.5p pd=10.5u as=4.4p ps=20.88u w=10u l=1u
X74 OUT.t2 a_9506_4846.t4 VDD.t4 VDD pfet_06v0 ad=4.4p pd=20.88u as=2.6p ps=10.52u w=10u l=1u
X75 VSS.t6 a_746_332.t3 a_4686_376.t0 VSS nfet_06v0 ad=2.2p pd=10.88u as=1.25p ps=5.5u w=5u l=1u
R0 VSS.n58 VSS.n57 9.0005
R1 VSS.n59 VSS.n54 9.0005
R2 VSS.n61 VSS.n60 9.0005
R3 VSS.n63 VSS.n62 9.0005
R4 VSS.n64 VSS.n52 9.0005
R5 VSS.n66 VSS.n65 9.0005
R6 VSS.n68 VSS.n67 9.0005
R7 VSS.n69 VSS.n50 9.0005
R8 VSS.n72 VSS.n71 9.0005
R9 VSS.n73 VSS.n49 9.0005
R10 VSS.n75 VSS.n74 9.0005
R11 VSS.n77 VSS.n48 9.0005
R12 VSS.n79 VSS.n78 9.0005
R13 VSS.n80 VSS.n47 9.0005
R14 VSS.n82 VSS.n81 9.0005
R15 VSS.n83 VSS.n46 9.0005
R16 VSS.n85 VSS.n84 9.0005
R17 VSS.n86 VSS.n45 9.0005
R18 VSS.n88 VSS.n87 9.0005
R19 VSS.n89 VSS.n44 9.0005
R20 VSS.n91 VSS.n90 9.0005
R21 VSS.n92 VSS.n4 9.0005
R22 VSS.n94 VSS.n93 9.0005
R23 VSS.n43 VSS.n42 9.0005
R24 VSS.n41 VSS.n5 9.0005
R25 VSS.n40 VSS.n39 9.0005
R26 VSS.n38 VSS.n6 9.0005
R27 VSS.n37 VSS.n36 9.0005
R28 VSS.n34 VSS.n7 9.0005
R29 VSS.n33 VSS.n32 9.0005
R30 VSS.n31 VSS.n11 9.0005
R31 VSS.n30 VSS.n29 9.0005
R32 VSS.n28 VSS.n12 9.0005
R33 VSS.n27 VSS.n26 9.0005
R34 VSS.n25 VSS.n13 9.0005
R35 VSS.n24 VSS.n23 9.0005
R36 VSS.n21 VSS.n14 9.0005
R37 VSS.n20 VSS.n19 9.0005
R38 VSS.n9 VSS.t18 7.46776
R39 VSS.n1 VSS.t4 7.46776
R40 VSS.n10 VSS.t3 6.6657
R41 VSS.n2 VSS.t17 6.6657
R42 VSS.n17 VSS.n16 6.60756
R43 VSS.n9 VSS.n8 6.0605
R44 VSS.n1 VSS.n0 6.0605
R45 VSS.n17 VSS.t8 6.0206
R46 VSS.n56 VSS.t0 5.3806
R47 VSS.n18 VSS.n17 5.37203
R48 VSS.n51 VSS.t7 5.28916
R49 VSS.n53 VSS.t14 5.28916
R50 VSS.n35 VSS.n10 5.19651
R51 VSS.n3 VSS.n2 5.19651
R52 VSS.n57 VSS.n56 4.71005
R53 VSS.n15 VSS.t12 1.91886
R54 VSS.n22 VSS.t13 1.91886
R55 VSS.n76 VSS.t6 1.91886
R56 VSS.n70 VSS.t1 1.91886
R57 VSS.n55 VSS.t16 1.91886
R58 VSS.n19 VSS.n18 1.57476
R59 VSS.n10 VSS.n9 0.802559
R60 VSS.n2 VSS.n1 0.802559
R61 VSS.n8 VSS.t11 0.6557
R62 VSS.n8 VSS.t2 0.6557
R63 VSS.n0 VSS.t9 0.6557
R64 VSS.n0 VSS.t10 0.6557
R65 VSS.n18 VSS.n15 0.42588
R66 VSS.n16 VSS.t5 0.3281
R67 VSS.n16 VSS.t15 0.3281
R68 VSS.n56 VSS.n55 0.274277
R69 VSS.n19 VSS.n14 0.2005
R70 VSS.n24 VSS.n14 0.2005
R71 VSS.n25 VSS.n24 0.2005
R72 VSS.n26 VSS.n25 0.2005
R73 VSS.n26 VSS.n12 0.2005
R74 VSS.n30 VSS.n12 0.2005
R75 VSS.n31 VSS.n30 0.2005
R76 VSS.n32 VSS.n31 0.2005
R77 VSS.n32 VSS.n7 0.2005
R78 VSS.n37 VSS.n7 0.2005
R79 VSS.n38 VSS.n37 0.2005
R80 VSS.n39 VSS.n38 0.2005
R81 VSS.n39 VSS.n5 0.2005
R82 VSS.n43 VSS.n5 0.2005
R83 VSS.n93 VSS.n43 0.2005
R84 VSS.n93 VSS.n92 0.2005
R85 VSS.n92 VSS.n91 0.2005
R86 VSS.n91 VSS.n44 0.2005
R87 VSS.n87 VSS.n44 0.2005
R88 VSS.n87 VSS.n86 0.2005
R89 VSS.n86 VSS.n85 0.2005
R90 VSS.n85 VSS.n46 0.2005
R91 VSS.n81 VSS.n46 0.2005
R92 VSS.n81 VSS.n80 0.2005
R93 VSS.n80 VSS.n79 0.2005
R94 VSS.n79 VSS.n48 0.2005
R95 VSS.n74 VSS.n48 0.2005
R96 VSS.n74 VSS.n73 0.2005
R97 VSS.n73 VSS.n72 0.2005
R98 VSS.n72 VSS.n50 0.2005
R99 VSS.n67 VSS.n50 0.2005
R100 VSS.n67 VSS.n66 0.2005
R101 VSS.n66 VSS.n52 0.2005
R102 VSS.n62 VSS.n52 0.2005
R103 VSS.n62 VSS.n61 0.2005
R104 VSS.n61 VSS.n54 0.2005
R105 VSS.n57 VSS.n54 0.2005
R106 VSS.n21 VSS.n20 0.2005
R107 VSS.n23 VSS.n13 0.2005
R108 VSS.n27 VSS.n13 0.2005
R109 VSS.n28 VSS.n27 0.2005
R110 VSS.n29 VSS.n28 0.2005
R111 VSS.n29 VSS.n11 0.2005
R112 VSS.n33 VSS.n11 0.2005
R113 VSS.n34 VSS.n33 0.2005
R114 VSS.n36 VSS.n6 0.2005
R115 VSS.n40 VSS.n6 0.2005
R116 VSS.n41 VSS.n40 0.2005
R117 VSS.n42 VSS.n41 0.2005
R118 VSS.n94 VSS.n4 0.2005
R119 VSS.n90 VSS.n4 0.2005
R120 VSS.n90 VSS.n89 0.2005
R121 VSS.n89 VSS.n88 0.2005
R122 VSS.n88 VSS.n45 0.2005
R123 VSS.n84 VSS.n45 0.2005
R124 VSS.n84 VSS.n83 0.2005
R125 VSS.n83 VSS.n82 0.2005
R126 VSS.n82 VSS.n47 0.2005
R127 VSS.n78 VSS.n47 0.2005
R128 VSS.n78 VSS.n77 0.2005
R129 VSS.n75 VSS.n49 0.2005
R130 VSS.n71 VSS.n49 0.2005
R131 VSS.n69 VSS.n68 0.2005
R132 VSS.n65 VSS.n64 0.2005
R133 VSS.n64 VSS.n63 0.2005
R134 VSS.n60 VSS.n59 0.2005
R135 VSS.n59 VSS.n58 0.2005
R136 VSS.n35 VSS.n34 0.1945
R137 VSS.n68 VSS.n51 0.184
R138 VSS.n76 VSS.n75 0.174
R139 VSS.n20 VSS.n15 0.169
R140 VSS.n22 VSS.n21 0.154
R141 VSS.n70 VSS.n69 0.139
R142 VSS VSS.n94 0.1135
R143 VSS.n60 VSS.n53 0.101
R144 VSS.n63 VSS.n53 0.1
R145 VSS.n71 VSS.n70 0.062
R146 VSS.n42 VSS.n3 0.0545
R147 VSS.n23 VSS.n22 0.047
R148 VSS VSS.n3 0.0335
R149 VSS.n77 VSS.n76 0.027
R150 VSS.n65 VSS.n51 0.017
R151 VSS.n58 VSS.n55 0.016
R152 VSS.n36 VSS.n35 0.0065
R153 OUT.n5 OUT.t7 19.8549
R154 OUT OUT.n1 11.4019
R155 OUT.n4 OUT.n3 9.95281
R156 OUT.n4 OUT.t4 9.35727
R157 OUT.n1 OUT.n0 6.97518
R158 OUT.n3 OUT.n2 6.60756
R159 OUT.n1 OUT.t2 6.11762
R160 OUT.n3 OUT.t0 6.0206
R161 OUT OUT.n5 4.5005
R162 OUT.n5 OUT.n4 1.18979
R163 OUT.n2 OUT.t5 0.3281
R164 OUT.n2 OUT.t1 0.3281
R165 OUT.n0 OUT.t3 0.1825
R166 OUT.n0 OUT.t6 0.1825
R167 INN.n0 INN.t2 47.1724
R168 INN.n0 INN.t3 43.4205
R169 INN.n1 INN.t1 27.1253
R170 INN.n1 INN.t0 25.3605
R171 INN INN.n1 10.7227
R172 INN INN.n0 2.89083
R173 VDD.n64 VDD.n63 9.0005
R174 VDD.n65 VDD.n60 9.0005
R175 VDD.n67 VDD.n66 9.0005
R176 VDD.n69 VDD.n59 9.0005
R177 VDD.n71 VDD.n70 9.0005
R178 VDD.n73 VDD.n72 9.0005
R179 VDD.n74 VDD.n56 9.0005
R180 VDD.n76 VDD.n75 9.0005
R181 VDD.n77 VDD.n55 9.0005
R182 VDD.n79 VDD.n78 9.0005
R183 VDD.n80 VDD.n54 9.0005
R184 VDD.n83 VDD.n82 9.0005
R185 VDD.n84 VDD.n53 9.0005
R186 VDD.n86 VDD.n85 9.0005
R187 VDD.n87 VDD.n52 9.0005
R188 VDD.n89 VDD.n88 9.0005
R189 VDD.n90 VDD.n51 9.0005
R190 VDD.n92 VDD.n91 9.0005
R191 VDD.n93 VDD.n50 9.0005
R192 VDD.n95 VDD.n94 9.0005
R193 VDD.n96 VDD.n1 9.0005
R194 VDD.n98 VDD.n97 9.0005
R195 VDD.n49 VDD.n0 9.0005
R196 VDD.n48 VDD.n47 9.0005
R197 VDD.n42 VDD.n2 9.0005
R198 VDD.n41 VDD.n40 9.0005
R199 VDD.n39 VDD.n3 9.0005
R200 VDD.n38 VDD.n37 9.0005
R201 VDD.n35 VDD.n4 9.0005
R202 VDD.n34 VDD.n33 9.0005
R203 VDD.n32 VDD.n8 9.0005
R204 VDD.n31 VDD.n30 9.0005
R205 VDD.n29 VDD.n9 9.0005
R206 VDD.n28 VDD.n27 9.0005
R207 VDD.n26 VDD.n10 9.0005
R208 VDD.n25 VDD.n24 9.0005
R209 VDD.n22 VDD.n11 9.0005
R210 VDD.n21 VDD.n20 9.0005
R211 VDD.n19 VDD.n12 9.0005
R212 VDD.n18 VDD.n17 9.0005
R213 VDD.n15 VDD.n14 8.15234
R214 VDD.n14 VDD.n13 6.97518
R215 VDD.n44 VDD.t9 6.74906
R216 VDD.n6 VDD.t15 6.74906
R217 VDD.n46 VDD.n45 6.54651
R218 VDD.n36 VDD.n7 6.54651
R219 VDD.n14 VDD.t18 6.11762
R220 VDD.n45 VDD.t14 5.947
R221 VDD.n7 VDD.t12 5.947
R222 VDD.n44 VDD.n43 5.6955
R223 VDD.n6 VDD.n5 5.6955
R224 VDD.n64 VDD.n61 3.23511
R225 VDD.n68 VDD.t2 2.82475
R226 VDD.n61 VDD.t3 2.14376
R227 VDD.n62 VDD.t6 1.96744
R228 VDD.n58 VDD.t1 1.96744
R229 VDD.n57 VDD.t0 1.96744
R230 VDD.n81 VDD.t17 1.96744
R231 VDD.n23 VDD.t7 1.96744
R232 VDD.n16 VDD.t8 1.96744
R233 VDD.n18 VDD.n15 1.84616
R234 VDD.n45 VDD.n44 0.802559
R235 VDD.n7 VDD.n6 0.802559
R236 VDD.n16 VDD.n15 0.390196
R237 VDD.n62 VDD.n61 0.37519
R238 VDD.n43 VDD.t10 0.3645
R239 VDD.n43 VDD.t13 0.3645
R240 VDD.n5 VDD.t16 0.3645
R241 VDD.n5 VDD.t11 0.3645
R242 VDD.n19 VDD.n18 0.2005
R243 VDD.n20 VDD.n19 0.2005
R244 VDD.n20 VDD.n11 0.2005
R245 VDD.n25 VDD.n11 0.2005
R246 VDD.n26 VDD.n25 0.2005
R247 VDD.n27 VDD.n26 0.2005
R248 VDD.n27 VDD.n9 0.2005
R249 VDD.n31 VDD.n9 0.2005
R250 VDD.n32 VDD.n31 0.2005
R251 VDD.n33 VDD.n32 0.2005
R252 VDD.n33 VDD.n4 0.2005
R253 VDD.n38 VDD.n4 0.2005
R254 VDD.n39 VDD.n38 0.2005
R255 VDD.n40 VDD.n39 0.2005
R256 VDD.n40 VDD.n2 0.2005
R257 VDD.n48 VDD.n2 0.2005
R258 VDD.n49 VDD.n48 0.2005
R259 VDD.n97 VDD.n49 0.2005
R260 VDD.n97 VDD.n96 0.2005
R261 VDD.n96 VDD.n95 0.2005
R262 VDD.n95 VDD.n50 0.2005
R263 VDD.n91 VDD.n50 0.2005
R264 VDD.n91 VDD.n90 0.2005
R265 VDD.n90 VDD.n89 0.2005
R266 VDD.n89 VDD.n52 0.2005
R267 VDD.n85 VDD.n52 0.2005
R268 VDD.n85 VDD.n84 0.2005
R269 VDD.n84 VDD.n83 0.2005
R270 VDD.n83 VDD.n54 0.2005
R271 VDD.n78 VDD.n54 0.2005
R272 VDD.n78 VDD.n77 0.2005
R273 VDD.n77 VDD.n76 0.2005
R274 VDD.n76 VDD.n56 0.2005
R275 VDD.n72 VDD.n56 0.2005
R276 VDD.n72 VDD.n71 0.2005
R277 VDD.n71 VDD.n59 0.2005
R278 VDD.n66 VDD.n59 0.2005
R279 VDD.n66 VDD.n65 0.2005
R280 VDD.n65 VDD.n64 0.2005
R281 VDD.n17 VDD.n12 0.2005
R282 VDD.n21 VDD.n12 0.2005
R283 VDD.n22 VDD.n21 0.2005
R284 VDD.n24 VDD.n10 0.2005
R285 VDD.n28 VDD.n10 0.2005
R286 VDD.n29 VDD.n28 0.2005
R287 VDD.n30 VDD.n29 0.2005
R288 VDD.n30 VDD.n8 0.2005
R289 VDD.n34 VDD.n8 0.2005
R290 VDD.n35 VDD.n34 0.2005
R291 VDD.n37 VDD.n3 0.2005
R292 VDD.n41 VDD.n3 0.2005
R293 VDD.n42 VDD.n41 0.2005
R294 VDD.n47 VDD.n42 0.2005
R295 VDD.n98 VDD.n1 0.2005
R296 VDD.n94 VDD.n1 0.2005
R297 VDD.n94 VDD.n93 0.2005
R298 VDD.n93 VDD.n92 0.2005
R299 VDD.n92 VDD.n51 0.2005
R300 VDD.n88 VDD.n51 0.2005
R301 VDD.n88 VDD.n87 0.2005
R302 VDD.n87 VDD.n86 0.2005
R303 VDD.n86 VDD.n53 0.2005
R304 VDD.n82 VDD.n53 0.2005
R305 VDD.n80 VDD.n79 0.2005
R306 VDD.n79 VDD.n55 0.2005
R307 VDD.n75 VDD.n74 0.2005
R308 VDD.n74 VDD.n73 0.2005
R309 VDD.n70 VDD.n69 0.2005
R310 VDD.n67 VDD.n60 0.2005
R311 VDD.n63 VDD.n60 0.2005
R312 VDD.n13 VDD.t4 0.1825
R313 VDD.n13 VDD.t5 0.1825
R314 VDD.n46 VDD.n0 0.1745
R315 VDD.n24 VDD.n23 0.165
R316 VDD.n36 VDD.n35 0.1645
R317 VDD.n70 VDD.n58 0.157
R318 VDD.n81 VDD.n80 0.154
R319 VDD.n68 VDD.n67 0.151
R320 VDD.n75 VDD.n57 0.119
R321 VDD VDD.n98 0.1135
R322 VDD VDD.n0 0.0875
R323 VDD.n17 VDD.n16 0.087
R324 VDD.n57 VDD.n55 0.082
R325 VDD.n69 VDD.n68 0.05
R326 VDD.n82 VDD.n81 0.047
R327 VDD.n73 VDD.n58 0.044
R328 VDD.n37 VDD.n36 0.0365
R329 VDD.n23 VDD.n22 0.036
R330 VDD.n47 VDD.n46 0.0265
R331 VDD.n63 VDD.n62 0.006
R332 INP.n0 INP.t2 47.1724
R333 INP.n0 INP.t3 43.4205
R334 INP.n1 INP.t1 27.1253
R335 INP.n1 INP.t0 25.3605
R336 INP INP.n1 10.717
R337 INP INP.n0 2.89083
R338 a_16114_376.t0 a_16114_376.t1 0.6305
R339 a_15070_376.t0 a_15070_376.t1 0.6305
R340 a_15914_332.n0 a_15914_332.t2 47.1771
R341 a_15914_332.t0 a_15914_332.n0 0.4163
R342 a_15914_332.n0 a_15914_332.t1 0.4163
R343 a_4686_376.t0 a_4686_376.t1 0.6305
R344 a_4054_376.t0 a_4054_376.t1 0.6305
R345 a_3010_376.t0 a_3010_376.t1 3.1505
R346 a_1978_376.t0 a_1978_376.t1 3.1505
R347 a_946_376.t0 a_946_376.t1 0.6305
R348 a_4354_376.t0 a_4354_376.n0 6.82001
R349 a_4354_376.n0 a_4354_376.n3 11.8193
R350 a_4354_376.n3 a_4354_376.n2 13.5743
R351 a_4354_376.n2 a_4354_376.t3 6.82001
R352 a_4354_376.n2 a_4354_376.t2 6.0206
R353 a_4354_376.n3 a_4354_376.n1 17.5509
R354 a_4354_376.n1 a_4354_376.t5 0.4163
R355 a_4354_376.n1 a_4354_376.t4 0.4163
R356 a_4354_376.n0 a_4354_376.t1 6.0206
R357 a_13406_332.t2 a_13406_332.n2 9.01481
R358 a_13406_332.n2 a_13406_332.t0 9.13017
R359 a_13406_332.n2 a_13406_332.n0 0.239964
R360 a_13406_332.n0 a_13406_332.n1 3.83836
R361 a_13406_332.n1 a_13406_332.t4 25.4371
R362 a_13406_332.n1 a_13406_332.t3 24.2928
R363 a_13406_332.n0 a_13406_332.t1 32.4395
R364 a_17150_3916.t0 a_17150_3916.t1 0.3505
R365 a_15706_3916.t0 a_15706_3916.t1 0.3505
R366 a_9054_446.n0 a_9054_446.t3 0.6557
R367 a_9054_446.t1 a_9054_446.n0 0.6557
R368 a_9054_446.n0 a_9054_446.n1 26.2127
R369 a_9054_446.n1 a_9054_446.n2 1.38586
R370 a_9054_446.n2 a_9054_446.n4 10.7125
R371 a_9054_446.n4 a_9054_446.n3 1.93907
R372 a_9054_446.n3 a_9054_446.t4 25.9305
R373 a_9054_446.n3 a_9054_446.t6 25.1705
R374 a_9054_446.n4 a_9054_446.t5 25.3605
R375 a_9054_446.n2 a_9054_446.t0 10.3816
R376 a_9054_446.n1 a_9054_446.t2 10.1457
R377 a_7942_446.n0 a_7942_446.t1 0.6557
R378 a_7942_446.t0 a_7942_446.n0 0.6557
R379 a_7942_446.n0 a_7942_446.n4 23.0741
R380 a_7942_446.n4 a_7942_446.n8 2.73264
R381 a_7942_446.n8 a_7942_446.n9 1.72818
R382 a_7942_446.n9 a_7942_446.t2 10.8636
R383 a_7942_446.n9 a_7942_446.t3 10.9205
R384 a_7942_446.n8 a_7942_446.n7 8.35289
R385 a_7942_446.n7 a_7942_446.n5 0.1905
R386 a_7942_446.n5 a_7942_446.n6 1.3255
R387 a_7942_446.n6 a_7942_446.t5 16.8055
R388 a_7942_446.n6 a_7942_446.t7 16.0455
R389 a_7942_446.n7 a_7942_446.t4 16.6155
R390 a_7942_446.n5 a_7942_446.t6 16.0455
R391 a_7942_446.n4 a_7942_446.n3 8.35289
R392 a_7942_446.n3 a_7942_446.n1 0.1905
R393 a_7942_446.n1 a_7942_446.n2 1.3255
R394 a_7942_446.n2 a_7942_446.t9 16.8055
R395 a_7942_446.n2 a_7942_446.t11 16.0455
R396 a_7942_446.n3 a_7942_446.t8 16.6155
R397 a_7942_446.n1 a_7942_446.t10 16.0455
R398 a_5718_446.n0 a_5718_446.t1 0.3281
R399 a_5718_446.t2 a_5718_446.n0 0.3281
R400 a_5718_446.n0 a_5718_446.n1 18.9298
R401 a_5718_446.n1 a_5718_446.n3 4.48443
R402 a_5718_446.n3 a_5718_446.n6 21.0284
R403 a_5718_446.n6 a_5718_446.n5 5.6955
R404 a_5718_446.n5 a_5718_446.t8 0.3645
R405 a_5718_446.n5 a_5718_446.t7 0.3645
R406 a_5718_446.n6 a_5718_446.n4 6.50021
R407 a_5718_446.n4 a_5718_446.t6 0.3645
R408 a_5718_446.n4 a_5718_446.t5 0.3645
R409 a_5718_446.n3 a_5718_446.n2 12.4259
R410 a_5718_446.n2 a_5718_446.t0 6.74641
R411 a_5718_446.n2 a_5718_446.t3 5.947
R412 a_5718_446.n1 a_5718_446.t4 9.27911
R413 a_6830_446.n0 a_6830_446.t1 0.3281
R414 a_6830_446.t2 a_6830_446.n0 0.3281
R415 a_6830_446.n0 a_6830_446.n2 18.322
R416 a_6830_446.n2 a_6830_446.n5 21.6008
R417 a_6830_446.n5 a_6830_446.n4 5.6955
R418 a_6830_446.n4 a_6830_446.t4 0.3645
R419 a_6830_446.n4 a_6830_446.t3 0.3645
R420 a_6830_446.n5 a_6830_446.n3 6.50021
R421 a_6830_446.n3 a_6830_446.t7 0.3645
R422 a_6830_446.n3 a_6830_446.t6 0.3645
R423 a_6830_446.n2 a_6830_446.n1 13.9754
R424 a_6830_446.n1 a_6830_446.t5 6.74641
R425 a_6830_446.n1 a_6830_446.t0 5.947
R426 a_7274_3846.n0 a_7274_3846.t4 0.6557
R427 a_7274_3846.t5 a_7274_3846.n0 0.6557
R428 a_7274_3846.n0 a_7274_3846.n5 6.0605
R429 a_7274_3846.n5 a_7274_3846.n4 6.86521
R430 a_7274_3846.n4 a_7274_3846.t2 0.6557
R431 a_7274_3846.n4 a_7274_3846.t3 0.6557
R432 a_7274_3846.n5 a_7274_3846.n2 17.6984
R433 a_7274_3846.n2 a_7274_3846.n3 12.5437
R434 a_7274_3846.n3 a_7274_3846.t0 7.46511
R435 a_7274_3846.n3 a_7274_3846.t1 6.6657
R436 a_7274_3846.n2 a_7274_3846.n1 21.6995
R437 a_7274_3846.n1 a_7274_3846.t6 0.1825
R438 a_7274_3846.n1 a_7274_3846.t7 0.1825
R439 a_6158_3846.n0 a_6158_3846.t4 0.6557
R440 a_6158_3846.t5 a_6158_3846.n0 0.6557
R441 a_6158_3846.n0 a_6158_3846.n6 6.0605
R442 a_6158_3846.n6 a_6158_3846.n5 6.86521
R443 a_6158_3846.n5 a_6158_3846.t2 0.6557
R444 a_6158_3846.n5 a_6158_3846.t3 0.6557
R445 a_6158_3846.n6 a_6158_3846.n1 12.0305
R446 a_6158_3846.n1 a_6158_3846.n3 6.61871
R447 a_6158_3846.n3 a_6158_3846.n4 25.2363
R448 a_6158_3846.n4 a_6158_3846.t0 0.1825
R449 a_6158_3846.n4 a_6158_3846.t1 0.1825
R450 a_6158_3846.n3 a_6158_3846.n2 12.0476
R451 a_6158_3846.n2 a_6158_3846.t6 7.46511
R452 a_6158_3846.n2 a_6158_3846.t7 6.6657
R453 a_6158_3846.n1 a_6158_3846.t8 14.0112
R454 a_9506_4846.t3 a_9506_4846.n4 10.4039
R455 a_9506_4846.n4 a_9506_4846.n1 0.299429
R456 a_9506_4846.n1 a_9506_4846.n3 12.5018
R457 a_9506_4846.n3 a_9506_4846.n2 0.3805
R458 a_9506_4846.n3 a_9506_4846.t4 43.8005
R459 a_9506_4846.n2 a_9506_4846.t5 47.1562
R460 a_9506_4846.n2 a_9506_4846.t6 43.4205
R461 a_9506_4846.n1 a_9506_4846.t1 10.1233
R462 a_9506_4846.n4 a_9506_4846.n0 27.7344
R463 a_9506_4846.n0 a_9506_4846.t2 0.3645
R464 a_9506_4846.n0 a_9506_4846.t0 0.3645
R465 a_15506_3800.n0 a_15506_3800.t2 70.3756
R466 a_15506_3800.t0 a_15506_3800.n0 0.2315
R467 a_15506_3800.n0 a_15506_3800.t1 0.2315
R468 a_13870_4800.t2 a_13870_4800.n2 9.53133
R469 a_13870_4800.n2 a_13870_4800.n1 1.25246
R470 a_13870_4800.n1 a_13870_4800.t1 7.75383
R471 a_13870_4800.n1 a_13870_4800.t0 49.14
R472 a_13870_4800.n2 a_13870_4800.n0 1.02425
R473 a_13870_4800.n0 a_13870_4800.t4 34.1193
R474 a_13870_4800.n0 a_13870_4800.t3 32.8465
R475 a_8390_4846.t3 a_8390_4846.n0 5.42581
R476 a_8390_4846.n0 a_8390_4846.t1 6.17821
R477 a_8390_4846.n0 a_8390_4846.n4 6.37764
R478 a_8390_4846.n4 a_8390_4846.n8 2.73907
R479 a_8390_4846.n8 a_8390_4846.n9 24.2894
R480 a_8390_4846.n9 a_8390_4846.t0 0.3645
R481 a_8390_4846.n9 a_8390_4846.t2 0.3645
R482 a_8390_4846.n8 a_8390_4846.n7 8.81463
R483 a_8390_4846.n7 a_8390_4846.n6 0.3805
R484 a_8390_4846.n7 a_8390_4846.t9 25.5505
R485 a_8390_4846.n6 a_8390_4846.n5 2.12907
R486 a_8390_4846.n5 a_8390_4846.t8 25.9305
R487 a_8390_4846.n5 a_8390_4846.t10 25.1705
R488 a_8390_4846.n6 a_8390_4846.t11 25.1705
R489 a_8390_4846.n4 a_8390_4846.n3 8.81463
R490 a_8390_4846.n3 a_8390_4846.n2 0.3805
R491 a_8390_4846.n3 a_8390_4846.t5 25.5505
R492 a_8390_4846.n2 a_8390_4846.n1 2.12907
R493 a_8390_4846.n1 a_8390_4846.t4 25.9305
R494 a_8390_4846.n1 a_8390_4846.t6 25.1705
R495 a_8390_4846.n2 a_8390_4846.t7 25.1705
R496 a_5046_3916.t0 a_5046_3916.t1 0.3505
R497 a_4714_3916.t1 a_4714_3916.n0 6.91703
R498 a_4714_3916.n0 a_4714_3916.n3 12.0189
R499 a_4714_3916.n3 a_4714_3916.n2 13.7803
R500 a_4714_3916.n2 a_4714_3916.t4 6.91703
R501 a_4714_3916.n2 a_4714_3916.t3 6.11762
R502 a_4714_3916.n3 a_4714_3916.n1 19.5315
R503 a_4714_3916.n1 a_4714_3916.t5 0.2315
R504 a_4714_3916.n1 a_4714_3916.t2 0.2315
R505 a_4714_3916.n0 a_4714_3916.t0 6.11762
R506 a_4414_3916.t0 a_4414_3916.t1 0.3505
R507 a_3290_3916.t0 a_3290_3916.t1 0.3505
R508 a_746_332.t1 a_746_332.n3 7.20698
R509 a_746_332.n3 a_746_332.n0 0.643357
R510 a_746_332.n0 a_746_332.n1 3.53461
R511 a_746_332.n1 a_746_332.n2 1.46621
R512 a_746_332.n2 a_746_332.t2 46.806
R513 a_746_332.n2 a_746_332.t3 30.6317
R514 a_746_332.n1 a_746_332.t4 30.6317
R515 a_746_332.n0 a_746_332.t0 9.83871
R516 a_746_332.n3 a_746_332.t5 31.3533
R517 a_1366_3916.t0 a_1366_3916.t1 0.3505
R518 a_14_332.t1 a_14_332.n9 11.8828
R519 a_14_332.n9 a_14_332.n0 0.514786
R520 a_14_332.n0 a_14_332.n1 0.808893
R521 a_14_332.n1 a_14_332.n2 4.96336
R522 a_14_332.n2 a_14_332.n3 0.501929
R523 a_14_332.n3 a_14_332.n5 5.4455
R524 a_14_332.n5 a_14_332.n7 1.7555
R525 a_14_332.n7 a_14_332.n8 9.87479
R526 a_14_332.n8 a_14_332.t3 32.0192
R527 a_14_332.n8 a_14_332.t4 30.3734
R528 a_14_332.n7 a_14_332.n6 6.02854
R529 a_14_332.n6 a_14_332.t6 17.1967
R530 a_14_332.n6 a_14_332.t5 16.2355
R531 a_14_332.n5 a_14_332.n4 6.02854
R532 a_14_332.n4 a_14_332.t8 17.1967
R533 a_14_332.n4 a_14_332.t7 16.2355
R534 a_14_332.n3 a_14_332.t9 30.3734
R535 a_14_332.n2 a_14_332.t10 30.3734
R536 a_14_332.n1 a_14_332.t11 30.3734
R537 a_14_332.n0 a_14_332.t2 10.097
R538 a_14_332.n9 a_14_332.t0 17.5781
R539 a_254_3916.t0 a_254_3916.t1 0.3505
R540 a_354_3800.t3 a_354_3800.n15 14.9819
R541 a_354_3800.n15 a_354_3800.n7 0.1805
R542 a_354_3800.n7 a_354_3800.n8 1.74104
R543 a_354_3800.n8 a_354_3800.n9 0.501929
R544 a_354_3800.n9 a_354_3800.n11 5.34264
R545 a_354_3800.n11 a_354_3800.n13 1.76193
R546 a_354_3800.n13 a_354_3800.n14 10.4148
R547 a_354_3800.n14 a_354_3800.t7 50.912
R548 a_354_3800.n14 a_354_3800.t8 48.6234
R549 a_354_3800.n13 a_354_3800.n12 7.023
R550 a_354_3800.n12 a_354_3800.t9 27.3153
R551 a_354_3800.n12 a_354_3800.t10 25.1705
R552 a_354_3800.n11 a_354_3800.n10 7.023
R553 a_354_3800.n10 a_354_3800.t11 27.3153
R554 a_354_3800.n10 a_354_3800.t12 25.1705
R555 a_354_3800.n9 a_354_3800.t13 48.6234
R556 a_354_3800.n8 a_354_3800.t14 48.6234
R557 a_354_3800.n7 a_354_3800.t15 48.6234
R558 a_354_3800.n15 a_354_3800.n0 0.230321
R559 a_354_3800.n0 a_354_3800.n1 0.460143
R560 a_354_3800.n1 a_354_3800.n2 0.55175
R561 a_354_3800.n2 a_354_3800.n3 0.239964
R562 a_354_3800.n3 a_354_3800.n4 0.289786
R563 a_354_3800.n4 a_354_3800.n5 0.4505
R564 a_354_3800.n5 a_354_3800.n6 0.469786
R565 a_354_3800.n6 a_354_3800.t17 50.3784
R566 a_354_3800.n6 a_354_3800.t16 48.6234
R567 a_354_3800.n5 a_354_3800.t6 20.4378
R568 a_354_3800.n4 a_354_3800.t5 20.4378
R569 a_354_3800.n3 a_354_3800.t0 22.5539
R570 a_354_3800.n2 a_354_3800.t1 10.9863
R571 a_354_3800.n1 a_354_3800.t4 20.4378
R572 a_354_3800.n0 a_354_3800.t2 20.4378
R573 a_54_3800.t0 a_54_3800.n5 14.7237
R574 a_54_3800.n5 a_54_3800.n1 1.19943
R575 a_54_3800.n1 a_54_3800.n2 0.845857
R576 a_54_3800.n2 a_54_3800.n3 1.02104
R577 a_54_3800.n3 a_54_3800.n4 1.46621
R578 a_54_3800.n4 a_54_3800.t2 67.8203
R579 a_54_3800.n4 a_54_3800.t3 48.8817
R580 a_54_3800.n3 a_54_3800.t4 48.8817
R581 a_54_3800.n2 a_54_3800.t1 7.2561
R582 a_54_3800.n1 a_54_3800.t5 48.9618
R583 a_54_3800.n5 a_54_3800.n0 1.70568
R584 a_54_3800.n0 a_54_3800.t7 50.6367
R585 a_54_3800.n0 a_54_3800.t6 48.8817
R586 VDD VDD 148.067
R587 VDD VDD 109.409
R588 VDD VDD 296.135
R589 VDD VDD 109.409
R590 VDD VDD 296.135
R591 VDD VDD 296.135
R592 VDD VDD 109.409
R593 VDD VDD 300.512
R594 VDD VDD 109.409
R595 VDD VDD 121.081
R596 VDD VDD 109.409
R597 VDD VDD 296.135
R598 VDD VDD 110.868
R599 VDD VDD 296.135
R600 VDD VDD 110.868
R601 VDD VDD 296.135
R602 VDD VDD 110.868
R603 VDD VDD 296.135
R604 VDD VDD 110.868
R605 VDD VDD 296.135
R606 VDD VDD 110.868
R607 VDD VDD 110.868
R608 VDD VDD 110.868
R609 VDD VDD 296.135
R610 VDD VDD 110.868
R611 VDD VDD 110.868
R612 VDD VDD 110.868
R613 VDD VDD 296.135
R614 VDD VDD 296.135
R615 VDD VDD 300.512
R616 VDD VDD 109.409
R617 VDD VDD 121.081
R618 VDD VDD 296.135
R619 VDD VDD 109.409
R620 VDD VDD 296.135
R621 VDD VDD 110.868
R622 VDD VDD 110.868
R623 VSS VSS 335.07
R624 VSS VSS 670.141
R625 VSS VSS 274.649
R626 VSS VSS 670.141
R627 VSS VSS 274.649
R628 VSS VSS 670.141
R629 VSS VSS 274.649
R630 VSS VSS 681.128
R631 VSS VSS 274.649
R632 VSS VSS 303.945
R633 VSS VSS 274.649
R634 VSS VSS 670.141
R635 VSS VSS 278.31
R636 VSS VSS 739.718
R637 VSS VSS 278.31
R638 VSS VSS 739.718
R639 VSS VSS 278.31
R640 VSS VSS 739.718
R641 VSS VSS 278.31
R642 VSS VSS 739.718
R643 VSS VSS 278.31
R644 VSS VSS 278.31
R645 VSS VSS 278.31
R646 VSS VSS 739.718
R647 VSS VSS 278.31
R648 VSS VSS 278.31
R649 VSS VSS 278.31
R650 VSS VSS 739.718
R651 VSS VSS 670.141
R652 VSS VSS 670.141
R653 VSS VSS 274.649
R654 VSS VSS 681.128
R655 VSS VSS 274.649
R656 VSS VSS 303.945
R657 VSS VSS 670.141
R658 VSS VSS 278.31
R659 VSS VSS 278.31
C0 VSS INN 0.1249f
C1 VDD INN 0.20529f
C2 INN OUT 0.07564f
C3 VSS OUT 0.80572f
C4 VDD OUT 1.53578f
C5 INP INN 0.0444f
C6 INP VSS 0.12362f
C7 VDD INP 0.19732f
C8 INP OUT 0.20691f
C9 VSS 0 17.39864f
C10 OUT 0 9.41883f
C11 INN 0 1.49544f
C12 VDD 0 9.82278f
C13 INP 0 1.42061f
C14 VDD 0 0.36509f
C15 VDD 0 0.63487f
C16 VDD 0 0.99996f
C17 VDD 0 0.99996f
C18 VDD 0 0.99996f
C19 VDD 0 1.46038f
C20 VDD 0 0.99996f
C21 VDD 0 1.01076f
C22 VDD 0 1.01076f
C23 VDD 0 0.56833f
C24 VDD 0 0.56833f
C25 VDD 0 0.99996f
C26 VDD 0 1.00356f
C27 VDD 0 1.00356f
C28 VDD 0 1.00356f
C29 VDD 0 1.00356f
C30 VDD 0 1.00356f
C31 VDD 0 1.00356f
C32 VDD 0 1.00356f
C33 VDD 0 1.00356f
C34 VDD 0 1.00356f
C35 VDD 0 0.54674f
C36 VDD 0 0.54674f
C37 VDD 0 1.00356f
C38 VDD 0 1.00356f
C39 VDD 0 0.54674f
C40 VDD 0 0.54674f
C41 VDD 0 1.00356f
C42 VDD 0 1.46038f
C43 VDD 0 1.47117f
C44 VDD 0 1.01076f
C45 VDD 0 0.56833f
C46 VDD 0 1.02874f
C47 VDD 0 0.99996f
C48 VDD 0 0.99996f
C49 VDD 0 1.00356f
C50 VDD 0 0.54674f
C51 VDD 0 1.00356f
C52 a_54_3800.t0 0 0.38327f
C53 a_54_3800.t6 0 1.58997f
C54 a_54_3800.n0 0 1.70772f
C55 a_54_3800.t7 0 1.61766f
C56 a_54_3800.t5 0 1.59075f
C57 a_54_3800.n1 0 0.81518f
C58 a_54_3800.t1 0 1.60773f
C59 a_54_3800.n2 0 0.30724f
C60 a_54_3800.t4 0 1.58997f
C61 a_54_3800.n3 0 0.85356f
C62 a_54_3800.t3 0 1.58997f
C63 a_54_3800.n4 0 4.00678f
C64 a_54_3800.t2 0 2.22121f
C65 a_54_3800.n5 0 0.59346f
C66 a_354_3800.t3 0 0.35782f
C67 a_354_3800.t2 0 0.43116f
C68 a_354_3800.n0 0 0.50322f
C69 a_354_3800.t4 0 0.43116f
C70 a_354_3800.n1 0 0.52781f
C71 a_354_3800.t1 0 0.50426f
C72 a_354_3800.n2 0 0.28716f
C73 a_354_3800.t0 0 0.48286f
C74 a_354_3800.n3 0 0.45652f
C75 a_354_3800.t5 0 0.43116f
C76 a_354_3800.n4 0 0.50703f
C77 a_354_3800.t6 0 0.43116f
C78 a_354_3800.n5 0 0.5208f
C79 a_354_3800.t16 0 1.42459f
C80 a_354_3800.n6 0 1.39921f
C81 a_354_3800.t17 0 1.44888f
C82 a_354_3800.t15 0 1.42459f
C83 a_354_3800.n7 0 0.70302f
C84 a_354_3800.t14 0 1.42459f
C85 a_354_3800.n8 0 0.72761f
C86 a_354_3800.t13 0 1.42459f
C87 a_354_3800.n9 0 1.00309f
C88 a_354_3800.t12 0 0.66189f
C89 a_354_3800.n10 0 1.15447f
C90 a_354_3800.t11 0 0.73956f
C91 a_354_3800.n11 0 0.60734f
C92 a_354_3800.t10 0 0.66189f
C93 a_354_3800.n12 0 1.15447f
C94 a_354_3800.t9 0 0.73956f
C95 a_354_3800.n13 0 0.99531f
C96 a_354_3800.t8 0 1.42459f
C97 a_354_3800.n14 0 2.23263f
C98 a_354_3800.t7 0 1.45776f
C99 a_354_3800.n15 0 0.35645f
C100 a_254_3916.t0 0 0.06808f
C101 a_254_3916.t1 0 0.06808f
C102 a_14_332.t1 0 0.19299f
C103 a_14_332.t0 0 0.29325f
C104 a_14_332.t2 0 1.58444f
C105 a_14_332.n0 0 0.31359f
C106 a_14_332.t11 0 0.73678f
C107 a_14_332.n1 0 0.74797f
C108 a_14_332.t10 0 0.73678f
C109 a_14_332.n2 0 0.72539f
C110 a_14_332.t9 0 0.73678f
C111 a_14_332.n3 0 0.76085f
C112 a_14_332.t7 0 0.35767f
C113 a_14_332.t8 0 0.37408f
C114 a_14_332.n4 0 0.73085f
C115 a_14_332.n5 0 0.56373f
C116 a_14_332.t5 0 0.35767f
C117 a_14_332.t6 0 0.37408f
C118 a_14_332.n6 0 0.73085f
C119 a_14_332.n7 0 0.8895f
C120 a_14_332.t4 0 0.73678f
C121 a_14_332.n8 0 1.59876f
C122 a_14_332.t3 0 0.75997f
C123 a_14_332.n9 0 0.48267f
C124 a_1366_3916.t0 0 0.07257f
C125 a_1366_3916.t1 0 0.07257f
C126 a_746_332.t1 0 0.65794f
C127 a_746_332.t5 0 1.08681f
C128 a_746_332.t0 0 2.26493f
C129 a_746_332.n0 0 0.74282f
C130 a_746_332.t4 0 1.07343f
C131 a_746_332.n1 0 1.02624f
C132 a_746_332.t3 0 1.07343f
C133 a_746_332.n2 0 3.82386f
C134 a_746_332.t2 0 1.84159f
C135 a_746_332.n3 0 0.81569f
C136 a_3290_3916.t0 0 0.08644f
C137 a_3290_3916.t1 0 0.08644f
C138 a_4414_3916.t0 0 0.09038f
C139 a_4414_3916.t1 0 0.09038f
C140 a_4714_3916.t1 0 1.81686f
C141 a_4714_3916.t0 0 1.78628f
C142 a_4714_3916.n0 0 1.2207f
C143 a_4714_3916.n1 0 2.21711f
C144 a_4714_3916.t5 0 0.39448f
C145 a_4714_3916.t2 0 0.39448f
C146 a_4714_3916.t3 0 1.78628f
C147 a_4714_3916.n2 0 1.3131f
C148 a_4714_3916.t4 0 1.81686f
C149 a_4714_3916.n3 0 2.116f
C150 a_5046_3916.t0 0 0.09417f
C151 a_5046_3916.t1 0 0.09417f
C152 a_8390_4846.t3 0 0.38473f
C153 a_8390_4846.n0 0 0.97926f
C154 a_8390_4846.t7 0 0.91719f
C155 a_8390_4846.t6 0 0.97072f
C156 a_8390_4846.n1 0 1.2719f
C157 a_8390_4846.t4 0 0.98569f
C158 a_8390_4846.n2 0 0.68213f
C159 a_8390_4846.t5 0 0.92379f
C160 a_8390_4846.n3 0 1.04771f
C161 a_8390_4846.n4 0 0.81935f
C162 a_8390_4846.t11 0 0.91719f
C163 a_8390_4846.t10 0 0.97072f
C164 a_8390_4846.n5 0 1.2719f
C165 a_8390_4846.t8 0 0.98569f
C166 a_8390_4846.n6 0 0.68213f
C167 a_8390_4846.t9 0 0.92379f
C168 a_8390_4846.n7 0 1.04771f
C169 a_8390_4846.n8 0 1.76646f
C170 a_8390_4846.t0 0 0.15818f
C171 a_8390_4846.t2 0 0.15818f
C172 a_8390_4846.n9 0 1.36135f
C173 a_8390_4846.t1 0 1.15077f
C174 a_13870_4800.t2 0 0.7808f
C175 a_13870_4800.t3 0 1.03759f
C176 a_13870_4800.n0 0 1.62234f
C177 a_13870_4800.t4 0 1.06674f
C178 a_13870_4800.t0 0 1.78551f
C179 a_13870_4800.n1 0 1.08607f
C180 a_13870_4800.t1 0 1.82999f
C181 a_13870_4800.n2 0 0.41558f
C182 a_15506_3800.t0 0 0.23565f
C183 a_15506_3800.n0 0 2.06088f
C184 a_15506_3800.t2 0 1.4805f
C185 a_15506_3800.t1 0 0.23565f
C186 a_9506_4846.t3 0 0.62893f
C187 a_9506_4846.t2 0 0.16748f
C188 a_9506_4846.t0 0 0.16748f
C189 a_9506_4846.n0 0 1.65772f
C190 a_9506_4846.t1 0 1.40616f
C191 a_9506_4846.n1 0 1.42716f
C192 a_9506_4846.t6 0 1.93893f
C193 a_9506_4846.t5 0 2.09336f
C194 a_9506_4846.n2 0 2.35342f
C195 a_9506_4846.t4 0 1.94579f
C196 a_9506_4846.n3 0 1.55659f
C197 a_9506_4846.n4 0 2.26744f
C198 a_6158_3846.t5 0 0.01545f
C199 a_6158_3846.n0 0 0.05818f
C200 a_6158_3846.n1 0 0.24061f
C201 a_6158_3846.t8 0 19.2025f
C202 a_6158_3846.t7 0 0.07869f
C203 a_6158_3846.n2 0 0.15072f
C204 a_6158_3846.t6 0 0.08339f
C205 a_6158_3846.n3 0 0.47838f
C206 a_6158_3846.t0 0 0.06181f
C207 a_6158_3846.t1 0 0.06181f
C208 a_6158_3846.n4 0 0.41441f
C209 a_6158_3846.t2 0 0.01545f
C210 a_6158_3846.t3 0 0.01545f
C211 a_6158_3846.n5 0 0.06233f
C212 a_6158_3846.n6 0 0.15865f
C213 a_6158_3846.t4 0 0.01545f
C214 a_7274_3846.t5 0 0.11459f
C215 a_7274_3846.n0 0 0.43145f
C216 a_7274_3846.t6 0 0.45834f
C217 a_7274_3846.t7 0 0.45834f
C218 a_7274_3846.n1 0 2.80933f
C219 a_7274_3846.n2 0 3.59851f
C220 a_7274_3846.t1 0 0.58353f
C221 a_7274_3846.n3 0 1.15549f
C222 a_7274_3846.t0 0 0.61838f
C223 a_7274_3846.t2 0 0.11459f
C224 a_7274_3846.t3 0 0.11459f
C225 a_7274_3846.n4 0 0.46226f
C226 a_7274_3846.n5 0 1.62115f
C227 a_7274_3846.t4 0 0.11459f
C228 a_6830_446.t2 0 0.21787f
C229 a_6830_446.n0 0 1.48302f
C230 a_6830_446.t0 0 1.20355f
C231 a_6830_446.n1 0 1.54762f
C232 a_6830_446.t5 0 1.24276f
C233 a_6830_446.n2 0 3.83764f
C234 a_6830_446.t7 0 0.21787f
C235 a_6830_446.t6 0 0.21787f
C236 a_6830_446.n3 0 0.90457f
C237 a_6830_446.t4 0 0.21787f
C238 a_6830_446.t3 0 0.21787f
C239 a_6830_446.n4 0 0.8728f
C240 a_6830_446.n5 0 1.95597f
C241 a_6830_446.t1 0 0.21787f
C242 a_5718_446.t2 0 0.11665f
C243 a_5718_446.n0 0 0.84576f
C244 a_5718_446.n1 0 0.97508f
C245 a_5718_446.t4 0 11.2962f
C246 a_5718_446.t3 0 0.6444f
C247 a_5718_446.n2 0 0.73545f
C248 a_5718_446.t0 0 0.66539f
C249 a_5718_446.n3 0 1.79536f
C250 a_5718_446.t6 0 0.11665f
C251 a_5718_446.t5 0 0.11665f
C252 a_5718_446.n4 0 0.48432f
C253 a_5718_446.t8 0 0.11665f
C254 a_5718_446.t7 0 0.11665f
C255 a_5718_446.n5 0 0.46731f
C256 a_5718_446.n6 0 1.00874f
C257 a_5718_446.t1 0 0.11665f
C258 a_7942_446.t0 0 0.07339f
C259 a_7942_446.n0 0 0.84476f
C260 a_7942_446.t10 0 0.47548f
C261 a_7942_446.n1 0 0.4024f
C262 a_7942_446.t8 0 0.4859f
C263 a_7942_446.n2 0 0.80304f
C264 a_7942_446.t11 0 0.47548f
C265 a_7942_446.t9 0 0.49062f
C266 a_7942_446.n3 0 0.82114f
C267 a_7942_446.n4 0 1.53311f
C268 a_7942_446.t6 0 0.47548f
C269 a_7942_446.n5 0 0.4024f
C270 a_7942_446.t4 0 0.4859f
C271 a_7942_446.n6 0 0.80304f
C272 a_7942_446.t7 0 0.47548f
C273 a_7942_446.t5 0 0.49062f
C274 a_7942_446.n7 0 0.82114f
C275 a_7942_446.n8 0 0.58076f
C276 a_7942_446.t3 0 0.59042f
C277 a_7942_446.n9 0 0.89276f
C278 a_7942_446.t2 0 1.23349f
C279 a_7942_446.t1 0 0.07339f
C280 a_9054_446.t1 0 0.08923f
C281 a_9054_446.n0 0 1.23135f
C282 a_9054_446.t2 0 0.64616f
C283 a_9054_446.n1 0 2.40101f
C284 a_9054_446.t0 0 1.52429f
C285 a_9054_446.n2 0 1.36669f
C286 a_9054_446.t5 0 1.09872f
C287 a_9054_446.n3 0 1.3734f
C288 a_9054_446.t6 0 1.09524f
C289 a_9054_446.t4 0 1.11213f
C290 a_9054_446.n4 0 1.32733f
C291 a_9054_446.t3 0 0.08923f
C292 a_15706_3916.t0 0 0.08179f
C293 a_15706_3916.t1 0 0.08179f
C294 a_17150_3916.t0 0 0.07765f
C295 a_17150_3916.t1 0 0.07765f
C296 a_13406_332.t2 0 0.82299f
C297 a_13406_332.t1 0 1.13744f
C298 a_13406_332.n0 0 1.11421f
C299 a_13406_332.t3 0 0.74699f
C300 a_13406_332.n1 0 1.83588f
C301 a_13406_332.t4 0 0.78011f
C302 a_13406_332.t0 0 2.12246f
C303 a_13406_332.n2 0 0.63327f
C304 a_4354_376.t0 0 0.87854f
C305 a_4354_376.t1 0 0.85085f
C306 a_4354_376.n0 0 0.80296f
C307 a_4354_376.n1 0 1.12326f
C308 a_4354_376.t5 0 0.19591f
C309 a_4354_376.t4 0 0.19591f
C310 a_4354_376.t2 0 0.85085f
C311 a_4354_376.n2 0 0.86812f
C312 a_4354_376.t3 0 0.87854f
C313 a_4354_376.n3 0 1.49146f
C314 a_946_376.t0 0 0.03764f
C315 a_946_376.t1 0 0.03764f
C316 a_4054_376.t0 0 0.04378f
C317 a_4054_376.t1 0 0.04378f
C318 a_4686_376.t0 0 0.04684f
C319 a_4686_376.t1 0 0.04684f
C320 a_15914_332.t0 0 0.10711f
C321 a_15914_332.n0 0 0.90493f
C322 a_15914_332.t2 0 0.73924f
C323 a_15914_332.t1 0 0.10711f
C324 a_15070_376.t0 0 0.0469f
C325 a_15070_376.t1 0 0.0469f
C326 a_16114_376.t0 0 0.04647f
C327 a_16114_376.t1 0 0.04647f
C328 INP.t2 0 1.70066f
C329 INP.t3 0 1.57479f
C330 INP.n0 0 2.06712f
C331 INP.t0 0 0.83741f
C332 INP.t1 0 0.87383f
C333 INP.n1 0 1.20069f
C334 VDD.n0 0 0.12975f
C335 VDD.n1 0 0.19753f
C336 VDD.n2 0 0.19753f
C337 VDD.n3 0 0.19664f
C338 VDD.n4 0 0.19753f
C339 VDD.t15 0 0.38961f
C340 VDD.t16 0 0.06829f
C341 VDD.t11 0 0.06829f
C342 VDD.n5 0 0.27359f
C343 VDD.n6 0 0.21914f
C344 VDD.t12 0 0.37727f
C345 VDD.n7 0 0.16025f
C346 VDD.n8 0 0.19753f
C347 VDD.n9 0 0.19753f
C348 VDD.n10 0 0.19753f
C349 VDD.n11 0 0.19753f
C350 VDD.t7 0 0.38669f
C351 VDD.n12 0 0.19669f
C352 VDD.t4 0 0.13659f
C353 VDD.t5 0 0.13659f
C354 VDD.n13 0 0.5662f
C355 VDD.t18 0 0.78501f
C356 VDD.n14 0 0.3236f
C357 VDD.n15 0 1.72708f
C358 VDD.t8 0 0.38669f
C359 VDD.n16 0 0.37987f
C360 VDD.n17 0 0.13965f
C361 VDD.n18 0 1.2521f
C362 VDD.n19 0 0.19753f
C363 VDD.n20 0 0.19753f
C364 VDD.n21 0 0.19753f
C365 VDD.n22 0 0.11975f
C366 VDD.n23 0 0.20841f
C367 VDD.n24 0 0.17689f
C368 VDD.n25 0 0.19753f
C369 VDD.n26 0 0.19753f
C370 VDD.n27 0 0.19753f
C371 VDD.n28 0 0.19753f
C372 VDD.n29 0 0.19685f
C373 VDD.n30 0 0.19316f
C374 VDD.n31 0 0.19753f
C375 VDD.n32 0 0.19753f
C376 VDD.n33 0 0.19753f
C377 VDD.n34 0 0.19753f
C378 VDD.n35 0 0.18051f
C379 VDD.n36 0 0.27123f
C380 VDD.n37 0 0.11583f
C381 VDD.n38 0 0.19753f
C382 VDD.n39 0 0.19753f
C383 VDD.n40 0 0.19753f
C384 VDD.n41 0 0.19753f
C385 VDD.n42 0 0.19753f
C386 VDD.t9 0 0.38961f
C387 VDD.t10 0 0.06829f
C388 VDD.t13 0 0.06829f
C389 VDD.n43 0 0.27359f
C390 VDD.n44 0 0.21914f
C391 VDD.t14 0 0.37727f
C392 VDD.n45 0 0.16025f
C393 VDD.n46 0 0.26824f
C394 VDD.n47 0 0.11526f
C395 VDD.n48 0 0.19753f
C396 VDD.n49 0 0.19753f
C397 VDD.n50 0 0.19753f
C398 VDD.n51 0 0.1972f
C399 VDD.n52 0 0.19753f
C400 VDD.n53 0 0.19574f
C401 VDD.n54 0 0.19753f
C402 VDD.t17 0 0.38669f
C403 VDD.n55 0 0.1415f
C404 VDD.n56 0 0.19753f
C405 VDD.t0 0 0.38669f
C406 VDD.n57 0 0.20961f
C407 VDD.t1 0 0.38669f
C408 VDD.n58 0 0.20842f
C409 VDD.n59 0 0.19753f
C410 VDD.t2 0 0.07209f
C411 VDD.n60 0 0.19753f
C412 VDD.t3 0 0.41698f
C413 VDD.n61 0 0.56497f
C414 VDD.t6 0 0.38669f
C415 VDD.n62 0 0.32444f
C416 VDD.n63 0 0.10557f
C417 VDD.n64 0 0.71758f
C418 VDD.n65 0 0.19753f
C419 VDD.n66 0 0.19753f
C420 VDD.n67 0 0.17412f
C421 VDD.n68 0 0.14176f
C422 VDD.n69 0 0.12637f
C423 VDD.n70 0 0.17311f
C424 VDD.n71 0 0.19753f
C425 VDD.n72 0 0.19753f
C426 VDD.n73 0 0.12353f
C427 VDD.n74 0 0.19753f
C428 VDD.n75 0 0.15899f
C429 VDD.n76 0 0.19753f
C430 VDD.n77 0 0.19753f
C431 VDD.n78 0 0.19753f
C432 VDD.n79 0 0.19753f
C433 VDD.n80 0 0.17554f
C434 VDD.n81 0 0.20961f
C435 VDD.n82 0 0.1217f
C436 VDD.n83 0 0.19753f
C437 VDD.n84 0 0.19753f
C438 VDD.n85 0 0.19753f
C439 VDD.n86 0 0.19753f
C440 VDD.n87 0 0.19753f
C441 VDD.n88 0 0.19753f
C442 VDD.n89 0 0.19753f
C443 VDD.n90 0 0.19753f
C444 VDD.n91 0 0.19753f
C445 VDD.n92 0 0.19281f
C446 VDD.n93 0 0.19753f
C447 VDD.n94 0 0.19753f
C448 VDD.n95 0 0.19753f
C449 VDD.n96 0 0.19753f
C450 VDD.n97 0 0.19753f
C451 VDD.n98 0 0.15639f
C452 INN.t2 0 1.50744f
C453 INN.t3 0 1.39588f
C454 INN.n0 0 1.83227f
C455 INN.t0 0 0.74228f
C456 INN.t1 0 0.77456f
C457 INN.n1 0 1.0994f
C458 OUT.t3 0 0.03803f
C459 OUT.t6 0 0.03803f
C460 OUT.n0 0 0.15764f
C461 OUT.t2 0 0.21856f
C462 OUT.n1 0 0.11659f
C463 OUT.t7 0 13.0841f
C464 OUT.t4 0 1.8414f
C465 OUT.t5 0 0.01901f
C466 OUT.t1 0 0.01901f
C467 OUT.n2 0 0.07825f
C468 OUT.t0 0 0.10481f
C469 OUT.n3 0 0.08952f
C470 OUT.n4 0 0.06056f
C471 OUT.n5 0 0.29695f
C472 VSS.t4 0 0.08715f
C473 VSS.t9 0 0.01614f
C474 VSS.t10 0 0.01614f
C475 VSS.n0 0 0.06079f
C476 VSS.n1 0 0.10033f
C477 VSS.t17 0 0.08222f
C478 VSS.n2 0 0.06113f
C479 VSS.n3 0 0.07716f
C480 VSS.n4 0 0.09339f
C481 VSS.n5 0 0.09339f
C482 VSS.n6 0 0.09339f
C483 VSS.n7 0 0.09339f
C484 VSS.t18 0 0.08715f
C485 VSS.t11 0 0.01614f
C486 VSS.t2 0 0.01614f
C487 VSS.n8 0 0.06079f
C488 VSS.n9 0 0.10033f
C489 VSS.t3 0 0.08222f
C490 VSS.n10 0 0.06113f
C491 VSS.n11 0 0.09339f
C492 VSS.n12 0 0.09339f
C493 VSS.n13 0 0.09339f
C494 VSS.n14 0 0.09339f
C495 VSS.t13 0 0.13661f
C496 VSS.t12 0 0.13661f
C497 VSS.n15 0 0.24741f
C498 VSS.t5 0 0.03229f
C499 VSS.t15 0 0.03229f
C500 VSS.n16 0 0.13288f
C501 VSS.t8 0 0.17799f
C502 VSS.n17 0 0.13407f
C503 VSS.n18 0 1.12656f
C504 VSS.n19 0 0.7134f
C505 VSS.n20 0 0.08635f
C506 VSS.n21 0 0.083f
C507 VSS.n22 0 0.12173f
C508 VSS.n23 0 0.05908f
C509 VSS.n24 0 0.09339f
C510 VSS.n25 0 0.09339f
C511 VSS.n26 0 0.09339f
C512 VSS.n27 0 0.09339f
C513 VSS.n28 0 0.09339f
C514 VSS.n29 0 0.09339f
C515 VSS.n30 0 0.09339f
C516 VSS.n31 0 0.09339f
C517 VSS.n32 0 0.09339f
C518 VSS.n33 0 0.09339f
C519 VSS.n34 0 0.09205f
C520 VSS.n35 0 0.10242f
C521 VSS.n36 0 0.05002f
C522 VSS.n37 0 0.09339f
C523 VSS.n38 0 0.09339f
C524 VSS.n39 0 0.09339f
C525 VSS.n40 0 0.09339f
C526 VSS.n41 0 0.09339f
C527 VSS.n42 0 0.06075f
C528 VSS.n43 0 0.09339f
C529 VSS.n44 0 0.09339f
C530 VSS.n45 0 0.09339f
C531 VSS.n46 0 0.09339f
C532 VSS.n47 0 0.09339f
C533 VSS.n48 0 0.09339f
C534 VSS.t6 0 0.13661f
C535 VSS.n49 0 0.09339f
C536 VSS.n50 0 0.09339f
C537 VSS.t1 0 0.13661f
C538 VSS.t7 0 0.01915f
C539 VSS.n51 0 0.07724f
C540 VSS.n52 0 0.09339f
C541 VSS.t14 0 0.01915f
C542 VSS.n53 0 0.07724f
C543 VSS.n54 0 0.09339f
C544 VSS.t16 0 0.13661f
C545 VSS.n55 0 0.1497f
C546 VSS.t0 0 0.02104f
C547 VSS.n56 0 0.17466f
C548 VSS.n57 0 0.26198f
C549 VSS.n58 0 0.05215f
C550 VSS.n59 0 0.09339f
C551 VSS.n60 0 0.07115f
C552 VSS.n61 0 0.09339f
C553 VSS.n62 0 0.09339f
C554 VSS.n63 0 0.07092f
C555 VSS.n64 0 0.09339f
C556 VSS.n65 0 0.05237f
C557 VSS.n66 0 0.09339f
C558 VSS.n67 0 0.09339f
C559 VSS.n68 0 0.0897f
C560 VSS.n69 0 0.07964f
C561 VSS.n70 0 0.12173f
C562 VSS.n71 0 0.06243f
C563 VSS.n72 0 0.09339f
C564 VSS.n73 0 0.09339f
C565 VSS.n74 0 0.09339f
C566 VSS.n75 0 0.08747f
C567 VSS.n76 0 0.12173f
C568 VSS.n77 0 0.05461f
C569 VSS.n78 0 0.09339f
C570 VSS.n79 0 0.09339f
C571 VSS.n80 0 0.09339f
C572 VSS.n81 0 0.09339f
C573 VSS.n82 0 0.09339f
C574 VSS.n83 0 0.09339f
C575 VSS.n84 0 0.09339f
C576 VSS.n85 0 0.09339f
C577 VSS.n86 0 0.09339f
C578 VSS.n87 0 0.09339f
C579 VSS.n88 0 0.09339f
C580 VSS.n89 0 0.09339f
C581 VSS.n90 0 0.09339f
C582 VSS.n91 0 0.09339f
C583 VSS.n92 0 0.09339f
C584 VSS.n93 0 0.09339f
C585 VSS.n94 0 0.07394f
.ends
