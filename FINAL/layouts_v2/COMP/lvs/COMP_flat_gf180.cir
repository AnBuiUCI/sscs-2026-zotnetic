* Extracted by KLayout with GF180MCU LVS runset on : 29/08/2026 18:10

.SUBCKT COMP INP INN OUT VDD VSS
M$1 \$646 \$22 VDD VDD pfet_06v0 L=1U W=10U AS=4.4P AD=2.5P PS=20.88U PD=10.5U
M$2 \$47 \$26 \$646 VDD pfet_06v0 L=1U W=10U AS=2.5P AD=4.4P PS=10.5U PD=20.88U
M$3 \$664 \$57 VDD VDD pfet_06v0 L=1U W=10U AS=4.4P AD=2.5P PS=20.88U PD=10.5U
M$4 \$57 \$26 \$664 VDD pfet_06v0 L=1U W=10U AS=2.5P AD=3.3P PS=10.5U PD=10.66U
M$5 \$59 \$59 \$57 VDD pfet_06v0 L=1U W=10U AS=3.3P AD=4.4P PS=10.66U PD=20.88U
M$6 \$640 \$22 VDD VDD pfet_06v0 L=1U W=10U AS=4.4P AD=2.5P PS=20.88U PD=10.5U
M$7 \$12 \$26 \$640 VDD pfet_06v0 L=1U W=10U AS=2.5P AD=4.4P PS=10.5U PD=20.88U
M$8 \$659 \$22 VDD VDD pfet_06v0 L=1U W=10U AS=4.4P AD=2.5P PS=20.88U PD=10.5U
M$9 \$22 \$26 \$659 VDD pfet_06v0 L=1U W=10U AS=2.5P AD=4.4P PS=10.5U PD=20.88U
M$10 \$684 \$22 VDD VDD pfet_06v0 L=1U W=10U AS=4.4P AD=2.5P PS=20.88U PD=10.5U
M$11 \$74 \$26 \$684 VDD pfet_06v0 L=1U W=10U AS=2.5P AD=3.3P PS=10.5U PD=10.66U
M$12 \$696 \$26 \$74 VDD pfet_06v0 L=1U W=10U AS=3.3P AD=2.5P PS=10.66U PD=10.5U
M$13 VDD \$22 \$696 VDD pfet_06v0 L=1U W=10U AS=2.5P AD=4.4P PS=10.5U PD=20.88U
M$14 \$643 \$22 VDD VDD pfet_06v0 L=1U W=10U AS=4.4P AD=2.5P PS=20.88U PD=10.5U
M$15 \$16 \$26 \$643 VDD pfet_06v0 L=1U W=10U AS=2.5P AD=4.4P PS=10.5U PD=20.88U
M$16 \$61 \$50 VSS VSS nfet_06v0 L=1U W=5U AS=2.2P AD=1.25P PS=10.88U PD=5.5U
M$17 \$50 \$12 \$61 VSS nfet_06v0 L=1U W=5U AS=1.25P AD=1.65P PS=5.5U PD=5.66U
M$18 \$47 \$47 \$50 VSS nfet_06v0 L=1U W=5U AS=1.65P AD=2.2P PS=5.66U PD=10.88U
M$19 \$56 \$16 VSS VSS nfet_06v0 L=1U W=5U AS=2.2P AD=1.25P PS=10.88U PD=5.5U
M$20 \$59 \$12 \$56 VSS nfet_06v0 L=1U W=5U AS=1.25P AD=2.2P PS=5.5U PD=10.88U
M$21 \$28 \$16 VSS VSS nfet_06v0 L=1U W=5U AS=2.2P AD=1.25P PS=10.88U PD=5.5U
M$22 \$32 \$12 \$28 VSS nfet_06v0 L=1U W=5U AS=1.25P AD=1.65P PS=5.5U PD=5.66U
M$23 \$31 \$12 \$32 VSS nfet_06v0 L=1U W=5U AS=1.65P AD=1.25P PS=5.66U PD=5.5U
M$24 VSS \$16 \$31 VSS nfet_06v0 L=1U W=5U AS=1.25P AD=2.2P PS=5.5U PD=10.88U
M$25 \$21 \$26 VSS VSS nfet_06v0 L=1U W=1U AS=0.44P AD=0.25P PS=2.88U PD=1.5U
M$26 \$22 \$26 \$21 VSS nfet_06v0 L=1U W=1U AS=0.25P AD=0.44P PS=1.5U PD=2.88U
M$27 \$15 \$16 VSS VSS nfet_06v0 L=1U W=5U AS=2.2P AD=1.25P PS=10.88U PD=5.5U
M$28 \$16 \$12 \$15 VSS nfet_06v0 L=1U W=5U AS=1.25P AD=2.2P PS=5.5U PD=10.88U
M$29 \$23 \$26 VSS VSS nfet_06v0 L=1U W=1U AS=0.44P AD=0.25P PS=2.88U PD=1.5U
M$30 \$26 \$26 \$23 VSS nfet_06v0 L=1U W=1U AS=0.25P AD=0.44P PS=1.5U PD=2.88U
C$31 OUT \$8 4e-13 cap_mim_2f0fF A=200P P=60U
C$32 \$180 OUT 4e-13 cap_mim_2f0fF A=200P P=60U
M$33 \$78 \$195 VSS VSS nfet_06v0 L=1U W=2.5U AS=1.1P AD=0.65P PS=5.88U PD=3.02U
M$34 VSS \$195 \$78 VSS nfet_06v0 L=1U W=2.5U AS=0.65P AD=0.65P PS=3.02U
+ PD=3.02U
M$35 \$78 \$195 VSS VSS nfet_06v0 L=1U W=2.5U AS=0.65P AD=0.65P PS=3.02U
+ PD=3.02U
M$36 VSS \$195 \$78 VSS nfet_06v0 L=1U W=2.5U AS=0.65P AD=1.1P PS=3.02U PD=5.88U
M$37 \$64 \$47 \$195 VSS nfet_06v0 L=1U W=2.5U AS=1.1P AD=1.1P PS=5.88U PD=5.88U
M$38 \$8 \$195 VSS VSS nfet_06v0 L=1U W=2.5U AS=1.1P AD=0.65P PS=5.88U PD=3.02U
M$39 VSS \$195 \$8 VSS nfet_06v0 L=1U W=2.5U AS=0.65P AD=0.65P PS=3.02U PD=3.02U
M$40 \$8 \$195 VSS VSS nfet_06v0 L=1U W=2.5U AS=0.65P AD=0.65P PS=3.02U PD=3.02U
M$41 VSS \$195 \$8 VSS nfet_06v0 L=1U W=2.5U AS=0.65P AD=1.1P PS=3.02U PD=5.88U
M$42 OUT \$135 VSS VSS nfet_06v0 L=1U W=5U AS=2.2P AD=1.3P PS=10.88U PD=5.52U
M$43 VSS \$135 OUT VSS nfet_06v0 L=1U W=5U AS=1.3P AD=1.3P PS=5.52U PD=5.52U
M$44 OUT \$135 VSS VSS nfet_06v0 L=1U W=5U AS=1.3P AD=2.2P PS=5.52U PD=10.88U
M$45 \$130 \$47 \$135 VSS nfet_06v0 L=1U W=2.5U AS=1.1P AD=1.1P PS=5.88U
+ PD=5.88U
M$46 \$195 \$12 \$78 VSS nfet_06v0 L=1U W=2.5U AS=1.1P AD=0.65P PS=5.88U
+ PD=3.02U
M$47 \$78 \$12 \$195 VSS nfet_06v0 L=1U W=2.5U AS=0.65P AD=1.1P PS=3.02U
+ PD=5.88U
M$48 \$12 \$12 VSS VSS nfet_06v0 L=1U W=1U AS=0.44P AD=0.44P PS=2.88U PD=2.88U
M$49 \$77 INN \$32 VSS nfet_06v0 L=1U W=5U AS=2.2P AD=1.3P PS=10.88U PD=5.52U
M$50 \$32 INN \$77 VSS nfet_06v0 L=1U W=5U AS=1.3P AD=2.2P PS=5.52U PD=10.88U
M$51 \$180 INP \$32 VSS nfet_06v0 L=1U W=5U AS=2.2P AD=1.3P PS=10.88U PD=5.52U
M$52 \$32 INP \$180 VSS nfet_06v0 L=1U W=5U AS=1.3P AD=2.2P PS=5.52U PD=10.88U
M$53 \$26 \$26 VDD VDD pfet_06v0 L=1U W=2U AS=0.88P AD=0.88P PS=4.88U PD=4.88U
M$54 \$78 INN \$74 VDD pfet_06v0 L=1U W=10U AS=4.4P AD=2.6P PS=20.88U PD=10.52U
M$55 \$74 INN \$78 VDD pfet_06v0 L=1U W=10U AS=2.6P AD=4.4P PS=10.52U PD=20.88U
M$56 \$8 INP \$74 VDD pfet_06v0 L=1U W=10U AS=4.4P AD=2.6P PS=20.88U PD=10.52U
M$57 \$74 INP \$8 VDD pfet_06v0 L=1U W=10U AS=2.6P AD=4.4P PS=10.52U PD=20.88U
M$58 \$64 \$26 \$77 VDD pfet_06v0 L=1U W=5U AS=2.2P AD=1.3P PS=10.88U PD=5.52U
M$59 \$77 \$26 \$64 VDD pfet_06v0 L=1U W=5U AS=1.3P AD=2.2P PS=5.52U PD=10.88U
M$60 OUT \$130 VDD VDD pfet_06v0 L=1U W=10U AS=4.4P AD=2.6P PS=20.88U PD=10.52U
M$61 VDD \$130 OUT VDD pfet_06v0 L=1U W=10U AS=2.6P AD=2.6P PS=10.52U PD=10.52U
M$62 OUT \$130 VDD VDD pfet_06v0 L=1U W=10U AS=2.6P AD=4.4P PS=10.52U PD=20.88U
M$63 \$135 \$59 \$130 VDD pfet_06v0 L=1U W=5U AS=2.2P AD=2.2P PS=10.88U
+ PD=10.88U
M$64 \$195 \$59 \$64 VDD pfet_06v0 L=1U W=5U AS=2.2P AD=2.2P PS=10.88U PD=10.88U
M$65 \$180 \$64 VDD VDD pfet_06v0 L=1U W=5U AS=2.2P AD=1.3P PS=10.88U PD=5.52U
M$66 VDD \$64 \$180 VDD pfet_06v0 L=1U W=5U AS=1.3P AD=1.3P PS=5.52U PD=5.52U
M$67 \$180 \$64 VDD VDD pfet_06v0 L=1U W=5U AS=1.3P AD=1.3P PS=5.52U PD=5.52U
M$68 VDD \$64 \$180 VDD pfet_06v0 L=1U W=5U AS=1.3P AD=2.2P PS=5.52U PD=10.88U
M$69 \$77 \$64 VDD VDD pfet_06v0 L=1U W=5U AS=2.2P AD=1.3P PS=10.88U PD=5.52U
M$70 VDD \$64 \$77 VDD pfet_06v0 L=1U W=5U AS=1.3P AD=1.3P PS=5.52U PD=5.52U
M$71 \$77 \$64 VDD VDD pfet_06v0 L=1U W=5U AS=1.3P AD=1.3P PS=5.52U PD=5.52U
M$72 VDD \$64 \$77 VDD pfet_06v0 L=1U W=5U AS=1.3P AD=2.2P PS=5.52U PD=10.88U
M$73 \$130 \$26 \$180 VDD pfet_06v0 L=1U W=5U AS=2.2P AD=1.3P PS=10.88U PD=5.52U
M$74 \$180 \$26 \$130 VDD pfet_06v0 L=1U W=5U AS=1.3P AD=2.2P PS=5.52U PD=10.88U
M$75 \$135 \$12 \$8 VSS nfet_06v0 L=1U W=2.5U AS=1.1P AD=0.65P PS=5.88U PD=3.02U
M$76 \$8 \$12 \$135 VSS nfet_06v0 L=1U W=2.5U AS=0.65P AD=1.1P PS=3.02U PD=5.88U
.ENDS COMP
