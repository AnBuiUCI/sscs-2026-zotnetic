* Extracted by KLayout with GF180MCU LVS runset on : 29/08/2026 10:31

.SUBCKT COMP INP INN OUT VDD VSS
M$1 \$646 \$22 VDD VDD pfet_06v0 L=1U W=10U AS=4.4P AD=2.5P PS=20.88U PD=10.5U
M$2 \$57 \$26 \$646 VDD pfet_06v0 L=1U W=10U AS=2.5P AD=4.4P PS=10.5U PD=20.88U
M$3 \$664 \$55 VDD VDD pfet_06v0 L=1U W=10U AS=4.4P AD=2.5P PS=20.88U PD=10.5U
M$4 \$55 \$26 \$664 VDD pfet_06v0 L=1U W=10U AS=2.5P AD=3.3P PS=10.5U PD=10.66U
M$5 \$44 \$44 \$55 VDD pfet_06v0 L=1U W=10U AS=3.3P AD=4.4P PS=10.66U PD=20.88U
M$6 \$640 \$22 VDD VDD pfet_06v0 L=1U W=10U AS=4.4P AD=2.5P PS=20.88U PD=10.5U
M$7 \$12 \$26 \$640 VDD pfet_06v0 L=1U W=10U AS=2.5P AD=4.4P PS=10.5U PD=20.88U
M$8 \$659 \$22 VDD VDD pfet_06v0 L=1U W=10U AS=4.4P AD=2.5P PS=20.88U PD=10.5U
M$9 \$22 \$26 \$659 VDD pfet_06v0 L=1U W=10U AS=2.5P AD=4.4P PS=10.5U PD=20.88U
M$10 \$685 \$22 VDD VDD pfet_06v0 L=1U W=10U AS=4.4P AD=2.5P PS=20.88U PD=10.5U
M$11 \$74 \$26 \$685 VDD pfet_06v0 L=1U W=10U AS=2.5P AD=3.3P PS=10.5U PD=10.66U
M$12 \$696 \$26 \$74 VDD pfet_06v0 L=1U W=10U AS=3.3P AD=2.5P PS=10.66U PD=10.5U
M$13 VDD \$22 \$696 VDD pfet_06v0 L=1U W=10U AS=2.5P AD=4.4P PS=10.5U PD=20.88U
M$14 \$643 \$22 VDD VDD pfet_06v0 L=1U W=10U AS=4.4P AD=2.5P PS=20.88U PD=10.5U
M$15 \$16 \$26 \$643 VDD pfet_06v0 L=1U W=10U AS=2.5P AD=4.4P PS=10.5U PD=20.88U
M$16 \$52 \$53 VSS VSS nfet_06v0 L=1U W=5U AS=2.2P AD=1.25P PS=10.88U PD=5.5U
M$17 \$53 \$12 \$52 VSS nfet_06v0 L=1U W=5U AS=1.25P AD=1.65P PS=5.5U PD=5.66U
M$18 \$57 \$57 \$53 VSS nfet_06v0 L=1U W=5U AS=1.65P AD=2.2P PS=5.66U PD=10.88U
M$19 \$46 \$16 VSS VSS nfet_06v0 L=1U W=5U AS=2.2P AD=1.25P PS=10.88U PD=5.5U
M$20 \$44 \$12 \$46 VSS nfet_06v0 L=1U W=5U AS=1.25P AD=2.2P PS=5.5U PD=10.88U
M$21 \$32 \$16 VSS VSS nfet_06v0 L=1U W=5U AS=2.2P AD=1.25P PS=10.88U PD=5.5U
M$22 \$28 \$12 \$32 VSS nfet_06v0 L=1U W=5U AS=1.25P AD=1.65P PS=5.5U PD=5.66U
M$23 \$36 \$12 \$28 VSS nfet_06v0 L=1U W=5U AS=1.65P AD=1.25P PS=5.66U PD=5.5U
M$24 VSS \$16 \$36 VSS nfet_06v0 L=1U W=5U AS=1.25P AD=2.2P PS=5.5U PD=10.88U
M$25 \$21 \$26 VSS VSS nfet_06v0 L=1U W=1U AS=0.44P AD=0.25P PS=2.88U PD=1.5U
M$26 \$22 \$26 \$21 VSS nfet_06v0 L=1U W=1U AS=0.25P AD=0.44P PS=1.5U PD=2.88U
M$27 \$17 \$16 VSS VSS nfet_06v0 L=1U W=5U AS=2.2P AD=1.25P PS=10.88U PD=5.5U
M$28 \$16 \$12 \$17 VSS nfet_06v0 L=1U W=5U AS=1.25P AD=2.2P PS=5.5U PD=10.88U
M$29 \$23 \$26 VSS VSS nfet_06v0 L=1U W=1U AS=0.44P AD=0.25P PS=2.88U PD=1.5U
M$30 \$26 \$26 \$23 VSS nfet_06v0 L=1U W=1U AS=0.25P AD=0.44P PS=1.5U PD=2.88U
C$31 OUT \$9 4e-13 cap_mim_2f0fF A=200P P=60U
C$32 \$180 OUT 4e-13 cap_mim_2f0fF A=200P P=60U
M$33 \$9 \$197 VSS VSS nfet_06v0 L=1U W=2.5U AS=1.1P AD=0.65P PS=5.88U PD=3.02U
M$34 VSS \$197 \$9 VSS nfet_06v0 L=1U W=2.5U AS=0.65P AD=0.65P PS=3.02U PD=3.02U
M$35 \$9 \$197 VSS VSS nfet_06v0 L=1U W=2.5U AS=0.65P AD=0.65P PS=3.02U PD=3.02U
M$36 VSS \$197 \$9 VSS nfet_06v0 L=1U W=2.5U AS=0.65P AD=1.1P PS=3.02U PD=5.88U
M$37 \$79 \$197 VSS VSS nfet_06v0 L=1U W=2.5U AS=1.1P AD=0.65P PS=5.88U PD=3.02U
M$38 VSS \$197 \$79 VSS nfet_06v0 L=1U W=2.5U AS=0.65P AD=0.65P PS=3.02U
+ PD=3.02U
M$39 \$79 \$197 VSS VSS nfet_06v0 L=1U W=2.5U AS=0.65P AD=0.65P PS=3.02U
+ PD=3.02U
M$40 VSS \$197 \$79 VSS nfet_06v0 L=1U W=2.5U AS=0.65P AD=1.1P PS=3.02U PD=5.88U
M$41 \$64 \$57 \$197 VSS nfet_06v0 L=1U W=2.5U AS=1.1P AD=1.1P PS=5.88U PD=5.88U
M$42 \$130 \$57 \$134 VSS nfet_06v0 L=1U W=2.5U AS=1.1P AD=1.1P PS=5.88U
+ PD=5.88U
M$43 OUT \$134 VSS VSS nfet_06v0 L=1U W=5U AS=2.2P AD=1.3P PS=10.88U PD=5.52U
M$44 VSS \$134 OUT VSS nfet_06v0 L=1U W=5U AS=1.3P AD=1.3P PS=5.52U PD=5.52U
M$45 OUT \$134 VSS VSS nfet_06v0 L=1U W=5U AS=1.3P AD=2.2P PS=5.52U PD=10.88U
M$46 \$197 \$12 \$79 VSS nfet_06v0 L=1U W=2.5U AS=1.1P AD=0.65P PS=5.88U
+ PD=3.02U
M$47 \$79 \$12 \$197 VSS nfet_06v0 L=1U W=2.5U AS=0.65P AD=1.1P PS=3.02U
+ PD=5.88U
M$48 \$12 \$12 VSS VSS nfet_06v0 L=1U W=1U AS=0.44P AD=0.44P PS=2.88U PD=2.88U
M$49 \$180 INP \$28 VSS nfet_06v0 L=1U W=5U AS=2.2P AD=1.3P PS=10.88U PD=5.52U
M$50 \$28 INP \$180 VSS nfet_06v0 L=1U W=5U AS=1.3P AD=2.2P PS=5.52U PD=10.88U
M$51 \$78 INN \$28 VSS nfet_06v0 L=1U W=5U AS=2.2P AD=1.3P PS=10.88U PD=5.52U
M$52 \$28 INN \$78 VSS nfet_06v0 L=1U W=5U AS=1.3P AD=2.2P PS=5.52U PD=10.88U
M$53 \$26 \$26 VDD VDD pfet_06v0 L=1U W=2U AS=0.88P AD=0.88P PS=4.88U PD=4.88U
M$54 \$79 INN \$74 VDD pfet_06v0 L=1U W=10U AS=4.4P AD=2.6P PS=20.88U PD=10.52U
M$55 \$74 INN \$79 VDD pfet_06v0 L=1U W=10U AS=2.6P AD=4.4P PS=10.52U PD=20.88U
M$56 \$9 INP \$74 VDD pfet_06v0 L=1U W=10U AS=4.4P AD=2.6P PS=20.88U PD=10.52U
M$57 \$74 INP \$9 VDD pfet_06v0 L=1U W=10U AS=2.6P AD=4.4P PS=10.52U PD=20.88U
M$58 \$64 \$26 \$78 VDD pfet_06v0 L=1U W=5U AS=2.2P AD=1.3P PS=10.88U PD=5.52U
M$59 \$78 \$26 \$64 VDD pfet_06v0 L=1U W=5U AS=1.3P AD=2.2P PS=5.52U PD=10.88U
M$60 OUT \$130 VDD VDD pfet_06v0 L=1U W=10U AS=4.4P AD=2.6P PS=20.88U PD=10.52U
M$61 VDD \$130 OUT VDD pfet_06v0 L=1U W=10U AS=2.6P AD=2.6P PS=10.52U PD=10.52U
M$62 OUT \$130 VDD VDD pfet_06v0 L=1U W=10U AS=2.6P AD=4.4P PS=10.52U PD=20.88U
M$63 \$134 \$44 \$130 VDD pfet_06v0 L=1U W=5U AS=2.2P AD=2.2P PS=10.88U
+ PD=10.88U
M$64 \$197 \$44 \$64 VDD pfet_06v0 L=1U W=5U AS=2.2P AD=2.2P PS=10.88U PD=10.88U
M$65 \$180 \$64 VDD VDD pfet_06v0 L=1U W=5U AS=2.2P AD=1.3P PS=10.88U PD=5.52U
M$66 VDD \$64 \$180 VDD pfet_06v0 L=1U W=5U AS=1.3P AD=1.3P PS=5.52U PD=5.52U
M$67 \$180 \$64 VDD VDD pfet_06v0 L=1U W=5U AS=1.3P AD=1.3P PS=5.52U PD=5.52U
M$68 VDD \$64 \$180 VDD pfet_06v0 L=1U W=5U AS=1.3P AD=2.2P PS=5.52U PD=10.88U
M$69 \$78 \$64 VDD VDD pfet_06v0 L=1U W=5U AS=2.2P AD=1.3P PS=10.88U PD=5.52U
M$70 VDD \$64 \$78 VDD pfet_06v0 L=1U W=5U AS=1.3P AD=1.3P PS=5.52U PD=5.52U
M$71 \$78 \$64 VDD VDD pfet_06v0 L=1U W=5U AS=1.3P AD=1.3P PS=5.52U PD=5.52U
M$72 VDD \$64 \$78 VDD pfet_06v0 L=1U W=5U AS=1.3P AD=2.2P PS=5.52U PD=10.88U
M$73 \$130 \$26 \$180 VDD pfet_06v0 L=1U W=5U AS=2.2P AD=1.3P PS=10.88U PD=5.52U
M$74 \$180 \$26 \$130 VDD pfet_06v0 L=1U W=5U AS=1.3P AD=2.2P PS=5.52U PD=10.88U
M$75 \$134 \$12 \$9 VSS nfet_06v0 L=1U W=2.5U AS=1.1P AD=0.65P PS=5.88U PD=3.02U
M$76 \$9 \$12 \$134 VSS nfet_06v0 L=1U W=2.5U AS=0.65P AD=1.1P PS=3.02U PD=5.88U
.ENDS COMP
