* Nodos de bulk atados: 10 de pozo n -> VDD, 11 de sustrato -> VSS.
*   magic no extrae los taps de este layout y los dejaba flotando;
*   la conexion si existe (el LVS de KLayout da 'match uniquely').
*   Quien detecta un tap que falte de verdad es el LVS, no esto.
* NGSPICE file created from DECODER.ext - technology: gf180mcuD

.subckt DECODER_V2 VSS VDD YZ Z XY XZ Y X
X0 a_278_2052.t1 YZ.t3 Z.t0 VDD pfet_06v0 ad=0.75p pd=3.5u as=1.32p ps=6.88u w=3u l=1u
X1 VDD.t0 XZ.t2 a_3598_332.t1 VDD pfet_06v0 ad=1.32p pd=6.88u as=0.99p ps=3.66u w=3u l=1u
X2 VSS.t1 a_1834_332.t3 Y.t0 VSS nfet_06v0 ad=0.44p pd=2.88u as=0.44p ps=2.88u w=1u l=1u
X3 a_3598_332.t2 XY.t2 VDD.t2 VDD pfet_06v0 ad=0.99p pd=3.66u as=1.32p ps=6.88u w=3u l=1u
X4 a_1014_376.t0 XY.t3 VDD.t5 VDD pfet_06v0 ad=1.32p pd=6.88u as=1.32p ps=6.88u w=3u l=1u
X5 a_4530_376.t0 XZ.t0 a_3598_332.t0 VSS nfet_06v0 ad=0.25p pd=1.5u as=0.44p ps=2.88u w=1u l=1u
X6 VSS.t4 XY.t0 a_4530_376.t1 VSS nfet_06v0 ad=0.44p pd=2.88u as=0.25p ps=1.5u w=1u l=1u
X7 a_2766_376.t0 a_1014_376.t2 a_1834_332.t0 VSS nfet_06v0 ad=0.25p pd=1.5u as=0.44p ps=2.88u w=1u l=1u
X8 X.t1 a_3598_332.t4 VDD.t6 VDD pfet_06v0 ad=1.32p pd=6.88u as=1.32p ps=6.88u w=3u l=1u
X9 VDD.t1 XZ.t3 a_278_2052.t0 VDD pfet_06v0 ad=1.32p pd=6.88u as=0.75p ps=3.5u w=3u l=1u
X10 VSS.t3 YZ.t0 a_2766_376.t1 VSS nfet_06v0 ad=0.44p pd=2.88u as=0.25p ps=1.5u w=1u l=1u
X11 Z.t2 YZ.t1 VSS.t6 VSS nfet_06v0 ad=0.33p pd=1.66u as=0.44p ps=2.88u w=1u l=1u
X12 VDD.t4 a_1014_376.t3 a_1834_332.t1 VDD pfet_06v0 ad=1.32p pd=6.88u as=0.99p ps=3.66u w=3u l=1u
X13 VSS.t2 XY.t1 a_1014_376.t1 VSS nfet_06v0 ad=0.44p pd=2.88u as=0.44p ps=2.88u w=1u l=1u
X14 a_1834_332.t2 YZ.t2 VDD.t3 VDD pfet_06v0 ad=0.99p pd=3.66u as=1.32p ps=6.88u w=3u l=1u
X15 VSS.t0 a_3598_332.t3 X.t0 VSS nfet_06v0 ad=0.44p pd=2.88u as=0.44p ps=2.88u w=1u l=1u
X16 Y.t1 a_1834_332.t4 VDD.t7 VDD pfet_06v0 ad=1.32p pd=6.88u as=1.32p ps=6.88u w=3u l=1u
X17 VSS.t5 XZ.t1 Z.t1 VSS nfet_06v0 ad=0.44p pd=2.88u as=0.33p ps=1.66u w=1u l=1u
R0 VSS.n13 VSS.n10 9.0005
R1 VSS.n15 VSS.n14 9.0005
R2 VSS.n17 VSS.n8 9.0005
R3 VSS.n19 VSS.n18 9.0005
R4 VSS.n20 VSS.n1 9.0005
R5 VSS.n22 VSS.n21 9.0005
R6 VSS.n7 VSS.n0 9.0005
R7 VSS.n6 VSS.n5 9.0005
R8 VSS.n2 VSS.t4 5.4494
R9 VSS.n12 VSS.t6 5.3806
R10 VSS.n3 VSS.t0 5.28916
R11 VSS.n4 VSS.t3 5.28916
R12 VSS.n9 VSS.t1 5.28916
R13 VSS.n16 VSS.t2 5.28916
R14 VSS.n11 VSS.t5 5.28916
R15 VSS.n13 VSS.n12 4.71005
R16 VSS.n6 VSS.n2 1.93597
R17 VSS.n3 VSS.n2 0.339601
R18 VSS.n12 VSS.n11 0.243277
R19 VSS.n7 VSS.n6 0.2005
R20 VSS.n21 VSS.n7 0.2005
R21 VSS.n21 VSS.n20 0.2005
R22 VSS.n20 VSS.n19 0.2005
R23 VSS.n19 VSS.n8 0.2005
R24 VSS.n14 VSS.n8 0.2005
R25 VSS.n14 VSS.n13 0.2005
R26 VSS.n22 VSS.n1 0.2005
R27 VSS.n18 VSS.n17 0.2005
R28 VSS.n15 VSS.n10 0.2005
R29 VSS.n5 VSS.n4 0.199
R30 VSS VSS.n22 0.1735
R31 VSS.n5 VSS.n3 0.168
R32 VSS.n16 VSS.n15 0.12
R33 VSS.n9 VSS.n1 0.115
R34 VSS.n18 VSS.n9 0.086
R35 VSS.n17 VSS.n16 0.081
R36 VSS.n11 VSS.n10 0.047
R37 VSS VSS.n0 0.0275
R38 VSS.n4 VSS.n0 0.002
R39 X X.t0 16.3901
R40 X X.t1 3.57145
R41 Y Y.t0 16.753
R42 Y Y.t1 2.85559
R43 VDD.n19 VDD.n15 9.0005
R44 VDD.n21 VDD.n20 9.0005
R45 VDD.n22 VDD.n1 9.0005
R46 VDD.n24 VDD.n23 9.0005
R47 VDD.n14 VDD.n0 9.0005
R48 VDD.n13 VDD.n12 9.0005
R49 VDD.n10 VDD.n2 9.0005
R50 VDD.n8 VDD.n7 9.0005
R51 VDD.n6 VDD.n3 9.0005
R52 VDD.n6 VDD.n5 3.2708
R53 VDD.n17 VDD.n15 2.61743
R54 VDD.n5 VDD.t0 2.30526
R55 VDD.n17 VDD.t1 2.28068
R56 VDD.n18 VDD.t5 2.20347
R57 VDD.n16 VDD.t7 2.20347
R58 VDD.n25 VDD.t3 2.20347
R59 VDD.n11 VDD.t4 2.20347
R60 VDD.n9 VDD.t6 2.20347
R61 VDD.n4 VDD.t2 2.20347
R62 VDD.n18 VDD.n17 0.26254
R63 VDD.n5 VDD.n4 0.231998
R64 VDD.n7 VDD.n6 0.2005
R65 VDD.n7 VDD.n2 0.2005
R66 VDD.n13 VDD.n2 0.2005
R67 VDD.n14 VDD.n13 0.2005
R68 VDD.n23 VDD.n14 0.2005
R69 VDD.n23 VDD.n22 0.2005
R70 VDD.n22 VDD.n21 0.2005
R71 VDD.n21 VDD.n15 0.2005
R72 VDD.n8 VDD.n3 0.2005
R73 VDD.n12 VDD.n0 0.2005
R74 VDD.n24 VDD.n1 0.2005
R75 VDD.n20 VDD.n19 0.2005
R76 VDD.n11 VDD.n10 0.1425
R77 VDD.n25 VDD.n24 0.1235
R78 VDD.n4 VDD.n3 0.1135
R79 VDD.n9 VDD.n8 0.1055
R80 VDD.n20 VDD.n16 0.1055
R81 VDD.n19 VDD.n18 0.1015
R82 VDD.n10 VDD.n9 0.0955
R83 VDD.n16 VDD.n1 0.0955
R84 VDD.n12 VDD.n11 0.0585
R85 VDD VDD.n25 0.0505
R86 VDD VDD.n0 0.0275
R87 Z Z.n0 25.5012
R88 Z Z.t0 3.81799
R89 Z.n0 Z.t1 2.0795
R90 Z.n0 Z.t2 2.0795
R91 XY.n0 XY.t2 24.3172
R92 XY XY.t3 19.2113
R93 XY.n1 XY.t1 16.5982
R94 XY.n0 XY.t0 16.153
R95 XY XY.n1 4.5005
R96 XY.n1 XY.n0 4.41902
R97 XZ.n0 XZ.t2 25.8494
R98 XZ XZ.t3 19.9441
R99 XZ.n1 XZ.t1 15.8165
R100 XZ.n0 XZ.t0 15.6365
R101 XZ.n1 XZ.n0 5.16924
R102 XZ XZ.n1 4.5005
R103 YZ.n0 YZ.t2 24.2283
R104 YZ YZ.t3 19.5108
R105 YZ.n1 YZ.t1 16.116
R106 YZ.n0 YZ.t0 15.8947
R107 YZ YZ.n1 4.5005
R108 YZ.n1 YZ.n0 4.33657
R109 a_4530_376.t0 a_4530_376.t1 3.1505
R110 a_2766_376.t0 a_2766_376.t1 3.1505
R111 a_278_2052.t0 a_278_2052.t1 1.16717
R112 a_3598_332.t0 a_3598_332.n2 10.9319
R113 a_3598_332.n2 a_3598_332.n0 0.1805
R114 a_3598_332.n0 a_3598_332.n1 17.361
R115 a_3598_332.n1 a_3598_332.t2 0.7705
R116 a_3598_332.n1 a_3598_332.t1 0.7705
R117 a_3598_332.n0 a_3598_332.t4 23.6418
R118 a_3598_332.n2 a_3598_332.t3 17.2518
R119 a_1014_376.t1 a_1014_376.n0 12.4603
R120 a_1014_376.n0 a_1014_376.n1 1.57229
R121 a_1014_376.n1 a_1014_376.t3 24.2109
R122 a_1014_376.n1 a_1014_376.t2 16.9278
R123 a_1014_376.n0 a_1014_376.t0 7.09733
R124 a_1834_332.t0 a_1834_332.n2 10.9554
R125 a_1834_332.n2 a_1834_332.n1 17.1938
R126 a_1834_332.n1 a_1834_332.t2 0.7705
R127 a_1834_332.n1 a_1834_332.t1 0.7705
R128 a_1834_332.n2 a_1834_332.n0 0.267286
R129 a_1834_332.n0 a_1834_332.t3 16.985
R130 a_1834_332.n0 a_1834_332.t4 23.453
R131 VDD VDD 319.183
R132 VDD VDD 235.85
R133 VDD VDD 802.673
R134 VDD VDD 638.365
R135 VDD VDD 657.234
R136 VDD VDD 261.007
R137 VDD VDD 638.365
R138 VDD VDD 657.234
R139 VDD VDD 261.007
R140 VSS VSS 677.393
R141 VSS VSS 614.466
R142 VSS VSS 1354.78
R143 VSS VSS 1354.78
R144 VSS VSS 1354.78
R145 VSS VSS 555.24
R146 VSS VSS 1354.78
R147 VSS VSS 1354.78
R148 VSS VSS 555.24
C0 XZ VDD 0.25411f
C1 X XY 0.61615f
C2 VSS YZ 0.16967f
C3 XZ YZ 1.44431f
C4 Y XY 0.23749f
C5 X VDD 0.19907f
C6 XZ VSS 0.47416f
C7 XY VDD 0.3548f
C8 Z VDD 0.07618f
C9 Y VDD 0.21501f
C10 X YZ 0.0622f
C11 XY YZ 0.87985f
C12 Z YZ 0.78734f
C13 X VSS 0.09621f
C14 X XZ 0.55986f
C15 XY VSS 0.1703f
C16 Y YZ 0.04757f
C17 Z VSS 0.14406f
C18 XY XZ 0.93243f
C19 Z XZ 0.27165f
C20 Y VSS 0.08579f
C21 Y XZ 0.07839f
C22 VDD YZ 0.20004f
C23 VSS 0 5.76734f
C24 X 0 1.59965f
C25 Y 0 1.53267f
C26 VDD 0 3.44846f
C27 Z 0 1.21037f
C28 XY 0 2.13788f
C29 XZ 0 2.7381f
C30 YZ 0 2.03217f
C31 VDD 0 0.22344f
C32 VDD 0 0.38855f
C33 VDD 0 0.72702f
C34 VDD 0 1.0088f
C35 VDD 0 0.90698f
C36 VDD 0 0.64281f
C37 VDD 0 0.6296f
C38 VDD 0 0.90698f
C39 VDD 0 0.64281f
C40 VDD 0 0.6296f
C41 a_1834_332.t0 0 0.2334f
C42 a_1834_332.t4 0 0.77957f
C43 a_1834_332.n0 0 0.88578f
C44 a_1834_332.t3 0 0.41355f
C45 a_1834_332.n1 0 0.80961f
C46 a_1834_332.t2 0 0.13175f
C47 a_1834_332.t1 0 0.13175f
C48 a_1834_332.n2 0 0.74493f
C49 a_1014_376.t1 0 0.28587f
C50 a_1014_376.t0 0 0.632f
C51 a_1014_376.n0 0 0.72446f
C52 a_1014_376.t2 0 0.41162f
C53 a_1014_376.n1 0 1.12374f
C54 a_1014_376.t3 0 0.74753f
C55 a_3598_332.t0 0 0.21869f
C56 a_3598_332.t3 0 0.38163f
C57 a_3598_332.t4 0 0.70874f
C58 a_3598_332.n0 0 0.92011f
C59 a_3598_332.n1 0 0.7392f
C60 a_3598_332.t2 0 0.11949f
C61 a_3598_332.t1 0 0.11949f
C62 a_3598_332.n2 0 0.62492f
C63 a_278_2052.t0 0 0.02652f
C64 a_278_2052.t1 0 0.02652f
C65 a_2766_376.t0 0 0.01073f
C66 a_2766_376.t1 0 0.01073f
C67 YZ.t3 0 0.69891f
C68 YZ.t2 0 0.80975f
C69 YZ.t0 0 0.3707f
C70 YZ.n0 0 1.29323f
C71 YZ.t1 0 0.37401f
C72 YZ.n1 0 0.80921f
C73 XZ.t3 0 0.55506f
C74 XZ.t2 0 0.67375f
C75 XZ.t0 0 0.27858f
C76 XZ.n0 0 2.07433f
C77 XZ.t1 0 0.28091f
C78 XZ.n1 0 1.15956f
C79 XY.t3 0 0.69294f
C80 XY.t2 0 0.80702f
C81 XY.t0 0 0.38656f
C82 XY.n0 0 2.04362f
C83 XY.t1 0 0.39578f
C84 XY.n1 0 1.51237f
C85 Z.t0 0 0.49319f
C86 Z.t1 0 0.03604f
C87 Z.t2 0 0.03604f
C88 Z.n0 0 0.27004f
C89 VDD.n0 0 0.08028f
C90 VDD.t3 0 0.07671f
C91 VDD.n1 0 0.10243f
C92 VDD.n2 0 0.13702f
C93 VDD.t4 0 0.07671f
C94 VDD.t6 0 0.07671f
C95 VDD.n3 0 0.10531f
C96 VDD.t2 0 0.07671f
C97 VDD.n4 0 0.17302f
C98 VDD.t0 0 0.09309f
C99 VDD.n5 0 0.44693f
C100 VDD.n6 0 0.57734f
C101 VDD.n7 0 0.13702f
C102 VDD.n8 0 0.10554f
C103 VDD.n9 0 0.1048f
C104 VDD.n10 0 0.08356f
C105 VDD.n11 0 0.1048f
C106 VDD.n12 0 0.09045f
C107 VDD.n13 0 0.13702f
C108 VDD.n14 0 0.13702f
C109 VDD.n15 0 0.60666f
C110 VDD.t7 0 0.07671f
C111 VDD.n16 0 0.1048f
C112 VDD.t5 0 0.07671f
C113 VDD.t1 0 0.09102f
C114 VDD.n17 0 0.50922f
C115 VDD.n18 0 0.17495f
C116 VDD.n19 0 0.10455f
C117 VDD.n20 0 0.10586f
C118 VDD.n21 0 0.13702f
C119 VDD.n22 0 0.13702f
C120 VDD.n23 0 0.13702f
C121 VDD.n24 0 0.10842f
C122 VDD.n25 0 0.09595f
C123 Y.t1 0 0.7293f
C124 Y.t0 0 0.65734f
C125 X.t1 0 0.98443f
C126 X.t0 0 0.57697f
C127 VSS.n1 0 0.03506f
C128 VSS.t4 0 0.01618f
C129 VSS.n2 0 0.29622f
C130 VSS.n3 0 0.08335f
C131 VSS.n4 0 0.03646f
C132 VSS.n5 0 0.0405f
C133 VSS.n6 0 0.26802f
C134 VSS.n7 0 0.04408f
C135 VSS.n8 0 0.04408f
C136 VSS.n9 0 0.03646f
C137 VSS.n10 0 0.02789f
C138 VSS.n11 0 0.05015f
C139 VSS.n12 0 0.08118f
C140 VSS.n13 0 0.12367f
C141 VSS.n14 0 0.04408f
C142 VSS.n15 0 0.03559f
C143 VSS.n16 0 0.03646f
C144 VSS.n17 0 0.03147f
C145 VSS.n18 0 0.032f
C146 VSS.n19 0 0.04408f
C147 VSS.n20 0 0.04408f
C148 VSS.n21 0 0.04408f
C149 VSS.n22 0 0.04124f
.ends
