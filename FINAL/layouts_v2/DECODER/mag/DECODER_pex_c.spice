* Nodos de bulk atados: 1 de pozo n -> VDD, 1 de sustrato -> VSS.
*   magic no extrae los taps de este layout y los dejaba flotando;
*   la conexion si existe (el LVS de KLayout da 'match uniquely').
*   Quien detecta un tap que falte de verdad es el LVS, no esto.
* NGSPICE file created from DECODER.ext - technology: gf180mcuD

.subckt DECODER VSS VDD Z XZ XY Y YZ X
X0 a_3586_332# XY VDD VDD pfet_06v0 ad=0.99p pd=3.66u as=1.32p ps=6.88u w=3u l=1u
X1 a_3034_1788# YZ Z VDD pfet_06v0 ad=0.75p pd=3.5u as=1.32p ps=6.88u w=3u l=1u
X2 a_1678_376# a_n74_376# a_746_332# VSS nfet_06v0 ad=0.25p pd=1.5u as=0.44p ps=2.88u w=1u l=1u
X3 Y a_746_332# VDD VDD pfet_06v0 ad=1.32p pd=6.88u as=1.32p ps=6.88u w=3u l=1u
X4 VSS YZ a_1678_376# VSS nfet_06v0 ad=0.44p pd=2.88u as=0.25p ps=1.5u w=1u l=1u
X5 a_4518_376# XZ a_3586_332# VSS nfet_06v0 ad=0.25p pd=1.5u as=0.44p ps=2.88u w=1u l=1u
X6 VSS XY a_4518_376# VSS nfet_06v0 ad=0.44p pd=2.88u as=0.25p ps=1.5u w=1u l=1u
X7 VSS XY a_n74_376# VSS nfet_06v0 ad=0.44p pd=2.88u as=0.44p ps=2.88u w=1u l=1u
X8 VSS XZ Z VSS nfet_06v0 ad=0.44p pd=2.88u as=0.33p ps=1.66u w=1u l=1u
X9 VSS a_746_332# Y VSS nfet_06v0 ad=0.44p pd=2.88u as=0.44p ps=2.88u w=1u l=1u
X10 a_n74_376# XY VDD VDD pfet_06v0 ad=1.32p pd=6.88u as=1.32p ps=6.88u w=3u l=1u
X11 VDD XZ a_3034_1788# VDD pfet_06v0 ad=1.32p pd=6.88u as=0.75p ps=3.5u w=3u l=1u
X12 VSS a_3586_332# X VSS nfet_06v0 ad=0.44p pd=2.88u as=0.44p ps=2.88u w=1u l=1u
X13 VDD a_n74_376# a_746_332# VDD pfet_06v0 ad=1.32p pd=6.88u as=0.99p ps=3.66u w=3u l=1u
X14 Z YZ VSS VSS nfet_06v0 ad=0.33p pd=1.66u as=0.44p ps=2.88u w=1u l=1u
X15 a_746_332# YZ VDD VDD pfet_06v0 ad=0.99p pd=3.66u as=1.32p ps=6.88u w=3u l=1u
X16 X a_3586_332# VDD VDD pfet_06v0 ad=1.32p pd=6.88u as=1.32p ps=6.88u w=3u l=1u
X17 VDD XZ a_3586_332# VDD pfet_06v0 ad=1.32p pd=6.88u as=0.99p ps=3.66u w=3u l=1u
C0 Z a_3034_1788# 0.01576f
C1 VDD Y 0.20144f
C2 XZ VDD 0.28159f
C3 VDD VDD 2.72564f
C4 VSS a_1678_376# 0.01198f
C5 VSS XZ 0.28988f
C6 a_3586_332# X 1.0294f
C7 Y a_n74_376# 0.10895f
C8 Y XY 0.52748f
C9 VDD VSS 0.04412f
C10 YZ XZ 0.19796f
C11 VDD a_n74_376# 0.33637f
C12 YZ VDD 0.64276f
C13 XY VDD 0.27242f
C14 VSS a_n74_376# 0.19767f
C15 Y a_746_332# 1.04616f
C16 VSS XY 0.19825f
C17 YZ a_n74_376# 0.35658f
C18 a_746_332# VDD 0.4287f
C19 YZ XY 0.55736f
C20 VDD X 0.24713f
C21 VDD a_3034_1788# 0.03338f
C22 VSS a_746_332# 0.14708f
C23 VDD XZ 0.61879f
C24 VSS X 0.09561f
C25 YZ a_746_332# 0.40017f
C26 Z VDD 0.13584f
C27 XY XZ 1.08256f
C28 VDD a_n74_376# 0.44549f
C29 VSS a_4518_376# 0.01198f
C30 VSS Z 0.13866f
C31 VDD XY 0.61934f
C32 a_3586_332# VDD 0.40634f
C33 YZ Z 0.70386f
C34 XY a_n74_376# 1.70653f
C35 VSS a_3586_332# 0.15024f
C36 VDD a_746_332# 0.50188f
C37 XZ X 0.19904f
C38 VDD X 0.25337f
C39 Y VDD 0.22786f
C40 a_746_332# a_n74_376# 0.54249f
C41 XY a_746_332# 0.09703f
C42 Z XZ 0.2328f
C43 XY X 0.14954f
C44 VSS Y 0.11227f
C45 VDD Z 0.14845f
C46 YZ Y 0.0489f
C47 XZ a_3586_332# 0.66403f
C48 YZ VDD 0.22148f
C49 Z a_n74_376# 0.06823f
C50 VDD a_3586_332# 0.44512f
C51 Z XY 0.27224f
C52 YZ VSS 0.17845f
C53 XY a_3586_332# 0.85985f
C54 VSS VSS 5.51391f
C55 X VSS 0.39561f
C56 Z VSS 0.3507f
C57 Y VSS 0.37493f
C58 VDD VSS 3.38584f
C59 XZ VSS 1.57625f
C60 YZ VSS 1.17619f
C61 XY VSS 1.50409f
C62 a_3586_332# VSS 0.97425f
C63 a_n74_376# VSS 1.16018f
C64 a_746_332# VSS 0.92463f
C65 VDD VSS 22.3618f
.ends
