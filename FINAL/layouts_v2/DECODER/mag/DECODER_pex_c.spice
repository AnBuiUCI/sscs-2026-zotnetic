* Nodos de bulk atados: 1 de pozo n -> VDD, 1 de sustrato -> VSS.
*   magic no extrae los taps de este layout y los dejaba flotando;
*   la conexion si existe (el LVS de KLayout da 'match uniquely').
*   Quien detecta un tap que falte de verdad es el LVS, no esto.
* NGSPICE file created from DECODER.ext - technology: gf180mcuD

.subckt DECODER VSS VDD Z XZ YZ X XY Y
X0 a_1002_376# XY VDD VDD pfet_06v0 ad=1.32p pd=6.88u as=1.32p ps=6.88u w=3u l=1u
X1 VSS a_1822_332# Y VSS nfet_06v0 ad=0.44p pd=2.88u as=0.44p ps=2.88u w=1u l=1u
X2 a_4518_376# XZ a_3586_332# VSS nfet_06v0 ad=0.25p pd=1.5u as=0.44p ps=2.88u w=1u l=1u
X3 VDD a_1002_376# a_1822_332# VDD pfet_06v0 ad=1.32p pd=6.88u as=0.99p ps=3.66u w=3u l=1u
X4 VSS XY a_4518_376# VSS nfet_06v0 ad=0.44p pd=2.88u as=0.25p ps=1.5u w=1u l=1u
X5 VSS XY a_1002_376# VSS nfet_06v0 ad=0.44p pd=2.88u as=0.44p ps=2.88u w=1u l=1u
X6 a_2754_376# a_1002_376# a_1822_332# VSS nfet_06v0 ad=0.25p pd=1.5u as=0.44p ps=2.88u w=1u l=1u
X7 VDD XZ a_266_2052# VDD pfet_06v0 ad=1.32p pd=6.88u as=0.75p ps=3.5u w=3u l=1u
X8 a_1822_332# YZ VDD VDD pfet_06v0 ad=0.99p pd=3.66u as=1.32p ps=6.88u w=3u l=1u
X9 VSS YZ a_2754_376# VSS nfet_06v0 ad=0.44p pd=2.88u as=0.25p ps=1.5u w=1u l=1u
X10 Z YZ VSS VSS nfet_06v0 ad=0.33p pd=1.66u as=0.44p ps=2.88u w=1u l=1u
X11 VDD XZ a_3586_332# VDD pfet_06v0 ad=1.32p pd=6.88u as=0.99p ps=3.66u w=3u l=1u
X12 a_3586_332# XY VDD VDD pfet_06v0 ad=0.99p pd=3.66u as=1.32p ps=6.88u w=3u l=1u
X13 Y a_1822_332# VDD VDD pfet_06v0 ad=1.32p pd=6.88u as=1.32p ps=6.88u w=3u l=1u
X14 VSS a_3586_332# X VSS nfet_06v0 ad=0.44p pd=2.88u as=0.44p ps=2.88u w=1u l=1u
X15 a_266_2052# YZ Z VDD pfet_06v0 ad=0.75p pd=3.5u as=1.32p ps=6.88u w=3u l=1u
X16 VSS XZ Z VSS nfet_06v0 ad=0.44p pd=2.88u as=0.33p ps=1.66u w=1u l=1u
X17 X a_3586_332# VDD VDD pfet_06v0 ad=1.32p pd=6.88u as=1.32p ps=6.88u w=3u l=1u
C0 VSS a_2754_376# 0.01215f
C1 VSS a_4518_376# 0.01198f
C2 a_1822_332# a_1002_376# 0.8378f
C3 Y VDD 0.1687f
C4 Y XY 0.24108f
C5 VSS XZ 0.47536f
C6 Y a_1822_332# 1.10614f
C7 VSS X 0.09676f
C8 XY VDD 0.68125f
C9 VDD a_1822_332# 0.42843f
C10 VSS a_3586_332# 0.14768f
C11 VSS YZ 0.17f
C12 XY a_1822_332# 0.73059f
C13 VSS Z 0.14353f
C14 VSS a_1002_376# 0.1487f
C15 VDD XZ 0.25093f
C16 VDD X 0.20293f
C17 VSS Y 0.0856f
C18 VDD a_3586_332# 0.42252f
C19 VDD YZ 0.20018f
C20 X XZ 0.55675f
C21 VDD Z 0.07618f
C22 VDD a_1002_376# 0.37668f
C23 VSS XY 0.18499f
C24 a_3586_332# XZ 0.60016f
C25 a_3586_332# X 1.08516f
C26 VSS a_1822_332# 0.14695f
C27 YZ XZ 1.45435f
C28 X YZ 0.06131f
C29 VDD Y 0.21651f
C30 XZ Z 0.27678f
C31 XZ a_1002_376# 0.18563f
C32 a_3586_332# YZ 0.01907f
C33 VDD VDD 2.85814f
C34 VDD XY 0.35997f
C35 a_3586_332# a_1002_376# 0.0235f
C36 Y XZ 0.08127f
C37 YZ Z 0.78889f
C38 VDD a_266_2052# 0.03427f
C39 YZ a_1002_376# 0.33544f
C40 VDD a_1822_332# 0.40314f
C41 VDD XZ 0.59301f
C42 X VDD 0.14939f
C43 XY XZ 0.88759f
C44 Y YZ 0.04855f
C45 X XY 0.61987f
C46 XZ a_1822_332# 0.09943f
C47 a_3586_332# VDD 0.4872f
C48 Y a_1002_376# 0.59127f
C49 YZ VDD 0.59625f
C50 a_3586_332# XY 1.02272f
C51 XY YZ 0.88079f
C52 VDD Z 0.10965f
C53 a_3586_332# a_1822_332# 0.0307f
C54 VDD a_1002_376# 0.61553f
C55 YZ a_1822_332# 0.38137f
C56 XY a_1002_376# 0.81143f
C57 a_266_2052# Z 0.01645f
C58 VSS VSS 5.71052f
C59 X VSS 0.40164f
C60 Y VSS 0.38733f
C61 VDD VSS 3.40518f
C62 Z VSS 0.63366f
C63 XY VSS 1.64011f
C64 XZ VSS 2.28045f
C65 YZ VSS 1.48011f
C66 a_3586_332# VSS 1.17305f
C67 a_1002_376# VSS 1.12952f
C68 a_1822_332# VSS 1.02441f
C69 VDD VSS 23.1593f
.ends
