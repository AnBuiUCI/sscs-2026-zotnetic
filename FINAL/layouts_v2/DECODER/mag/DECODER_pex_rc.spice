* Nodos de bulk atados: 10 de pozo n -> VDD, 11 de sustrato -> VSS.
*   magic no extrae los taps de este layout y los dejaba flotando;
*   la conexion si existe (el LVS de KLayout da 'match uniquely').
*   Quien detecta un tap que falte de verdad es el LVS, no esto.
* NGSPICE file created from DECODER.ext - technology: gf180mcuD

.subckt DECODER VSS VDD Z XZ XY Y YZ X
X0 a_3586_332.t0 XY.t2 VDD.t2 VDD pfet_06v0 ad=0.99p pd=3.66u as=1.32p ps=6.88u w=3u l=1u
X1 a_3034_1788.t0 YZ.t2 Z.t1 VDD pfet_06v0 ad=0.75p pd=3.5u as=1.32p ps=6.88u w=3u l=1u
X2 a_1678_376.t0 a_n74_376.t2 a_746_332.t1 VSS nfet_06v0 ad=0.25p pd=1.5u as=0.44p ps=2.88u w=1u l=1u
X3 Y.t0 a_746_332.t4 VDD.t1 VDD pfet_06v0 ad=1.32p pd=6.88u as=1.32p ps=6.88u w=3u l=1u
X4 VSS.t4 YZ.t1 a_1678_376.t1 VSS nfet_06v0 ad=0.44p pd=2.88u as=0.25p ps=1.5u w=1u l=1u
X5 a_4518_376.t1 XZ.t0 a_3586_332.t2 VSS nfet_06v0 ad=0.25p pd=1.5u as=0.44p ps=2.88u w=1u l=1u
X6 VSS.t0 XY.t0 a_4518_376.t0 VSS nfet_06v0 ad=0.44p pd=2.88u as=0.25p ps=1.5u w=1u l=1u
X7 VSS.t2 XY.t1 a_n74_376.t0 VSS nfet_06v0 ad=0.44p pd=2.88u as=0.44p ps=2.88u w=1u l=1u
X8 VSS.t5 XZ.t1 Z.t2 VSS nfet_06v0 ad=0.44p pd=2.88u as=0.33p ps=1.66u w=1u l=1u
X9 VSS.t6 a_746_332.t3 Y.t1 VSS nfet_06v0 ad=0.44p pd=2.88u as=0.44p ps=2.88u w=1u l=1u
X10 a_n74_376.t1 XY.t3 VDD.t7 VDD pfet_06v0 ad=1.32p pd=6.88u as=1.32p ps=6.88u w=3u l=1u
X11 VDD.t0 XZ.t3 a_3034_1788.t1 VDD pfet_06v0 ad=1.32p pd=6.88u as=0.75p ps=3.5u w=3u l=1u
X12 VSS.t1 a_3586_332.t3 X.t0 VSS nfet_06v0 ad=0.44p pd=2.88u as=0.44p ps=2.88u w=1u l=1u
X13 VDD.t4 a_n74_376.t3 a_746_332.t0 VDD pfet_06v0 ad=1.32p pd=6.88u as=0.99p ps=3.66u w=3u l=1u
X14 Z.t0 YZ.t0 VSS.t3 VSS nfet_06v0 ad=0.33p pd=1.66u as=0.44p ps=2.88u w=1u l=1u
X15 a_746_332.t2 YZ.t3 VDD.t5 VDD pfet_06v0 ad=0.99p pd=3.66u as=1.32p ps=6.88u w=3u l=1u
X16 X.t1 a_3586_332.t4 VDD.t6 VDD pfet_06v0 ad=1.32p pd=6.88u as=1.32p ps=6.88u w=3u l=1u
X17 VDD.t3 XZ.t2 a_3586_332.t1 VDD pfet_06v0 ad=1.32p pd=6.88u as=0.99p ps=3.66u w=3u l=1u
R0 VSS.n12 VSS.n9 9.0005
R1 VSS.n14 VSS.n13 9.0005
R2 VSS.n15 VSS.n8 9.0005
R3 VSS.n18 VSS.n17 9.0005
R4 VSS.n20 VSS.n19 9.0005
R5 VSS.n7 VSS.n0 9.0005
R6 VSS.n6 VSS.n5 9.0005
R7 VSS.n2 VSS.t0 5.45242
R8 VSS.n11 VSS.t2 5.36727
R9 VSS.n3 VSS.t1 5.28916
R10 VSS.n4 VSS.t5 5.28916
R11 VSS.n1 VSS.t3 5.28916
R12 VSS.n16 VSS.t4 5.28916
R13 VSS.n10 VSS.t6 5.28916
R14 VSS.n12 VSS.n11 3.28197
R15 VSS.n6 VSS.n2 1.93348
R16 VSS.n3 VSS.n2 0.336087
R17 VSS.n11 VSS.n10 0.287335
R18 VSS.n7 VSS.n6 0.2005
R19 VSS.n19 VSS.n7 0.2005
R20 VSS.n19 VSS.n18 0.2005
R21 VSS.n18 VSS.n8 0.2005
R22 VSS.n13 VSS.n8 0.2005
R23 VSS.n13 VSS.n12 0.2005
R24 VSS.n15 VSS.n14 0.2005
R25 VSS.n14 VSS.n9 0.2005
R26 VSS.n5 VSS.n4 0.193
R27 VSS.n5 VSS.n3 0.174
R28 VSS.n17 VSS.n16 0.131
R29 VSS.n20 VSS.n1 0.128
R30 VSS VSS.n20 0.1215
R31 VSS VSS.n0 0.0795
R32 VSS.n17 VSS.n1 0.073
R33 VSS.n16 VSS.n15 0.07
R34 VSS.n10 VSS.n9 0.047
R35 VSS.n4 VSS.n0 0.008
R36 X X.t0 16.4369
R37 X X.t1 2.59733
R38 Z Z.n0 16.0121
R39 Z Z.t1 3.29085
R40 Z.n0 Z.t2 2.0795
R41 Z.n0 Z.t0 2.0795
R42 Y Y.t1 15.8663
R43 Y Y.t0 2.85559
R44 VDD.n18 VDD.n17 9.0005
R45 VDD.n19 VDD.n13 9.0005
R46 VDD.n22 VDD.n21 9.0005
R47 VDD.n23 VDD.n1 9.0005
R48 VDD.n25 VDD.n24 9.0005
R49 VDD.n12 VDD.n0 9.0005
R50 VDD.n11 VDD.n10 9.0005
R51 VDD.n7 VDD.n2 9.0005
R52 VDD.n6 VDD.n5 9.0005
R53 VDD.n17 VDD.n16 3.23511
R54 VDD.n5 VDD.n4 2.57661
R55 VDD.n16 VDD.t7 2.37978
R56 VDD.n4 VDD.t3 2.32543
R57 VDD.n15 VDD.t1 2.20347
R58 VDD.n20 VDD.t5 2.20347
R59 VDD.n14 VDD.t4 2.20347
R60 VDD.n9 VDD.t0 2.20347
R61 VDD.n8 VDD.t6 2.20347
R62 VDD.n3 VDD.t2 2.20347
R63 VDD.n16 VDD.n15 0.22519
R64 VDD.n4 VDD.n3 0.207863
R65 VDD.n5 VDD.n2 0.2005
R66 VDD.n11 VDD.n2 0.2005
R67 VDD.n12 VDD.n11 0.2005
R68 VDD.n24 VDD.n12 0.2005
R69 VDD.n24 VDD.n23 0.2005
R70 VDD.n23 VDD.n22 0.2005
R71 VDD.n22 VDD.n13 0.2005
R72 VDD.n17 VDD.n13 0.2005
R73 VDD.n7 VDD.n6 0.2005
R74 VDD.n25 VDD.n1 0.2005
R75 VDD.n19 VDD.n18 0.2005
R76 VDD.n6 VDD.n3 0.197
R77 VDD.n21 VDD.n14 0.192
R78 VDD.n10 VDD.n8 0.185
R79 VDD.n18 VDD.n15 0.156
R80 VDD.n9 VDD.n0 0.148
R81 VDD.n21 VDD.n20 0.144
R82 VDD VDD.n25 0.1215
R83 VDD VDD.n0 0.0795
R84 VDD.n20 VDD.n19 0.057
R85 VDD.n10 VDD.n9 0.053
R86 VDD.n8 VDD.n7 0.016
R87 VDD.n14 VDD.n1 0.009
R88 XZ.n0 XZ.t2 24.88
R89 XZ XZ.t3 19.2113
R90 XZ.n1 XZ.t1 16.0543
R91 XZ.n0 XZ.t0 15.6538
R92 XZ XZ.n1 4.5005
R93 XZ.n1 XZ.n0 1.68172
R94 YZ.n0 YZ.t2 23.6261
R95 YZ YZ.t3 18.7335
R96 YZ.n1 YZ.t1 16.153
R97 YZ.n0 YZ.t0 16.153
R98 YZ YZ.n1 4.6805
R99 YZ.n1 YZ.n0 1.11168
R100 XY.n0 XY.t2 23.6651
R101 XY XY.t3 18.908
R102 XY.n0 XY.t0 15.8947
R103 XY.n1 XY.n0 11.7696
R104 XY.n1 XY.t1 11.5171
R105 XY XY.n1 0.0878529
R106 a_4518_376.t0 a_4518_376.t1 3.1505
R107 a_1678_376.t0 a_1678_376.t1 3.1505
R108 a_3034_1788.t0 a_3034_1788.t1 1.16717
R109 a_3586_332.t2 a_3586_332.n2 10.6971
R110 a_3586_332.n2 a_3586_332.n1 16.8841
R111 a_3586_332.n1 a_3586_332.t0 0.7705
R112 a_3586_332.n1 a_3586_332.t1 0.7705
R113 a_3586_332.n2 a_3586_332.n0 0.294607
R114 a_3586_332.n0 a_3586_332.t3 16.6994
R115 a_3586_332.n0 a_3586_332.t4 23.1947
R116 a_n74_376.t0 a_n74_376.n0 10.7594
R117 a_n74_376.n0 a_n74_376.n1 1.98532
R118 a_n74_376.n1 a_n74_376.t3 24.5534
R119 a_n74_376.n1 a_n74_376.t2 15.6365
R120 a_n74_376.n0 a_n74_376.t1 7.87211
R121 a_746_332.t1 a_746_332.n2 10.9554
R122 a_746_332.n2 a_746_332.n1 16.2402
R123 a_746_332.n1 a_746_332.t2 0.7705
R124 a_746_332.n1 a_746_332.t0 0.7705
R125 a_746_332.n2 a_746_332.n0 0.680321
R126 a_746_332.n0 a_746_332.t3 16.5913
R127 a_746_332.n0 a_746_332.t4 22.9365
R128 VDD VDD 319.183
R129 VDD VDD 638.365
R130 VDD VDD 647.799
R131 VDD VDD 261.007
R132 VDD VDD 638.365
R133 VDD VDD 235.85
R134 VDD VDD 638.365
R135 VDD VDD 647.799
R136 VDD VDD 261.007
R137 VSS VSS 797.253
R138 VSS VSS 1594.5
R139 VSS VSS 1594.5
R140 VSS VSS 653.486
R141 VSS VSS 1620.64
R142 VSS VSS 723.191
R143 VSS VSS 1594.5
R144 VSS VSS 1594.5
R145 VSS VSS 653.486
C0 Y XY 0.52748f
C1 YZ XY 0.55736f
C2 Y VSS 0.11227f
C3 YZ VSS 0.17845f
C4 Z VDD 0.13584f
C5 XZ VDD 0.28159f
C6 XZ X 0.19904f
C7 XY VSS 0.19825f
C8 Y VDD 0.22786f
C9 YZ VDD 0.22148f
C10 XZ Z 0.2328f
C11 VDD XY 0.27242f
C12 X XY 0.14954f
C13 X VSS 0.09561f
C14 YZ Z 0.70386f
C15 XZ YZ 0.19796f
C16 Z XY 0.27224f
C17 Z VSS 0.13866f
C18 XZ XY 1.08256f
C19 XZ VSS 0.28988f
C20 X VDD 0.24713f
C21 YZ Y 0.0489f
C22 VSS 0 5.53517f
C23 X 0 1.15463f
C24 Z 0 1.03956f
C25 Y 0 1.24101f
C26 VDD 0 3.45224f
C27 XZ 0 1.94105f
C28 YZ 0 1.57115f
C29 XY 0 2.1017f
C30 VDD 0 0.23024f
C31 VDD 0 0.69073f
C32 VDD 0 0.92777f
C33 VDD 0 0.65557f
C34 VDD 0 0.64876f
C35 VDD 0 0.63061f
C36 VDD 0 0.63061f
C37 VDD 0 0.92777f
C38 VDD 0 0.65557f
C39 VDD 0 0.64876f
C40 a_746_332.t1 0 0.1916f
C41 a_746_332.t4 0 0.62069f
C42 a_746_332.n0 0 0.652f
C43 a_746_332.t3 0 0.33186f
C44 a_746_332.n1 0 0.62825f
C45 a_746_332.t2 0 0.10815f
C46 a_746_332.t0 0 0.10815f
C47 a_746_332.n2 0 0.53797f
C48 a_n74_376.t0 0 0.18421f
C49 a_n74_376.t1 0 0.72934f
C50 a_n74_376.n0 0 0.64949f
C51 a_n74_376.t2 0 0.34655f
C52 a_n74_376.n1 0 1.0653f
C53 a_n74_376.t3 0 0.78989f
C54 a_3586_332.t2 0 0.19281f
C55 a_3586_332.t4 0 0.69257f
C56 a_3586_332.n0 0 0.74883f
C57 a_3586_332.t3 0 0.35817f
C58 a_3586_332.n1 0 0.71448f
C59 a_3586_332.t0 0 0.11885f
C60 a_3586_332.t1 0 0.11885f
C61 a_3586_332.n2 0 0.62518f
C62 a_3034_1788.t0 0 0.02727f
C63 a_3034_1788.t1 0 0.02727f
C64 a_1678_376.t0 0 0.01053f
C65 a_1678_376.t1 0 0.01053f
C66 a_4518_376.t0 0 0.01046f
C67 a_4518_376.t1 0 0.01046f
C68 XY.t3 0 0.82987f
C69 XY.t1 0 0.33889f
C70 XY.t2 0 0.95185f
C71 XY.t0 0 0.44999f
C72 XY.n0 0 2.16648f
C73 XY.n1 0 1.01125f
C74 YZ.t3 0 0.57833f
C75 YZ.t2 0 0.66069f
C76 YZ.t0 0 0.32848f
C77 YZ.n0 0 0.6513f
C78 YZ.t1 0 0.32848f
C79 YZ.n1 0 0.37458f
C80 XZ.t3 0 0.47552f
C81 XZ.t2 0 0.56501f
C82 XZ.t0 0 0.24502f
C83 XZ.n0 0 1.16176f
C84 XZ.t1 0 0.24992f
C85 XZ.n1 0 0.51153f
C86 VDD.n0 0 0.0811f
C87 VDD.n1 0 0.07351f
C88 VDD.n2 0 0.13871f
C89 VDD.t6 0 0.07765f
C90 VDD.t2 0 0.07765f
C91 VDD.n3 0 0.21105f
C92 VDD.t3 0 0.0992f
C93 VDD.n4 0 0.47155f
C94 VDD.n5 0 0.61814f
C95 VDD.n6 0 0.13528f
C96 VDD.n7 0 0.07745f
C97 VDD.n8 0 0.10609f
C98 VDD.t0 0 0.07765f
C99 VDD.n9 0 0.10609f
C100 VDD.n10 0 0.08459f
C101 VDD.n11 0 0.13871f
C102 VDD.n12 0 0.13871f
C103 VDD.n13 0 0.13871f
C104 VDD.t4 0 0.07765f
C105 VDD.n14 0 0.10609f
C106 VDD.t5 0 0.07765f
C107 VDD.t1 0 0.07765f
C108 VDD.n15 0 0.20257f
C109 VDD.t7 0 0.09373f
C110 VDD.n16 0 0.29518f
C111 VDD.n17 0 0.5039f
C112 VDD.n18 0 0.12393f
C113 VDD.n19 0 0.09106f
C114 VDD.n20 0 0.10609f
C115 VDD.n21 0 0.11713f
C116 VDD.n22 0 0.13871f
C117 VDD.n23 0 0.13871f
C118 VDD.n24 0 0.13871f
C119 VDD.n25 0 0.11055f
C120 Y.t0 0 0.91597f
C121 Y.t1 0 0.49217f
C122 Z.t1 0 0.67277f
C123 Z.t2 0 0.05458f
C124 Z.t0 0 0.05458f
C125 Z.n0 0 0.25637f
C126 X.t1 0 0.7516f
C127 X.t0 0 0.47191f
C128 VSS.n0 0 0.01108f
C129 VSS.n1 0 0.03673f
C130 VSS.t0 0 0.01557f
C131 VSS.n2 0 0.26676f
C132 VSS.n3 0 0.08471f
C133 VSS.n4 0 0.03673f
C134 VSS.n5 0 0.0408f
C135 VSS.n6 0 0.25144f
C136 VSS.n7 0 0.04441f
C137 VSS.n8 0 0.04441f
C138 VSS.n9 0 0.02809f
C139 VSS.t2 0 0.01049f
C140 VSS.n10 0 0.05544f
C141 VSS.n11 0 0.12523f
C142 VSS.n12 0 0.16204f
C143 VSS.n13 0 0.04441f
C144 VSS.n14 0 0.04441f
C145 VSS.n15 0 0.03054f
C146 VSS.n16 0 0.03673f
C147 VSS.n17 0 0.02347f
C148 VSS.n18 0 0.04441f
C149 VSS.n19 0 0.04441f
C150 VSS.n20 0 0.0283f
.ends
