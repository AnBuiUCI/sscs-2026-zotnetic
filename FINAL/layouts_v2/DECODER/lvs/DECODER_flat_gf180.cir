* Extracted by KLayout with GF180MCU LVS runset on : 29/08/2026 10:31

.SUBCKT DECODER Z XZ YZ X XY VDD Y VSS
M$1 \$19 XY VDD VDD pfet_06v0 L=1U W=3U AS=1.32P AD=0.99P PS=6.88U PD=3.66U
M$2 VDD XZ \$19 VDD pfet_06v0 L=1U W=3U AS=0.99P AD=1.32P PS=3.66U PD=6.88U
M$3 \$15 YZ VDD VDD pfet_06v0 L=1U W=3U AS=1.32P AD=0.99P PS=6.88U PD=3.66U
M$4 VDD \$36 \$15 VDD pfet_06v0 L=1U W=3U AS=0.99P AD=1.32P PS=3.66U PD=6.88U
M$5 \$53 YZ Z VDD pfet_06v0 L=1U W=3U AS=1.32P AD=0.75P PS=6.88U PD=3.5U
M$6 VDD XZ \$53 VDD pfet_06v0 L=1U W=3U AS=0.75P AD=1.32P PS=3.5U PD=6.88U
M$7 \$20 XZ \$19 VSS nfet_06v0 L=1U W=1U AS=0.44P AD=0.25P PS=2.88U PD=1.5U
M$8 VSS XY \$20 VSS nfet_06v0 L=1U W=1U AS=0.25P AD=0.44P PS=1.5U PD=2.88U
M$9 \$16 \$36 \$15 VSS nfet_06v0 L=1U W=1U AS=0.44P AD=0.25P PS=2.88U PD=1.5U
M$10 VSS YZ \$16 VSS nfet_06v0 L=1U W=1U AS=0.25P AD=0.44P PS=1.5U PD=2.88U
M$11 Z YZ VSS VSS nfet_06v0 L=1U W=1U AS=0.44P AD=0.33P PS=2.88U PD=1.66U
M$12 VSS XZ Z VSS nfet_06v0 L=1U W=1U AS=0.33P AD=0.44P PS=1.66U PD=2.88U
M$13 VSS \$19 X VSS nfet_06v0 L=1U W=1U AS=0.44P AD=0.44P PS=2.88U PD=2.88U
M$14 VSS XY \$36 VSS nfet_06v0 L=1U W=1U AS=0.44P AD=0.44P PS=2.88U PD=2.88U
M$15 VSS \$15 Y VSS nfet_06v0 L=1U W=1U AS=0.44P AD=0.44P PS=2.88U PD=2.88U
M$16 Y \$15 VDD VDD pfet_06v0 L=1U W=3U AS=1.32P AD=1.32P PS=6.88U PD=6.88U
M$17 \$36 XY VDD VDD pfet_06v0 L=1U W=3U AS=1.32P AD=1.32P PS=6.88U PD=6.88U
M$18 X \$19 VDD VDD pfet_06v0 L=1U W=3U AS=1.32P AD=1.32P PS=6.88U PD=6.88U
.ENDS DECODER
