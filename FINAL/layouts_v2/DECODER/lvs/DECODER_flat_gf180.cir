* Extracted by KLayout with GF180MCU LVS runset on : 29/08/2026 18:10

.SUBCKT DECODER XY Z XZ Y YZ VDD X VSS
M$1 \$22 XY VDD VDD pfet_06v0 L=1U W=3U AS=1.32P AD=0.99P PS=6.88U PD=3.66U
M$2 VDD XZ \$22 VDD pfet_06v0 L=1U W=3U AS=0.99P AD=1.32P PS=3.66U PD=6.88U
M$3 \$62 YZ Z VDD pfet_06v0 L=1U W=3U AS=1.32P AD=0.75P PS=6.88U PD=3.5U
M$4 VDD XZ \$62 VDD pfet_06v0 L=1U W=3U AS=0.75P AD=1.32P PS=3.5U PD=6.88U
M$5 \$9 YZ VDD VDD pfet_06v0 L=1U W=3U AS=1.32P AD=0.99P PS=6.88U PD=3.66U
M$6 VDD \$8 \$9 VDD pfet_06v0 L=1U W=3U AS=0.99P AD=1.32P PS=3.66U PD=6.88U
M$7 \$21 XZ \$22 VSS nfet_06v0 L=1U W=1U AS=0.44P AD=0.25P PS=2.88U PD=1.5U
M$8 VSS XY \$21 VSS nfet_06v0 L=1U W=1U AS=0.25P AD=0.44P PS=1.5U PD=2.88U
M$9 Z YZ VSS VSS nfet_06v0 L=1U W=1U AS=0.44P AD=0.33P PS=2.88U PD=1.66U
M$10 VSS XZ Z VSS nfet_06v0 L=1U W=1U AS=0.33P AD=0.44P PS=1.66U PD=2.88U
M$11 \$10 \$8 \$9 VSS nfet_06v0 L=1U W=1U AS=0.44P AD=0.25P PS=2.88U PD=1.5U
M$12 VSS YZ \$10 VSS nfet_06v0 L=1U W=1U AS=0.25P AD=0.44P PS=1.5U PD=2.88U
M$13 VSS \$22 X VSS nfet_06v0 L=1U W=1U AS=0.44P AD=0.44P PS=2.88U PD=2.88U
M$14 VSS \$9 Y VSS nfet_06v0 L=1U W=1U AS=0.44P AD=0.44P PS=2.88U PD=2.88U
M$15 VSS XY \$8 VSS nfet_06v0 L=1U W=1U AS=0.44P AD=0.44P PS=2.88U PD=2.88U
M$16 \$8 XY VDD VDD pfet_06v0 L=1U W=3U AS=1.32P AD=1.32P PS=6.88U PD=6.88U
M$17 Y \$9 VDD VDD pfet_06v0 L=1U W=3U AS=1.32P AD=1.32P PS=6.88U PD=6.88U
M$18 X \$22 VDD VDD pfet_06v0 L=1U W=3U AS=1.32P AD=1.32P PS=6.88U PD=6.88U
.ENDS DECODER
