** sch_path: /foss/designs/a_zonetic2026/XSCHEM/TEST_TOTAL/test_GRADIENT.sch
**.subckt test_GRADIENT
V1 VEXC GND 5
V2 VDD1 GND 5
V6 VDD2 GND 5
x2 S1N S1P VDD1 X1 S2N Y1 Z1 S2P GND S3N S3P GRADIENT
x3 S1N S1P VDD2 X2 S2N Y2 Z2 S2P GND S3N S3P GRADIENT2
R1 VEXC S2P r=' 1meg*(1-v(by)) '
R2 VEXC S2N r=' 1meg*(1+v(by)) '
R3 S2P GND r=' 1meg*(1+v(by)) '
R4 S2N GND r=' 1meg*(1-v(by)) '
V3 VDD3 GND 5
V4 VDD4 GND 5
R5 VEXC S3P r=' 1meg*(1-v(bz)) '
R6 VEXC S3N r=' 1meg*(1+v(bz)) '
R7 S3P GND r=' 1meg*(1+v(bz)) '
R8 S3N GND r=' 1meg*(1-v(bz)) '
R9 VEXC S1P r=' 1meg*(1-v(bx)) '
R10 VEXC S1N r=' 1meg*(1+v(bx)) '
R11 S1P GND r=' 1meg*(1+v(bx)) '
R12 S1N GND r=' 1meg*(1-v(bx)) '
**** begin user architecture code

.include /foss/designs/pdks/gf180mcuD/libs.tech/ngspice/design.ngspice
.lib /foss/designs/pdks/gf180mcuD/libs.tech/ngspice/sm141064.ngspice typical
.lib /foss/designs/pdks/gf180mcuD/libs.tech/ngspice/sm141064.ngspice cap_mim
.lib /foss/designs/pdks/gf180mcuD/libs.tech/ngspice/sm141064.ngspice res_typical
.lib /foss/designs/pdks/gf180mcuD/libs.tech/ngspice/sm141064.ngspice moscap_typical
.lib /foss/designs/pdks/gf180mcuD/libs.tech/ngspice/sm141064.ngspice mimcap_typical

* THE FIELD. Three components 120 degrees apart, which is what makes them sum
* to zero: the vector only changes DIRECTION, not magnitude. Sweeping
* Vang from 0 to 360 covers the whole circle, and if the chain is right each
* eje deberia ganar exactamente 120 grados: X de -60 a 60, Y de 60 a 180 y Z de
* 180 to 300. How far those three boundaries drift is the figure of the bench.
*
* v(amp) IS dR/R, with no conversion factors in between: each bridge arm is
* 1meg*(1 +- v(bx)), so the amplifier sees VEXC*v(bx) of differential signal
* and the common mode stays pinned at VEXC/2 whatever happens to
* la senal. Eso segundo no es un adorno: si el modo comun se moviera con la
* signal it would mix with these cells' common-mode sensitivity and there
* would be no way to separate the two when reading the curve.
*
* Va con fuentes B y resistencias de comportamiento, y no barriendo
* resistors, because dc takes two nested sources at most and here there are
* TWELVE resistors that must all move at once and consistently.
*
* AND A SECOND MODE, for the octant cases. The rotation above pins the three
* readings to bx+by+bz = 0, so patterns like (+,+,+) are unreachable by
* construction and this bench can only ever see three of the eight sign
* combinations. With v(sel) = 1 each reading becomes v(amp) times its own
* coefficient cx/cy/cz, so the SIGNS of those three coefficients pick the
* octant and their MAGNITUDES pick the ordering, while sweeping Vamp still
* sweeps the field inside that octant.
*
* The decoder puts out the SMALLEST axis (X = XY*XZ), so the expected answer
* at every point is argmin(cx, cy, cz) -- a truth table checkable entry by
* entry. Coefficients are given distinct magnitudes on purpose: three equal
* ones are a three-way tie with no right answer.
*
* v(sel) = 0 leaves the rotation exactly as it was: nothing above changes.
Vamp amp 0 0.02
Vang ang 0 0
Vsel sel 0 0
Vcx cx 0 1
Vcy cy 0 0
Vcz cz 0 0
Bbx bx 0 v='v(sel) > 0.5 ? v(amp)*v(cx) : v(amp)*cos( v(ang)       *3.14159265358979/180)'
Bby by 0 v='v(sel) > 0.5 ? v(amp)*v(cy) : v(amp)*cos((v(ang)-120.0)*3.14159265358979/180)'
Bbz bz 0 v='v(sel) > 0.5 ? v(amp)*v(cz) : v(amp)*cos((v(ang)+120.0)*3.14159265358979/180)'

* THE SAME TWO CHAINS, REBUILT FROM THE v2 LAYOUT BLOCKS.
* They hang off the SAME six sensor nodes as the schematic ones and each
* carries its own supply, so current draw can be compared too.
*
* La topologia es la de COMBINATION/GRADIENT.sch, copiada nodo a nodo:
*
*     amp X: S1N->INN  S1P->INP  -> SX        COMP XY: INN=SX INP=SY -> XY
*     amp Y: S2N->INN  S2P->INP  -> SY        COMP XZ: INN=SX INP=SZ -> XZ
*     amp Z: S3N->INN  S3P->INP  -> SZ        COMP YZ: INN=SY INP=SZ -> YZ
*                                             DECODER: XY XZ YZ -> X Y Z
*
* CAREFUL WITH THE PORT ORDER. xschem emits them in the order of the symbol B
* lines and magic in the order it finds them in the layout, and they do NOT agree:
* el esquematico declara OPAM VDD INN OUT INP VSS y el extraido OPAM VSS VDD OUT
* INP INN. Cablear las dos igual significa cosas distintas y no da ningun error.
* That is why the real order is written above each group, and why the files are
* the _V2_ ones produced by TEST/preparar_extraidos.sh: it renames the subcircuit
* -- both declare the same name and cannot be included together -- and normalises
* the order. Note that OPAM_LIN_flat has OUT in the middle and the others do not.
.include ../../../../layouts_v2/OPAM/mag/OPAM_V2_pex_rc.spice
.include ../../../../layouts_v2/OPAM_LIN_flat/mag/OPAM_LIN_flat_V2_pex_rc.spice
.include ../../../../layouts_v2/COMP/mag/COMP_V2_pex_rc.spice
.include ../../../../layouts_v2/DECODER/mag/DECODER_V2_pex_rc.spice

* --- G3: the G1 chain, with the v2 layout OPAM
* .subckt OPAM_V2     VSS VDD OUT INP INN
XA31 GND VDD3 SX3 S1P S1N OPAM_V2
XA32 GND VDD3 SY3 S2P S2N OPAM_V2
XA33 GND VDD3 SZ3 S3P S3N OPAM_V2
* .subckt COMP_V2     VSS VDD OUT INP INN
XC31 GND VDD3 XY3 SY3 SX3 COMP_V2
XC32 GND VDD3 XZ3 SZ3 SX3 COMP_V2
XC33 GND VDD3 YZ3 SZ3 SY3 COMP_V2
* .subckt DECODER_V2  VSS VDD YZ Z XY XZ Y X
XD3  GND VDD3 YZ3 Z3 XY3 XZ3 Y3 X3 DECODER_V2

* --- G4: the G2 chain, with the v2 layout OPAM_LIN_flat
* .subckt OPAM_LIN_flat_V2  VSS VDD INP OUT INN
XA41 GND VDD4 S1P SX4 S1N OPAM_LIN_flat_V2
XA42 GND VDD4 S2P SY4 S2N OPAM_LIN_flat_V2
XA43 GND VDD4 S3P SZ4 S3N OPAM_LIN_flat_V2
* .subckt COMP_V2     VSS VDD OUT INP INN
XC41 GND VDD4 XY4 SY4 SX4 COMP_V2
XC42 GND VDD4 XZ4 SZ4 SX4 COMP_V2
XC43 GND VDD4 YZ4 SZ4 SY4 COMP_V2
* .subckt DECODER_V2  VSS VDD YZ Z XY XZ Y X
XD4  GND VDD4 YZ4 Z4 XY4 XZ4 Y4 X4 DECODER_V2

* CAREFUL: not one brace in this text. xschem counts them to find where the
* attribute block ends and a single one inside a comment cuts it in half,
* leaving the netlist with the template 'blabla' and raising no error.
*
* This bench does NOT need a common-mode source, unlike test_comp_* and
* test_opam_*: there the input pair were two gates with no DC path to
* ground, and here the bridge itself provides it.
*
* The intermediate signals of the schematic chains come out by hierarchical
* name, v(x2.SX) and company. In the hand-rebuilt ones the nodes are
* primer nivel y se llaman SX3, XY3 y asi.
.save all
.control
* Fondo de escala de una AMR tipica: dR/R = 2 %, o sea 100 mV diferenciales.
alter Vamp = 0.02
dc Vang 0 360 0.5
wrdata ancho.txt v(X1) v(Y1) v(Z1) v(X2) v(Y2) v(Z2) v(X3) v(Y3) v(Z3) v(X4) v(Y4) v(Z4) v(x2.SX) v(x2.SY) v(x2.SZ) v(x3.SX) v(x3.SY) v(x3.SZ) v(SX3) v(SY3) v(SZ3) v(SX4) v(SY4) v(SZ4) v(x2.net1) v(x2.net2) v(x2.net3) v(x3.net1) v(x3.net2) v(x3.net3) v(XY3) v(XZ3) v(YZ3) v(XY4) v(XZ4) v(YZ4) v(S1P) v(S1N) v(S2P) v(S2N) v(S3P) v(S3N) v(VEXC)*i(V1) v(VDD1)*i(V2) v(VDD2)*i(V6) v(VDD3)*i(V3) v(VDD4)*i(V4)
* Ventana fina: dR/R = 50 ppm, o sea 250 uV diferenciales.
alter Vamp = 50u
dc Vang 0 360 0.5
wrdata fino.txt v(X1) v(Y1) v(Z1) v(X2) v(Y2) v(Z2) v(X3) v(Y3) v(Z3) v(X4) v(Y4) v(Z4) v(x2.SX) v(x2.SY) v(x2.SZ) v(x3.SX) v(x3.SY) v(x3.SZ) v(SX3) v(SY3) v(SZ3) v(SX4) v(SY4) v(SZ4) v(x2.net1) v(x2.net2) v(x2.net3) v(x3.net1) v(x3.net2) v(x3.net3) v(XY3) v(XZ3) v(YZ3) v(XY4) v(XZ4) v(YZ4) v(S1P) v(S1N) v(S2P) v(S2N) v(S3P) v(S3N) v(VEXC)*i(V1) v(VDD1)*i(V2) v(VDD2)*i(V6) v(VDD3)*i(V3) v(VDD4)*i(V4)
* --------------------------------------------------------------------------
* FIELD SWEEP. Everything above turns the field and keeps its size; these two
* do the opposite -- hold the direction and sweep the MAGNITUDE, which is the
* axis a real magnet moves along as you walk towards it.
*
* The angle is parked at 60 deg, the middle of a sector: on a boundary the
* decision is meant to be undefined and the sweep would only measure noise.
*
* AND THE SWEEP DOES NOT START AT ZERO. With Vamp = 0 the three bridges are
* identical, so the three amplifiers sit at the same output and all three
* comparators land exactly on their trip point: the operating point is not
* unique and ngspice spends the sweep in gmin stepping. Starting one step in
* costs nothing and the solution is definite everywhere.
*
* Only the linear-amplifier chain, G2 (schematic) and G4 (layout), and their
* own new files so ancho.txt and fino.txt keep the column order analizar.py
* reads.
alter Vang = 60
dc Vamp 20u 0.02 20u
wrdata campo.txt v(S1P) v(S1N) v(S2P) v(S2N) v(S3P) v(S3N)
+ v(x3.SX) v(x3.SY) v(x3.SZ) v(x3.net1) v(x3.net2) v(x3.net3)
+ v(X2) v(Y2) v(Z2)
+ v(SX4) v(SY4) v(SZ4) v(XY4) v(XZ4) v(YZ4)
+ v(X4) v(Y4) v(Z4)
+ v(VDD2)*i(V6) v(VDD4)*i(V4)
* And the low end on its own scale, where the offsets and the noise live.
dc Vamp 1u 1m 1u
wrdata campo_fino.txt v(S1P) v(S1N) v(S2P) v(S2N) v(S3P) v(S3N)
+ v(x3.SX) v(x3.SY) v(x3.SZ) v(x3.net1) v(x3.net2) v(x3.net3)
+ v(X2) v(Y2) v(Z2)
+ v(SX4) v(SY4) v(SZ4) v(XY4) v(XZ4) v(YZ4)
+ v(X4) v(Y4) v(Z4)
+ v(VDD2)*i(V6) v(VDD4)*i(V4)
* --------------------------------------------------------------------------
* OCTANT CASES. Eight sign patterns times three magnitude orderings, so
* every axis gets to be the smallest, the middle one and the largest in
* each octant: 24 cases. The coefficients are written into the file as
* its first three vectors, so each file says which case it is and no
* separate manifest can drift out of step with it.
alter Vsel = 1
* case 01: c = (+1.0, +0.6, +0.3)  ->  expected Z
alter Vcx = 1.0
alter Vcy = 0.6
alter Vcz = 0.3
dc Vamp 200u 0.02 200u
wrdata oct_01.txt v(cx) v(cy) v(cz) v(S1P) v(S1N) v(S2P) v(S2N) v(S3P) v(S3N)
+ v(x3.SX) v(x3.SY) v(x3.SZ) v(x3.net1) v(x3.net2) v(x3.net3)
+ v(X2) v(Y2) v(Z2)
+ v(SX4) v(SY4) v(SZ4) v(XY4) v(XZ4) v(YZ4)
+ v(X4) v(Y4) v(Z4)
* case 02: c = (+0.3, +1.0, +0.6)  ->  expected X
alter Vcx = 0.3
alter Vcy = 1.0
alter Vcz = 0.6
dc Vamp 200u 0.02 200u
wrdata oct_02.txt v(cx) v(cy) v(cz) v(S1P) v(S1N) v(S2P) v(S2N) v(S3P) v(S3N)
+ v(x3.SX) v(x3.SY) v(x3.SZ) v(x3.net1) v(x3.net2) v(x3.net3)
+ v(X2) v(Y2) v(Z2)
+ v(SX4) v(SY4) v(SZ4) v(XY4) v(XZ4) v(YZ4)
+ v(X4) v(Y4) v(Z4)
* case 03: c = (+0.6, +0.3, +1.0)  ->  expected Y
alter Vcx = 0.6
alter Vcy = 0.3
alter Vcz = 1.0
dc Vamp 200u 0.02 200u
wrdata oct_03.txt v(cx) v(cy) v(cz) v(S1P) v(S1N) v(S2P) v(S2N) v(S3P) v(S3N)
+ v(x3.SX) v(x3.SY) v(x3.SZ) v(x3.net1) v(x3.net2) v(x3.net3)
+ v(X2) v(Y2) v(Z2)
+ v(SX4) v(SY4) v(SZ4) v(XY4) v(XZ4) v(YZ4)
+ v(X4) v(Y4) v(Z4)
* case 04: c = (+1.0, +0.6, -0.3)  ->  expected Z
alter Vcx = 1.0
alter Vcy = 0.6
alter Vcz = -0.3
dc Vamp 200u 0.02 200u
wrdata oct_04.txt v(cx) v(cy) v(cz) v(S1P) v(S1N) v(S2P) v(S2N) v(S3P) v(S3N)
+ v(x3.SX) v(x3.SY) v(x3.SZ) v(x3.net1) v(x3.net2) v(x3.net3)
+ v(X2) v(Y2) v(Z2)
+ v(SX4) v(SY4) v(SZ4) v(XY4) v(XZ4) v(YZ4)
+ v(X4) v(Y4) v(Z4)
* case 05: c = (+0.3, +1.0, -0.6)  ->  expected Z
alter Vcx = 0.3
alter Vcy = 1.0
alter Vcz = -0.6
dc Vamp 200u 0.02 200u
wrdata oct_05.txt v(cx) v(cy) v(cz) v(S1P) v(S1N) v(S2P) v(S2N) v(S3P) v(S3N)
+ v(x3.SX) v(x3.SY) v(x3.SZ) v(x3.net1) v(x3.net2) v(x3.net3)
+ v(X2) v(Y2) v(Z2)
+ v(SX4) v(SY4) v(SZ4) v(XY4) v(XZ4) v(YZ4)
+ v(X4) v(Y4) v(Z4)
* case 06: c = (+0.6, +0.3, -1.0)  ->  expected Z
alter Vcx = 0.6
alter Vcy = 0.3
alter Vcz = -1.0
dc Vamp 200u 0.02 200u
wrdata oct_06.txt v(cx) v(cy) v(cz) v(S1P) v(S1N) v(S2P) v(S2N) v(S3P) v(S3N)
+ v(x3.SX) v(x3.SY) v(x3.SZ) v(x3.net1) v(x3.net2) v(x3.net3)
+ v(X2) v(Y2) v(Z2)
+ v(SX4) v(SY4) v(SZ4) v(XY4) v(XZ4) v(YZ4)
+ v(X4) v(Y4) v(Z4)
* case 07: c = (+1.0, -0.6, +0.3)  ->  expected Y
alter Vcx = 1.0
alter Vcy = -0.6
alter Vcz = 0.3
dc Vamp 200u 0.02 200u
wrdata oct_07.txt v(cx) v(cy) v(cz) v(S1P) v(S1N) v(S2P) v(S2N) v(S3P) v(S3N)
+ v(x3.SX) v(x3.SY) v(x3.SZ) v(x3.net1) v(x3.net2) v(x3.net3)
+ v(X2) v(Y2) v(Z2)
+ v(SX4) v(SY4) v(SZ4) v(XY4) v(XZ4) v(YZ4)
+ v(X4) v(Y4) v(Z4)
* case 08: c = (+0.3, -1.0, +0.6)  ->  expected Y
alter Vcx = 0.3
alter Vcy = -1.0
alter Vcz = 0.6
dc Vamp 200u 0.02 200u
wrdata oct_08.txt v(cx) v(cy) v(cz) v(S1P) v(S1N) v(S2P) v(S2N) v(S3P) v(S3N)
+ v(x3.SX) v(x3.SY) v(x3.SZ) v(x3.net1) v(x3.net2) v(x3.net3)
+ v(X2) v(Y2) v(Z2)
+ v(SX4) v(SY4) v(SZ4) v(XY4) v(XZ4) v(YZ4)
+ v(X4) v(Y4) v(Z4)
* case 09: c = (+0.6, -0.3, +1.0)  ->  expected Y
alter Vcx = 0.6
alter Vcy = -0.3
alter Vcz = 1.0
dc Vamp 200u 0.02 200u
wrdata oct_09.txt v(cx) v(cy) v(cz) v(S1P) v(S1N) v(S2P) v(S2N) v(S3P) v(S3N)
+ v(x3.SX) v(x3.SY) v(x3.SZ) v(x3.net1) v(x3.net2) v(x3.net3)
+ v(X2) v(Y2) v(Z2)
+ v(SX4) v(SY4) v(SZ4) v(XY4) v(XZ4) v(YZ4)
+ v(X4) v(Y4) v(Z4)
* case 10: c = (+1.0, -0.6, -0.3)  ->  expected Y
alter Vcx = 1.0
alter Vcy = -0.6
alter Vcz = -0.3
dc Vamp 200u 0.02 200u
wrdata oct_10.txt v(cx) v(cy) v(cz) v(S1P) v(S1N) v(S2P) v(S2N) v(S3P) v(S3N)
+ v(x3.SX) v(x3.SY) v(x3.SZ) v(x3.net1) v(x3.net2) v(x3.net3)
+ v(X2) v(Y2) v(Z2)
+ v(SX4) v(SY4) v(SZ4) v(XY4) v(XZ4) v(YZ4)
+ v(X4) v(Y4) v(Z4)
* case 11: c = (+0.3, -1.0, -0.6)  ->  expected Y
alter Vcx = 0.3
alter Vcy = -1.0
alter Vcz = -0.6
dc Vamp 200u 0.02 200u
wrdata oct_11.txt v(cx) v(cy) v(cz) v(S1P) v(S1N) v(S2P) v(S2N) v(S3P) v(S3N)
+ v(x3.SX) v(x3.SY) v(x3.SZ) v(x3.net1) v(x3.net2) v(x3.net3)
+ v(X2) v(Y2) v(Z2)
+ v(SX4) v(SY4) v(SZ4) v(XY4) v(XZ4) v(YZ4)
+ v(X4) v(Y4) v(Z4)
* case 12: c = (+0.6, -0.3, -1.0)  ->  expected Z
alter Vcx = 0.6
alter Vcy = -0.3
alter Vcz = -1.0
dc Vamp 200u 0.02 200u
wrdata oct_12.txt v(cx) v(cy) v(cz) v(S1P) v(S1N) v(S2P) v(S2N) v(S3P) v(S3N)
+ v(x3.SX) v(x3.SY) v(x3.SZ) v(x3.net1) v(x3.net2) v(x3.net3)
+ v(X2) v(Y2) v(Z2)
+ v(SX4) v(SY4) v(SZ4) v(XY4) v(XZ4) v(YZ4)
+ v(X4) v(Y4) v(Z4)
* case 13: c = (-1.0, +0.6, +0.3)  ->  expected X
alter Vcx = -1.0
alter Vcy = 0.6
alter Vcz = 0.3
dc Vamp 200u 0.02 200u
wrdata oct_13.txt v(cx) v(cy) v(cz) v(S1P) v(S1N) v(S2P) v(S2N) v(S3P) v(S3N)
+ v(x3.SX) v(x3.SY) v(x3.SZ) v(x3.net1) v(x3.net2) v(x3.net3)
+ v(X2) v(Y2) v(Z2)
+ v(SX4) v(SY4) v(SZ4) v(XY4) v(XZ4) v(YZ4)
+ v(X4) v(Y4) v(Z4)
* case 14: c = (-0.3, +1.0, +0.6)  ->  expected X
alter Vcx = -0.3
alter Vcy = 1.0
alter Vcz = 0.6
dc Vamp 200u 0.02 200u
wrdata oct_14.txt v(cx) v(cy) v(cz) v(S1P) v(S1N) v(S2P) v(S2N) v(S3P) v(S3N)
+ v(x3.SX) v(x3.SY) v(x3.SZ) v(x3.net1) v(x3.net2) v(x3.net3)
+ v(X2) v(Y2) v(Z2)
+ v(SX4) v(SY4) v(SZ4) v(XY4) v(XZ4) v(YZ4)
+ v(X4) v(Y4) v(Z4)
* case 15: c = (-0.6, +0.3, +1.0)  ->  expected X
alter Vcx = -0.6
alter Vcy = 0.3
alter Vcz = 1.0
dc Vamp 200u 0.02 200u
wrdata oct_15.txt v(cx) v(cy) v(cz) v(S1P) v(S1N) v(S2P) v(S2N) v(S3P) v(S3N)
+ v(x3.SX) v(x3.SY) v(x3.SZ) v(x3.net1) v(x3.net2) v(x3.net3)
+ v(X2) v(Y2) v(Z2)
+ v(SX4) v(SY4) v(SZ4) v(XY4) v(XZ4) v(YZ4)
+ v(X4) v(Y4) v(Z4)
* case 16: c = (-1.0, +0.6, -0.3)  ->  expected X
alter Vcx = -1.0
alter Vcy = 0.6
alter Vcz = -0.3
dc Vamp 200u 0.02 200u
wrdata oct_16.txt v(cx) v(cy) v(cz) v(S1P) v(S1N) v(S2P) v(S2N) v(S3P) v(S3N)
+ v(x3.SX) v(x3.SY) v(x3.SZ) v(x3.net1) v(x3.net2) v(x3.net3)
+ v(X2) v(Y2) v(Z2)
+ v(SX4) v(SY4) v(SZ4) v(XY4) v(XZ4) v(YZ4)
+ v(X4) v(Y4) v(Z4)
* case 17: c = (-0.3, +1.0, -0.6)  ->  expected Z
alter Vcx = -0.3
alter Vcy = 1.0
alter Vcz = -0.6
dc Vamp 200u 0.02 200u
wrdata oct_17.txt v(cx) v(cy) v(cz) v(S1P) v(S1N) v(S2P) v(S2N) v(S3P) v(S3N)
+ v(x3.SX) v(x3.SY) v(x3.SZ) v(x3.net1) v(x3.net2) v(x3.net3)
+ v(X2) v(Y2) v(Z2)
+ v(SX4) v(SY4) v(SZ4) v(XY4) v(XZ4) v(YZ4)
+ v(X4) v(Y4) v(Z4)
* case 18: c = (-0.6, +0.3, -1.0)  ->  expected Z
alter Vcx = -0.6
alter Vcy = 0.3
alter Vcz = -1.0
dc Vamp 200u 0.02 200u
wrdata oct_18.txt v(cx) v(cy) v(cz) v(S1P) v(S1N) v(S2P) v(S2N) v(S3P) v(S3N)
+ v(x3.SX) v(x3.SY) v(x3.SZ) v(x3.net1) v(x3.net2) v(x3.net3)
+ v(X2) v(Y2) v(Z2)
+ v(SX4) v(SY4) v(SZ4) v(XY4) v(XZ4) v(YZ4)
+ v(X4) v(Y4) v(Z4)
* case 19: c = (-1.0, -0.6, +0.3)  ->  expected X
alter Vcx = -1.0
alter Vcy = -0.6
alter Vcz = 0.3
dc Vamp 200u 0.02 200u
wrdata oct_19.txt v(cx) v(cy) v(cz) v(S1P) v(S1N) v(S2P) v(S2N) v(S3P) v(S3N)
+ v(x3.SX) v(x3.SY) v(x3.SZ) v(x3.net1) v(x3.net2) v(x3.net3)
+ v(X2) v(Y2) v(Z2)
+ v(SX4) v(SY4) v(SZ4) v(XY4) v(XZ4) v(YZ4)
+ v(X4) v(Y4) v(Z4)
* case 20: c = (-0.3, -1.0, +0.6)  ->  expected Y
alter Vcx = -0.3
alter Vcy = -1.0
alter Vcz = 0.6
dc Vamp 200u 0.02 200u
wrdata oct_20.txt v(cx) v(cy) v(cz) v(S1P) v(S1N) v(S2P) v(S2N) v(S3P) v(S3N)
+ v(x3.SX) v(x3.SY) v(x3.SZ) v(x3.net1) v(x3.net2) v(x3.net3)
+ v(X2) v(Y2) v(Z2)
+ v(SX4) v(SY4) v(SZ4) v(XY4) v(XZ4) v(YZ4)
+ v(X4) v(Y4) v(Z4)
* case 21: c = (-0.6, -0.3, +1.0)  ->  expected X
alter Vcx = -0.6
alter Vcy = -0.3
alter Vcz = 1.0
dc Vamp 200u 0.02 200u
wrdata oct_21.txt v(cx) v(cy) v(cz) v(S1P) v(S1N) v(S2P) v(S2N) v(S3P) v(S3N)
+ v(x3.SX) v(x3.SY) v(x3.SZ) v(x3.net1) v(x3.net2) v(x3.net3)
+ v(X2) v(Y2) v(Z2)
+ v(SX4) v(SY4) v(SZ4) v(XY4) v(XZ4) v(YZ4)
+ v(X4) v(Y4) v(Z4)
* case 22: c = (-1.0, -0.6, -0.3)  ->  expected X
alter Vcx = -1.0
alter Vcy = -0.6
alter Vcz = -0.3
dc Vamp 200u 0.02 200u
wrdata oct_22.txt v(cx) v(cy) v(cz) v(S1P) v(S1N) v(S2P) v(S2N) v(S3P) v(S3N)
+ v(x3.SX) v(x3.SY) v(x3.SZ) v(x3.net1) v(x3.net2) v(x3.net3)
+ v(X2) v(Y2) v(Z2)
+ v(SX4) v(SY4) v(SZ4) v(XY4) v(XZ4) v(YZ4)
+ v(X4) v(Y4) v(Z4)
* case 23: c = (-0.3, -1.0, -0.6)  ->  expected Y
alter Vcx = -0.3
alter Vcy = -1.0
alter Vcz = -0.6
dc Vamp 200u 0.02 200u
wrdata oct_23.txt v(cx) v(cy) v(cz) v(S1P) v(S1N) v(S2P) v(S2N) v(S3P) v(S3N)
+ v(x3.SX) v(x3.SY) v(x3.SZ) v(x3.net1) v(x3.net2) v(x3.net3)
+ v(X2) v(Y2) v(Z2)
+ v(SX4) v(SY4) v(SZ4) v(XY4) v(XZ4) v(YZ4)
+ v(X4) v(Y4) v(Z4)
* case 24: c = (-0.6, -0.3, -1.0)  ->  expected Z
alter Vcx = -0.6
alter Vcy = -0.3
alter Vcz = -1.0
dc Vamp 200u 0.02 200u
wrdata oct_24.txt v(cx) v(cy) v(cz) v(S1P) v(S1N) v(S2P) v(S2N) v(S3P) v(S3N)
+ v(x3.SX) v(x3.SY) v(x3.SZ) v(x3.net1) v(x3.net2) v(x3.net3)
+ v(X2) v(Y2) v(Z2)
+ v(SX4) v(SY4) v(SZ4) v(XY4) v(XZ4) v(YZ4)
+ v(X4) v(Y4) v(Z4)
alter Vsel = 0
.endc

**** end user architecture code
**.ends

* expanding   symbol:  a_zonetic2026/XSCHEM/COMBINATION/GRADIENT.sym # of pins=11
** sym_path: /foss/designs/a_zonetic2026/XSCHEM/COMBINATION/GRADIENT.sym
** sch_path: /foss/designs/a_zonetic2026/XSCHEM/COMBINATION/GRADIENT.sch
.subckt GRADIENT SXN SXP VDD X SYN Y Z SYP VSS SZN SZP
*.ipin SXN
*.ipin SXP
*.iopin VDD
*.iopin VSS
*.iopin X
*.iopin Y
*.iopin Z
*.ipin SYN
*.ipin SYP
*.ipin SZN
*.ipin SZP
x1 VDD SXN SX SXP VSS OPAM
x2 VDD SYN SY SYP VSS OPAM
x3 VDD SZN SZ SZP VSS OPAM
x4 VDD SX net1 SY VSS COMP
x5 VDD SX net2 SZ VSS COMP
x6 VDD SY net3 SZ VSS COMP
x7 VDD net1 net2 X Y net3 Z VSS DECODER
.ends

* expanding   symbol:  a_zonetic2026/XSCHEM/COMBINATION/GRADIENT2.sym # of pins=11
** sym_path: /foss/designs/a_zonetic2026/XSCHEM/COMBINATION/GRADIENT2.sym
** sch_path: /foss/designs/a_zonetic2026/XSCHEM/COMBINATION/GRADIENT2.sch
.subckt GRADIENT2 SXN SXP VDD X SYN Y Z SYP VSS SZN SZP
*.ipin SXN
*.ipin SXP
*.iopin VDD
*.iopin VSS
*.iopin X
*.iopin Y
*.iopin Z
*.ipin SYN
*.ipin SYP
*.ipin SZN
*.ipin SZP
x4 VDD SX net1 SY VSS COMP
x5 VDD SX net2 SZ VSS COMP
x6 VDD SY net3 SZ VSS COMP
x7 VDD net1 net2 X Y net3 Z VSS DECODER
x8 VDD SXN SX SXP VSS OPAM_LIN
x1 VDD SYN SY SYP VSS OPAM_LIN
x2 VDD SZN SZ SZP VSS OPAM_LIN
.ends

* expanding   symbol:  a_zonetic2026/XSCHEM/OPAM/OPAM.sym # of pins=5
** sym_path: /foss/designs/a_zonetic2026/XSCHEM/OPAM/OPAM.sym
** sch_path: /foss/designs/a_zonetic2026/XSCHEM/OPAM/OPAM.sch
.subckt OPAM VDD INN OUT INP VSS
*.ipin INN
*.ipin INP
*.iopin VDD
*.iopin VSS
*.iopin OUT
XM11 net5 net1 VDD VDD pfet_06v0 L=1.0u W=10.0u nf=1 ad='int((nf+1)/2) * W/nf * 0.18u' as='int((nf+2)/2) * W/nf * 0.18u' pd='2*int((nf+1)/2)
+ * (W/nf + 0.18u)' ps='2*int((nf+2)/2) * (W/nf + 0.18u)' nrd='0.18u / W' nrs='0.18u / W' sa=0 sb=0 sd=0
XM12 net11 net6 net5 VDD pfet_06v0 L=1.0u W=10.0u nf=1 ad='int((nf+1)/2) * W/nf * 0.18u' as='int((nf+2)/2) * W/nf * 0.18u' pd='2*int((nf+1)/2)
+ * (W/nf + 0.18u)' ps='2*int((nf+2)/2) * (W/nf + 0.18u)' nrd='0.18u / W' nrs='0.18u / W' sa=0 sb=0 sd=0
XM13 net23 net1 VDD VDD pfet_06v0 L=1.0u W=10.0u nf=1 ad='int((nf+1)/2) * W/nf * 0.18u' as='int((nf+2)/2) * W/nf * 0.18u' pd='2*int((nf+1)/2)
+ * (W/nf + 0.18u)' ps='2*int((nf+2)/2) * (W/nf + 0.18u)' nrd='0.18u / W' nrs='0.18u / W' sa=0 sb=0 sd=0
XM14 net11 net6 net23 VDD pfet_06v0 L=1.0u W=10.0u nf=1 ad='int((nf+1)/2) * W/nf * 0.18u' as='int((nf+2)/2) * W/nf * 0.18u' pd='2*int((nf+1)/2)
+ * (W/nf + 0.18u)' ps='2*int((nf+2)/2) * (W/nf + 0.18u)' nrd='0.18u / W' nrs='0.18u / W' sa=0 sb=0 sd=0
XM15 net9 INP net11 VDD pfet_06v0 L=1.0u W=10.0u nf=1 ad='int((nf+1)/2) * W/nf * 0.18u' as='int((nf+2)/2) * W/nf * 0.18u' pd='2*int((nf+1)/2)
+ * (W/nf + 0.18u)' ps='2*int((nf+2)/2) * (W/nf + 0.18u)' nrd='0.18u / W' nrs='0.18u / W' sa=0 sb=0 sd=0
XM16 net8 INN net11 VDD pfet_06v0 L=1.0u W=10.0u nf=1 ad='int((nf+1)/2) * W/nf * 0.18u' as='int((nf+2)/2) * W/nf * 0.18u' pd='2*int((nf+1)/2)
+ * (W/nf + 0.18u)' ps='2*int((nf+2)/2) * (W/nf + 0.18u)' nrd='0.18u / W' nrs='0.18u / W' sa=0 sb=0 sd=0
XM17 net12 net4 net2 VSS nfet_06v0 L=1.0u W=5.0u nf=1 ad='int((nf+1)/2) * W/nf * 0.18u' as='int((nf+2)/2) * W/nf * 0.18u' pd='2*int((nf+1)/2)
+ * (W/nf + 0.18u)' ps='2*int((nf+2)/2) * (W/nf + 0.18u)' nrd='0.18u / W' nrs='0.18u / W' sa=0 sb=0 sd=0
XM18 net2 net3 VSS VSS nfet_06v0 L=1.0u W=5.0u nf=1 ad='int((nf+1)/2) * W/nf * 0.18u' as='int((nf+2)/2) * W/nf * 0.18u' pd='2*int((nf+1)/2)
+ * (W/nf + 0.18u)' ps='2*int((nf+2)/2) * (W/nf + 0.18u)' nrd='0.18u / W' nrs='0.18u / W' sa=0 sb=0 sd=0
XM19 net12 net4 net24 VSS nfet_06v0 L=1.0u W=5.0u nf=1 ad='int((nf+1)/2) * W/nf * 0.18u' as='int((nf+2)/2) * W/nf * 0.18u' pd='2*int((nf+1)/2)
+ * (W/nf + 0.18u)' ps='2*int((nf+2)/2) * (W/nf + 0.18u)' nrd='0.18u / W' nrs='0.18u / W' sa=0 sb=0 sd=0
XM20 net24 net3 VSS VSS nfet_06v0 L=1.0u W=5.0u nf=1 ad='int((nf+1)/2) * W/nf * 0.18u' as='int((nf+2)/2) * W/nf * 0.18u' pd='2*int((nf+1)/2)
+ * (W/nf + 0.18u)' ps='2*int((nf+2)/2) * (W/nf + 0.18u)' nrd='0.18u / W' nrs='0.18u / W' sa=0 sb=0 sd=0
XM21 net10 INP net12 VSS nfet_06v0 L=1.0u W=5u nf=1 ad='int((nf+1)/2) * W/nf * 0.18u' as='int((nf+2)/2) * W/nf * 0.18u' pd='2*int((nf+1)/2)
+ * (W/nf + 0.18u)' ps='2*int((nf+2)/2) * (W/nf + 0.18u)' nrd='0.18u / W' nrs='0.18u / W' sa=0 sb=0 sd=0
XM22 net7 INN net12 VSS nfet_06v0 L=1.0u W=5u nf=1 ad='int((nf+1)/2) * W/nf * 0.18u' as='int((nf+2)/2) * W/nf * 0.18u' pd='2*int((nf+1)/2)
+ * (W/nf + 0.18u)' ps='2*int((nf+2)/2) * (W/nf + 0.18u)' nrd='0.18u / W' nrs='0.18u / W' sa=0 sb=0 sd=0
XM29 net13 net6 net7 VDD pfet_06v0 L=1.0u W=5u nf=1 ad='int((nf+1)/2) * W/nf * 0.18u' as='int((nf+2)/2) * W/nf * 0.18u' pd='2*int((nf+1)/2)
+ * (W/nf + 0.18u)' ps='2*int((nf+2)/2) * (W/nf + 0.18u)' nrd='0.18u / W' nrs='0.18u / W' sa=0 sb=0 sd=0
XM30 net16 net6 net10 VDD pfet_06v0 L=1.0u W=5u nf=1 ad='int((nf+1)/2) * W/nf * 0.18u' as='int((nf+2)/2) * W/nf * 0.18u' pd='2*int((nf+1)/2)
+ * (W/nf + 0.18u)' ps='2*int((nf+2)/2) * (W/nf + 0.18u)' nrd='0.18u / W' nrs='0.18u / W' sa=0 sb=0 sd=0
XM31 net7 net13 VDD VDD pfet_06v0 L=1.0u W=5u nf=1 ad='int((nf+1)/2) * W/nf * 0.18u' as='int((nf+2)/2) * W/nf * 0.18u' pd='2*int((nf+1)/2)
+ * (W/nf + 0.18u)' ps='2*int((nf+2)/2) * (W/nf + 0.18u)' nrd='0.18u / W' nrs='0.18u / W' sa=0 sb=0 sd=0
XM35 net10 net13 VDD VDD pfet_06v0 L=1.0u W=5u nf=1 ad='int((nf+1)/2) * W/nf * 0.18u' as='int((nf+2)/2) * W/nf * 0.18u' pd='2*int((nf+1)/2)
+ * (W/nf + 0.18u)' ps='2*int((nf+2)/2) * (W/nf + 0.18u)' nrd='0.18u / W' nrs='0.18u / W' sa=0 sb=0 sd=0
XM32 net14 net25 net13 VDD pfet_06v0 L=1.0u W=5.0u nf=1 ad='int((nf+1)/2) * W/nf * 0.18u' as='int((nf+2)/2) * W/nf * 0.18u' pd='2*int((nf+1)/2)
+ * (W/nf + 0.18u)' ps='2*int((nf+2)/2) * (W/nf + 0.18u)' nrd='0.18u / W' nrs='0.18u / W' sa=0 sb=0 sd=0
XM33 net26 net25 net16 VDD pfet_06v0 L=1.0u W=5.0u nf=1 ad='int((nf+1)/2) * W/nf * 0.18u' as='int((nf+2)/2) * W/nf * 0.18u' pd='2*int((nf+1)/2)
+ * (W/nf + 0.18u)' ps='2*int((nf+2)/2) * (W/nf + 0.18u)' nrd='0.18u / W' nrs='0.18u / W' sa=0 sb=0 sd=0
XM23 net14 net4 net8 VSS nfet_06v0 L=1.0u W=2.5u nf=1 ad='int((nf+1)/2) * W/nf * 0.18u' as='int((nf+2)/2) * W/nf * 0.18u' pd='2*int((nf+1)/2)
+ * (W/nf + 0.18u)' ps='2*int((nf+2)/2) * (W/nf + 0.18u)' nrd='0.18u / W' nrs='0.18u / W' sa=0 sb=0 sd=0
XM24 net26 net4 net9 VSS nfet_06v0 L=1.0u W=2.5u nf=1 ad='int((nf+1)/2) * W/nf * 0.18u' as='int((nf+2)/2) * W/nf * 0.18u' pd='2*int((nf+1)/2)
+ * (W/nf + 0.18u)' ps='2*int((nf+2)/2) * (W/nf + 0.18u)' nrd='0.18u / W' nrs='0.18u / W' sa=0 sb=0 sd=0
XM25 net8 net14 VSS VSS nfet_06v0 L=1.0u W=2.5u nf=1 ad='int((nf+1)/2) * W/nf * 0.18u' as='int((nf+2)/2) * W/nf * 0.18u' pd='2*int((nf+1)/2)
+ * (W/nf + 0.18u)' ps='2*int((nf+2)/2) * (W/nf + 0.18u)' nrd='0.18u / W' nrs='0.18u / W' sa=0 sb=0 sd=0
XM26 net9 net14 VSS VSS nfet_06v0 L=1.0u W=2.5u nf=1 ad='int((nf+1)/2) * W/nf * 0.18u' as='int((nf+2)/2) * W/nf * 0.18u' pd='2*int((nf+1)/2)
+ * (W/nf + 0.18u)' ps='2*int((nf+2)/2) * (W/nf + 0.18u)' nrd='0.18u / W' nrs='0.18u / W' sa=0 sb=0 sd=0
XM27 net13 net15 net14 VSS nfet_06v0 L=1.0u W=2.5u nf=1 ad='int((nf+1)/2) * W/nf * 0.18u' as='int((nf+2)/2) * W/nf * 0.18u' pd='2*int((nf+1)/2)
+ * (W/nf + 0.18u)' ps='2*int((nf+2)/2) * (W/nf + 0.18u)' nrd='0.18u / W' nrs='0.18u / W' sa=0 sb=0 sd=0
XM28 net16 net15 net26 VSS nfet_06v0 L=1.0u W=2.5u nf=1 ad='int((nf+1)/2) * W/nf * 0.18u' as='int((nf+2)/2) * W/nf * 0.18u' pd='2*int((nf+1)/2)
+ * (W/nf + 0.18u)' ps='2*int((nf+2)/2) * (W/nf + 0.18u)' nrd='0.18u / W' nrs='0.18u / W' sa=0 sb=0 sd=0
XM34 net17 net18 VDD VDD pfet_06v0 L=1.0u W=10.0u nf=1 ad='int((nf+1)/2) * W/nf * 0.18u' as='int((nf+2)/2) * W/nf * 0.18u' pd='2*int((nf+1)/2)
+ * (W/nf + 0.18u)' ps='2*int((nf+2)/2) * (W/nf + 0.18u)' nrd='0.18u / W' nrs='0.18u / W' sa=0 sb=0 sd=0
XM36 net18 net6 net17 VDD pfet_06v0 L=1.0u W=10.0u nf=1 ad='int((nf+1)/2) * W/nf * 0.18u' as='int((nf+2)/2) * W/nf * 0.18u' pd='2*int((nf+1)/2)
+ * (W/nf + 0.18u)' ps='2*int((nf+2)/2) * (W/nf + 0.18u)' nrd='0.18u / W' nrs='0.18u / W' sa=0 sb=0 sd=0
XM37 net25 net25 net18 VDD pfet_06v0 L=1.0u W=10.0u nf=1 ad='int((nf+1)/2) * W/nf * 0.18u' as='int((nf+2)/2) * W/nf * 0.18u' pd='2*int((nf+1)/2)
+ * (W/nf + 0.18u)' ps='2*int((nf+2)/2) * (W/nf + 0.18u)' nrd='0.18u / W' nrs='0.18u / W' sa=0 sb=0 sd=0
XM38 net25 net4 net19 VSS nfet_06v0 L=1.0u W=5.0u nf=1 ad='int((nf+1)/2) * W/nf * 0.18u' as='int((nf+2)/2) * W/nf * 0.18u' pd='2*int((nf+1)/2)
+ * (W/nf + 0.18u)' ps='2*int((nf+2)/2) * (W/nf + 0.18u)' nrd='0.18u / W' nrs='0.18u / W' sa=0 sb=0 sd=0
XM39 net19 net3 VSS VSS nfet_06v0 L=1.0u W=5.0u nf=1 ad='int((nf+1)/2) * W/nf * 0.18u' as='int((nf+2)/2) * W/nf * 0.18u' pd='2*int((nf+1)/2)
+ * (W/nf + 0.18u)' ps='2*int((nf+2)/2) * (W/nf + 0.18u)' nrd='0.18u / W' nrs='0.18u / W' sa=0 sb=0 sd=0
XM45 net20 net1 VDD VDD pfet_06v0 L=1.0u W=10.0u nf=1 ad='int((nf+1)/2) * W/nf * 0.18u' as='int((nf+2)/2) * W/nf * 0.18u' pd='2*int((nf+1)/2)
+ * (W/nf + 0.18u)' ps='2*int((nf+2)/2) * (W/nf + 0.18u)' nrd='0.18u / W' nrs='0.18u / W' sa=0 sb=0 sd=0
XM46 net15 net6 net20 VDD pfet_06v0 L=1.0u W=10.0u nf=1 ad='int((nf+1)/2) * W/nf * 0.18u' as='int((nf+2)/2) * W/nf * 0.18u' pd='2*int((nf+1)/2)
+ * (W/nf + 0.18u)' ps='2*int((nf+2)/2) * (W/nf + 0.18u)' nrd='0.18u / W' nrs='0.18u / W' sa=0 sb=0 sd=0
XM40 net15 net15 net22 VSS nfet_06v0 L=1.0u W=5.0u nf=1 ad='int((nf+1)/2) * W/nf * 0.18u' as='int((nf+2)/2) * W/nf * 0.18u' pd='2*int((nf+1)/2)
+ * (W/nf + 0.18u)' ps='2*int((nf+2)/2) * (W/nf + 0.18u)' nrd='0.18u / W' nrs='0.18u / W' sa=0 sb=0 sd=0
XM41 net22 net4 net21 VSS nfet_06v0 L=1.0u W=5.0u nf=1 ad='int((nf+1)/2) * W/nf * 0.18u' as='int((nf+2)/2) * W/nf * 0.18u' pd='2*int((nf+1)/2)
+ * (W/nf + 0.18u)' ps='2*int((nf+2)/2) * (W/nf + 0.18u)' nrd='0.18u / W' nrs='0.18u / W' sa=0 sb=0 sd=0
XM42 net21 net22 VSS VSS nfet_06v0 L=1.0u W=5.0u nf=1 ad='int((nf+1)/2) * W/nf * 0.18u' as='int((nf+2)/2) * W/nf * 0.18u' pd='2*int((nf+1)/2)
+ * (W/nf + 0.18u)' ps='2*int((nf+2)/2) * (W/nf + 0.18u)' nrd='0.18u / W' nrs='0.18u / W' sa=0 sb=0 sd=0
XM43 OUT net16 VDD VDD pfet_06v0 L=20.0u W=0.7u nf=1 ad='int((nf+1)/2) * W/nf * 0.18u' as='int((nf+2)/2) * W/nf * 0.18u' pd='2*int((nf+1)/2)
+ * (W/nf + 0.18u)' ps='2*int((nf+2)/2) * (W/nf + 0.18u)' nrd='0.18u / W' nrs='0.18u / W' sa=0 sb=0 sd=0
XM44 OUT net26 VSS VSS nfet_06v0 L=1.0u W=1.0u nf=1 ad='int((nf+1)/2) * W/nf * 0.18u' as='int((nf+2)/2) * W/nf * 0.18u' pd='2*int((nf+1)/2)
+ * (W/nf + 0.18u)' ps='2*int((nf+2)/2) * (W/nf + 0.18u)' nrd='0.18u / W' nrs='0.18u / W' sa=0 sb=0 sd=0
XC3 net10 OUT cap_mim_2f0fF c_width=20e-6 c_length=10e-6
XC1 OUT net9 cap_mim_2f0fF c_width=20e-6 c_length=10e-6
XM4 net29 net1 VDD VDD pfet_06v0 L=1.0u W=10.0u nf=1 ad='int((nf+1)/2) * W/nf * 0.18u' as='int((nf+2)/2) * W/nf * 0.18u' pd='2*int((nf+1)/2)
+ * (W/nf + 0.18u)' ps='2*int((nf+2)/2) * (W/nf + 0.18u)' nrd='0.18u / W' nrs='0.18u / W' sa=0 sb=0 sd=0
XM5 net4 net6 net29 VDD pfet_06v0 L=1.0u W=10.0u nf=1 ad='int((nf+1)/2) * W/nf * 0.18u' as='int((nf+2)/2) * W/nf * 0.18u' pd='2*int((nf+1)/2)
+ * (W/nf + 0.18u)' ps='2*int((nf+2)/2) * (W/nf + 0.18u)' nrd='0.18u / W' nrs='0.18u / W' sa=0 sb=0 sd=0
XM6 net4 net4 VSS VSS nfet_06v0 L=1.0u W=1.0u nf=1 ad='int((nf+1)/2) * W/nf * 0.18u' as='int((nf+2)/2) * W/nf * 0.18u' pd='2*int((nf+1)/2)
+ * (W/nf + 0.18u)' ps='2*int((nf+2)/2) * (W/nf + 0.18u)' nrd='0.18u / W' nrs='0.18u / W' sa=0 sb=0 sd=0
XM7 net28 net1 VDD VDD pfet_06v0 L=1.0u W=10.0u nf=1 ad='int((nf+1)/2) * W/nf * 0.18u' as='int((nf+2)/2) * W/nf * 0.18u' pd='2*int((nf+1)/2)
+ * (W/nf + 0.18u)' ps='2*int((nf+2)/2) * (W/nf + 0.18u)' nrd='0.18u / W' nrs='0.18u / W' sa=0 sb=0 sd=0
XM8 net3 net6 net28 VDD pfet_06v0 L=1.0u W=10.0u nf=1 ad='int((nf+1)/2) * W/nf * 0.18u' as='int((nf+2)/2) * W/nf * 0.18u' pd='2*int((nf+1)/2)
+ * (W/nf + 0.18u)' ps='2*int((nf+2)/2) * (W/nf + 0.18u)' nrd='0.18u / W' nrs='0.18u / W' sa=0 sb=0 sd=0
XM9 net3 net4 net27 VSS nfet_06v0 L=1.0u W=5.0u nf=1 ad='int((nf+1)/2) * W/nf * 0.18u' as='int((nf+2)/2) * W/nf * 0.18u' pd='2*int((nf+1)/2)
+ * (W/nf + 0.18u)' ps='2*int((nf+2)/2) * (W/nf + 0.18u)' nrd='0.18u / W' nrs='0.18u / W' sa=0 sb=0 sd=0
XM10 net27 net3 VSS VSS nfet_06v0 L=1.0u W=5.0u nf=1 ad='int((nf+1)/2) * W/nf * 0.18u' as='int((nf+2)/2) * W/nf * 0.18u' pd='2*int((nf+1)/2)
+ * (W/nf + 0.18u)' ps='2*int((nf+2)/2) * (W/nf + 0.18u)' nrd='0.18u / W' nrs='0.18u / W' sa=0 sb=0 sd=0
XM1 net6 net6 VDD VDD pfet_06v0 L=1.0u W=2u nf=1 ad='int((nf+1)/2) * W/nf * 0.18u' as='int((nf+2)/2) * W/nf * 0.18u' pd='2*int((nf+1)/2)
+ * (W/nf + 0.18u)' ps='2*int((nf+2)/2) * (W/nf + 0.18u)' nrd='0.18u / W' nrs='0.18u / W' sa=0 sb=0 sd=0
XM2 net30 net1 VDD VDD pfet_06v0 L=1.0u W=10.0u nf=1 ad='int((nf+1)/2) * W/nf * 0.18u' as='int((nf+2)/2) * W/nf * 0.18u' pd='2*int((nf+1)/2)
+ * (W/nf + 0.18u)' ps='2*int((nf+2)/2) * (W/nf + 0.18u)' nrd='0.18u / W' nrs='0.18u / W' sa=0 sb=0 sd=0
XM3 net1 net6 net30 VDD pfet_06v0 L=1.0u W=10.0u nf=1 ad='int((nf+1)/2) * W/nf * 0.18u' as='int((nf+2)/2) * W/nf * 0.18u' pd='2*int((nf+1)/2)
+ * (W/nf + 0.18u)' ps='2*int((nf+2)/2) * (W/nf + 0.18u)' nrd='0.18u / W' nrs='0.18u / W' sa=0 sb=0 sd=0
XM47 net31 net6 VSS VSS nfet_06v0 L=1.0u W=1.0u nf=1 ad='int((nf+1)/2) * W/nf * 0.18u' as='int((nf+2)/2) * W/nf * 0.18u' pd='2*int((nf+1)/2)
+ * (W/nf + 0.18u)' ps='2*int((nf+2)/2) * (W/nf + 0.18u)' nrd='0.18u / W' nrs='0.18u / W' sa=0 sb=0 sd=0
XM48 net32 net6 VSS VSS nfet_06v0 L=1.0u W=1.0u nf=1 ad='int((nf+1)/2) * W/nf * 0.18u' as='int((nf+2)/2) * W/nf * 0.18u' pd='2*int((nf+1)/2)
+ * (W/nf + 0.18u)' ps='2*int((nf+2)/2) * (W/nf + 0.18u)' nrd='0.18u / W' nrs='0.18u / W' sa=0 sb=0 sd=0
XM49 net6 net6 net32 VSS nfet_06v0 L=1.0u W=1.0u nf=1 ad='int((nf+1)/2) * W/nf * 0.18u' as='int((nf+2)/2) * W/nf * 0.18u' pd='2*int((nf+1)/2)
+ * (W/nf + 0.18u)' ps='2*int((nf+2)/2) * (W/nf + 0.18u)' nrd='0.18u / W' nrs='0.18u / W' sa=0 sb=0 sd=0
XM50 net1 net6 net31 VSS nfet_06v0 L=1.0u W=1.0u nf=1 ad='int((nf+1)/2) * W/nf * 0.18u' as='int((nf+2)/2) * W/nf * 0.18u' pd='2*int((nf+1)/2)
+ * (W/nf + 0.18u)' ps='2*int((nf+2)/2) * (W/nf + 0.18u)' nrd='0.18u / W' nrs='0.18u / W' sa=0 sb=0 sd=0
.ends

* expanding   symbol:  a_zonetic2026/XSCHEM/OPAM/COMP.sym # of pins=5
** sym_path: /foss/designs/a_zonetic2026/XSCHEM/OPAM/COMP.sym
** sch_path: /foss/designs/a_zonetic2026/XSCHEM/OPAM/COMP.sch
.subckt COMP VDD INN OUT INP VSS
*.ipin INN
*.ipin INP
*.iopin VDD
*.iopin VSS
*.iopin OUT
x1 VDD net4 net3 net2 net1 VSS bias
x2 VDD net4 net3 INN OUT INP net2 net1 VSS sub_diff
.ends

* expanding   symbol:  a_zonetic2026/XSCHEM/DECODER/DECODER.sym # of pins=8
** sym_path: /foss/designs/a_zonetic2026/XSCHEM/DECODER/DECODER.sym
** sch_path: /foss/designs/a_zonetic2026/XSCHEM/DECODER/DECODER.sch
.subckt DECODER VDD XY XZ X Y YZ Z VSS
*.ipin XY
*.ipin XZ
*.iopin VDD
*.iopin VSS
*.iopin X
*.ipin YZ
*.iopin Y
*.iopin Z
x2 YZ XY VDD Y VSS yGates
x1 VSS VDD XZ YZ Z Z
x3 VDD XY X XZ VSS xGates
.ends

* expanding   symbol:  a_zonetic2026/XSCHEM/OPAM/OPAM_LIN.sym # of pins=5
** sym_path: /foss/designs/a_zonetic2026/XSCHEM/OPAM/OPAM_LIN.sym
** sch_path: /foss/designs/a_zonetic2026/XSCHEM/OPAM/OPAM_LIN.sch
.subckt OPAM_LIN VDD INN OUT INP VSS
*.ipin INN
*.ipin INP
*.iopin VDD
*.iopin VSS
*.iopin OUT
x1 VDD net3 net4 net2 net1 VSS bias
x2 VDD net3 net4 OUT INN INP net2 net1 VSS sub_diff_2_LIN
.ends

* expanding   symbol:  a_zonetic2026/XSCHEM/OPAM/bias.sym # of pins=6
** sym_path: /foss/designs/a_zonetic2026/XSCHEM/OPAM/bias.sym
** sch_path: /foss/designs/a_zonetic2026/XSCHEM/OPAM/bias.sch
.subckt bias vdd bias1 bias2 bias3 bias4 vss
*.opin bias1
*.opin bias2
*.opin bias3
*.opin bias4
*.iopin vdd
*.iopin vss
XM4 net3 bias1 vdd vdd pfet_06v0 L=1.0u W=10.0u nf=1 ad='int((nf+1)/2) * W/nf * 0.18u' as='int((nf+2)/2) * W/nf * 0.18u' pd='2*int((nf+1)/2)
+ * (W/nf + 0.18u)' ps='2*int((nf+2)/2) * (W/nf + 0.18u)' nrd='0.18u / W' nrs='0.18u / W' sa=0 sb=0 sd=0
XM5 bias3 bias2 net3 vdd pfet_06v0 L=1.0u W=10.0u nf=1 ad='int((nf+1)/2) * W/nf * 0.18u' as='int((nf+2)/2) * W/nf * 0.18u' pd='2*int((nf+1)/2)
+ * (W/nf + 0.18u)' ps='2*int((nf+2)/2) * (W/nf + 0.18u)' nrd='0.18u / W' nrs='0.18u / W' sa=0 sb=0 sd=0
XM6 bias3 bias3 vss vss nfet_06v0 L=1.0u W=1.0u nf=1 ad='int((nf+1)/2) * W/nf * 0.18u' as='int((nf+2)/2) * W/nf * 0.18u' pd='2*int((nf+1)/2)
+ * (W/nf + 0.18u)' ps='2*int((nf+2)/2) * (W/nf + 0.18u)' nrd='0.18u / W' nrs='0.18u / W' sa=0 sb=0 sd=0
XM7 net2 bias1 vdd vdd pfet_06v0 L=1.0u W=10.0u nf=1 ad='int((nf+1)/2) * W/nf * 0.18u' as='int((nf+2)/2) * W/nf * 0.18u' pd='2*int((nf+1)/2)
+ * (W/nf + 0.18u)' ps='2*int((nf+2)/2) * (W/nf + 0.18u)' nrd='0.18u / W' nrs='0.18u / W' sa=0 sb=0 sd=0
XM8 bias4 bias2 net2 vdd pfet_06v0 L=1.0u W=10.0u nf=1 ad='int((nf+1)/2) * W/nf * 0.18u' as='int((nf+2)/2) * W/nf * 0.18u' pd='2*int((nf+1)/2)
+ * (W/nf + 0.18u)' ps='2*int((nf+2)/2) * (W/nf + 0.18u)' nrd='0.18u / W' nrs='0.18u / W' sa=0 sb=0 sd=0
XM9 bias4 bias3 net1 vss nfet_06v0 L=1.0u W=5.0u nf=1 ad='int((nf+1)/2) * W/nf * 0.18u' as='int((nf+2)/2) * W/nf * 0.18u' pd='2*int((nf+1)/2)
+ * (W/nf + 0.18u)' ps='2*int((nf+2)/2) * (W/nf + 0.18u)' nrd='0.18u / W' nrs='0.18u / W' sa=0 sb=0 sd=0
XM10 net1 bias4 vss vss nfet_06v0 L=1.0u W=5.0u nf=1 ad='int((nf+1)/2) * W/nf * 0.18u' as='int((nf+2)/2) * W/nf * 0.18u' pd='2*int((nf+1)/2)
+ * (W/nf + 0.18u)' ps='2*int((nf+2)/2) * (W/nf + 0.18u)' nrd='0.18u / W' nrs='0.18u / W' sa=0 sb=0 sd=0
XM1 bias2 bias2 vdd vdd pfet_06v0 L=1.0u W=2u nf=1 ad='int((nf+1)/2) * W/nf * 0.18u' as='int((nf+2)/2) * W/nf * 0.18u' pd='2*int((nf+1)/2)
+ * (W/nf + 0.18u)' ps='2*int((nf+2)/2) * (W/nf + 0.18u)' nrd='0.18u / W' nrs='0.18u / W' sa=0 sb=0 sd=0
XM2 net4 bias1 vdd vdd pfet_06v0 L=1.0u W=10.0u nf=1 ad='int((nf+1)/2) * W/nf * 0.18u' as='int((nf+2)/2) * W/nf * 0.18u' pd='2*int((nf+1)/2)
+ * (W/nf + 0.18u)' ps='2*int((nf+2)/2) * (W/nf + 0.18u)' nrd='0.18u / W' nrs='0.18u / W' sa=0 sb=0 sd=0
XM3 bias1 bias2 net4 vdd pfet_06v0 L=1.0u W=10.0u nf=1 ad='int((nf+1)/2) * W/nf * 0.18u' as='int((nf+2)/2) * W/nf * 0.18u' pd='2*int((nf+1)/2)
+ * (W/nf + 0.18u)' ps='2*int((nf+2)/2) * (W/nf + 0.18u)' nrd='0.18u / W' nrs='0.18u / W' sa=0 sb=0 sd=0
XM47 net5 bias2 vss vss nfet_06v0 L=1.0u W=1.0u nf=1 ad='int((nf+1)/2) * W/nf * 0.18u' as='int((nf+2)/2) * W/nf * 0.18u' pd='2*int((nf+1)/2)
+ * (W/nf + 0.18u)' ps='2*int((nf+2)/2) * (W/nf + 0.18u)' nrd='0.18u / W' nrs='0.18u / W' sa=0 sb=0 sd=0
XM48 net6 bias2 vss vss nfet_06v0 L=1.0u W=1.0u nf=1 ad='int((nf+1)/2) * W/nf * 0.18u' as='int((nf+2)/2) * W/nf * 0.18u' pd='2*int((nf+1)/2)
+ * (W/nf + 0.18u)' ps='2*int((nf+2)/2) * (W/nf + 0.18u)' nrd='0.18u / W' nrs='0.18u / W' sa=0 sb=0 sd=0
XM49 bias2 bias2 net6 vss nfet_06v0 L=1.0u W=1.0u nf=1 ad='int((nf+1)/2) * W/nf * 0.18u' as='int((nf+2)/2) * W/nf * 0.18u' pd='2*int((nf+1)/2)
+ * (W/nf + 0.18u)' ps='2*int((nf+2)/2) * (W/nf + 0.18u)' nrd='0.18u / W' nrs='0.18u / W' sa=0 sb=0 sd=0
XM50 bias1 bias2 net5 vss nfet_06v0 L=1.0u W=1.0u nf=1 ad='int((nf+1)/2) * W/nf * 0.18u' as='int((nf+2)/2) * W/nf * 0.18u' pd='2*int((nf+1)/2)
+ * (W/nf + 0.18u)' ps='2*int((nf+2)/2) * (W/nf + 0.18u)' nrd='0.18u / W' nrs='0.18u / W' sa=0 sb=0 sd=0
.ends

* expanding   symbol:  a_zonetic2026/XSCHEM/OPAM/sub_diff.sym # of pins=9
** sym_path: /foss/designs/a_zonetic2026/XSCHEM/OPAM/sub_diff.sym
** sch_path: /foss/designs/a_zonetic2026/XSCHEM/OPAM/sub_diff.sch
.subckt sub_diff vdd bias1 bias2 vinn out vinp bias3 bias4 vss
*.opin out
*.iopin vdd
*.iopin vss
*.ipin vinp
*.ipin vinn
*.ipin bias1
*.ipin bias2
*.ipin bias3
*.ipin bias4
XM11 net2 bias1 vdd vdd pfet_06v0 L=1.0u W=10.0u nf=1 ad='int((nf+1)/2) * W/nf * 0.18u' as='int((nf+2)/2) * W/nf * 0.18u' pd='2*int((nf+1)/2)
+ * (W/nf + 0.18u)' ps='2*int((nf+2)/2) * (W/nf + 0.18u)' nrd='0.18u / W' nrs='0.18u / W' sa=0 sb=0 sd=0
XM12 net7 bias2 net2 vdd pfet_06v0 L=1.0u W=10.0u nf=1 ad='int((nf+1)/2) * W/nf * 0.18u' as='int((nf+2)/2) * W/nf * 0.18u' pd='2*int((nf+1)/2)
+ * (W/nf + 0.18u)' ps='2*int((nf+2)/2) * (W/nf + 0.18u)' nrd='0.18u / W' nrs='0.18u / W' sa=0 sb=0 sd=0
XM13 net19 bias1 vdd vdd pfet_06v0 L=1.0u W=10.0u nf=1 ad='int((nf+1)/2) * W/nf * 0.18u' as='int((nf+2)/2) * W/nf * 0.18u' pd='2*int((nf+1)/2)
+ * (W/nf + 0.18u)' ps='2*int((nf+2)/2) * (W/nf + 0.18u)' nrd='0.18u / W' nrs='0.18u / W' sa=0 sb=0 sd=0
XM14 net7 bias2 net19 vdd pfet_06v0 L=1.0u W=10.0u nf=1 ad='int((nf+1)/2) * W/nf * 0.18u' as='int((nf+2)/2) * W/nf * 0.18u' pd='2*int((nf+1)/2)
+ * (W/nf + 0.18u)' ps='2*int((nf+2)/2) * (W/nf + 0.18u)' nrd='0.18u / W' nrs='0.18u / W' sa=0 sb=0 sd=0
XM15 net5 vinp net7 vdd pfet_06v0 L=1.0u W=10.0u nf=1 ad='int((nf+1)/2) * W/nf * 0.18u' as='int((nf+2)/2) * W/nf * 0.18u' pd='2*int((nf+1)/2)
+ * (W/nf + 0.18u)' ps='2*int((nf+2)/2) * (W/nf + 0.18u)' nrd='0.18u / W' nrs='0.18u / W' sa=0 sb=0 sd=0 m=2
XM16 net4 vinn net7 vdd pfet_06v0 L=1.0u W=10.0u nf=1 ad='int((nf+1)/2) * W/nf * 0.18u' as='int((nf+2)/2) * W/nf * 0.18u' pd='2*int((nf+1)/2)
+ * (W/nf + 0.18u)' ps='2*int((nf+2)/2) * (W/nf + 0.18u)' nrd='0.18u / W' nrs='0.18u / W' sa=0 sb=0 sd=0 m=2
XM17 net8 bias3 net1 vss nfet_06v0 L=1.0u W=5.0u nf=1 ad='int((nf+1)/2) * W/nf * 0.18u' as='int((nf+2)/2) * W/nf * 0.18u' pd='2*int((nf+1)/2)
+ * (W/nf + 0.18u)' ps='2*int((nf+2)/2) * (W/nf + 0.18u)' nrd='0.18u / W' nrs='0.18u / W' sa=0 sb=0 sd=0
XM18 net1 bias4 vss vss nfet_06v0 L=1.0u W=5.0u nf=1 ad='int((nf+1)/2) * W/nf * 0.18u' as='int((nf+2)/2) * W/nf * 0.18u' pd='2*int((nf+1)/2)
+ * (W/nf + 0.18u)' ps='2*int((nf+2)/2) * (W/nf + 0.18u)' nrd='0.18u / W' nrs='0.18u / W' sa=0 sb=0 sd=0
XM19 net8 bias3 net20 vss nfet_06v0 L=1.0u W=5.0u nf=1 ad='int((nf+1)/2) * W/nf * 0.18u' as='int((nf+2)/2) * W/nf * 0.18u' pd='2*int((nf+1)/2)
+ * (W/nf + 0.18u)' ps='2*int((nf+2)/2) * (W/nf + 0.18u)' nrd='0.18u / W' nrs='0.18u / W' sa=0 sb=0 sd=0
XM20 net20 bias4 vss vss nfet_06v0 L=1.0u W=5.0u nf=1 ad='int((nf+1)/2) * W/nf * 0.18u' as='int((nf+2)/2) * W/nf * 0.18u' pd='2*int((nf+1)/2)
+ * (W/nf + 0.18u)' ps='2*int((nf+2)/2) * (W/nf + 0.18u)' nrd='0.18u / W' nrs='0.18u / W' sa=0 sb=0 sd=0
XM21 net6 vinp net8 vss nfet_06v0 L=1.0u W=5u nf=1 ad='int((nf+1)/2) * W/nf * 0.18u' as='int((nf+2)/2) * W/nf * 0.18u' pd='2*int((nf+1)/2)
+ * (W/nf + 0.18u)' ps='2*int((nf+2)/2) * (W/nf + 0.18u)' nrd='0.18u / W' nrs='0.18u / W' sa=0 sb=0 sd=0 m=2
XM22 net3 vinn net8 vss nfet_06v0 L=1.0u W=5u nf=1 ad='int((nf+1)/2) * W/nf * 0.18u' as='int((nf+2)/2) * W/nf * 0.18u' pd='2*int((nf+1)/2)
+ * (W/nf + 0.18u)' ps='2*int((nf+2)/2) * (W/nf + 0.18u)' nrd='0.18u / W' nrs='0.18u / W' sa=0 sb=0 sd=0 m=2
XM29 net9 bias2 net3 vdd pfet_06v0 L=1.0u W=5u nf=1 ad='int((nf+1)/2) * W/nf * 0.18u' as='int((nf+2)/2) * W/nf * 0.18u' pd='2*int((nf+1)/2)
+ * (W/nf + 0.18u)' ps='2*int((nf+2)/2) * (W/nf + 0.18u)' nrd='0.18u / W' nrs='0.18u / W' sa=0 sb=0 sd=0 m=2
XM30 net12 bias2 net6 vdd pfet_06v0 L=1.0u W=5.0u nf=1 ad='int((nf+1)/2) * W/nf * 0.18u' as='int((nf+2)/2) * W/nf * 0.18u' pd='2*int((nf+1)/2)
+ * (W/nf + 0.18u)' ps='2*int((nf+2)/2) * (W/nf + 0.18u)' nrd='0.18u / W' nrs='0.18u / W' sa=0 sb=0 sd=0 m=2
XM31 net3 net9 vdd vdd pfet_06v0 L=1.0u W=5u nf=1 ad='int((nf+1)/2) * W/nf * 0.18u' as='int((nf+2)/2) * W/nf * 0.18u' pd='2*int((nf+1)/2)
+ * (W/nf + 0.18u)' ps='2*int((nf+2)/2) * (W/nf + 0.18u)' nrd='0.18u / W' nrs='0.18u / W' sa=0 sb=0 sd=0 m=4
XM35 net6 net9 vdd vdd pfet_06v0 L=1.0u W=5.0u nf=1 ad='int((nf+1)/2) * W/nf * 0.18u' as='int((nf+2)/2) * W/nf * 0.18u' pd='2*int((nf+1)/2)
+ * (W/nf + 0.18u)' ps='2*int((nf+2)/2) * (W/nf + 0.18u)' nrd='0.18u / W' nrs='0.18u / W' sa=0 sb=0 sd=0 m=4
XM32 net10 net21 net9 vdd pfet_06v0 L=1.0u W=5u nf=1 ad='int((nf+1)/2) * W/nf * 0.18u' as='int((nf+2)/2) * W/nf * 0.18u' pd='2*int((nf+1)/2)
+ * (W/nf + 0.18u)' ps='2*int((nf+2)/2) * (W/nf + 0.18u)' nrd='0.18u / W' nrs='0.18u / W' sa=0 sb=0 sd=0
XM33 net22 net21 net12 vdd pfet_06v0 L=1.0u W=5.0u nf=1 ad='int((nf+1)/2) * W/nf * 0.18u' as='int((nf+2)/2) * W/nf * 0.18u' pd='2*int((nf+1)/2)
+ * (W/nf + 0.18u)' ps='2*int((nf+2)/2) * (W/nf + 0.18u)' nrd='0.18u / W' nrs='0.18u / W' sa=0 sb=0 sd=0
XM23 net10 bias3 net4 vss nfet_06v0 L=1.0u W=2.5u nf=1 ad='int((nf+1)/2) * W/nf * 0.18u' as='int((nf+2)/2) * W/nf * 0.18u' pd='2*int((nf+1)/2)
+ * (W/nf + 0.18u)' ps='2*int((nf+2)/2) * (W/nf + 0.18u)' nrd='0.18u / W' nrs='0.18u / W' sa=0 sb=0 sd=0 m=2
XM24 net22 bias3 net5 vss nfet_06v0 L=1.0u W=2.5u nf=1 ad='int((nf+1)/2) * W/nf * 0.18u' as='int((nf+2)/2) * W/nf * 0.18u' pd='2*int((nf+1)/2)
+ * (W/nf + 0.18u)' ps='2*int((nf+2)/2) * (W/nf + 0.18u)' nrd='0.18u / W' nrs='0.18u / W' sa=0 sb=0 sd=0 m=2
XM25 net4 net10 vss vss nfet_06v0 L=1.0u W=2.5u nf=1 ad='int((nf+1)/2) * W/nf * 0.18u' as='int((nf+2)/2) * W/nf * 0.18u' pd='2*int((nf+1)/2)
+ * (W/nf + 0.18u)' ps='2*int((nf+2)/2) * (W/nf + 0.18u)' nrd='0.18u / W' nrs='0.18u / W' sa=0 sb=0 sd=0 m=4
XM26 net5 net10 vss vss nfet_06v0 L=1.0u W=2.5u nf=1 ad='int((nf+1)/2) * W/nf * 0.18u' as='int((nf+2)/2) * W/nf * 0.18u' pd='2*int((nf+1)/2)
+ * (W/nf + 0.18u)' ps='2*int((nf+2)/2) * (W/nf + 0.18u)' nrd='0.18u / W' nrs='0.18u / W' sa=0 sb=0 sd=0 m=4
XM27 net9 net11 net10 vss nfet_06v0 L=1.0u W=2.5u nf=1 ad='int((nf+1)/2) * W/nf * 0.18u' as='int((nf+2)/2) * W/nf * 0.18u' pd='2*int((nf+1)/2)
+ * (W/nf + 0.18u)' ps='2*int((nf+2)/2) * (W/nf + 0.18u)' nrd='0.18u / W' nrs='0.18u / W' sa=0 sb=0 sd=0
XM28 net12 net11 net22 vss nfet_06v0 L=1.0u W=2.5u nf=1 ad='int((nf+1)/2) * W/nf * 0.18u' as='int((nf+2)/2) * W/nf * 0.18u' pd='2*int((nf+1)/2)
+ * (W/nf + 0.18u)' ps='2*int((nf+2)/2) * (W/nf + 0.18u)' nrd='0.18u / W' nrs='0.18u / W' sa=0 sb=0 sd=0
XM34 net13 net14 vdd vdd pfet_06v0 L=1.0u W=10.0u nf=1 ad='int((nf+1)/2) * W/nf * 0.18u' as='int((nf+2)/2) * W/nf * 0.18u' pd='2*int((nf+1)/2)
+ * (W/nf + 0.18u)' ps='2*int((nf+2)/2) * (W/nf + 0.18u)' nrd='0.18u / W' nrs='0.18u / W' sa=0 sb=0 sd=0
XM36 net14 bias2 net13 vdd pfet_06v0 L=1.0u W=10.0u nf=1 ad='int((nf+1)/2) * W/nf * 0.18u' as='int((nf+2)/2) * W/nf * 0.18u' pd='2*int((nf+1)/2)
+ * (W/nf + 0.18u)' ps='2*int((nf+2)/2) * (W/nf + 0.18u)' nrd='0.18u / W' nrs='0.18u / W' sa=0 sb=0 sd=0
XM37 net21 net21 net14 vdd pfet_06v0 L=1.0u W=10.0u nf=1 ad='int((nf+1)/2) * W/nf * 0.18u' as='int((nf+2)/2) * W/nf * 0.18u' pd='2*int((nf+1)/2)
+ * (W/nf + 0.18u)' ps='2*int((nf+2)/2) * (W/nf + 0.18u)' nrd='0.18u / W' nrs='0.18u / W' sa=0 sb=0 sd=0
XM38 net21 bias3 net15 vss nfet_06v0 L=1.0u W=5.0u nf=1 ad='int((nf+1)/2) * W/nf * 0.18u' as='int((nf+2)/2) * W/nf * 0.18u' pd='2*int((nf+1)/2)
+ * (W/nf + 0.18u)' ps='2*int((nf+2)/2) * (W/nf + 0.18u)' nrd='0.18u / W' nrs='0.18u / W' sa=0 sb=0 sd=0
XM39 net15 bias4 vss vss nfet_06v0 L=1.0u W=5.0u nf=1 ad='int((nf+1)/2) * W/nf * 0.18u' as='int((nf+2)/2) * W/nf * 0.18u' pd='2*int((nf+1)/2)
+ * (W/nf + 0.18u)' ps='2*int((nf+2)/2) * (W/nf + 0.18u)' nrd='0.18u / W' nrs='0.18u / W' sa=0 sb=0 sd=0
XM45 net16 bias1 vdd vdd pfet_06v0 L=1.0u W=10.0u nf=1 ad='int((nf+1)/2) * W/nf * 0.18u' as='int((nf+2)/2) * W/nf * 0.18u' pd='2*int((nf+1)/2)
+ * (W/nf + 0.18u)' ps='2*int((nf+2)/2) * (W/nf + 0.18u)' nrd='0.18u / W' nrs='0.18u / W' sa=0 sb=0 sd=0
XM46 net11 bias2 net16 vdd pfet_06v0 L=1.0u W=10.0u nf=1 ad='int((nf+1)/2) * W/nf * 0.18u' as='int((nf+2)/2) * W/nf * 0.18u' pd='2*int((nf+1)/2)
+ * (W/nf + 0.18u)' ps='2*int((nf+2)/2) * (W/nf + 0.18u)' nrd='0.18u / W' nrs='0.18u / W' sa=0 sb=0 sd=0
XM40 net11 net11 net18 vss nfet_06v0 L=1.0u W=5.0u nf=1 ad='int((nf+1)/2) * W/nf * 0.18u' as='int((nf+2)/2) * W/nf * 0.18u' pd='2*int((nf+1)/2)
+ * (W/nf + 0.18u)' ps='2*int((nf+2)/2) * (W/nf + 0.18u)' nrd='0.18u / W' nrs='0.18u / W' sa=0 sb=0 sd=0
XM41 net18 bias3 net17 vss nfet_06v0 L=1.0u W=5.0u nf=1 ad='int((nf+1)/2) * W/nf * 0.18u' as='int((nf+2)/2) * W/nf * 0.18u' pd='2*int((nf+1)/2)
+ * (W/nf + 0.18u)' ps='2*int((nf+2)/2) * (W/nf + 0.18u)' nrd='0.18u / W' nrs='0.18u / W' sa=0 sb=0 sd=0
XM42 net17 net18 vss vss nfet_06v0 L=1.0u W=5.0u nf=1 ad='int((nf+1)/2) * W/nf * 0.18u' as='int((nf+2)/2) * W/nf * 0.18u' pd='2*int((nf+1)/2)
+ * (W/nf + 0.18u)' ps='2*int((nf+2)/2) * (W/nf + 0.18u)' nrd='0.18u / W' nrs='0.18u / W' sa=0 sb=0 sd=0
XM43 out net12 vdd vdd pfet_06v0 L=1.0u W=10u nf=1 ad='int((nf+1)/2) * W/nf * 0.18u' as='int((nf+2)/2) * W/nf * 0.18u' pd='2*int((nf+1)/2)
+ * (W/nf + 0.18u)' ps='2*int((nf+2)/2) * (W/nf + 0.18u)' nrd='0.18u / W' nrs='0.18u / W' sa=0 sb=0 sd=0 m=3
XM44 out net22 vss vss nfet_06v0 L=1.0u W=5u nf=1 ad='int((nf+1)/2) * W/nf * 0.18u' as='int((nf+2)/2) * W/nf * 0.18u' pd='2*int((nf+1)/2)
+ * (W/nf + 0.18u)' ps='2*int((nf+2)/2) * (W/nf + 0.18u)' nrd='0.18u / W' nrs='0.18u / W' sa=0 sb=0 sd=0 m=3
XC2 out net5 cap_mim_2f0fF c_width=20e-6 c_length=10e-6
XC3 net6 out cap_mim_2f0fF c_width=20e-6 c_length=10e-6
.ends

* expanding   symbol:  a_zonetic2026/XSCHEM/DECODER/yGates.sym # of pins=5
** sym_path: /foss/designs/a_zonetic2026/XSCHEM/DECODER/yGates.sym
** sch_path: /foss/designs/a_zonetic2026/XSCHEM/DECODER/yGates.sch
.subckt yGates YZ XY VDD output VSS
*.ipin VDD
*.ipin VSS
*.ipin YZ
*.ipin XY
*.opin output
x2 VDD net1 XY VSS invertor
x3 YZ VDD net1 output VSS andGate
.ends

* expanding   symbol:  a_zonetic2026/XSCHEM/DECODER/Z.sym # of pins=5
** sym_path: /foss/designs/a_zonetic2026/XSCHEM/DECODER/Z.sym
** sch_path: /foss/designs/a_zonetic2026/XSCHEM/DECODER/Z.sch
.subckt Z VSS VDD XZ YZ out
*.iopin VSS
*.iopin VDD
*.ipin XZ
*.ipin YZ
*.opin out
XM4 net1 YZ out VDD pfet_06v0 L=1.0u W=3.0u nf=1 ad='int((nf+1)/2) * W/nf * 0.18u' as='int((nf+2)/2) * W/nf * 0.18u' pd='2*int((nf+1)/2)
+ * (W/nf + 0.18u)' ps='2*int((nf+2)/2) * (W/nf + 0.18u)' nrd='0.18u / W' nrs='0.18u / W' sa=0 sb=0 sd=0
XM5 VDD XZ net1 VDD pfet_06v0 L=1.0u W=3.0u nf=1 ad='int((nf+1)/2) * W/nf * 0.18u' as='int((nf+2)/2) * W/nf * 0.18u' pd='2*int((nf+1)/2)
+ * (W/nf + 0.18u)' ps='2*int((nf+2)/2) * (W/nf + 0.18u)' nrd='0.18u / W' nrs='0.18u / W' sa=0 sb=0 sd=0
XM7 VSS YZ out VSS nfet_06v0 L=1u W=1u nf=1 ad='int((nf+1)/2) * W/nf * 0.18u' as='int((nf+2)/2) * W/nf * 0.18u' pd='2*int((nf+1)/2)
+ * (W/nf + 0.18u)' ps='2*int((nf+2)/2) * (W/nf + 0.18u)' nrd='0.18u / W' nrs='0.18u / W' sa=0 sb=0 sd=0
XM1 VSS XZ out VSS nfet_06v0 L=1u W=1u nf=1 ad='int((nf+1)/2) * W/nf * 0.18u' as='int((nf+2)/2) * W/nf * 0.18u' pd='2*int((nf+1)/2)
+ * (W/nf + 0.18u)' ps='2*int((nf+2)/2) * (W/nf + 0.18u)' nrd='0.18u / W' nrs='0.18u / W' sa=0 sb=0 sd=0
.ends

* expanding   symbol:  a_zonetic2026/XSCHEM/DECODER/xGates.sym # of pins=5
** sym_path: /foss/designs/a_zonetic2026/XSCHEM/DECODER/xGates.sym
** sch_path: /foss/designs/a_zonetic2026/XSCHEM/DECODER/xGates.sch
.subckt xGates VDD XY output XZ VSS
*.ipin XY
*.opin output
*.ipin VDD
*.ipin VSS
*.ipin XZ
x2 XY VDD XZ output VSS andGate
.ends

* expanding   symbol:  a_zonetic2026/XSCHEM/OPAM/sub_diff_2_LIN.sym # of pins=9
** sym_path: /foss/designs/a_zonetic2026/XSCHEM/OPAM/sub_diff_2_LIN.sym
** sch_path: /foss/designs/a_zonetic2026/XSCHEM/OPAM/sub_diff_2_LIN.sch
.subckt sub_diff_2_LIN VDD bias1 bias2 OUT INN INP bias3 bias4 VSS
*.ipin INN
*.ipin INP
*.iopin VDD
*.iopin VSS
*.iopin OUT
*.ipin bias1
*.ipin bias2
*.ipin bias3
*.ipin bias4
XM11 net2 bias1 VDD VDD pfet_06v0 L=1.0u W=10.0u nf=1 ad='int((nf+1)/2) * W/nf * 0.18u' as='int((nf+2)/2) * W/nf * 0.18u' pd='2*int((nf+1)/2)
+ * (W/nf + 0.18u)' ps='2*int((nf+2)/2) * (W/nf + 0.18u)' nrd='0.18u / W' nrs='0.18u / W' sa=0 sb=0 sd=0
XM12 net7 bias2 net2 VDD pfet_06v0 L=1.0u W=10.0u nf=1 ad='int((nf+1)/2) * W/nf * 0.18u' as='int((nf+2)/2) * W/nf * 0.18u' pd='2*int((nf+1)/2)
+ * (W/nf + 0.18u)' ps='2*int((nf+2)/2) * (W/nf + 0.18u)' nrd='0.18u / W' nrs='0.18u / W' sa=0 sb=0 sd=0
XM13 net18 bias1 VDD VDD pfet_06v0 L=1.0u W=10.0u nf=1 ad='int((nf+1)/2) * W/nf * 0.18u' as='int((nf+2)/2) * W/nf * 0.18u' pd='2*int((nf+1)/2)
+ * (W/nf + 0.18u)' ps='2*int((nf+2)/2) * (W/nf + 0.18u)' nrd='0.18u / W' nrs='0.18u / W' sa=0 sb=0 sd=0
XM14 net7 bias2 net18 VDD pfet_06v0 L=1.0u W=10.0u nf=1 ad='int((nf+1)/2) * W/nf * 0.18u' as='int((nf+2)/2) * W/nf * 0.18u' pd='2*int((nf+1)/2)
+ * (W/nf + 0.18u)' ps='2*int((nf+2)/2) * (W/nf + 0.18u)' nrd='0.18u / W' nrs='0.18u / W' sa=0 sb=0 sd=0
XM15 net5 INP net7 VDD pfet_06v0 L=1.0u W=0.55u nf=1 ad='int((nf+1)/2) * W/nf * 0.18u' as='int((nf+2)/2) * W/nf * 0.18u' pd='2*int((nf+1)/2)
+ * (W/nf + 0.18u)' ps='2*int((nf+2)/2) * (W/nf + 0.18u)' nrd='0.18u / W' nrs='0.18u / W' sa=0 sb=0 sd=0
XM16 net4 INN net7 VDD pfet_06v0 L=1.0u W=0.5u nf=1 ad='int((nf+1)/2) * W/nf * 0.18u' as='int((nf+2)/2) * W/nf * 0.18u' pd='2*int((nf+1)/2)
+ * (W/nf + 0.18u)' ps='2*int((nf+2)/2) * (W/nf + 0.18u)' nrd='0.18u / W' nrs='0.18u / W' sa=0 sb=0 sd=0
XM17 net8 bias3 net1 VSS nfet_06v0 L=1.0u W=5.0u nf=1 ad='int((nf+1)/2) * W/nf * 0.18u' as='int((nf+2)/2) * W/nf * 0.18u' pd='2*int((nf+1)/2)
+ * (W/nf + 0.18u)' ps='2*int((nf+2)/2) * (W/nf + 0.18u)' nrd='0.18u / W' nrs='0.18u / W' sa=0 sb=0 sd=0
XM18 net1 bias4 VSS VSS nfet_06v0 L=1.0u W=5.0u nf=1 ad='int((nf+1)/2) * W/nf * 0.18u' as='int((nf+2)/2) * W/nf * 0.18u' pd='2*int((nf+1)/2)
+ * (W/nf + 0.18u)' ps='2*int((nf+2)/2) * (W/nf + 0.18u)' nrd='0.18u / W' nrs='0.18u / W' sa=0 sb=0 sd=0
XM19 net8 bias3 net19 VSS nfet_06v0 L=1.0u W=5.0u nf=1 ad='int((nf+1)/2) * W/nf * 0.18u' as='int((nf+2)/2) * W/nf * 0.18u' pd='2*int((nf+1)/2)
+ * (W/nf + 0.18u)' ps='2*int((nf+2)/2) * (W/nf + 0.18u)' nrd='0.18u / W' nrs='0.18u / W' sa=0 sb=0 sd=0
XM20 net19 bias4 VSS VSS nfet_06v0 L=1.0u W=5.0u nf=1 ad='int((nf+1)/2) * W/nf * 0.18u' as='int((nf+2)/2) * W/nf * 0.18u' pd='2*int((nf+1)/2)
+ * (W/nf + 0.18u)' ps='2*int((nf+2)/2) * (W/nf + 0.18u)' nrd='0.18u / W' nrs='0.18u / W' sa=0 sb=0 sd=0
XM21 net6 INP net8 VSS nfet_06v0 L=1.0u W=7.5u nf=1 ad='int((nf+1)/2) * W/nf * 0.18u' as='int((nf+2)/2) * W/nf * 0.18u' pd='2*int((nf+1)/2)
+ * (W/nf + 0.18u)' ps='2*int((nf+2)/2) * (W/nf + 0.18u)' nrd='0.18u / W' nrs='0.18u / W' sa=0 sb=0 sd=0
XM22 net3 INN net8 VSS nfet_06v0 L=1.0u W=8.5u nf=1 ad='int((nf+1)/2) * W/nf * 0.18u' as='int((nf+2)/2) * W/nf * 0.18u' pd='2*int((nf+1)/2)
+ * (W/nf + 0.18u)' ps='2*int((nf+2)/2) * (W/nf + 0.18u)' nrd='0.18u / W' nrs='0.18u / W' sa=0 sb=0 sd=0
XM29 net9 bias2 net3 VDD pfet_06v0 L=1.0u W=10u nf=1 ad='int((nf+1)/2) * W/nf * 0.18u' as='int((nf+2)/2) * W/nf * 0.18u' pd='2*int((nf+1)/2)
+ * (W/nf + 0.18u)' ps='2*int((nf+2)/2) * (W/nf + 0.18u)' nrd='0.18u / W' nrs='0.18u / W' sa=0 sb=0 sd=0
XM30 G_OUT_P bias2 net6 VDD pfet_06v0 L=1.0u W=10u nf=1 ad='int((nf+1)/2) * W/nf * 0.18u' as='int((nf+2)/2) * W/nf * 0.18u' pd='2*int((nf+1)/2)
+ * (W/nf + 0.18u)' ps='2*int((nf+2)/2) * (W/nf + 0.18u)' nrd='0.18u / W' nrs='0.18u / W' sa=0 sb=0 sd=0
XM31 net3 net9 VDD VDD pfet_06v0 L=1.0u W=5u nf=1 ad='int((nf+1)/2) * W/nf * 0.18u' as='int((nf+2)/2) * W/nf * 0.18u' pd='2*int((nf+1)/2)
+ * (W/nf + 0.18u)' ps='2*int((nf+2)/2) * (W/nf + 0.18u)' nrd='0.18u / W' nrs='0.18u / W' sa=0 sb=0 sd=0
XM35 net6 net9 VDD VDD pfet_06v0 L=1.0u W=5u nf=1 ad='int((nf+1)/2) * W/nf * 0.18u' as='int((nf+2)/2) * W/nf * 0.18u' pd='2*int((nf+1)/2)
+ * (W/nf + 0.18u)' ps='2*int((nf+2)/2) * (W/nf + 0.18u)' nrd='0.18u / W' nrs='0.18u / W' sa=0 sb=0 sd=0
XM32 net10 net20 net9 VDD pfet_06v0 L=1.0u W=4.0u nf=1 ad='int((nf+1)/2) * W/nf * 0.18u' as='int((nf+2)/2) * W/nf * 0.18u' pd='2*int((nf+1)/2)
+ * (W/nf + 0.18u)' ps='2*int((nf+2)/2) * (W/nf + 0.18u)' nrd='0.18u / W' nrs='0.18u / W' sa=0 sb=0 sd=0
XM33 net21 net20 G_OUT_P VDD pfet_06v0 L=1.0u W=4.0u nf=1 ad='int((nf+1)/2) * W/nf * 0.18u' as='int((nf+2)/2) * W/nf * 0.18u' pd='2*int((nf+1)/2)
+ * (W/nf + 0.18u)' ps='2*int((nf+2)/2) * (W/nf + 0.18u)' nrd='0.18u / W' nrs='0.18u / W' sa=0 sb=0 sd=0
XM23 net10 bias3 net4 VSS nfet_06v0 L=1.0u W=2.5u nf=1 ad='int((nf+1)/2) * W/nf * 0.18u' as='int((nf+2)/2) * W/nf * 0.18u' pd='2*int((nf+1)/2)
+ * (W/nf + 0.18u)' ps='2*int((nf+2)/2) * (W/nf + 0.18u)' nrd='0.18u / W' nrs='0.18u / W' sa=0 sb=0 sd=0
XM24 net21 bias3 net5 VSS nfet_06v0 L=1.0u W=2.5u nf=1 ad='int((nf+1)/2) * W/nf * 0.18u' as='int((nf+2)/2) * W/nf * 0.18u' pd='2*int((nf+1)/2)
+ * (W/nf + 0.18u)' ps='2*int((nf+2)/2) * (W/nf + 0.18u)' nrd='0.18u / W' nrs='0.18u / W' sa=0 sb=0 sd=0
XM25 net4 net10 VSS VSS nfet_06v0 L=1.0u W=2.5u nf=1 ad='int((nf+1)/2) * W/nf * 0.18u' as='int((nf+2)/2) * W/nf * 0.18u' pd='2*int((nf+1)/2)
+ * (W/nf + 0.18u)' ps='2*int((nf+2)/2) * (W/nf + 0.18u)' nrd='0.18u / W' nrs='0.18u / W' sa=0 sb=0 sd=0
XM26 net5 net10 VSS VSS nfet_06v0 L=1.0u W=2.5u nf=1 ad='int((nf+1)/2) * W/nf * 0.18u' as='int((nf+2)/2) * W/nf * 0.18u' pd='2*int((nf+1)/2)
+ * (W/nf + 0.18u)' ps='2*int((nf+2)/2) * (W/nf + 0.18u)' nrd='0.18u / W' nrs='0.18u / W' sa=0 sb=0 sd=0
XM27 net9 net11 net10 VSS nfet_06v0 L=1.0u W=2.0u nf=1 ad='int((nf+1)/2) * W/nf * 0.18u' as='int((nf+2)/2) * W/nf * 0.18u' pd='2*int((nf+1)/2)
+ * (W/nf + 0.18u)' ps='2*int((nf+2)/2) * (W/nf + 0.18u)' nrd='0.18u / W' nrs='0.18u / W' sa=0 sb=0 sd=0
XM28 G_OUT_P net11 net21 VSS nfet_06v0 L=1.0u W=2.0u nf=1 ad='int((nf+1)/2) * W/nf * 0.18u' as='int((nf+2)/2) * W/nf * 0.18u' pd='2*int((nf+1)/2)
+ * (W/nf + 0.18u)' ps='2*int((nf+2)/2) * (W/nf + 0.18u)' nrd='0.18u / W' nrs='0.18u / W' sa=0 sb=0 sd=0
XM34 net12 net13 VDD VDD pfet_06v0 L=1.0u W=10.0u nf=1 ad='int((nf+1)/2) * W/nf * 0.18u' as='int((nf+2)/2) * W/nf * 0.18u' pd='2*int((nf+1)/2)
+ * (W/nf + 0.18u)' ps='2*int((nf+2)/2) * (W/nf + 0.18u)' nrd='0.18u / W' nrs='0.18u / W' sa=0 sb=0 sd=0
XM36 net13 bias2 net12 VDD pfet_06v0 L=1.0u W=10.0u nf=1 ad='int((nf+1)/2) * W/nf * 0.18u' as='int((nf+2)/2) * W/nf * 0.18u' pd='2*int((nf+1)/2)
+ * (W/nf + 0.18u)' ps='2*int((nf+2)/2) * (W/nf + 0.18u)' nrd='0.18u / W' nrs='0.18u / W' sa=0 sb=0 sd=0
XM37 net20 net20 net13 VDD pfet_06v0 L=1.0u W=10.0u nf=1 ad='int((nf+1)/2) * W/nf * 0.18u' as='int((nf+2)/2) * W/nf * 0.18u' pd='2*int((nf+1)/2)
+ * (W/nf + 0.18u)' ps='2*int((nf+2)/2) * (W/nf + 0.18u)' nrd='0.18u / W' nrs='0.18u / W' sa=0 sb=0 sd=0
XM38 net20 bias3 net14 VSS nfet_06v0 L=1.0u W=5.0u nf=1 ad='int((nf+1)/2) * W/nf * 0.18u' as='int((nf+2)/2) * W/nf * 0.18u' pd='2*int((nf+1)/2)
+ * (W/nf + 0.18u)' ps='2*int((nf+2)/2) * (W/nf + 0.18u)' nrd='0.18u / W' nrs='0.18u / W' sa=0 sb=0 sd=0
XM39 net14 bias4 VSS VSS nfet_06v0 L=1.0u W=5.0u nf=1 ad='int((nf+1)/2) * W/nf * 0.18u' as='int((nf+2)/2) * W/nf * 0.18u' pd='2*int((nf+1)/2)
+ * (W/nf + 0.18u)' ps='2*int((nf+2)/2) * (W/nf + 0.18u)' nrd='0.18u / W' nrs='0.18u / W' sa=0 sb=0 sd=0
XM45 net15 bias1 VDD VDD pfet_06v0 L=1.0u W=10.0u nf=1 ad='int((nf+1)/2) * W/nf * 0.18u' as='int((nf+2)/2) * W/nf * 0.18u' pd='2*int((nf+1)/2)
+ * (W/nf + 0.18u)' ps='2*int((nf+2)/2) * (W/nf + 0.18u)' nrd='0.18u / W' nrs='0.18u / W' sa=0 sb=0 sd=0
XM46 net11 bias2 net15 VDD pfet_06v0 L=1.0u W=10.0u nf=1 ad='int((nf+1)/2) * W/nf * 0.18u' as='int((nf+2)/2) * W/nf * 0.18u' pd='2*int((nf+1)/2)
+ * (W/nf + 0.18u)' ps='2*int((nf+2)/2) * (W/nf + 0.18u)' nrd='0.18u / W' nrs='0.18u / W' sa=0 sb=0 sd=0
XM40 net11 net11 net17 VSS nfet_06v0 L=1.0u W=5.0u nf=1 ad='int((nf+1)/2) * W/nf * 0.18u' as='int((nf+2)/2) * W/nf * 0.18u' pd='2*int((nf+1)/2)
+ * (W/nf + 0.18u)' ps='2*int((nf+2)/2) * (W/nf + 0.18u)' nrd='0.18u / W' nrs='0.18u / W' sa=0 sb=0 sd=0
XM41 net17 bias3 net16 VSS nfet_06v0 L=1.0u W=5.0u nf=1 ad='int((nf+1)/2) * W/nf * 0.18u' as='int((nf+2)/2) * W/nf * 0.18u' pd='2*int((nf+1)/2)
+ * (W/nf + 0.18u)' ps='2*int((nf+2)/2) * (W/nf + 0.18u)' nrd='0.18u / W' nrs='0.18u / W' sa=0 sb=0 sd=0
XM42 net16 net17 VSS VSS nfet_06v0 L=1.0u W=5.0u nf=1 ad='int((nf+1)/2) * W/nf * 0.18u' as='int((nf+2)/2) * W/nf * 0.18u' pd='2*int((nf+1)/2)
+ * (W/nf + 0.18u)' ps='2*int((nf+2)/2) * (W/nf + 0.18u)' nrd='0.18u / W' nrs='0.18u / W' sa=0 sb=0 sd=0
XM43 OUT G_OUT_P VDD VDD pfet_06v0 L=1.0u W=1.0u nf=1 ad='int((nf+1)/2) * W/nf * 0.18u' as='int((nf+2)/2) * W/nf * 0.18u' pd='2*int((nf+1)/2)
+ * (W/nf + 0.18u)' ps='2*int((nf+2)/2) * (W/nf + 0.18u)' nrd='0.18u / W' nrs='0.18u / W' sa=0 sb=0 sd=0 m=4
XM44 OUT net21 VSS VSS nfet_06v0 L=1.0u W=1.0u nf=1 ad='int((nf+1)/2) * W/nf * 0.18u' as='int((nf+2)/2) * W/nf * 0.18u' pd='2*int((nf+1)/2)
+ * (W/nf + 0.18u)' ps='2*int((nf+2)/2) * (W/nf + 0.18u)' nrd='0.18u / W' nrs='0.18u / W' sa=0 sb=0 sd=0
XC3 net6 OUT cap_mim_2f0fF c_width=8e-6 c_length=25e-6
XC1 OUT net5 cap_mim_2f0fF c_width=8e-6 c_length=25e-6
XRFB G_OUT_P OUT VSS ppolyf_u_1k r_width=1e-6 r_length=76.45e-6 m=1 s=5
.ends

* expanding   symbol:  a_zonetic2026/XSCHEM/DECODER/invertor.sym # of pins=4
** sym_path: /foss/designs/a_zonetic2026/XSCHEM/DECODER/invertor.sym
** sch_path: /foss/designs/a_zonetic2026/XSCHEM/DECODER/invertor.sch
.subckt invertor VDD output In VSS
*.opin output
*.ipin In
*.ipin VDD
*.ipin VSS
XM4 output In VDD VDD pfet_06v0 L=1.0u W=3.0u nf=1 ad='int((nf+1)/2) * W/nf * 0.18u' as='int((nf+2)/2) * W/nf * 0.18u' pd='2*int((nf+1)/2)
+ * (W/nf + 0.18u)' ps='2*int((nf+2)/2) * (W/nf + 0.18u)' nrd='0.18u / W' nrs='0.18u / W' sa=0 sb=0 sd=0
XM5 VSS In output VSS nfet_06v0 L=1u W=1u nf=1 ad='int((nf+1)/2) * W/nf * 0.18u' as='int((nf+2)/2) * W/nf * 0.18u' pd='2*int((nf+1)/2)
+ * (W/nf + 0.18u)' ps='2*int((nf+2)/2) * (W/nf + 0.18u)' nrd='0.18u / W' nrs='0.18u / W' sa=0 sb=0 sd=0
.ends

* expanding   symbol:  a_zonetic2026/XSCHEM/DECODER/andGate.sym # of pins=5
** sym_path: /foss/designs/a_zonetic2026/XSCHEM/DECODER/andGate.sym
** sch_path: /foss/designs/a_zonetic2026/XSCHEM/DECODER/andGate.sch
.subckt andGate A VDD B output VSS
*.ipin VDD
*.ipin B
*.ipin A
*.ipin VSS
*.opin output
XM4 output net1 VDD VDD pfet_06v0 L=1.0u W=3.0u nf=1 ad='int((nf+1)/2) * W/nf * 0.18u' as='int((nf+2)/2) * W/nf * 0.18u' pd='2*int((nf+1)/2)
+ * (W/nf + 0.18u)' ps='2*int((nf+2)/2) * (W/nf + 0.18u)' nrd='0.18u / W' nrs='0.18u / W' sa=0 sb=0 sd=0
XM5 VSS net1 output VSS nfet_06v0 L=1u W=1u nf=1 ad='int((nf+1)/2) * W/nf * 0.18u' as='int((nf+2)/2) * W/nf * 0.18u' pd='2*int((nf+1)/2)
+ * (W/nf + 0.18u)' ps='2*int((nf+2)/2) * (W/nf + 0.18u)' nrd='0.18u / W' nrs='0.18u / W' sa=0 sb=0 sd=0
XM2 VDD A net1 VDD pfet_06v0 L=1.0u W=3.0u nf=1 ad='int((nf+1)/2) * W/nf * 0.18u' as='int((nf+2)/2) * W/nf * 0.18u' pd='2*int((nf+1)/2)
+ * (W/nf + 0.18u)' ps='2*int((nf+2)/2) * (W/nf + 0.18u)' nrd='0.18u / W' nrs='0.18u / W' sa=0 sb=0 sd=0
XM1 VDD B net1 VDD pfet_06v0 L=1.0u W=3.0u nf=1 ad='int((nf+1)/2) * W/nf * 0.18u' as='int((nf+2)/2) * W/nf * 0.18u' pd='2*int((nf+1)/2)
+ * (W/nf + 0.18u)' ps='2*int((nf+2)/2) * (W/nf + 0.18u)' nrd='0.18u / W' nrs='0.18u / W' sa=0 sb=0 sd=0
XM3 VSS A net2 VSS nfet_06v0 L=1u W=1u nf=1 ad='int((nf+1)/2) * W/nf * 0.18u' as='int((nf+2)/2) * W/nf * 0.18u' pd='2*int((nf+1)/2)
+ * (W/nf + 0.18u)' ps='2*int((nf+2)/2) * (W/nf + 0.18u)' nrd='0.18u / W' nrs='0.18u / W' sa=0 sb=0 sd=0
XM6 net2 B net1 VSS nfet_06v0 L=1u W=1u nf=1 ad='int((nf+1)/2) * W/nf * 0.18u' as='int((nf+2)/2) * W/nf * 0.18u' pd='2*int((nf+1)/2)
+ * (W/nf + 0.18u)' ps='2*int((nf+2)/2) * (W/nf + 0.18u)' nrd='0.18u / W' nrs='0.18u / W' sa=0 sb=0 sd=0
.ends

.GLOBAL GND
.end
