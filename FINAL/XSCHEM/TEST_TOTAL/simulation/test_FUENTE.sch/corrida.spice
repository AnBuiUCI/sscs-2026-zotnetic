** sch_path: /foss/designs/a_zonetic2026/XSCHEM/TEST_TOTAL/test_FUENTE.sch
**.subckt test_FUENTE
V1 VEXC GND 5
V3 VDDR GND 5
xnav2 VDDV GND XPv Xv XNv YPv Yv YNv ZPv Zv ZNv S2P S2N S4P S4N S3P S3N S1P S1N GRADIENT_NAV2_V2
V4 VDDV GND 5
xnavt VDDT GND XPt Xt XNt YPt Yt YNt ZPt Zt ZNt S2P S2N S4P S4N S3P S3N S1P S1N GRADIENT_NAV2
V6 VDDT GND 5
**** begin user architecture code

.include /headless/pdks/gf180mcuD/libs.tech/ngspice/design.ngspice
.lib /headless/pdks/gf180mcuD/libs.tech/ngspice/sm141064.ngspice typical
.lib /headless/pdks/gf180mcuD/libs.tech/ngspice/sm141064.ngspice cap_mim
.lib /headless/pdks/gf180mcuD/libs.tech/ngspice/sm141064.ngspice res_typical
.lib /headless/pdks/gf180mcuD/libs.tech/ngspice/sm141064.ngspice moscap_typical
.lib /headless/pdks/gf180mcuD/libs.tech/ngspice/sm141064.ngspice mimcap_typical
.lib /headless/pdks/gf180mcuD/libs.tech/ngspice/sm141064.ngspice diode_typical

* A SOURCE AT A PLACE, and does the chip point at it?
*
* Everything measured so far imposed a UNIFORM gradient in a direction. Here
* there is a source sitting somewhere and each sensor reads the MAGNITUDE of
* its field at its own vertex. That is the question the chip exists to answer.
*
* The source goes in spherical coordinates about the centre of the box, reusing
* the two angles the other bench already has plus the distance `rad`:
*
*     p = rad * (cos(ang), sin(ang) sin(tilt), sin(ang) cos(tilt))
*
* and `dip` picks the model, which is the point of the whole thing:
*
*   dip = 0  SYMMETRIC: |B| depends on the DISTANCE only, so grad|B| points
*            EXACTLY at the source and whatever error comes out is the chip.
*   dip = 1  A REAL DIPOLE, axis along +z: |B| depends on the angle too, so
*            grad|B| does NOT point exactly at the source even with a perfect
*            chip. The difference between the two separates the error of the
*            circuit from the error of the physics.
*
* `bcen` is |B| at the centre of the box in dR/R, and the amplitude is scaled
* so that it comes out that way whatever the distance: amp = bcen * rad^3.
* The sensor mismatch keeps the same fixed, deliberately asymmetric pattern.
Voff  off  0 0
Vlxy  lxy  0 1000
Vlz   lz   0 1000
Vrad  rad  0 3000
Vbcen bcen 0 5m
Vdip  dip  0 0
Vang  ang  0 0
Vtilt tilt 0 0

Bux ux 0 v='cos(v(ang)*3.14159265358979/180)'
Buy uy 0 v='sin(v(ang)*3.14159265358979/180)*sin(v(tilt)*3.14159265358979/180)'
Buz uz 0 v='sin(v(ang)*3.14159265358979/180)*cos(v(tilt)*3.14159265358979/180)'
Bpx px 0 v='v(rad)*v(ux)'
Bpy py 0 v='v(rad)*v(uy)'
Bpz pz 0 v='v(rad)*v(uz)'
Bamp amp 0 v='v(bcen)*v(rad)*v(rad)*v(rad)'

* sensor 1 at (-1Lxy/2, +1Lxy/2, +1Lz/2)
B1x q1x 0 v='-1*v(lxy)/2 - v(px)'
B1y q1y 0 v='1*v(lxy)/2 - v(py)'
B1z q1z 0 v='1*v(lz)/2  - v(pz)'
B1d q1d 0 v='sqrt(v(q1x)*v(q1x)+v(q1y)*v(q1y)+v(q1z)*v(q1z))'
B1c q1c 0 v='v(q1z)/v(q1d)'
Bb1 b1 0 v='+1.00*v(off) + v(amp)/(v(q1d)*v(q1d)*v(q1d)) * (1 + v(dip)*(sqrt(1+3*v(q1c)*v(q1c))-1))'

* sensor 2 at (+1Lxy/2, -1Lxy/2, +1Lz/2)
B2x q2x 0 v='1*v(lxy)/2 - v(px)'
B2y q2y 0 v='-1*v(lxy)/2 - v(py)'
B2z q2z 0 v='1*v(lz)/2  - v(pz)'
B2d q2d 0 v='sqrt(v(q2x)*v(q2x)+v(q2y)*v(q2y)+v(q2z)*v(q2z))'
B2c q2c 0 v='v(q2z)/v(q2d)'
Bb2 b2 0 v='-0.62*v(off) + v(amp)/(v(q2d)*v(q2d)*v(q2d)) * (1 + v(dip)*(sqrt(1+3*v(q2c)*v(q2c))-1))'

* sensor 3 at (-1Lxy/2, -1Lxy/2, -1Lz/2)
B3x q3x 0 v='-1*v(lxy)/2 - v(px)'
B3y q3y 0 v='-1*v(lxy)/2 - v(py)'
B3z q3z 0 v='-1*v(lz)/2  - v(pz)'
B3d q3d 0 v='sqrt(v(q3x)*v(q3x)+v(q3y)*v(q3y)+v(q3z)*v(q3z))'
B3c q3c 0 v='v(q3z)/v(q3d)'
Bb3 b3 0 v='+0.31*v(off) + v(amp)/(v(q3d)*v(q3d)*v(q3d)) * (1 + v(dip)*(sqrt(1+3*v(q3c)*v(q3c))-1))'

* sensor 4 at (+1Lxy/2, +1Lxy/2, -1Lz/2)
B4x q4x 0 v='1*v(lxy)/2 - v(px)'
B4y q4y 0 v='1*v(lxy)/2 - v(py)'
B4z q4z 0 v='-1*v(lz)/2  - v(pz)'
B4d q4d 0 v='sqrt(v(q4x)*v(q4x)+v(q4y)*v(q4y)+v(q4z)*v(q4z))'
B4c q4c 0 v='v(q4z)/v(q4d)'
Bb4 b4 0 v='-0.85*v(off) + v(amp)/(v(q4d)*v(q4d)*v(q4d)) * (1 + v(dip)*(sqrt(1+3*v(q4c)*v(q4c))-1))'

* The four bridges, 1 Mohm per arm and all four arms moving at once, so Vcm
* is VEXC/2 exactly and independent of b.
R1a VEXC S1P r='1meg*(1-v(b1))'
R1b S1P  GND r='1meg*(1+v(b1))'
R1c VEXC S1N r='1meg*(1+v(b1))'
R1d S1N  GND r='1meg*(1-v(b1))'
R2a VEXC S2P r='1meg*(1-v(b2))'
R2b S2P  GND r='1meg*(1+v(b2))'
R2c VEXC S2N r='1meg*(1+v(b2))'
R2d S2N  GND r='1meg*(1-v(b2))'
R3a VEXC S3P r='1meg*(1-v(b3))'
R3b S3P  GND r='1meg*(1+v(b3))'
R3c VEXC S3N r='1meg*(1+v(b3))'
R3d S3N  GND r='1meg*(1-v(b3))'
R4a VEXC S4P r='1meg*(1-v(b4))'
R4b S4P  GND r='1meg*(1+v(b4))'
R4c VEXC S4N r='1meg*(1+v(b4))'
R4d S4N  GND r='1meg*(1-v(b4))'

**** end user architecture code
**.ends

* expanding   symbol:  a_zonetic2026/XSCHEM_v2/GRADIENT_NAV2_V2.sym # of pins=19
** sym_path: /foss/designs/a_zonetic2026/XSCHEM_v2/GRADIENT_NAV2_V2.sym
** sch_path: /foss/designs/a_zonetic2026/XSCHEM_v2/GRADIENT_NAV2_V2.sch
.subckt GRADIENT_NAV2_V2 VDD VSS XP X XN YP Y YN ZP Z ZN S2P S2N S4P S4N S3P S3N S1P S1N
*.ipin S1N
*.iopin VDD
*.opin XN
*.iopin VSS
*.ipin S1P
*.ipin S2N
*.ipin S2P
*.ipin S3N
*.ipin S3P
*.ipin S4N
*.ipin S4P
*.opin XP
*.opin YN
*.opin YP
*.opin ZN
*.opin ZP
*.opin X
*.opin Y
*.opin Z
x5 VDD VSS X X1 X2 X3 X4 WEIGHT
x6 VDD VSS Y Y1 Y2 Y3 Y4 WEIGHT
x7 VDD VSS Z Z1 Z2 Z3 Z4 WEIGHT
x1 S1N S1P VDD X1 S2N Y1 Z1 S2P VSS S3N S3P GRADIENT2
x2 S4N S4P VDD X2 S1N Y2 Z2 S1P VSS S2N S2P GRADIENT2
x3 S3N S3P VDD X3 S4N Y3 Z3 S4P VSS S1N S1P GRADIENT2
x4 S2N S2P VDD X4 S3N Y4 Z4 S3P VSS S4N S4P GRADIENT2
**** begin user architecture code

* THE OUTPUT DECISION, REDONE. Replaces the three COMP_OUT of today's top.
*
* WHAT WAS WRONG. The weight block is an ANALOGUE VOTE COUNTER and also
* INVERSOR: medido, 0/1/2/3 cadenas votando dan 3.035 / 2.579 / 2.178 / 1.814 V,
* escalones iguales de 0.4 V y correlacion -0.999. Detras iba un par de
* inverters, i.e. a NON-inverting buffer with its trip point wherever it fell:
*
*   * the output called 'P' was high when the axis does NOT win, the opposite of
*     nombre;
*   * and the trip point fell at ~2.0 V, i.e. between 2 and 3 votes, when the
*     decision correcta es a partir de DOS. Medido: X e Y disparaban el 22.5 %
*     of the sweep when they were due 47.7 % and 52.3 %.
*
* WHY A SKEWED INVERTER WILL NOT DO. It was tried: with the PMOS at 3.0/0.5 the
* de disparo cae en 2.365 V a 27 C y 5 V, justo en medio de la ventana. Pero es
* a ratio divider, so it **follows VDD**: 2.110 V at 4.5 V and 2.620 V at
* 5.5 V. The window between steps is 2.178..2.579, so with VDD +-10 % it goes
* out on both sides. Temperature does not matter (+-0.02 V); VDD does.
*
* WHAT GOES IN. A comparator against a reference taken from TWO REPLICAS OF THE
* WEIGHT BLOCK ITSELF, one loaded with 1 vote and one with 2, averaged. The
* reference moves with process, VDD and temperature just like the signal, which
* is exactly what an inverter's trip point does not do. And the comparator is
* the COMP cell that already exists, already drawn and with clean DRC and LVS.
*
* THIS IS A CODE BLOCK ON PURPOSE: it instantiates cells already in the design,
* so the idea can be measured before drawing it. If the numbers convince,
* it gets drawn as a cell (REF_VOTOS + COMP_OUT_v2) and then the two resistors
* pasan a ser ppolyf de verdad.
*
*   .subckt WEIGHT   VDD GND OUT VA VC VB VD
*   .subckt COMP     VDD INN OUT INP VSS
*   .subckt invertor VDD output In VSS
XREF1 VDD VSS VREFA VDD VSS VSS VSS WEIGHT
XREF2 VDD VSS VREFB VDD VDD VSS VSS WEIGHT
RREF1 VREFA VREF 100k
RREF2 VREF VREFB 100k
XCMPX VDD X XP VREF VSS COMP
XCMPY VDD Y YP VREF VSS COMP
XCMPZ VDD Z ZP VREF VSS COMP
XINVX VDD XN XP VSS invertor
XINVY VDD YN YP VSS invertor
XINVZ VDD ZN ZP VSS invertor

**** end user architecture code
.ends

* expanding   symbol:  a_zonetic2026/XSCHEM/GRADIENT_NAV2.sym # of pins=19
** sym_path: /foss/designs/a_zonetic2026/XSCHEM/GRADIENT_NAV2.sym
** sch_path: /foss/designs/a_zonetic2026/XSCHEM/GRADIENT_NAV2.sch
.subckt GRADIENT_NAV2 VDD VSS XP X XN YP Y YN ZP Z ZN S2P S2N S4P S4N S3P S3N S1P S1N
*.ipin S1N
*.iopin VDD
*.opin XP
*.iopin VSS
*.ipin S1P
*.ipin S2N
*.ipin S2P
*.ipin S3N
*.ipin S3P
*.ipin S4N
*.ipin S4P
*.opin XN
*.opin YP
*.opin YN
*.opin ZP
*.opin ZN
*.opin X
*.opin Y
*.opin Z
x5 VDD VSS X_I X1 X2 X3 X4 WEIGHT
x6 VDD VSS Y_I Y1 Y2 Y3 Y4 WEIGHT
x7 VDD VSS Z_I Z1 Z2 Z3 Z4 WEIGHT
x8 VDD XN X_I XP VSS COMP_OUT
x9 VDD YN Y_I YP VSS COMP_OUT
x10 VDD ZN Z_I ZP VSS COMP_OUT
x1 S1N_I S1P_I VDD X1 S2N_I Y1 Z1 S2P_I VSS S3N_I S3P_I GRADIENT2
x2 S4N_I S4P_I VDD X2 S1N_I Y2 Z2 S1P_I VSS S2N_I S2P_I GRADIENT2
x3 S3N_I S3P_I VDD X3 S4N_I Y3 Z3 S4P_I VSS S1N_I S1P_I GRADIENT2
x4 S2N_I S2P_I VDD X4 S3N_I Y4 Z4 S3P_I VSS S4N_I S4P_I GRADIENT2
xesdS1P S1P S1P_I VDD VSS ESD_CDM
xesdS1N S1N S1N_I VDD VSS ESD_CDM
xesdS2P S2P S2P_I VDD VSS ESD_CDM
xesdS2N S2N S2N_I VDD VSS ESD_CDM
xesdS3P S3P S3P_I VDD VSS ESD_CDM
xesdS3N S3N S3N_I VDD VSS ESD_CDM
xesdS4P S4P S4P_I VDD VSS ESD_CDM
xesdS4N S4N S4N_I VDD VSS ESD_CDM
xesdX X X_I VDD VSS ESD_CDM
xesdY Y Y_I VDD VSS ESD_CDM
xesdZ Z Z_I VDD VSS ESD_CDM
.ends

* expanding   symbol:  a_zonetic2026/XSCHEM/WEIGTH/WEIGHT.sym # of pins=7
** sym_path: /foss/designs/a_zonetic2026/XSCHEM/WEIGTH/WEIGHT.sym
** sch_path: /foss/designs/a_zonetic2026/XSCHEM/WEIGTH/WEIGHT.sch
.subckt WEIGHT VDD GND OUT VA VC VB VD
*.iopin VDD
*.iopin GND
*.ipin VA
*.ipin VB
*.ipin VC
*.ipin VD
*.iopin OUT
XM2 OUT OUT VDD VDD pfet_06v0 L=1u W=2u nf=1 ad='int((nf+1)/2) * W/nf * 0.18u' as='int((nf+2)/2) * W/nf * 0.18u' pd='2*int((nf+1)/2) * (W/nf + 0.18u)'
+ ps='2*int((nf+2)/2) * (W/nf + 0.18u)' nrd='0.18u / W' nrs='0.18u / W' sa=0 sb=0 sd=0 m=6
XM3 OUT VD net1 GND nfet_06v0 L=1u W=2.48u nf=1 ad='int((nf+1)/2) * W/nf * 0.18u' as='int((nf+2)/2) * W/nf * 0.18u' pd='2*int((nf+1)/2) * (W/nf + 0.18u)'
+ ps='2*int((nf+2)/2) * (W/nf + 0.18u)' nrd='0.18u / W' nrs='0.18u / W' sa=0 sb=0 sd=0 m=2
XM5 OUT VC net2 GND nfet_06v0 L=1u W=2.48u nf=1 ad='int((nf+1)/2) * W/nf * 0.18u' as='int((nf+2)/2) * W/nf * 0.18u' pd='2*int((nf+1)/2) * (W/nf + 0.18u)'
+ ps='2*int((nf+2)/2) * (W/nf + 0.18u)' nrd='0.18u / W' nrs='0.18u / W' sa=0 sb=0 sd=0 m=2
XM6 net2 IN net10 GND nfet_06v0 L=1u W=1.24u nf=1 ad='int((nf+1)/2) * W/nf * 0.18u' as='int((nf+2)/2) * W/nf * 0.18u' pd='2*int((nf+1)/2) * (W/nf + 0.18u)'
+ ps='2*int((nf+2)/2) * (W/nf + 0.18u)' nrd='0.18u / W' nrs='0.18u / W' sa=0 sb=0 sd=0
XM1 OUT OUT net3 GND nfet_06v0 L=1u W=2u nf=1 ad='int((nf+1)/2) * W/nf * 0.18u' as='int((nf+2)/2) * W/nf * 0.18u' pd='2*int((nf+1)/2) * (W/nf + 0.18u)'
+ ps='2*int((nf+2)/2) * (W/nf + 0.18u)' nrd='0.18u / W' nrs='0.18u / W' sa=0 sb=0 sd=0 m=2
XM7 net3 OUT net4 GND nfet_06v0 L=1u W=2u nf=1 ad='int((nf+1)/2) * W/nf * 0.18u' as='int((nf+2)/2) * W/nf * 0.18u' pd='2*int((nf+1)/2) * (W/nf + 0.18u)'
+ ps='2*int((nf+2)/2) * (W/nf + 0.18u)' nrd='0.18u / W' nrs='0.18u / W' sa=0 sb=0 sd=0
XM8 net4 OUT GND GND nfet_06v0 L=1u W=2u nf=1 ad='int((nf+1)/2) * W/nf * 0.18u' as='int((nf+2)/2) * W/nf * 0.18u' pd='2*int((nf+1)/2) * (W/nf + 0.18u)'
+ ps='2*int((nf+2)/2) * (W/nf + 0.18u)' nrd='0.18u / W' nrs='0.18u / W' sa=0 sb=0 sd=0
XM9 OUT VA net5 GND nfet_06v0 L=1u W=2.48u nf=1 ad='int((nf+1)/2) * W/nf * 0.18u' as='int((nf+2)/2) * W/nf * 0.18u' pd='2*int((nf+1)/2) * (W/nf + 0.18u)'
+ ps='2*int((nf+2)/2) * (W/nf + 0.18u)' nrd='0.18u / W' nrs='0.18u / W' sa=0 sb=0 sd=0 m=2
XM10 net5 IN net11 GND nfet_06v0 L=1u W=1.24u nf=1 ad='int((nf+1)/2) * W/nf * 0.18u' as='int((nf+2)/2) * W/nf * 0.18u' pd='2*int((nf+1)/2) * (W/nf + 0.18u)'
+ ps='2*int((nf+2)/2) * (W/nf + 0.18u)' nrd='0.18u / W' nrs='0.18u / W' sa=0 sb=0 sd=0
XM11 OUT VB net6 GND nfet_06v0 L=1u W=2.48u nf=1 ad='int((nf+1)/2) * W/nf * 0.18u' as='int((nf+2)/2) * W/nf * 0.18u' pd='2*int((nf+1)/2) * (W/nf + 0.18u)'
+ ps='2*int((nf+2)/2) * (W/nf + 0.18u)' nrd='0.18u / W' nrs='0.18u / W' sa=0 sb=0 sd=0 m=2
XM12 net6 IN net12 GND nfet_06v0 L=1u W=1.24u nf=1 ad='int((nf+1)/2) * W/nf * 0.18u' as='int((nf+2)/2) * W/nf * 0.18u' pd='2*int((nf+1)/2) * (W/nf + 0.18u)'
+ ps='2*int((nf+2)/2) * (W/nf + 0.18u)' nrd='0.18u / W' nrs='0.18u / W' sa=0 sb=0 sd=0
XM4 net1 IN net13 GND nfet_06v0 L=1u W=1.24u nf=1 ad='int((nf+1)/2) * W/nf * 0.18u' as='int((nf+2)/2) * W/nf * 0.18u' pd='2*int((nf+1)/2) * (W/nf + 0.18u)'
+ ps='2*int((nf+2)/2) * (W/nf + 0.18u)' nrd='0.18u / W' nrs='0.18u / W' sa=0 sb=0 sd=0
XM13 IN IN VDD VDD pfet_06v0 L=1u W=2u nf=1 ad='int((nf+1)/2) * W/nf * 0.18u' as='int((nf+2)/2) * W/nf * 0.18u' pd='2*int((nf+1)/2) * (W/nf + 0.18u)'
+ ps='2*int((nf+2)/2) * (W/nf + 0.18u)' nrd='0.18u / W' nrs='0.18u / W' sa=0 sb=0 sd=0
XM14 net8 IN net9 GND nfet_06v0 L=1u W=0.7u nf=1 ad='int((nf+1)/2) * W/nf * 0.18u' as='int((nf+2)/2) * W/nf * 0.18u' pd='2*int((nf+1)/2) * (W/nf + 0.18u)'
+ ps='2*int((nf+2)/2) * (W/nf + 0.18u)' nrd='0.18u / W' nrs='0.18u / W' sa=0 sb=0 sd=0
XM15 net7 IN net8 GND nfet_06v0 L=1u W=0.7u nf=1 ad='int((nf+1)/2) * W/nf * 0.18u' as='int((nf+2)/2) * W/nf * 0.18u' pd='2*int((nf+1)/2) * (W/nf + 0.18u)'
+ ps='2*int((nf+2)/2) * (W/nf + 0.18u)' nrd='0.18u / W' nrs='0.18u / W' sa=0 sb=0 sd=0
XM16 IN IN net7 GND nfet_06v0 L=1u W=0.7u nf=1 ad='int((nf+1)/2) * W/nf * 0.18u' as='int((nf+2)/2) * W/nf * 0.18u' pd='2*int((nf+1)/2) * (W/nf + 0.18u)'
+ ps='2*int((nf+2)/2) * (W/nf + 0.18u)' nrd='0.18u / W' nrs='0.18u / W' sa=0 sb=0 sd=0
XM17 net9 IN GND GND nfet_06v0 L=1u W=0.7u nf=1 ad='int((nf+1)/2) * W/nf * 0.18u' as='int((nf+2)/2) * W/nf * 0.18u' pd='2*int((nf+1)/2) * (W/nf + 0.18u)'
+ ps='2*int((nf+2)/2) * (W/nf + 0.18u)' nrd='0.18u / W' nrs='0.18u / W' sa=0 sb=0 sd=0
Vmeas net11 GND 0
.save i(vmeas)
Vmeas1 net12 GND 0
.save i(vmeas1)
Vmeas2 net10 GND 0
.save i(vmeas2)
Vmeas3 net13 GND 0
.save i(vmeas3)
XMF1 OUT VDD netF GND nfet_06v0 L=1u W=2.48u nf=1 ad='int((nf+1)/2) * W/nf * 0.18u' as='int((nf+2)/2) * W/nf * 0.18u' pd='2*int((nf+1)/2) * (W/nf + 0.18u)'
+ ps='2*int((nf+2)/2) * (W/nf + 0.18u)' nrd='0.18u / W' nrs='0.18u / W' sa=0 sb=0 sd=0 m=2
XMF2 netF IN GND GND nfet_06v0 L=1u W=1.24u nf=1 ad='int((nf+1)/2) * W/nf * 0.18u' as='int((nf+2)/2) * W/nf * 0.18u' pd='2*int((nf+1)/2) * (W/nf + 0.18u)'
+ ps='2*int((nf+2)/2) * (W/nf + 0.18u)' nrd='0.18u / W' nrs='0.18u / W' sa=0 sb=0 sd=0
.ends

* expanding   symbol:  a_zonetic2026/XSCHEM/COMBINATION/GRADIENT2.sym # of pins=11
** sym_path: /foss/designs/a_zonetic2026/XSCHEM/COMBINATION/GRADIENT2.sym
** sch_path: /foss/designs/a_zonetic2026/XSCHEM/COMBINATION/GRADIENT2.sch
.subckt GRADIENT2 SXN SXP VDD X SYN Y Z SYP VSS SZN SZP
*.ipin SXN
*.ipin SXP
*.iopin VDD
*.iopin VSS
*.iopin X
*.iopin Y
*.iopin Z
*.ipin SYN
*.ipin SYP
*.ipin SZN
*.ipin SZP
x4 VDD SX net1 SY VSS COMP
x5 VDD SX net2 SZ VSS COMP
x6 VDD SY net3 SZ VSS COMP
x7 VDD net1 net2 X Y net3 Z VSS DECODER
x8 VDD SXN SX SXP VSS OPAM_LIN
x1 VDD SYN SY SYP VSS OPAM_LIN
x2 VDD SZN SZ SZP VSS OPAM_LIN
.ends

* expanding   symbol:  a_zonetic2026/XSCHEM/WEIGTH/COMP_OUT.sym # of pins=5
** sym_path: /foss/designs/a_zonetic2026/XSCHEM/WEIGTH/COMP_OUT.sym
** sch_path: /foss/designs/a_zonetic2026/XSCHEM/WEIGTH/COMP_OUT.sch
.subckt COMP_OUT VDD OUT IN OUT_N VSS
*.ipin IN
*.iopin VDD
*.opin OUT
*.iopin VSS
*.opin OUT_N
x1 VDD IN net1 VSS INV_1
x2 VDD net1 OUT VSS INV_1
x3 VDD OUT OUT_N VSS INV_1
.ends

* expanding   symbol:  a_zonetic2026/XSCHEM_v2/ESD_CDM.sym # of pins=4
** sym_path: /foss/designs/a_zonetic2026/XSCHEM_v2/ESD_CDM.sym
** sch_path: /foss/designs/a_zonetic2026/XSCHEM_v2/ESD_CDM.sch
.subckt ESD_CDM PAD CORE VDD VSS
*.ipin PAD
*.opin CORE
*.iopin VDD
*.iopin VSS
**** begin user architecture code

* SECONDARY (CDM) ESD NETWORK -- one per analogue pin.
*
* The GF180MCU analogue pads carry HBM diodes ONLY. `gf180mcu_fd_io` section 4.5:
*
*   The analogue signal pads contain only HBM protection diodes. If they are
*   connected to input gates, the designer needs to include CDM protection
*   network near to these gates. [...] The perimeter of the CDM diode should be
*   larger than 25um. The CDM resistor should be larger than 50 ohm and should
*   be realized using appropriate poly resistor.
*
* So `secondary_esd: true` in info.yaml is about what WE put inside the block.
*
* WHY THESE TWO DIODE TYPES AND NOT FOUR. The first draft had a mirrored pair on
* each rail, but two of them cannot be built:
*
*   * `diode_nd2ps` has its ANODE IN THE P SUBSTRATE, and the substrate is VSS
*     everywhere on the die. An nd2ps with its anode on PAD would tie the signal
*     to the substrate.
*   * a `pd2nw` with its CATHODE on PAD leaves the n-well floating with the
*     signal, and hangs the whole well capacitance off the pin.
*
* What is left is the standard clamp, and it is doubled to keep four devices:
*
*   D1, D2  nd2ps  anode VSS (the substrate) -> cathode PAD : clamps below VSS
*   D3, D4  pd2nw  anode PAD -> cathode VDD (the n-well)    : clamps above VDD
*
* Each is 10 x 5 um, so pj = 2*(10+5) = 30 um against the 25 the PDK asks for,
* and there are two per direction: 60 um.
*
* R1..R5 are the series resistor: five 1 x 2 um bodies of high-sheet poly in
* PARALLEL, about 1.3 kohm. The floor the PDK sets is 50 ohm, so this is
* generous on purpose -- the pin drives a MOS gate, no DC flows, and the bridge
* outside is a 500 kohm Thevenin source, so a couple of kohm divide nothing,
* while more series resistance is less current into the gate during a CDM event.
*
* The model is `ppolyf_u_3k` and not the plain `ppolyf_u` of the first draft,
* because that is what the PDK can DRAW clean: measured on the PCells alone,
* `ppolyf_u_high_Rs_res` comes out with no violation of its own, while
* `ppolyf_res(ppolyf_u)` brings SB.4, PP.2 and PRES.7 with it. It is also the
* only resistor this project has ever taped out -- sixty of them in
* GRADIENT_NAV2.
*
* Five separate lines and not one with m=5: the layout draws five bodies and
* both LVS tools extract five devices, so the reference netlist says five.
D1 VSS PAD diode_nd2ps_06v0 AREA=50p PJ=30u
D2 VSS PAD diode_nd2ps_06v0 AREA=50p PJ=30u
D3 PAD VDD diode_pd2nw_06v0 AREA=50p PJ=30u
D4 PAD VDD diode_pd2nw_06v0 AREA=50p PJ=30u
XR1 CORE PAD VSS ppolyf_u_3k r_width=1e-6 r_length=2e-6 m=1 s=1
XR2 CORE PAD VSS ppolyf_u_3k r_width=1e-6 r_length=2e-6 m=1 s=1
XR3 CORE PAD VSS ppolyf_u_3k r_width=1e-6 r_length=2e-6 m=1 s=1
XR4 CORE PAD VSS ppolyf_u_3k r_width=1e-6 r_length=2e-6 m=1 s=1
XR5 CORE PAD VSS ppolyf_u_3k r_width=1e-6 r_length=2e-6 m=1 s=1

**** end user architecture code
.ends

* expanding   symbol:  a_zonetic2026/XSCHEM/OPAM/COMP.sym # of pins=5
** sym_path: /foss/designs/a_zonetic2026/XSCHEM/OPAM/COMP.sym
** sch_path: /foss/designs/a_zonetic2026/XSCHEM/OPAM/COMP.sch
.subckt COMP VDD INN OUT INP VSS
*.ipin INN
*.ipin INP
*.iopin VDD
*.iopin VSS
*.iopin OUT
x1 VDD net4 net3 net2 net1 VSS bias
x2 VDD net4 net3 INN OUT INP net2 net1 VSS sub_diff
.ends

* expanding   symbol:  a_zonetic2026/XSCHEM/DECODER/DECODER.sym # of pins=8
** sym_path: /foss/designs/a_zonetic2026/XSCHEM/DECODER/DECODER.sym
** sch_path: /foss/designs/a_zonetic2026/XSCHEM/DECODER/DECODER.sch
.subckt DECODER VDD XY XZ X Y YZ Z VSS
*.ipin XY
*.ipin XZ
*.iopin VDD
*.iopin VSS
*.iopin X
*.ipin YZ
*.iopin Y
*.iopin Z
x2 YZ XY VDD Y VSS yGates
x1 VSS VDD XZ YZ Z Z
x3 VDD XY X XZ VSS xGates
.ends

* expanding   symbol:  a_zonetic2026/XSCHEM/OPAM/OPAM_LIN.sym # of pins=5
** sym_path: /foss/designs/a_zonetic2026/XSCHEM/OPAM/OPAM_LIN.sym
** sch_path: /foss/designs/a_zonetic2026/XSCHEM/OPAM/OPAM_LIN.sch
.subckt OPAM_LIN VDD INN OUT INP VSS
*.ipin INN
*.ipin INP
*.iopin VDD
*.iopin VSS
*.iopin OUT
x1 VDD net3 net4 net2 net1 VSS bias
x2 VDD net3 net4 OUT INN INP net2 net1 VSS sub_diff_2_LIN
.ends

* expanding   symbol:  a_zonetic2026/XSCHEM/WEIGTH/INV_1.sym # of pins=4
** sym_path: /foss/designs/a_zonetic2026/XSCHEM/WEIGTH/INV_1.sym
** sch_path: /foss/designs/a_zonetic2026/XSCHEM/WEIGTH/INV_1.sch
.subckt INV_1 VDD IN OUT VSS
*.ipin IN
*.iopin VDD
*.opin OUT
*.iopin VSS
XM3 OUT IN VDD VDD pfet_05v0 L=0.5u W=1.83u nf=1 ad='int((nf+1)/2) * W/nf * 0.18u' as='int((nf+2)/2) * W/nf * 0.18u' pd='2*int((nf+1)/2) * (W/nf + 0.18u)'
+ ps='2*int((nf+2)/2) * (W/nf + 0.18u)' nrd='0.18u / W' nrs='0.18u / W' sa=0 sb=0 sd=0
XM4 OUT IN VSS VSS nfet_05v0 L=0.6u W=1.32u nf=1 ad='int((nf+1)/2) * W/nf * 0.18u' as='int((nf+2)/2) * W/nf * 0.18u' pd='2*int((nf+1)/2) * (W/nf + 0.18u)'
+ ps='2*int((nf+2)/2) * (W/nf + 0.18u)' nrd='0.18u / W' nrs='0.18u / W' sa=0 sb=0 sd=0
.ends

* expanding   symbol:  a_zonetic2026/XSCHEM/OPAM/bias.sym # of pins=6
** sym_path: /foss/designs/a_zonetic2026/XSCHEM/OPAM/bias.sym
** sch_path: /foss/designs/a_zonetic2026/XSCHEM/OPAM/bias.sch
.subckt bias vdd bias1 bias2 bias3 bias4 vss
*.opin bias1
*.opin bias2
*.opin bias3
*.opin bias4
*.iopin vdd
*.iopin vss
XM4 net3 bias1 vdd vdd pfet_06v0 L=1.0u W=10.0u nf=1 ad='int((nf+1)/2) * W/nf * 0.18u' as='int((nf+2)/2) * W/nf * 0.18u' pd='2*int((nf+1)/2) * (W/nf + 0.18u)'
+ ps='2*int((nf+2)/2) * (W/nf + 0.18u)' nrd='0.18u / W' nrs='0.18u / W' sa=0 sb=0 sd=0
XM5 bias3 bias2 net3 vdd pfet_06v0 L=1.0u W=10.0u nf=1 ad='int((nf+1)/2) * W/nf * 0.18u' as='int((nf+2)/2) * W/nf * 0.18u' pd='2*int((nf+1)/2) * (W/nf + 0.18u)'
+ ps='2*int((nf+2)/2) * (W/nf + 0.18u)' nrd='0.18u / W' nrs='0.18u / W' sa=0 sb=0 sd=0
XM6 bias3 bias3 vss vss nfet_06v0 L=1.0u W=1.0u nf=1 ad='int((nf+1)/2) * W/nf * 0.18u' as='int((nf+2)/2) * W/nf * 0.18u' pd='2*int((nf+1)/2) * (W/nf + 0.18u)'
+ ps='2*int((nf+2)/2) * (W/nf + 0.18u)' nrd='0.18u / W' nrs='0.18u / W' sa=0 sb=0 sd=0
XM7 net2 bias1 vdd vdd pfet_06v0 L=1.0u W=10.0u nf=1 ad='int((nf+1)/2) * W/nf * 0.18u' as='int((nf+2)/2) * W/nf * 0.18u' pd='2*int((nf+1)/2) * (W/nf + 0.18u)'
+ ps='2*int((nf+2)/2) * (W/nf + 0.18u)' nrd='0.18u / W' nrs='0.18u / W' sa=0 sb=0 sd=0
XM8 bias4 bias2 net2 vdd pfet_06v0 L=1.0u W=10.0u nf=1 ad='int((nf+1)/2) * W/nf * 0.18u' as='int((nf+2)/2) * W/nf * 0.18u' pd='2*int((nf+1)/2) * (W/nf + 0.18u)'
+ ps='2*int((nf+2)/2) * (W/nf + 0.18u)' nrd='0.18u / W' nrs='0.18u / W' sa=0 sb=0 sd=0
XM9 bias4 bias3 net1 vss nfet_06v0 L=1.0u W=5.0u nf=1 ad='int((nf+1)/2) * W/nf * 0.18u' as='int((nf+2)/2) * W/nf * 0.18u' pd='2*int((nf+1)/2) * (W/nf + 0.18u)'
+ ps='2*int((nf+2)/2) * (W/nf + 0.18u)' nrd='0.18u / W' nrs='0.18u / W' sa=0 sb=0 sd=0
XM10 net1 bias4 vss vss nfet_06v0 L=1.0u W=5.0u nf=1 ad='int((nf+1)/2) * W/nf * 0.18u' as='int((nf+2)/2) * W/nf * 0.18u' pd='2*int((nf+1)/2) * (W/nf + 0.18u)'
+ ps='2*int((nf+2)/2) * (W/nf + 0.18u)' nrd='0.18u / W' nrs='0.18u / W' sa=0 sb=0 sd=0
XM1 bias2 bias2 vdd vdd pfet_06v0 L=1.0u W=2u nf=1 ad='int((nf+1)/2) * W/nf * 0.18u' as='int((nf+2)/2) * W/nf * 0.18u' pd='2*int((nf+1)/2) * (W/nf + 0.18u)'
+ ps='2*int((nf+2)/2) * (W/nf + 0.18u)' nrd='0.18u / W' nrs='0.18u / W' sa=0 sb=0 sd=0
XM2 net4 bias1 vdd vdd pfet_06v0 L=1.0u W=10.0u nf=1 ad='int((nf+1)/2) * W/nf * 0.18u' as='int((nf+2)/2) * W/nf * 0.18u' pd='2*int((nf+1)/2) * (W/nf + 0.18u)'
+ ps='2*int((nf+2)/2) * (W/nf + 0.18u)' nrd='0.18u / W' nrs='0.18u / W' sa=0 sb=0 sd=0
XM3 bias1 bias2 net4 vdd pfet_06v0 L=1.0u W=10.0u nf=1 ad='int((nf+1)/2) * W/nf * 0.18u' as='int((nf+2)/2) * W/nf * 0.18u' pd='2*int((nf+1)/2) * (W/nf + 0.18u)'
+ ps='2*int((nf+2)/2) * (W/nf + 0.18u)' nrd='0.18u / W' nrs='0.18u / W' sa=0 sb=0 sd=0
XM47 net5 bias2 vss vss nfet_06v0 L=1.0u W=1.0u nf=1 ad='int((nf+1)/2) * W/nf * 0.18u' as='int((nf+2)/2) * W/nf * 0.18u' pd='2*int((nf+1)/2) * (W/nf + 0.18u)'
+ ps='2*int((nf+2)/2) * (W/nf + 0.18u)' nrd='0.18u / W' nrs='0.18u / W' sa=0 sb=0 sd=0
XM48 net6 bias2 vss vss nfet_06v0 L=1.0u W=1.0u nf=1 ad='int((nf+1)/2) * W/nf * 0.18u' as='int((nf+2)/2) * W/nf * 0.18u' pd='2*int((nf+1)/2) * (W/nf + 0.18u)'
+ ps='2*int((nf+2)/2) * (W/nf + 0.18u)' nrd='0.18u / W' nrs='0.18u / W' sa=0 sb=0 sd=0
XM49 bias2 bias2 net6 vss nfet_06v0 L=1.0u W=1.0u nf=1 ad='int((nf+1)/2) * W/nf * 0.18u' as='int((nf+2)/2) * W/nf * 0.18u' pd='2*int((nf+1)/2) * (W/nf + 0.18u)'
+ ps='2*int((nf+2)/2) * (W/nf + 0.18u)' nrd='0.18u / W' nrs='0.18u / W' sa=0 sb=0 sd=0
XM50 bias1 bias2 net5 vss nfet_06v0 L=1.0u W=1.0u nf=1 ad='int((nf+1)/2) * W/nf * 0.18u' as='int((nf+2)/2) * W/nf * 0.18u' pd='2*int((nf+1)/2) * (W/nf + 0.18u)'
+ ps='2*int((nf+2)/2) * (W/nf + 0.18u)' nrd='0.18u / W' nrs='0.18u / W' sa=0 sb=0 sd=0
.ends

* expanding   symbol:  a_zonetic2026/XSCHEM/OPAM/sub_diff.sym # of pins=9
** sym_path: /foss/designs/a_zonetic2026/XSCHEM/OPAM/sub_diff.sym
** sch_path: /foss/designs/a_zonetic2026/XSCHEM/OPAM/sub_diff.sch
.subckt sub_diff vdd bias1 bias2 vinn out vinp bias3 bias4 vss
*.opin out
*.iopin vdd
*.iopin vss
*.ipin vinp
*.ipin vinn
*.ipin bias1
*.ipin bias2
*.ipin bias3
*.ipin bias4
XM11 net2 bias1 vdd vdd pfet_06v0 L=1.0u W=10.0u nf=1 ad='int((nf+1)/2) * W/nf * 0.18u' as='int((nf+2)/2) * W/nf * 0.18u' pd='2*int((nf+1)/2) * (W/nf + 0.18u)'
+ ps='2*int((nf+2)/2) * (W/nf + 0.18u)' nrd='0.18u / W' nrs='0.18u / W' sa=0 sb=0 sd=0
XM12 net7 bias2 net2 vdd pfet_06v0 L=1.0u W=10.0u nf=1 ad='int((nf+1)/2) * W/nf * 0.18u' as='int((nf+2)/2) * W/nf * 0.18u' pd='2*int((nf+1)/2) * (W/nf + 0.18u)'
+ ps='2*int((nf+2)/2) * (W/nf + 0.18u)' nrd='0.18u / W' nrs='0.18u / W' sa=0 sb=0 sd=0
XM13 net19 bias1 vdd vdd pfet_06v0 L=1.0u W=10.0u nf=1 ad='int((nf+1)/2) * W/nf * 0.18u' as='int((nf+2)/2) * W/nf * 0.18u' pd='2*int((nf+1)/2) * (W/nf + 0.18u)'
+ ps='2*int((nf+2)/2) * (W/nf + 0.18u)' nrd='0.18u / W' nrs='0.18u / W' sa=0 sb=0 sd=0
XM14 net7 bias2 net19 vdd pfet_06v0 L=1.0u W=10.0u nf=1 ad='int((nf+1)/2) * W/nf * 0.18u' as='int((nf+2)/2) * W/nf * 0.18u' pd='2*int((nf+1)/2) * (W/nf + 0.18u)'
+ ps='2*int((nf+2)/2) * (W/nf + 0.18u)' nrd='0.18u / W' nrs='0.18u / W' sa=0 sb=0 sd=0
XM15 net5 vinp net7 vdd pfet_06v0 L=1.0u W=10.0u nf=1 ad='int((nf+1)/2) * W/nf * 0.18u' as='int((nf+2)/2) * W/nf * 0.18u' pd='2*int((nf+1)/2) * (W/nf + 0.18u)'
+ ps='2*int((nf+2)/2) * (W/nf + 0.18u)' nrd='0.18u / W' nrs='0.18u / W' sa=0 sb=0 sd=0 m=2
XM16 net4 vinn net7 vdd pfet_06v0 L=1.0u W=10.0u nf=1 ad='int((nf+1)/2) * W/nf * 0.18u' as='int((nf+2)/2) * W/nf * 0.18u' pd='2*int((nf+1)/2) * (W/nf + 0.18u)'
+ ps='2*int((nf+2)/2) * (W/nf + 0.18u)' nrd='0.18u / W' nrs='0.18u / W' sa=0 sb=0 sd=0 m=2
XM17 net8 bias3 net1 vss nfet_06v0 L=1.0u W=5.0u nf=1 ad='int((nf+1)/2) * W/nf * 0.18u' as='int((nf+2)/2) * W/nf * 0.18u' pd='2*int((nf+1)/2) * (W/nf + 0.18u)'
+ ps='2*int((nf+2)/2) * (W/nf + 0.18u)' nrd='0.18u / W' nrs='0.18u / W' sa=0 sb=0 sd=0
XM18 net1 bias4 vss vss nfet_06v0 L=1.0u W=5.0u nf=1 ad='int((nf+1)/2) * W/nf * 0.18u' as='int((nf+2)/2) * W/nf * 0.18u' pd='2*int((nf+1)/2) * (W/nf + 0.18u)'
+ ps='2*int((nf+2)/2) * (W/nf + 0.18u)' nrd='0.18u / W' nrs='0.18u / W' sa=0 sb=0 sd=0
XM19 net8 bias3 net20 vss nfet_06v0 L=1.0u W=5.0u nf=1 ad='int((nf+1)/2) * W/nf * 0.18u' as='int((nf+2)/2) * W/nf * 0.18u' pd='2*int((nf+1)/2) * (W/nf + 0.18u)'
+ ps='2*int((nf+2)/2) * (W/nf + 0.18u)' nrd='0.18u / W' nrs='0.18u / W' sa=0 sb=0 sd=0
XM20 net20 bias4 vss vss nfet_06v0 L=1.0u W=5.0u nf=1 ad='int((nf+1)/2) * W/nf * 0.18u' as='int((nf+2)/2) * W/nf * 0.18u' pd='2*int((nf+1)/2) * (W/nf + 0.18u)'
+ ps='2*int((nf+2)/2) * (W/nf + 0.18u)' nrd='0.18u / W' nrs='0.18u / W' sa=0 sb=0 sd=0
XM21 net6 vinp net8 vss nfet_06v0 L=1.0u W=5u nf=1 ad='int((nf+1)/2) * W/nf * 0.18u' as='int((nf+2)/2) * W/nf * 0.18u' pd='2*int((nf+1)/2) * (W/nf + 0.18u)'
+ ps='2*int((nf+2)/2) * (W/nf + 0.18u)' nrd='0.18u / W' nrs='0.18u / W' sa=0 sb=0 sd=0 m=2
XM22 net3 vinn net8 vss nfet_06v0 L=1.0u W=5u nf=1 ad='int((nf+1)/2) * W/nf * 0.18u' as='int((nf+2)/2) * W/nf * 0.18u' pd='2*int((nf+1)/2) * (W/nf + 0.18u)'
+ ps='2*int((nf+2)/2) * (W/nf + 0.18u)' nrd='0.18u / W' nrs='0.18u / W' sa=0 sb=0 sd=0 m=2
XM29 net9 bias2 net3 vdd pfet_06v0 L=1.0u W=5u nf=1 ad='int((nf+1)/2) * W/nf * 0.18u' as='int((nf+2)/2) * W/nf * 0.18u' pd='2*int((nf+1)/2) * (W/nf + 0.18u)'
+ ps='2*int((nf+2)/2) * (W/nf + 0.18u)' nrd='0.18u / W' nrs='0.18u / W' sa=0 sb=0 sd=0 m=2
XM30 net12 bias2 net6 vdd pfet_06v0 L=1.0u W=5.0u nf=1 ad='int((nf+1)/2) * W/nf * 0.18u' as='int((nf+2)/2) * W/nf * 0.18u' pd='2*int((nf+1)/2) * (W/nf + 0.18u)'
+ ps='2*int((nf+2)/2) * (W/nf + 0.18u)' nrd='0.18u / W' nrs='0.18u / W' sa=0 sb=0 sd=0 m=2
XM31 net3 net9 vdd vdd pfet_06v0 L=1.0u W=5u nf=1 ad='int((nf+1)/2) * W/nf * 0.18u' as='int((nf+2)/2) * W/nf * 0.18u' pd='2*int((nf+1)/2) * (W/nf + 0.18u)'
+ ps='2*int((nf+2)/2) * (W/nf + 0.18u)' nrd='0.18u / W' nrs='0.18u / W' sa=0 sb=0 sd=0 m=4
XM35 net6 net9 vdd vdd pfet_06v0 L=1.0u W=5.0u nf=1 ad='int((nf+1)/2) * W/nf * 0.18u' as='int((nf+2)/2) * W/nf * 0.18u' pd='2*int((nf+1)/2) * (W/nf + 0.18u)'
+ ps='2*int((nf+2)/2) * (W/nf + 0.18u)' nrd='0.18u / W' nrs='0.18u / W' sa=0 sb=0 sd=0 m=4
XM32 net10 net21 net9 vdd pfet_06v0 L=1.0u W=5u nf=1 ad='int((nf+1)/2) * W/nf * 0.18u' as='int((nf+2)/2) * W/nf * 0.18u' pd='2*int((nf+1)/2) * (W/nf + 0.18u)'
+ ps='2*int((nf+2)/2) * (W/nf + 0.18u)' nrd='0.18u / W' nrs='0.18u / W' sa=0 sb=0 sd=0
XM33 net22 net21 net12 vdd pfet_06v0 L=1.0u W=5.0u nf=1 ad='int((nf+1)/2) * W/nf * 0.18u' as='int((nf+2)/2) * W/nf * 0.18u' pd='2*int((nf+1)/2) * (W/nf + 0.18u)'
+ ps='2*int((nf+2)/2) * (W/nf + 0.18u)' nrd='0.18u / W' nrs='0.18u / W' sa=0 sb=0 sd=0
XM23 net10 bias3 net4 vss nfet_06v0 L=1.0u W=2.5u nf=1 ad='int((nf+1)/2) * W/nf * 0.18u' as='int((nf+2)/2) * W/nf * 0.18u' pd='2*int((nf+1)/2) * (W/nf + 0.18u)'
+ ps='2*int((nf+2)/2) * (W/nf + 0.18u)' nrd='0.18u / W' nrs='0.18u / W' sa=0 sb=0 sd=0 m=2
XM24 net22 bias3 net5 vss nfet_06v0 L=1.0u W=2.5u nf=1 ad='int((nf+1)/2) * W/nf * 0.18u' as='int((nf+2)/2) * W/nf * 0.18u' pd='2*int((nf+1)/2) * (W/nf + 0.18u)'
+ ps='2*int((nf+2)/2) * (W/nf + 0.18u)' nrd='0.18u / W' nrs='0.18u / W' sa=0 sb=0 sd=0 m=2
XM25 net4 net10 vss vss nfet_06v0 L=1.0u W=2.5u nf=1 ad='int((nf+1)/2) * W/nf * 0.18u' as='int((nf+2)/2) * W/nf * 0.18u' pd='2*int((nf+1)/2) * (W/nf + 0.18u)'
+ ps='2*int((nf+2)/2) * (W/nf + 0.18u)' nrd='0.18u / W' nrs='0.18u / W' sa=0 sb=0 sd=0 m=4
XM26 net5 net10 vss vss nfet_06v0 L=1.0u W=2.5u nf=1 ad='int((nf+1)/2) * W/nf * 0.18u' as='int((nf+2)/2) * W/nf * 0.18u' pd='2*int((nf+1)/2) * (W/nf + 0.18u)'
+ ps='2*int((nf+2)/2) * (W/nf + 0.18u)' nrd='0.18u / W' nrs='0.18u / W' sa=0 sb=0 sd=0 m=4
XM27 net9 net11 net10 vss nfet_06v0 L=1.0u W=2.5u nf=1 ad='int((nf+1)/2) * W/nf * 0.18u' as='int((nf+2)/2) * W/nf * 0.18u' pd='2*int((nf+1)/2) * (W/nf + 0.18u)'
+ ps='2*int((nf+2)/2) * (W/nf + 0.18u)' nrd='0.18u / W' nrs='0.18u / W' sa=0 sb=0 sd=0
XM28 net12 net11 net22 vss nfet_06v0 L=1.0u W=2.5u nf=1 ad='int((nf+1)/2) * W/nf * 0.18u' as='int((nf+2)/2) * W/nf * 0.18u' pd='2*int((nf+1)/2) * (W/nf + 0.18u)'
+ ps='2*int((nf+2)/2) * (W/nf + 0.18u)' nrd='0.18u / W' nrs='0.18u / W' sa=0 sb=0 sd=0
XM34 net13 net14 vdd vdd pfet_06v0 L=1.0u W=10.0u nf=1 ad='int((nf+1)/2) * W/nf * 0.18u' as='int((nf+2)/2) * W/nf * 0.18u' pd='2*int((nf+1)/2) * (W/nf + 0.18u)'
+ ps='2*int((nf+2)/2) * (W/nf + 0.18u)' nrd='0.18u / W' nrs='0.18u / W' sa=0 sb=0 sd=0
XM36 net14 bias2 net13 vdd pfet_06v0 L=1.0u W=10.0u nf=1 ad='int((nf+1)/2) * W/nf * 0.18u' as='int((nf+2)/2) * W/nf * 0.18u' pd='2*int((nf+1)/2) * (W/nf + 0.18u)'
+ ps='2*int((nf+2)/2) * (W/nf + 0.18u)' nrd='0.18u / W' nrs='0.18u / W' sa=0 sb=0 sd=0
XM37 net21 net21 net14 vdd pfet_06v0 L=1.0u W=10.0u nf=1 ad='int((nf+1)/2) * W/nf * 0.18u' as='int((nf+2)/2) * W/nf * 0.18u' pd='2*int((nf+1)/2) * (W/nf + 0.18u)'
+ ps='2*int((nf+2)/2) * (W/nf + 0.18u)' nrd='0.18u / W' nrs='0.18u / W' sa=0 sb=0 sd=0
XM38 net21 bias3 net15 vss nfet_06v0 L=1.0u W=5.0u nf=1 ad='int((nf+1)/2) * W/nf * 0.18u' as='int((nf+2)/2) * W/nf * 0.18u' pd='2*int((nf+1)/2) * (W/nf + 0.18u)'
+ ps='2*int((nf+2)/2) * (W/nf + 0.18u)' nrd='0.18u / W' nrs='0.18u / W' sa=0 sb=0 sd=0
XM39 net15 bias4 vss vss nfet_06v0 L=1.0u W=5.0u nf=1 ad='int((nf+1)/2) * W/nf * 0.18u' as='int((nf+2)/2) * W/nf * 0.18u' pd='2*int((nf+1)/2) * (W/nf + 0.18u)'
+ ps='2*int((nf+2)/2) * (W/nf + 0.18u)' nrd='0.18u / W' nrs='0.18u / W' sa=0 sb=0 sd=0
XM45 net16 bias1 vdd vdd pfet_06v0 L=1.0u W=10.0u nf=1 ad='int((nf+1)/2) * W/nf * 0.18u' as='int((nf+2)/2) * W/nf * 0.18u' pd='2*int((nf+1)/2) * (W/nf + 0.18u)'
+ ps='2*int((nf+2)/2) * (W/nf + 0.18u)' nrd='0.18u / W' nrs='0.18u / W' sa=0 sb=0 sd=0
XM46 net11 bias2 net16 vdd pfet_06v0 L=1.0u W=10.0u nf=1 ad='int((nf+1)/2) * W/nf * 0.18u' as='int((nf+2)/2) * W/nf * 0.18u' pd='2*int((nf+1)/2) * (W/nf + 0.18u)'
+ ps='2*int((nf+2)/2) * (W/nf + 0.18u)' nrd='0.18u / W' nrs='0.18u / W' sa=0 sb=0 sd=0
XM40 net11 net11 net18 vss nfet_06v0 L=1.0u W=5.0u nf=1 ad='int((nf+1)/2) * W/nf * 0.18u' as='int((nf+2)/2) * W/nf * 0.18u' pd='2*int((nf+1)/2) * (W/nf + 0.18u)'
+ ps='2*int((nf+2)/2) * (W/nf + 0.18u)' nrd='0.18u / W' nrs='0.18u / W' sa=0 sb=0 sd=0
XM41 net18 bias3 net17 vss nfet_06v0 L=1.0u W=5.0u nf=1 ad='int((nf+1)/2) * W/nf * 0.18u' as='int((nf+2)/2) * W/nf * 0.18u' pd='2*int((nf+1)/2) * (W/nf + 0.18u)'
+ ps='2*int((nf+2)/2) * (W/nf + 0.18u)' nrd='0.18u / W' nrs='0.18u / W' sa=0 sb=0 sd=0
XM42 net17 net18 vss vss nfet_06v0 L=1.0u W=5.0u nf=1 ad='int((nf+1)/2) * W/nf * 0.18u' as='int((nf+2)/2) * W/nf * 0.18u' pd='2*int((nf+1)/2) * (W/nf + 0.18u)'
+ ps='2*int((nf+2)/2) * (W/nf + 0.18u)' nrd='0.18u / W' nrs='0.18u / W' sa=0 sb=0 sd=0
XM43 out net12 vdd vdd pfet_06v0 L=1.0u W=10u nf=1 ad='int((nf+1)/2) * W/nf * 0.18u' as='int((nf+2)/2) * W/nf * 0.18u' pd='2*int((nf+1)/2) * (W/nf + 0.18u)'
+ ps='2*int((nf+2)/2) * (W/nf + 0.18u)' nrd='0.18u / W' nrs='0.18u / W' sa=0 sb=0 sd=0 m=3
XM44 out net22 vss vss nfet_06v0 L=1.0u W=5u nf=1 ad='int((nf+1)/2) * W/nf * 0.18u' as='int((nf+2)/2) * W/nf * 0.18u' pd='2*int((nf+1)/2) * (W/nf + 0.18u)'
+ ps='2*int((nf+2)/2) * (W/nf + 0.18u)' nrd='0.18u / W' nrs='0.18u / W' sa=0 sb=0 sd=0 m=3
XC2 out net5 cap_mim_2f0fF c_width=20e-6 c_length=10e-6
XC3 net6 out cap_mim_2f0fF c_width=20e-6 c_length=10e-6
.ends

* expanding   symbol:  a_zonetic2026/XSCHEM/DECODER/yGates.sym # of pins=5
** sym_path: /foss/designs/a_zonetic2026/XSCHEM/DECODER/yGates.sym
** sch_path: /foss/designs/a_zonetic2026/XSCHEM/DECODER/yGates.sch
.subckt yGates YZ XY VDD output VSS
*.ipin VDD
*.ipin VSS
*.ipin YZ
*.ipin XY
*.opin output
x2 VDD net1 XY VSS invertor
x3 YZ VDD net1 output VSS andGate
.ends

* expanding   symbol:  a_zonetic2026/XSCHEM/DECODER/Z.sym # of pins=5
** sym_path: /foss/designs/a_zonetic2026/XSCHEM/DECODER/Z.sym
** sch_path: /foss/designs/a_zonetic2026/XSCHEM/DECODER/Z.sch
.subckt Z VSS VDD XZ YZ out
*.iopin VSS
*.iopin VDD
*.ipin XZ
*.ipin YZ
*.opin out
XM4 net1 YZ out VDD pfet_06v0 L=1.0u W=3.0u nf=1 ad='int((nf+1)/2) * W/nf * 0.18u' as='int((nf+2)/2) * W/nf * 0.18u' pd='2*int((nf+1)/2) * (W/nf + 0.18u)'
+ ps='2*int((nf+2)/2) * (W/nf + 0.18u)' nrd='0.18u / W' nrs='0.18u / W' sa=0 sb=0 sd=0
XM5 VDD XZ net1 VDD pfet_06v0 L=1.0u W=3.0u nf=1 ad='int((nf+1)/2) * W/nf * 0.18u' as='int((nf+2)/2) * W/nf * 0.18u' pd='2*int((nf+1)/2) * (W/nf + 0.18u)'
+ ps='2*int((nf+2)/2) * (W/nf + 0.18u)' nrd='0.18u / W' nrs='0.18u / W' sa=0 sb=0 sd=0
XM7 VSS YZ out VSS nfet_06v0 L=1u W=1u nf=1 ad='int((nf+1)/2) * W/nf * 0.18u' as='int((nf+2)/2) * W/nf * 0.18u' pd='2*int((nf+1)/2) * (W/nf + 0.18u)'
+ ps='2*int((nf+2)/2) * (W/nf + 0.18u)' nrd='0.18u / W' nrs='0.18u / W' sa=0 sb=0 sd=0
XM1 VSS XZ out VSS nfet_06v0 L=1u W=1u nf=1 ad='int((nf+1)/2) * W/nf * 0.18u' as='int((nf+2)/2) * W/nf * 0.18u' pd='2*int((nf+1)/2) * (W/nf + 0.18u)'
+ ps='2*int((nf+2)/2) * (W/nf + 0.18u)' nrd='0.18u / W' nrs='0.18u / W' sa=0 sb=0 sd=0
.ends

* expanding   symbol:  a_zonetic2026/XSCHEM/DECODER/xGates.sym # of pins=5
** sym_path: /foss/designs/a_zonetic2026/XSCHEM/DECODER/xGates.sym
** sch_path: /foss/designs/a_zonetic2026/XSCHEM/DECODER/xGates.sch
.subckt xGates VDD XY output XZ VSS
*.ipin XY
*.opin output
*.ipin VDD
*.ipin VSS
*.ipin XZ
x2 XY VDD XZ output VSS andGate
.ends

* expanding   symbol:  a_zonetic2026/XSCHEM/OPAM/sub_diff_2_LIN.sym # of pins=9
** sym_path: /foss/designs/a_zonetic2026/XSCHEM/OPAM/sub_diff_2_LIN.sym
** sch_path: /foss/designs/a_zonetic2026/XSCHEM/OPAM/sub_diff_2_LIN.sch
.subckt sub_diff_2_LIN VDD bias1 bias2 OUT INN INP bias3 bias4 VSS
*.ipin INN
*.ipin INP
*.iopin VDD
*.iopin VSS
*.iopin OUT
*.ipin bias1
*.ipin bias2
*.ipin bias3
*.ipin bias4
XM11 net2 bias1 VDD VDD pfet_06v0 L=1.0u W=10.0u nf=1 ad='int((nf+1)/2) * W/nf * 0.18u' as='int((nf+2)/2) * W/nf * 0.18u' pd='2*int((nf+1)/2) * (W/nf + 0.18u)'
+ ps='2*int((nf+2)/2) * (W/nf + 0.18u)' nrd='0.18u / W' nrs='0.18u / W' sa=0 sb=0 sd=0
XM12 net7 bias2 net2 VDD pfet_06v0 L=1.0u W=10.0u nf=1 ad='int((nf+1)/2) * W/nf * 0.18u' as='int((nf+2)/2) * W/nf * 0.18u' pd='2*int((nf+1)/2) * (W/nf + 0.18u)'
+ ps='2*int((nf+2)/2) * (W/nf + 0.18u)' nrd='0.18u / W' nrs='0.18u / W' sa=0 sb=0 sd=0
XM13 net18 bias1 VDD VDD pfet_06v0 L=1.0u W=10.0u nf=1 ad='int((nf+1)/2) * W/nf * 0.18u' as='int((nf+2)/2) * W/nf * 0.18u' pd='2*int((nf+1)/2) * (W/nf + 0.18u)'
+ ps='2*int((nf+2)/2) * (W/nf + 0.18u)' nrd='0.18u / W' nrs='0.18u / W' sa=0 sb=0 sd=0
XM14 net7 bias2 net18 VDD pfet_06v0 L=1.0u W=10.0u nf=1 ad='int((nf+1)/2) * W/nf * 0.18u' as='int((nf+2)/2) * W/nf * 0.18u' pd='2*int((nf+1)/2) * (W/nf + 0.18u)'
+ ps='2*int((nf+2)/2) * (W/nf + 0.18u)' nrd='0.18u / W' nrs='0.18u / W' sa=0 sb=0 sd=0
XM15 net5 INP net7 VDD pfet_06v0 L=1.0u W=1.1u nf=1 ad='int((nf+1)/2) * W/nf * 0.18u' as='int((nf+2)/2) * W/nf * 0.18u' pd='2*int((nf+1)/2) * (W/nf + 0.18u)'
+ ps='2*int((nf+2)/2) * (W/nf + 0.18u)' nrd='0.18u / W' nrs='0.18u / W' sa=0 sb=0 sd=0
XM16 net4 INN net7 VDD pfet_06v0 L=1.0u W=1.0u nf=1 ad='int((nf+1)/2) * W/nf * 0.18u' as='int((nf+2)/2) * W/nf * 0.18u' pd='2*int((nf+1)/2) * (W/nf + 0.18u)'
+ ps='2*int((nf+2)/2) * (W/nf + 0.18u)' nrd='0.18u / W' nrs='0.18u / W' sa=0 sb=0 sd=0
XM17 net8 bias3 net1 VSS nfet_06v0 L=1.0u W=5.0u nf=1 ad='int((nf+1)/2) * W/nf * 0.18u' as='int((nf+2)/2) * W/nf * 0.18u' pd='2*int((nf+1)/2) * (W/nf + 0.18u)'
+ ps='2*int((nf+2)/2) * (W/nf + 0.18u)' nrd='0.18u / W' nrs='0.18u / W' sa=0 sb=0 sd=0
XM18 net1 bias4 VSS VSS nfet_06v0 L=1.0u W=5.0u nf=1 ad='int((nf+1)/2) * W/nf * 0.18u' as='int((nf+2)/2) * W/nf * 0.18u' pd='2*int((nf+1)/2) * (W/nf + 0.18u)'
+ ps='2*int((nf+2)/2) * (W/nf + 0.18u)' nrd='0.18u / W' nrs='0.18u / W' sa=0 sb=0 sd=0
XM19 net8 bias3 net19 VSS nfet_06v0 L=1.0u W=5.0u nf=1 ad='int((nf+1)/2) * W/nf * 0.18u' as='int((nf+2)/2) * W/nf * 0.18u' pd='2*int((nf+1)/2) * (W/nf + 0.18u)'
+ ps='2*int((nf+2)/2) * (W/nf + 0.18u)' nrd='0.18u / W' nrs='0.18u / W' sa=0 sb=0 sd=0
XM20 net19 bias4 VSS VSS nfet_06v0 L=1.0u W=5.0u nf=1 ad='int((nf+1)/2) * W/nf * 0.18u' as='int((nf+2)/2) * W/nf * 0.18u' pd='2*int((nf+1)/2) * (W/nf + 0.18u)'
+ ps='2*int((nf+2)/2) * (W/nf + 0.18u)' nrd='0.18u / W' nrs='0.18u / W' sa=0 sb=0 sd=0
XM21 net6 INP net8 VSS nfet_06v0 L=1.0u W=1u nf=1 ad='int((nf+1)/2) * W/nf * 0.18u' as='int((nf+2)/2) * W/nf * 0.18u' pd='2*int((nf+1)/2) * (W/nf + 0.18u)'
+ ps='2*int((nf+2)/2) * (W/nf + 0.18u)' nrd='0.18u / W' nrs='0.18u / W' sa=0 sb=0 sd=0
XM22 net3 INN net8 VSS nfet_06v0 L=1.0u W=1u nf=1 ad='int((nf+1)/2) * W/nf * 0.18u' as='int((nf+2)/2) * W/nf * 0.18u' pd='2*int((nf+1)/2) * (W/nf + 0.18u)'
+ ps='2*int((nf+2)/2) * (W/nf + 0.18u)' nrd='0.18u / W' nrs='0.18u / W' sa=0 sb=0 sd=0
XM29 net9 bias2 net3 VDD pfet_06v0 L=1.0u W=5u nf=1 ad='int((nf+1)/2) * W/nf * 0.18u' as='int((nf+2)/2) * W/nf * 0.18u' pd='2*int((nf+1)/2) * (W/nf + 0.18u)'
+ ps='2*int((nf+2)/2) * (W/nf + 0.18u)' nrd='0.18u / W' nrs='0.18u / W' sa=0 sb=0 sd=0
XM30 G_OUT_P bias2 net6 VDD pfet_06v0 L=1.0u W=5u nf=1 ad='int((nf+1)/2) * W/nf * 0.18u' as='int((nf+2)/2) * W/nf * 0.18u' pd='2*int((nf+1)/2) * (W/nf + 0.18u)'
+ ps='2*int((nf+2)/2) * (W/nf + 0.18u)' nrd='0.18u / W' nrs='0.18u / W' sa=0 sb=0 sd=0
XM31 net3 net9 VDD VDD pfet_06v0 L=1.0u W=5u nf=1 ad='int((nf+1)/2) * W/nf * 0.18u' as='int((nf+2)/2) * W/nf * 0.18u' pd='2*int((nf+1)/2) * (W/nf + 0.18u)'
+ ps='2*int((nf+2)/2) * (W/nf + 0.18u)' nrd='0.18u / W' nrs='0.18u / W' sa=0 sb=0 sd=0
XM35 net6 net9 VDD VDD pfet_06v0 L=1.0u W=5u nf=1 ad='int((nf+1)/2) * W/nf * 0.18u' as='int((nf+2)/2) * W/nf * 0.18u' pd='2*int((nf+1)/2) * (W/nf + 0.18u)'
+ ps='2*int((nf+2)/2) * (W/nf + 0.18u)' nrd='0.18u / W' nrs='0.18u / W' sa=0 sb=0 sd=0
XM32 net10 net20 net9 VDD pfet_06v0 L=1.0u W=5.0u nf=1 ad='int((nf+1)/2) * W/nf * 0.18u' as='int((nf+2)/2) * W/nf * 0.18u' pd='2*int((nf+1)/2) * (W/nf + 0.18u)'
+ ps='2*int((nf+2)/2) * (W/nf + 0.18u)' nrd='0.18u / W' nrs='0.18u / W' sa=0 sb=0 sd=0
XM33 net21 net20 G_OUT_P VDD pfet_06v0 L=1.0u W=5.0u nf=1 ad='int((nf+1)/2) * W/nf * 0.18u' as='int((nf+2)/2) * W/nf * 0.18u' pd='2*int((nf+1)/2) * (W/nf + 0.18u)'
+ ps='2*int((nf+2)/2) * (W/nf + 0.18u)' nrd='0.18u / W' nrs='0.18u / W' sa=0 sb=0 sd=0
XM23 net10 bias3 net4 VSS nfet_06v0 L=1.0u W=2.5u nf=1 ad='int((nf+1)/2) * W/nf * 0.18u' as='int((nf+2)/2) * W/nf * 0.18u' pd='2*int((nf+1)/2) * (W/nf + 0.18u)'
+ ps='2*int((nf+2)/2) * (W/nf + 0.18u)' nrd='0.18u / W' nrs='0.18u / W' sa=0 sb=0 sd=0
XM24 net21 bias3 net5 VSS nfet_06v0 L=1.0u W=2.5u nf=1 ad='int((nf+1)/2) * W/nf * 0.18u' as='int((nf+2)/2) * W/nf * 0.18u' pd='2*int((nf+1)/2) * (W/nf + 0.18u)'
+ ps='2*int((nf+2)/2) * (W/nf + 0.18u)' nrd='0.18u / W' nrs='0.18u / W' sa=0 sb=0 sd=0
XM25 net4 net10 VSS VSS nfet_06v0 L=1.0u W=2.5u nf=1 ad='int((nf+1)/2) * W/nf * 0.18u' as='int((nf+2)/2) * W/nf * 0.18u' pd='2*int((nf+1)/2) * (W/nf + 0.18u)'
+ ps='2*int((nf+2)/2) * (W/nf + 0.18u)' nrd='0.18u / W' nrs='0.18u / W' sa=0 sb=0 sd=0
XM26 net5 net10 VSS VSS nfet_06v0 L=1.0u W=2.5u nf=1 ad='int((nf+1)/2) * W/nf * 0.18u' as='int((nf+2)/2) * W/nf * 0.18u' pd='2*int((nf+1)/2) * (W/nf + 0.18u)'
+ ps='2*int((nf+2)/2) * (W/nf + 0.18u)' nrd='0.18u / W' nrs='0.18u / W' sa=0 sb=0 sd=0
XM27 net9 net11 net10 VSS nfet_06v0 L=1.0u W=2.5u nf=1 ad='int((nf+1)/2) * W/nf * 0.18u' as='int((nf+2)/2) * W/nf * 0.18u' pd='2*int((nf+1)/2) * (W/nf + 0.18u)'
+ ps='2*int((nf+2)/2) * (W/nf + 0.18u)' nrd='0.18u / W' nrs='0.18u / W' sa=0 sb=0 sd=0
XM28 G_OUT_P net11 net21 VSS nfet_06v0 L=1.0u W=2.5u nf=1 ad='int((nf+1)/2) * W/nf * 0.18u' as='int((nf+2)/2) * W/nf * 0.18u' pd='2*int((nf+1)/2) * (W/nf + 0.18u)'
+ ps='2*int((nf+2)/2) * (W/nf + 0.18u)' nrd='0.18u / W' nrs='0.18u / W' sa=0 sb=0 sd=0
XM34 net12 net13 VDD VDD pfet_06v0 L=1.0u W=10.0u nf=1 ad='int((nf+1)/2) * W/nf * 0.18u' as='int((nf+2)/2) * W/nf * 0.18u' pd='2*int((nf+1)/2) * (W/nf + 0.18u)'
+ ps='2*int((nf+2)/2) * (W/nf + 0.18u)' nrd='0.18u / W' nrs='0.18u / W' sa=0 sb=0 sd=0
XM36 net13 bias2 net12 VDD pfet_06v0 L=1.0u W=10.0u nf=1 ad='int((nf+1)/2) * W/nf * 0.18u' as='int((nf+2)/2) * W/nf * 0.18u' pd='2*int((nf+1)/2) * (W/nf + 0.18u)'
+ ps='2*int((nf+2)/2) * (W/nf + 0.18u)' nrd='0.18u / W' nrs='0.18u / W' sa=0 sb=0 sd=0
XM37 net20 net20 net13 VDD pfet_06v0 L=1.0u W=10.0u nf=1 ad='int((nf+1)/2) * W/nf * 0.18u' as='int((nf+2)/2) * W/nf * 0.18u' pd='2*int((nf+1)/2) * (W/nf + 0.18u)'
+ ps='2*int((nf+2)/2) * (W/nf + 0.18u)' nrd='0.18u / W' nrs='0.18u / W' sa=0 sb=0 sd=0
XM38 net20 bias3 net14 VSS nfet_06v0 L=1.0u W=5.0u nf=1 ad='int((nf+1)/2) * W/nf * 0.18u' as='int((nf+2)/2) * W/nf * 0.18u' pd='2*int((nf+1)/2) * (W/nf + 0.18u)'
+ ps='2*int((nf+2)/2) * (W/nf + 0.18u)' nrd='0.18u / W' nrs='0.18u / W' sa=0 sb=0 sd=0
XM39 net14 bias4 VSS VSS nfet_06v0 L=1.0u W=5.0u nf=1 ad='int((nf+1)/2) * W/nf * 0.18u' as='int((nf+2)/2) * W/nf * 0.18u' pd='2*int((nf+1)/2) * (W/nf + 0.18u)'
+ ps='2*int((nf+2)/2) * (W/nf + 0.18u)' nrd='0.18u / W' nrs='0.18u / W' sa=0 sb=0 sd=0
XM45 net15 bias1 VDD VDD pfet_06v0 L=1.0u W=10.0u nf=1 ad='int((nf+1)/2) * W/nf * 0.18u' as='int((nf+2)/2) * W/nf * 0.18u' pd='2*int((nf+1)/2) * (W/nf + 0.18u)'
+ ps='2*int((nf+2)/2) * (W/nf + 0.18u)' nrd='0.18u / W' nrs='0.18u / W' sa=0 sb=0 sd=0
XM46 net11 bias2 net15 VDD pfet_06v0 L=1.0u W=10.0u nf=1 ad='int((nf+1)/2) * W/nf * 0.18u' as='int((nf+2)/2) * W/nf * 0.18u' pd='2*int((nf+1)/2) * (W/nf + 0.18u)'
+ ps='2*int((nf+2)/2) * (W/nf + 0.18u)' nrd='0.18u / W' nrs='0.18u / W' sa=0 sb=0 sd=0
XM40 net11 net11 net17 VSS nfet_06v0 L=1.0u W=5.0u nf=1 ad='int((nf+1)/2) * W/nf * 0.18u' as='int((nf+2)/2) * W/nf * 0.18u' pd='2*int((nf+1)/2) * (W/nf + 0.18u)'
+ ps='2*int((nf+2)/2) * (W/nf + 0.18u)' nrd='0.18u / W' nrs='0.18u / W' sa=0 sb=0 sd=0
XM41 net17 bias3 net16 VSS nfet_06v0 L=1.0u W=5.0u nf=1 ad='int((nf+1)/2) * W/nf * 0.18u' as='int((nf+2)/2) * W/nf * 0.18u' pd='2*int((nf+1)/2) * (W/nf + 0.18u)'
+ ps='2*int((nf+2)/2) * (W/nf + 0.18u)' nrd='0.18u / W' nrs='0.18u / W' sa=0 sb=0 sd=0
XM42 net16 net17 VSS VSS nfet_06v0 L=1.0u W=5.0u nf=1 ad='int((nf+1)/2) * W/nf * 0.18u' as='int((nf+2)/2) * W/nf * 0.18u' pd='2*int((nf+1)/2) * (W/nf + 0.18u)'
+ ps='2*int((nf+2)/2) * (W/nf + 0.18u)' nrd='0.18u / W' nrs='0.18u / W' sa=0 sb=0 sd=0
XM43 OUT G_OUT_P VDD VDD pfet_06v0 L=1.0u W=0.5u nf=1 ad='int((nf+1)/2) * W/nf * 0.18u' as='int((nf+2)/2) * W/nf * 0.18u' pd='2*int((nf+1)/2) * (W/nf + 0.18u)'
+ ps='2*int((nf+2)/2) * (W/nf + 0.18u)' nrd='0.18u / W' nrs='0.18u / W' sa=0 sb=0 sd=0 m=4
XM44 OUT net21 VSS VSS nfet_06v0 L=1.0u W=1.0u nf=1 ad='int((nf+1)/2) * W/nf * 0.18u' as='int((nf+2)/2) * W/nf * 0.18u' pd='2*int((nf+1)/2) * (W/nf + 0.18u)'
+ ps='2*int((nf+2)/2) * (W/nf + 0.18u)' nrd='0.18u / W' nrs='0.18u / W' sa=0 sb=0 sd=0
XC3 net6 OUT cap_mim_2f0fF c_width=4e-6 c_length=25e-6
XC1 OUT net5 cap_mim_2f0fF c_width=4e-6 c_length=25e-6
XRFB G_OUT_P OUT VSS ppolyf_u_3k r_width=1e-6 r_length=76.45e-6 m=1 s=5
.ends

* expanding   symbol:  a_zonetic2026/XSCHEM/DECODER/invertor.sym # of pins=4
** sym_path: /foss/designs/a_zonetic2026/XSCHEM/DECODER/invertor.sym
** sch_path: /foss/designs/a_zonetic2026/XSCHEM/DECODER/invertor.sch
.subckt invertor VDD output In VSS
*.opin output
*.ipin In
*.ipin VDD
*.ipin VSS
XM4 output In VDD VDD pfet_06v0 L=1.0u W=3.0u nf=1 ad='int((nf+1)/2) * W/nf * 0.18u' as='int((nf+2)/2) * W/nf * 0.18u' pd='2*int((nf+1)/2) * (W/nf + 0.18u)'
+ ps='2*int((nf+2)/2) * (W/nf + 0.18u)' nrd='0.18u / W' nrs='0.18u / W' sa=0 sb=0 sd=0
XM5 VSS In output VSS nfet_06v0 L=1u W=1u nf=1 ad='int((nf+1)/2) * W/nf * 0.18u' as='int((nf+2)/2) * W/nf * 0.18u' pd='2*int((nf+1)/2) * (W/nf + 0.18u)'
+ ps='2*int((nf+2)/2) * (W/nf + 0.18u)' nrd='0.18u / W' nrs='0.18u / W' sa=0 sb=0 sd=0
.ends

* expanding   symbol:  a_zonetic2026/XSCHEM/DECODER/andGate.sym # of pins=5
** sym_path: /foss/designs/a_zonetic2026/XSCHEM/DECODER/andGate.sym
** sch_path: /foss/designs/a_zonetic2026/XSCHEM/DECODER/andGate.sch
.subckt andGate A VDD B output VSS
*.ipin VDD
*.ipin B
*.ipin A
*.ipin VSS
*.opin output
XM4 output net1 VDD VDD pfet_06v0 L=1.0u W=3.0u nf=1 ad='int((nf+1)/2) * W/nf * 0.18u' as='int((nf+2)/2) * W/nf * 0.18u' pd='2*int((nf+1)/2) * (W/nf + 0.18u)'
+ ps='2*int((nf+2)/2) * (W/nf + 0.18u)' nrd='0.18u / W' nrs='0.18u / W' sa=0 sb=0 sd=0
XM5 VSS net1 output VSS nfet_06v0 L=1u W=1u nf=1 ad='int((nf+1)/2) * W/nf * 0.18u' as='int((nf+2)/2) * W/nf * 0.18u' pd='2*int((nf+1)/2) * (W/nf + 0.18u)'
+ ps='2*int((nf+2)/2) * (W/nf + 0.18u)' nrd='0.18u / W' nrs='0.18u / W' sa=0 sb=0 sd=0
XM2 VDD A net1 VDD pfet_06v0 L=1.0u W=3.0u nf=1 ad='int((nf+1)/2) * W/nf * 0.18u' as='int((nf+2)/2) * W/nf * 0.18u' pd='2*int((nf+1)/2) * (W/nf + 0.18u)'
+ ps='2*int((nf+2)/2) * (W/nf + 0.18u)' nrd='0.18u / W' nrs='0.18u / W' sa=0 sb=0 sd=0
XM1 VDD B net1 VDD pfet_06v0 L=1.0u W=3.0u nf=1 ad='int((nf+1)/2) * W/nf * 0.18u' as='int((nf+2)/2) * W/nf * 0.18u' pd='2*int((nf+1)/2) * (W/nf + 0.18u)'
+ ps='2*int((nf+2)/2) * (W/nf + 0.18u)' nrd='0.18u / W' nrs='0.18u / W' sa=0 sb=0 sd=0
XM3 VSS A net2 VSS nfet_06v0 L=1u W=1u nf=1 ad='int((nf+1)/2) * W/nf * 0.18u' as='int((nf+2)/2) * W/nf * 0.18u' pd='2*int((nf+1)/2) * (W/nf + 0.18u)'
+ ps='2*int((nf+2)/2) * (W/nf + 0.18u)' nrd='0.18u / W' nrs='0.18u / W' sa=0 sb=0 sd=0
XM6 net2 B net1 VSS nfet_06v0 L=1u W=1u nf=1 ad='int((nf+1)/2) * W/nf * 0.18u' as='int((nf+2)/2) * W/nf * 0.18u' pd='2*int((nf+1)/2) * (W/nf + 0.18u)'
+ ps='2*int((nf+2)/2) * (W/nf + 0.18u)' nrd='0.18u / W' nrs='0.18u / W' sa=0 sb=0 sd=0
.ends

.GLOBAL GND
.save all
.control
alter Vdip = 0
alter Vrad = 3000
alter Vtilt = 0
alter Voff = 200e-6
dc Vang 0 360 5
wrdata s001.txt v(S1P) v(S1N) v(S2P) v(S2N) v(S3P) v(S3N) v(S4P) v(S4N) v(XPv) v(Xv) v(XNv) v(YPv) v(Yv) v(YNv) v(ZPv) v(Zv) v(ZNv) v(xnav2.X1) v(xnav2.X2) v(xnav2.X3) v(xnav2.X4) v(xnav2.Y1) v(xnav2.Y2) v(xnav2.Y3) v(xnav2.Y4) v(xnav2.Z1) v(xnav2.Z2) v(xnav2.Z3) v(xnav2.Z4) v(XPt) v(Xt) v(XNt) v(YPt) v(Yt) v(YNt) v(ZPt) v(Zt) v(ZNt) v(xnavt.X1) v(xnavt.X2) v(xnavt.X3) v(xnavt.X4) v(xnavt.Y1) v(xnavt.Y2) v(xnavt.Y3) v(xnavt.Y4) v(xnavt.Z1) v(xnavt.Z2) v(xnavt.Z3) v(xnavt.Z4) v(xnavt.x1.net1) v(xnavt.x1.net2) v(xnavt.x1.net3) v(xnavt.x2.net1) v(xnavt.x2.net2) v(xnavt.x2.net3) v(xnavt.x3.net1) v(xnavt.x3.net2) v(xnavt.x3.net3) v(xnavt.x4.net1) v(xnavt.x4.net2) v(xnavt.x4.net3)
alter Vdip = 0
alter Vrad = 3000
alter Vtilt = 30
alter Voff = 200e-6
dc Vang 0 360 5
wrdata s002.txt v(S1P) v(S1N) v(S2P) v(S2N) v(S3P) v(S3N) v(S4P) v(S4N) v(XPv) v(Xv) v(XNv) v(YPv) v(Yv) v(YNv) v(ZPv) v(Zv) v(ZNv) v(xnav2.X1) v(xnav2.X2) v(xnav2.X3) v(xnav2.X4) v(xnav2.Y1) v(xnav2.Y2) v(xnav2.Y3) v(xnav2.Y4) v(xnav2.Z1) v(xnav2.Z2) v(xnav2.Z3) v(xnav2.Z4) v(XPt) v(Xt) v(XNt) v(YPt) v(Yt) v(YNt) v(ZPt) v(Zt) v(ZNt) v(xnavt.X1) v(xnavt.X2) v(xnavt.X3) v(xnavt.X4) v(xnavt.Y1) v(xnavt.Y2) v(xnavt.Y3) v(xnavt.Y4) v(xnavt.Z1) v(xnavt.Z2) v(xnavt.Z3) v(xnavt.Z4) v(xnavt.x1.net1) v(xnavt.x1.net2) v(xnavt.x1.net3) v(xnavt.x2.net1) v(xnavt.x2.net2) v(xnavt.x2.net3) v(xnavt.x3.net1) v(xnavt.x3.net2) v(xnavt.x3.net3) v(xnavt.x4.net1) v(xnavt.x4.net2) v(xnavt.x4.net3)
alter Vdip = 0
alter Vrad = 3000
alter Vtilt = 60
alter Voff = 200e-6
dc Vang 0 360 5
wrdata s003.txt v(S1P) v(S1N) v(S2P) v(S2N) v(S3P) v(S3N) v(S4P) v(S4N) v(XPv) v(Xv) v(XNv) v(YPv) v(Yv) v(YNv) v(ZPv) v(Zv) v(ZNv) v(xnav2.X1) v(xnav2.X2) v(xnav2.X3) v(xnav2.X4) v(xnav2.Y1) v(xnav2.Y2) v(xnav2.Y3) v(xnav2.Y4) v(xnav2.Z1) v(xnav2.Z2) v(xnav2.Z3) v(xnav2.Z4) v(XPt) v(Xt) v(XNt) v(YPt) v(Yt) v(YNt) v(ZPt) v(Zt) v(ZNt) v(xnavt.X1) v(xnavt.X2) v(xnavt.X3) v(xnavt.X4) v(xnavt.Y1) v(xnavt.Y2) v(xnavt.Y3) v(xnavt.Y4) v(xnavt.Z1) v(xnavt.Z2) v(xnavt.Z3) v(xnavt.Z4) v(xnavt.x1.net1) v(xnavt.x1.net2) v(xnavt.x1.net3) v(xnavt.x2.net1) v(xnavt.x2.net2) v(xnavt.x2.net3) v(xnavt.x3.net1) v(xnavt.x3.net2) v(xnavt.x3.net3) v(xnavt.x4.net1) v(xnavt.x4.net2) v(xnavt.x4.net3)
alter Vdip = 0
alter Vrad = 3000
alter Vtilt = 90
alter Voff = 200e-6
dc Vang 0 360 5
wrdata s004.txt v(S1P) v(S1N) v(S2P) v(S2N) v(S3P) v(S3N) v(S4P) v(S4N) v(XPv) v(Xv) v(XNv) v(YPv) v(Yv) v(YNv) v(ZPv) v(Zv) v(ZNv) v(xnav2.X1) v(xnav2.X2) v(xnav2.X3) v(xnav2.X4) v(xnav2.Y1) v(xnav2.Y2) v(xnav2.Y3) v(xnav2.Y4) v(xnav2.Z1) v(xnav2.Z2) v(xnav2.Z3) v(xnav2.Z4) v(XPt) v(Xt) v(XNt) v(YPt) v(Yt) v(YNt) v(ZPt) v(Zt) v(ZNt) v(xnavt.X1) v(xnavt.X2) v(xnavt.X3) v(xnavt.X4) v(xnavt.Y1) v(xnavt.Y2) v(xnavt.Y3) v(xnavt.Y4) v(xnavt.Z1) v(xnavt.Z2) v(xnavt.Z3) v(xnavt.Z4) v(xnavt.x1.net1) v(xnavt.x1.net2) v(xnavt.x1.net3) v(xnavt.x2.net1) v(xnavt.x2.net2) v(xnavt.x2.net3) v(xnavt.x3.net1) v(xnavt.x3.net2) v(xnavt.x3.net3) v(xnavt.x4.net1) v(xnavt.x4.net2) v(xnavt.x4.net3)
alter Vdip = 0
alter Vrad = 3000
alter Vtilt = 120
alter Voff = 200e-6
dc Vang 0 360 5
wrdata s005.txt v(S1P) v(S1N) v(S2P) v(S2N) v(S3P) v(S3N) v(S4P) v(S4N) v(XPv) v(Xv) v(XNv) v(YPv) v(Yv) v(YNv) v(ZPv) v(Zv) v(ZNv) v(xnav2.X1) v(xnav2.X2) v(xnav2.X3) v(xnav2.X4) v(xnav2.Y1) v(xnav2.Y2) v(xnav2.Y3) v(xnav2.Y4) v(xnav2.Z1) v(xnav2.Z2) v(xnav2.Z3) v(xnav2.Z4) v(XPt) v(Xt) v(XNt) v(YPt) v(Yt) v(YNt) v(ZPt) v(Zt) v(ZNt) v(xnavt.X1) v(xnavt.X2) v(xnavt.X3) v(xnavt.X4) v(xnavt.Y1) v(xnavt.Y2) v(xnavt.Y3) v(xnavt.Y4) v(xnavt.Z1) v(xnavt.Z2) v(xnavt.Z3) v(xnavt.Z4) v(xnavt.x1.net1) v(xnavt.x1.net2) v(xnavt.x1.net3) v(xnavt.x2.net1) v(xnavt.x2.net2) v(xnavt.x2.net3) v(xnavt.x3.net1) v(xnavt.x3.net2) v(xnavt.x3.net3) v(xnavt.x4.net1) v(xnavt.x4.net2) v(xnavt.x4.net3)
alter Vdip = 0
alter Vrad = 3000
alter Vtilt = 150
alter Voff = 200e-6
dc Vang 0 360 5
wrdata s006.txt v(S1P) v(S1N) v(S2P) v(S2N) v(S3P) v(S3N) v(S4P) v(S4N) v(XPv) v(Xv) v(XNv) v(YPv) v(Yv) v(YNv) v(ZPv) v(Zv) v(ZNv) v(xnav2.X1) v(xnav2.X2) v(xnav2.X3) v(xnav2.X4) v(xnav2.Y1) v(xnav2.Y2) v(xnav2.Y3) v(xnav2.Y4) v(xnav2.Z1) v(xnav2.Z2) v(xnav2.Z3) v(xnav2.Z4) v(XPt) v(Xt) v(XNt) v(YPt) v(Yt) v(YNt) v(ZPt) v(Zt) v(ZNt) v(xnavt.X1) v(xnavt.X2) v(xnavt.X3) v(xnavt.X4) v(xnavt.Y1) v(xnavt.Y2) v(xnavt.Y3) v(xnavt.Y4) v(xnavt.Z1) v(xnavt.Z2) v(xnavt.Z3) v(xnavt.Z4) v(xnavt.x1.net1) v(xnavt.x1.net2) v(xnavt.x1.net3) v(xnavt.x2.net1) v(xnavt.x2.net2) v(xnavt.x2.net3) v(xnavt.x3.net1) v(xnavt.x3.net2) v(xnavt.x3.net3) v(xnavt.x4.net1) v(xnavt.x4.net2) v(xnavt.x4.net3)
alter Vdip = 0
alter Vrad = 3000
alter Vtilt = 180
alter Voff = 200e-6
dc Vang 0 360 5
wrdata s007.txt v(S1P) v(S1N) v(S2P) v(S2N) v(S3P) v(S3N) v(S4P) v(S4N) v(XPv) v(Xv) v(XNv) v(YPv) v(Yv) v(YNv) v(ZPv) v(Zv) v(ZNv) v(xnav2.X1) v(xnav2.X2) v(xnav2.X3) v(xnav2.X4) v(xnav2.Y1) v(xnav2.Y2) v(xnav2.Y3) v(xnav2.Y4) v(xnav2.Z1) v(xnav2.Z2) v(xnav2.Z3) v(xnav2.Z4) v(XPt) v(Xt) v(XNt) v(YPt) v(Yt) v(YNt) v(ZPt) v(Zt) v(ZNt) v(xnavt.X1) v(xnavt.X2) v(xnavt.X3) v(xnavt.X4) v(xnavt.Y1) v(xnavt.Y2) v(xnavt.Y3) v(xnavt.Y4) v(xnavt.Z1) v(xnavt.Z2) v(xnavt.Z3) v(xnavt.Z4) v(xnavt.x1.net1) v(xnavt.x1.net2) v(xnavt.x1.net3) v(xnavt.x2.net1) v(xnavt.x2.net2) v(xnavt.x2.net3) v(xnavt.x3.net1) v(xnavt.x3.net2) v(xnavt.x3.net3) v(xnavt.x4.net1) v(xnavt.x4.net2) v(xnavt.x4.net3)
alter Vdip = 0
alter Vrad = 6000
alter Vtilt = 0
alter Voff = 200e-6
dc Vang 0 360 5
wrdata s008.txt v(S1P) v(S1N) v(S2P) v(S2N) v(S3P) v(S3N) v(S4P) v(S4N) v(XPv) v(Xv) v(XNv) v(YPv) v(Yv) v(YNv) v(ZPv) v(Zv) v(ZNv) v(xnav2.X1) v(xnav2.X2) v(xnav2.X3) v(xnav2.X4) v(xnav2.Y1) v(xnav2.Y2) v(xnav2.Y3) v(xnav2.Y4) v(xnav2.Z1) v(xnav2.Z2) v(xnav2.Z3) v(xnav2.Z4) v(XPt) v(Xt) v(XNt) v(YPt) v(Yt) v(YNt) v(ZPt) v(Zt) v(ZNt) v(xnavt.X1) v(xnavt.X2) v(xnavt.X3) v(xnavt.X4) v(xnavt.Y1) v(xnavt.Y2) v(xnavt.Y3) v(xnavt.Y4) v(xnavt.Z1) v(xnavt.Z2) v(xnavt.Z3) v(xnavt.Z4) v(xnavt.x1.net1) v(xnavt.x1.net2) v(xnavt.x1.net3) v(xnavt.x2.net1) v(xnavt.x2.net2) v(xnavt.x2.net3) v(xnavt.x3.net1) v(xnavt.x3.net2) v(xnavt.x3.net3) v(xnavt.x4.net1) v(xnavt.x4.net2) v(xnavt.x4.net3)
alter Vdip = 0
alter Vrad = 6000
alter Vtilt = 30
alter Voff = 200e-6
dc Vang 0 360 5
wrdata s009.txt v(S1P) v(S1N) v(S2P) v(S2N) v(S3P) v(S3N) v(S4P) v(S4N) v(XPv) v(Xv) v(XNv) v(YPv) v(Yv) v(YNv) v(ZPv) v(Zv) v(ZNv) v(xnav2.X1) v(xnav2.X2) v(xnav2.X3) v(xnav2.X4) v(xnav2.Y1) v(xnav2.Y2) v(xnav2.Y3) v(xnav2.Y4) v(xnav2.Z1) v(xnav2.Z2) v(xnav2.Z3) v(xnav2.Z4) v(XPt) v(Xt) v(XNt) v(YPt) v(Yt) v(YNt) v(ZPt) v(Zt) v(ZNt) v(xnavt.X1) v(xnavt.X2) v(xnavt.X3) v(xnavt.X4) v(xnavt.Y1) v(xnavt.Y2) v(xnavt.Y3) v(xnavt.Y4) v(xnavt.Z1) v(xnavt.Z2) v(xnavt.Z3) v(xnavt.Z4) v(xnavt.x1.net1) v(xnavt.x1.net2) v(xnavt.x1.net3) v(xnavt.x2.net1) v(xnavt.x2.net2) v(xnavt.x2.net3) v(xnavt.x3.net1) v(xnavt.x3.net2) v(xnavt.x3.net3) v(xnavt.x4.net1) v(xnavt.x4.net2) v(xnavt.x4.net3)
alter Vdip = 0
alter Vrad = 6000
alter Vtilt = 60
alter Voff = 200e-6
dc Vang 0 360 5
wrdata s010.txt v(S1P) v(S1N) v(S2P) v(S2N) v(S3P) v(S3N) v(S4P) v(S4N) v(XPv) v(Xv) v(XNv) v(YPv) v(Yv) v(YNv) v(ZPv) v(Zv) v(ZNv) v(xnav2.X1) v(xnav2.X2) v(xnav2.X3) v(xnav2.X4) v(xnav2.Y1) v(xnav2.Y2) v(xnav2.Y3) v(xnav2.Y4) v(xnav2.Z1) v(xnav2.Z2) v(xnav2.Z3) v(xnav2.Z4) v(XPt) v(Xt) v(XNt) v(YPt) v(Yt) v(YNt) v(ZPt) v(Zt) v(ZNt) v(xnavt.X1) v(xnavt.X2) v(xnavt.X3) v(xnavt.X4) v(xnavt.Y1) v(xnavt.Y2) v(xnavt.Y3) v(xnavt.Y4) v(xnavt.Z1) v(xnavt.Z2) v(xnavt.Z3) v(xnavt.Z4) v(xnavt.x1.net1) v(xnavt.x1.net2) v(xnavt.x1.net3) v(xnavt.x2.net1) v(xnavt.x2.net2) v(xnavt.x2.net3) v(xnavt.x3.net1) v(xnavt.x3.net2) v(xnavt.x3.net3) v(xnavt.x4.net1) v(xnavt.x4.net2) v(xnavt.x4.net3)
alter Vdip = 0
alter Vrad = 6000
alter Vtilt = 90
alter Voff = 200e-6
dc Vang 0 360 5
wrdata s011.txt v(S1P) v(S1N) v(S2P) v(S2N) v(S3P) v(S3N) v(S4P) v(S4N) v(XPv) v(Xv) v(XNv) v(YPv) v(Yv) v(YNv) v(ZPv) v(Zv) v(ZNv) v(xnav2.X1) v(xnav2.X2) v(xnav2.X3) v(xnav2.X4) v(xnav2.Y1) v(xnav2.Y2) v(xnav2.Y3) v(xnav2.Y4) v(xnav2.Z1) v(xnav2.Z2) v(xnav2.Z3) v(xnav2.Z4) v(XPt) v(Xt) v(XNt) v(YPt) v(Yt) v(YNt) v(ZPt) v(Zt) v(ZNt) v(xnavt.X1) v(xnavt.X2) v(xnavt.X3) v(xnavt.X4) v(xnavt.Y1) v(xnavt.Y2) v(xnavt.Y3) v(xnavt.Y4) v(xnavt.Z1) v(xnavt.Z2) v(xnavt.Z3) v(xnavt.Z4) v(xnavt.x1.net1) v(xnavt.x1.net2) v(xnavt.x1.net3) v(xnavt.x2.net1) v(xnavt.x2.net2) v(xnavt.x2.net3) v(xnavt.x3.net1) v(xnavt.x3.net2) v(xnavt.x3.net3) v(xnavt.x4.net1) v(xnavt.x4.net2) v(xnavt.x4.net3)
alter Vdip = 0
alter Vrad = 6000
alter Vtilt = 120
alter Voff = 200e-6
dc Vang 0 360 5
wrdata s012.txt v(S1P) v(S1N) v(S2P) v(S2N) v(S3P) v(S3N) v(S4P) v(S4N) v(XPv) v(Xv) v(XNv) v(YPv) v(Yv) v(YNv) v(ZPv) v(Zv) v(ZNv) v(xnav2.X1) v(xnav2.X2) v(xnav2.X3) v(xnav2.X4) v(xnav2.Y1) v(xnav2.Y2) v(xnav2.Y3) v(xnav2.Y4) v(xnav2.Z1) v(xnav2.Z2) v(xnav2.Z3) v(xnav2.Z4) v(XPt) v(Xt) v(XNt) v(YPt) v(Yt) v(YNt) v(ZPt) v(Zt) v(ZNt) v(xnavt.X1) v(xnavt.X2) v(xnavt.X3) v(xnavt.X4) v(xnavt.Y1) v(xnavt.Y2) v(xnavt.Y3) v(xnavt.Y4) v(xnavt.Z1) v(xnavt.Z2) v(xnavt.Z3) v(xnavt.Z4) v(xnavt.x1.net1) v(xnavt.x1.net2) v(xnavt.x1.net3) v(xnavt.x2.net1) v(xnavt.x2.net2) v(xnavt.x2.net3) v(xnavt.x3.net1) v(xnavt.x3.net2) v(xnavt.x3.net3) v(xnavt.x4.net1) v(xnavt.x4.net2) v(xnavt.x4.net3)
alter Vdip = 0
alter Vrad = 6000
alter Vtilt = 150
alter Voff = 200e-6
dc Vang 0 360 5
wrdata s013.txt v(S1P) v(S1N) v(S2P) v(S2N) v(S3P) v(S3N) v(S4P) v(S4N) v(XPv) v(Xv) v(XNv) v(YPv) v(Yv) v(YNv) v(ZPv) v(Zv) v(ZNv) v(xnav2.X1) v(xnav2.X2) v(xnav2.X3) v(xnav2.X4) v(xnav2.Y1) v(xnav2.Y2) v(xnav2.Y3) v(xnav2.Y4) v(xnav2.Z1) v(xnav2.Z2) v(xnav2.Z3) v(xnav2.Z4) v(XPt) v(Xt) v(XNt) v(YPt) v(Yt) v(YNt) v(ZPt) v(Zt) v(ZNt) v(xnavt.X1) v(xnavt.X2) v(xnavt.X3) v(xnavt.X4) v(xnavt.Y1) v(xnavt.Y2) v(xnavt.Y3) v(xnavt.Y4) v(xnavt.Z1) v(xnavt.Z2) v(xnavt.Z3) v(xnavt.Z4) v(xnavt.x1.net1) v(xnavt.x1.net2) v(xnavt.x1.net3) v(xnavt.x2.net1) v(xnavt.x2.net2) v(xnavt.x2.net3) v(xnavt.x3.net1) v(xnavt.x3.net2) v(xnavt.x3.net3) v(xnavt.x4.net1) v(xnavt.x4.net2) v(xnavt.x4.net3)
alter Vdip = 0
alter Vrad = 6000
alter Vtilt = 180
alter Voff = 200e-6
dc Vang 0 360 5
wrdata s014.txt v(S1P) v(S1N) v(S2P) v(S2N) v(S3P) v(S3N) v(S4P) v(S4N) v(XPv) v(Xv) v(XNv) v(YPv) v(Yv) v(YNv) v(ZPv) v(Zv) v(ZNv) v(xnav2.X1) v(xnav2.X2) v(xnav2.X3) v(xnav2.X4) v(xnav2.Y1) v(xnav2.Y2) v(xnav2.Y3) v(xnav2.Y4) v(xnav2.Z1) v(xnav2.Z2) v(xnav2.Z3) v(xnav2.Z4) v(XPt) v(Xt) v(XNt) v(YPt) v(Yt) v(YNt) v(ZPt) v(Zt) v(ZNt) v(xnavt.X1) v(xnavt.X2) v(xnavt.X3) v(xnavt.X4) v(xnavt.Y1) v(xnavt.Y2) v(xnavt.Y3) v(xnavt.Y4) v(xnavt.Z1) v(xnavt.Z2) v(xnavt.Z3) v(xnavt.Z4) v(xnavt.x1.net1) v(xnavt.x1.net2) v(xnavt.x1.net3) v(xnavt.x2.net1) v(xnavt.x2.net2) v(xnavt.x2.net3) v(xnavt.x3.net1) v(xnavt.x3.net2) v(xnavt.x3.net3) v(xnavt.x4.net1) v(xnavt.x4.net2) v(xnavt.x4.net3)
alter Vdip = 0
alter Vrad = 12000
alter Vtilt = 0
alter Voff = 200e-6
dc Vang 0 360 5
wrdata s015.txt v(S1P) v(S1N) v(S2P) v(S2N) v(S3P) v(S3N) v(S4P) v(S4N) v(XPv) v(Xv) v(XNv) v(YPv) v(Yv) v(YNv) v(ZPv) v(Zv) v(ZNv) v(xnav2.X1) v(xnav2.X2) v(xnav2.X3) v(xnav2.X4) v(xnav2.Y1) v(xnav2.Y2) v(xnav2.Y3) v(xnav2.Y4) v(xnav2.Z1) v(xnav2.Z2) v(xnav2.Z3) v(xnav2.Z4) v(XPt) v(Xt) v(XNt) v(YPt) v(Yt) v(YNt) v(ZPt) v(Zt) v(ZNt) v(xnavt.X1) v(xnavt.X2) v(xnavt.X3) v(xnavt.X4) v(xnavt.Y1) v(xnavt.Y2) v(xnavt.Y3) v(xnavt.Y4) v(xnavt.Z1) v(xnavt.Z2) v(xnavt.Z3) v(xnavt.Z4) v(xnavt.x1.net1) v(xnavt.x1.net2) v(xnavt.x1.net3) v(xnavt.x2.net1) v(xnavt.x2.net2) v(xnavt.x2.net3) v(xnavt.x3.net1) v(xnavt.x3.net2) v(xnavt.x3.net3) v(xnavt.x4.net1) v(xnavt.x4.net2) v(xnavt.x4.net3)
alter Vdip = 0
alter Vrad = 12000
alter Vtilt = 30
alter Voff = 200e-6
dc Vang 0 360 5
wrdata s016.txt v(S1P) v(S1N) v(S2P) v(S2N) v(S3P) v(S3N) v(S4P) v(S4N) v(XPv) v(Xv) v(XNv) v(YPv) v(Yv) v(YNv) v(ZPv) v(Zv) v(ZNv) v(xnav2.X1) v(xnav2.X2) v(xnav2.X3) v(xnav2.X4) v(xnav2.Y1) v(xnav2.Y2) v(xnav2.Y3) v(xnav2.Y4) v(xnav2.Z1) v(xnav2.Z2) v(xnav2.Z3) v(xnav2.Z4) v(XPt) v(Xt) v(XNt) v(YPt) v(Yt) v(YNt) v(ZPt) v(Zt) v(ZNt) v(xnavt.X1) v(xnavt.X2) v(xnavt.X3) v(xnavt.X4) v(xnavt.Y1) v(xnavt.Y2) v(xnavt.Y3) v(xnavt.Y4) v(xnavt.Z1) v(xnavt.Z2) v(xnavt.Z3) v(xnavt.Z4) v(xnavt.x1.net1) v(xnavt.x1.net2) v(xnavt.x1.net3) v(xnavt.x2.net1) v(xnavt.x2.net2) v(xnavt.x2.net3) v(xnavt.x3.net1) v(xnavt.x3.net2) v(xnavt.x3.net3) v(xnavt.x4.net1) v(xnavt.x4.net2) v(xnavt.x4.net3)
alter Vdip = 0
alter Vrad = 12000
alter Vtilt = 60
alter Voff = 200e-6
dc Vang 0 360 5
wrdata s017.txt v(S1P) v(S1N) v(S2P) v(S2N) v(S3P) v(S3N) v(S4P) v(S4N) v(XPv) v(Xv) v(XNv) v(YPv) v(Yv) v(YNv) v(ZPv) v(Zv) v(ZNv) v(xnav2.X1) v(xnav2.X2) v(xnav2.X3) v(xnav2.X4) v(xnav2.Y1) v(xnav2.Y2) v(xnav2.Y3) v(xnav2.Y4) v(xnav2.Z1) v(xnav2.Z2) v(xnav2.Z3) v(xnav2.Z4) v(XPt) v(Xt) v(XNt) v(YPt) v(Yt) v(YNt) v(ZPt) v(Zt) v(ZNt) v(xnavt.X1) v(xnavt.X2) v(xnavt.X3) v(xnavt.X4) v(xnavt.Y1) v(xnavt.Y2) v(xnavt.Y3) v(xnavt.Y4) v(xnavt.Z1) v(xnavt.Z2) v(xnavt.Z3) v(xnavt.Z4) v(xnavt.x1.net1) v(xnavt.x1.net2) v(xnavt.x1.net3) v(xnavt.x2.net1) v(xnavt.x2.net2) v(xnavt.x2.net3) v(xnavt.x3.net1) v(xnavt.x3.net2) v(xnavt.x3.net3) v(xnavt.x4.net1) v(xnavt.x4.net2) v(xnavt.x4.net3)
alter Vdip = 0
alter Vrad = 12000
alter Vtilt = 90
alter Voff = 200e-6
dc Vang 0 360 5
wrdata s018.txt v(S1P) v(S1N) v(S2P) v(S2N) v(S3P) v(S3N) v(S4P) v(S4N) v(XPv) v(Xv) v(XNv) v(YPv) v(Yv) v(YNv) v(ZPv) v(Zv) v(ZNv) v(xnav2.X1) v(xnav2.X2) v(xnav2.X3) v(xnav2.X4) v(xnav2.Y1) v(xnav2.Y2) v(xnav2.Y3) v(xnav2.Y4) v(xnav2.Z1) v(xnav2.Z2) v(xnav2.Z3) v(xnav2.Z4) v(XPt) v(Xt) v(XNt) v(YPt) v(Yt) v(YNt) v(ZPt) v(Zt) v(ZNt) v(xnavt.X1) v(xnavt.X2) v(xnavt.X3) v(xnavt.X4) v(xnavt.Y1) v(xnavt.Y2) v(xnavt.Y3) v(xnavt.Y4) v(xnavt.Z1) v(xnavt.Z2) v(xnavt.Z3) v(xnavt.Z4) v(xnavt.x1.net1) v(xnavt.x1.net2) v(xnavt.x1.net3) v(xnavt.x2.net1) v(xnavt.x2.net2) v(xnavt.x2.net3) v(xnavt.x3.net1) v(xnavt.x3.net2) v(xnavt.x3.net3) v(xnavt.x4.net1) v(xnavt.x4.net2) v(xnavt.x4.net3)
alter Vdip = 0
alter Vrad = 12000
alter Vtilt = 120
alter Voff = 200e-6
dc Vang 0 360 5
wrdata s019.txt v(S1P) v(S1N) v(S2P) v(S2N) v(S3P) v(S3N) v(S4P) v(S4N) v(XPv) v(Xv) v(XNv) v(YPv) v(Yv) v(YNv) v(ZPv) v(Zv) v(ZNv) v(xnav2.X1) v(xnav2.X2) v(xnav2.X3) v(xnav2.X4) v(xnav2.Y1) v(xnav2.Y2) v(xnav2.Y3) v(xnav2.Y4) v(xnav2.Z1) v(xnav2.Z2) v(xnav2.Z3) v(xnav2.Z4) v(XPt) v(Xt) v(XNt) v(YPt) v(Yt) v(YNt) v(ZPt) v(Zt) v(ZNt) v(xnavt.X1) v(xnavt.X2) v(xnavt.X3) v(xnavt.X4) v(xnavt.Y1) v(xnavt.Y2) v(xnavt.Y3) v(xnavt.Y4) v(xnavt.Z1) v(xnavt.Z2) v(xnavt.Z3) v(xnavt.Z4) v(xnavt.x1.net1) v(xnavt.x1.net2) v(xnavt.x1.net3) v(xnavt.x2.net1) v(xnavt.x2.net2) v(xnavt.x2.net3) v(xnavt.x3.net1) v(xnavt.x3.net2) v(xnavt.x3.net3) v(xnavt.x4.net1) v(xnavt.x4.net2) v(xnavt.x4.net3)
alter Vdip = 0
alter Vrad = 12000
alter Vtilt = 150
alter Voff = 200e-6
dc Vang 0 360 5
wrdata s020.txt v(S1P) v(S1N) v(S2P) v(S2N) v(S3P) v(S3N) v(S4P) v(S4N) v(XPv) v(Xv) v(XNv) v(YPv) v(Yv) v(YNv) v(ZPv) v(Zv) v(ZNv) v(xnav2.X1) v(xnav2.X2) v(xnav2.X3) v(xnav2.X4) v(xnav2.Y1) v(xnav2.Y2) v(xnav2.Y3) v(xnav2.Y4) v(xnav2.Z1) v(xnav2.Z2) v(xnav2.Z3) v(xnav2.Z4) v(XPt) v(Xt) v(XNt) v(YPt) v(Yt) v(YNt) v(ZPt) v(Zt) v(ZNt) v(xnavt.X1) v(xnavt.X2) v(xnavt.X3) v(xnavt.X4) v(xnavt.Y1) v(xnavt.Y2) v(xnavt.Y3) v(xnavt.Y4) v(xnavt.Z1) v(xnavt.Z2) v(xnavt.Z3) v(xnavt.Z4) v(xnavt.x1.net1) v(xnavt.x1.net2) v(xnavt.x1.net3) v(xnavt.x2.net1) v(xnavt.x2.net2) v(xnavt.x2.net3) v(xnavt.x3.net1) v(xnavt.x3.net2) v(xnavt.x3.net3) v(xnavt.x4.net1) v(xnavt.x4.net2) v(xnavt.x4.net3)
alter Vdip = 0
alter Vrad = 12000
alter Vtilt = 180
alter Voff = 200e-6
dc Vang 0 360 5
wrdata s021.txt v(S1P) v(S1N) v(S2P) v(S2N) v(S3P) v(S3N) v(S4P) v(S4N) v(XPv) v(Xv) v(XNv) v(YPv) v(Yv) v(YNv) v(ZPv) v(Zv) v(ZNv) v(xnav2.X1) v(xnav2.X2) v(xnav2.X3) v(xnav2.X4) v(xnav2.Y1) v(xnav2.Y2) v(xnav2.Y3) v(xnav2.Y4) v(xnav2.Z1) v(xnav2.Z2) v(xnav2.Z3) v(xnav2.Z4) v(XPt) v(Xt) v(XNt) v(YPt) v(Yt) v(YNt) v(ZPt) v(Zt) v(ZNt) v(xnavt.X1) v(xnavt.X2) v(xnavt.X3) v(xnavt.X4) v(xnavt.Y1) v(xnavt.Y2) v(xnavt.Y3) v(xnavt.Y4) v(xnavt.Z1) v(xnavt.Z2) v(xnavt.Z3) v(xnavt.Z4) v(xnavt.x1.net1) v(xnavt.x1.net2) v(xnavt.x1.net3) v(xnavt.x2.net1) v(xnavt.x2.net2) v(xnavt.x2.net3) v(xnavt.x3.net1) v(xnavt.x3.net2) v(xnavt.x3.net3) v(xnavt.x4.net1) v(xnavt.x4.net2) v(xnavt.x4.net3)
alter Vdip = 1
alter Vrad = 3000
alter Vtilt = 0
alter Voff = 200e-6
dc Vang 0 360 5
wrdata s022.txt v(S1P) v(S1N) v(S2P) v(S2N) v(S3P) v(S3N) v(S4P) v(S4N) v(XPv) v(Xv) v(XNv) v(YPv) v(Yv) v(YNv) v(ZPv) v(Zv) v(ZNv) v(xnav2.X1) v(xnav2.X2) v(xnav2.X3) v(xnav2.X4) v(xnav2.Y1) v(xnav2.Y2) v(xnav2.Y3) v(xnav2.Y4) v(xnav2.Z1) v(xnav2.Z2) v(xnav2.Z3) v(xnav2.Z4) v(XPt) v(Xt) v(XNt) v(YPt) v(Yt) v(YNt) v(ZPt) v(Zt) v(ZNt) v(xnavt.X1) v(xnavt.X2) v(xnavt.X3) v(xnavt.X4) v(xnavt.Y1) v(xnavt.Y2) v(xnavt.Y3) v(xnavt.Y4) v(xnavt.Z1) v(xnavt.Z2) v(xnavt.Z3) v(xnavt.Z4) v(xnavt.x1.net1) v(xnavt.x1.net2) v(xnavt.x1.net3) v(xnavt.x2.net1) v(xnavt.x2.net2) v(xnavt.x2.net3) v(xnavt.x3.net1) v(xnavt.x3.net2) v(xnavt.x3.net3) v(xnavt.x4.net1) v(xnavt.x4.net2) v(xnavt.x4.net3)
alter Vdip = 1
alter Vrad = 3000
alter Vtilt = 30
alter Voff = 200e-6
dc Vang 0 360 5
wrdata s023.txt v(S1P) v(S1N) v(S2P) v(S2N) v(S3P) v(S3N) v(S4P) v(S4N) v(XPv) v(Xv) v(XNv) v(YPv) v(Yv) v(YNv) v(ZPv) v(Zv) v(ZNv) v(xnav2.X1) v(xnav2.X2) v(xnav2.X3) v(xnav2.X4) v(xnav2.Y1) v(xnav2.Y2) v(xnav2.Y3) v(xnav2.Y4) v(xnav2.Z1) v(xnav2.Z2) v(xnav2.Z3) v(xnav2.Z4) v(XPt) v(Xt) v(XNt) v(YPt) v(Yt) v(YNt) v(ZPt) v(Zt) v(ZNt) v(xnavt.X1) v(xnavt.X2) v(xnavt.X3) v(xnavt.X4) v(xnavt.Y1) v(xnavt.Y2) v(xnavt.Y3) v(xnavt.Y4) v(xnavt.Z1) v(xnavt.Z2) v(xnavt.Z3) v(xnavt.Z4) v(xnavt.x1.net1) v(xnavt.x1.net2) v(xnavt.x1.net3) v(xnavt.x2.net1) v(xnavt.x2.net2) v(xnavt.x2.net3) v(xnavt.x3.net1) v(xnavt.x3.net2) v(xnavt.x3.net3) v(xnavt.x4.net1) v(xnavt.x4.net2) v(xnavt.x4.net3)
alter Vdip = 1
alter Vrad = 3000
alter Vtilt = 60
alter Voff = 200e-6
dc Vang 0 360 5
wrdata s024.txt v(S1P) v(S1N) v(S2P) v(S2N) v(S3P) v(S3N) v(S4P) v(S4N) v(XPv) v(Xv) v(XNv) v(YPv) v(Yv) v(YNv) v(ZPv) v(Zv) v(ZNv) v(xnav2.X1) v(xnav2.X2) v(xnav2.X3) v(xnav2.X4) v(xnav2.Y1) v(xnav2.Y2) v(xnav2.Y3) v(xnav2.Y4) v(xnav2.Z1) v(xnav2.Z2) v(xnav2.Z3) v(xnav2.Z4) v(XPt) v(Xt) v(XNt) v(YPt) v(Yt) v(YNt) v(ZPt) v(Zt) v(ZNt) v(xnavt.X1) v(xnavt.X2) v(xnavt.X3) v(xnavt.X4) v(xnavt.Y1) v(xnavt.Y2) v(xnavt.Y3) v(xnavt.Y4) v(xnavt.Z1) v(xnavt.Z2) v(xnavt.Z3) v(xnavt.Z4) v(xnavt.x1.net1) v(xnavt.x1.net2) v(xnavt.x1.net3) v(xnavt.x2.net1) v(xnavt.x2.net2) v(xnavt.x2.net3) v(xnavt.x3.net1) v(xnavt.x3.net2) v(xnavt.x3.net3) v(xnavt.x4.net1) v(xnavt.x4.net2) v(xnavt.x4.net3)
alter Vdip = 1
alter Vrad = 3000
alter Vtilt = 90
alter Voff = 200e-6
dc Vang 0 360 5
wrdata s025.txt v(S1P) v(S1N) v(S2P) v(S2N) v(S3P) v(S3N) v(S4P) v(S4N) v(XPv) v(Xv) v(XNv) v(YPv) v(Yv) v(YNv) v(ZPv) v(Zv) v(ZNv) v(xnav2.X1) v(xnav2.X2) v(xnav2.X3) v(xnav2.X4) v(xnav2.Y1) v(xnav2.Y2) v(xnav2.Y3) v(xnav2.Y4) v(xnav2.Z1) v(xnav2.Z2) v(xnav2.Z3) v(xnav2.Z4) v(XPt) v(Xt) v(XNt) v(YPt) v(Yt) v(YNt) v(ZPt) v(Zt) v(ZNt) v(xnavt.X1) v(xnavt.X2) v(xnavt.X3) v(xnavt.X4) v(xnavt.Y1) v(xnavt.Y2) v(xnavt.Y3) v(xnavt.Y4) v(xnavt.Z1) v(xnavt.Z2) v(xnavt.Z3) v(xnavt.Z4) v(xnavt.x1.net1) v(xnavt.x1.net2) v(xnavt.x1.net3) v(xnavt.x2.net1) v(xnavt.x2.net2) v(xnavt.x2.net3) v(xnavt.x3.net1) v(xnavt.x3.net2) v(xnavt.x3.net3) v(xnavt.x4.net1) v(xnavt.x4.net2) v(xnavt.x4.net3)
alter Vdip = 1
alter Vrad = 3000
alter Vtilt = 120
alter Voff = 200e-6
dc Vang 0 360 5
wrdata s026.txt v(S1P) v(S1N) v(S2P) v(S2N) v(S3P) v(S3N) v(S4P) v(S4N) v(XPv) v(Xv) v(XNv) v(YPv) v(Yv) v(YNv) v(ZPv) v(Zv) v(ZNv) v(xnav2.X1) v(xnav2.X2) v(xnav2.X3) v(xnav2.X4) v(xnav2.Y1) v(xnav2.Y2) v(xnav2.Y3) v(xnav2.Y4) v(xnav2.Z1) v(xnav2.Z2) v(xnav2.Z3) v(xnav2.Z4) v(XPt) v(Xt) v(XNt) v(YPt) v(Yt) v(YNt) v(ZPt) v(Zt) v(ZNt) v(xnavt.X1) v(xnavt.X2) v(xnavt.X3) v(xnavt.X4) v(xnavt.Y1) v(xnavt.Y2) v(xnavt.Y3) v(xnavt.Y4) v(xnavt.Z1) v(xnavt.Z2) v(xnavt.Z3) v(xnavt.Z4) v(xnavt.x1.net1) v(xnavt.x1.net2) v(xnavt.x1.net3) v(xnavt.x2.net1) v(xnavt.x2.net2) v(xnavt.x2.net3) v(xnavt.x3.net1) v(xnavt.x3.net2) v(xnavt.x3.net3) v(xnavt.x4.net1) v(xnavt.x4.net2) v(xnavt.x4.net3)
alter Vdip = 1
alter Vrad = 3000
alter Vtilt = 150
alter Voff = 200e-6
dc Vang 0 360 5
wrdata s027.txt v(S1P) v(S1N) v(S2P) v(S2N) v(S3P) v(S3N) v(S4P) v(S4N) v(XPv) v(Xv) v(XNv) v(YPv) v(Yv) v(YNv) v(ZPv) v(Zv) v(ZNv) v(xnav2.X1) v(xnav2.X2) v(xnav2.X3) v(xnav2.X4) v(xnav2.Y1) v(xnav2.Y2) v(xnav2.Y3) v(xnav2.Y4) v(xnav2.Z1) v(xnav2.Z2) v(xnav2.Z3) v(xnav2.Z4) v(XPt) v(Xt) v(XNt) v(YPt) v(Yt) v(YNt) v(ZPt) v(Zt) v(ZNt) v(xnavt.X1) v(xnavt.X2) v(xnavt.X3) v(xnavt.X4) v(xnavt.Y1) v(xnavt.Y2) v(xnavt.Y3) v(xnavt.Y4) v(xnavt.Z1) v(xnavt.Z2) v(xnavt.Z3) v(xnavt.Z4) v(xnavt.x1.net1) v(xnavt.x1.net2) v(xnavt.x1.net3) v(xnavt.x2.net1) v(xnavt.x2.net2) v(xnavt.x2.net3) v(xnavt.x3.net1) v(xnavt.x3.net2) v(xnavt.x3.net3) v(xnavt.x4.net1) v(xnavt.x4.net2) v(xnavt.x4.net3)
alter Vdip = 1
alter Vrad = 3000
alter Vtilt = 180
alter Voff = 200e-6
dc Vang 0 360 5
wrdata s028.txt v(S1P) v(S1N) v(S2P) v(S2N) v(S3P) v(S3N) v(S4P) v(S4N) v(XPv) v(Xv) v(XNv) v(YPv) v(Yv) v(YNv) v(ZPv) v(Zv) v(ZNv) v(xnav2.X1) v(xnav2.X2) v(xnav2.X3) v(xnav2.X4) v(xnav2.Y1) v(xnav2.Y2) v(xnav2.Y3) v(xnav2.Y4) v(xnav2.Z1) v(xnav2.Z2) v(xnav2.Z3) v(xnav2.Z4) v(XPt) v(Xt) v(XNt) v(YPt) v(Yt) v(YNt) v(ZPt) v(Zt) v(ZNt) v(xnavt.X1) v(xnavt.X2) v(xnavt.X3) v(xnavt.X4) v(xnavt.Y1) v(xnavt.Y2) v(xnavt.Y3) v(xnavt.Y4) v(xnavt.Z1) v(xnavt.Z2) v(xnavt.Z3) v(xnavt.Z4) v(xnavt.x1.net1) v(xnavt.x1.net2) v(xnavt.x1.net3) v(xnavt.x2.net1) v(xnavt.x2.net2) v(xnavt.x2.net3) v(xnavt.x3.net1) v(xnavt.x3.net2) v(xnavt.x3.net3) v(xnavt.x4.net1) v(xnavt.x4.net2) v(xnavt.x4.net3)
alter Vdip = 1
alter Vrad = 6000
alter Vtilt = 0
alter Voff = 200e-6
dc Vang 0 360 5
wrdata s029.txt v(S1P) v(S1N) v(S2P) v(S2N) v(S3P) v(S3N) v(S4P) v(S4N) v(XPv) v(Xv) v(XNv) v(YPv) v(Yv) v(YNv) v(ZPv) v(Zv) v(ZNv) v(xnav2.X1) v(xnav2.X2) v(xnav2.X3) v(xnav2.X4) v(xnav2.Y1) v(xnav2.Y2) v(xnav2.Y3) v(xnav2.Y4) v(xnav2.Z1) v(xnav2.Z2) v(xnav2.Z3) v(xnav2.Z4) v(XPt) v(Xt) v(XNt) v(YPt) v(Yt) v(YNt) v(ZPt) v(Zt) v(ZNt) v(xnavt.X1) v(xnavt.X2) v(xnavt.X3) v(xnavt.X4) v(xnavt.Y1) v(xnavt.Y2) v(xnavt.Y3) v(xnavt.Y4) v(xnavt.Z1) v(xnavt.Z2) v(xnavt.Z3) v(xnavt.Z4) v(xnavt.x1.net1) v(xnavt.x1.net2) v(xnavt.x1.net3) v(xnavt.x2.net1) v(xnavt.x2.net2) v(xnavt.x2.net3) v(xnavt.x3.net1) v(xnavt.x3.net2) v(xnavt.x3.net3) v(xnavt.x4.net1) v(xnavt.x4.net2) v(xnavt.x4.net3)
alter Vdip = 1
alter Vrad = 6000
alter Vtilt = 30
alter Voff = 200e-6
dc Vang 0 360 5
wrdata s030.txt v(S1P) v(S1N) v(S2P) v(S2N) v(S3P) v(S3N) v(S4P) v(S4N) v(XPv) v(Xv) v(XNv) v(YPv) v(Yv) v(YNv) v(ZPv) v(Zv) v(ZNv) v(xnav2.X1) v(xnav2.X2) v(xnav2.X3) v(xnav2.X4) v(xnav2.Y1) v(xnav2.Y2) v(xnav2.Y3) v(xnav2.Y4) v(xnav2.Z1) v(xnav2.Z2) v(xnav2.Z3) v(xnav2.Z4) v(XPt) v(Xt) v(XNt) v(YPt) v(Yt) v(YNt) v(ZPt) v(Zt) v(ZNt) v(xnavt.X1) v(xnavt.X2) v(xnavt.X3) v(xnavt.X4) v(xnavt.Y1) v(xnavt.Y2) v(xnavt.Y3) v(xnavt.Y4) v(xnavt.Z1) v(xnavt.Z2) v(xnavt.Z3) v(xnavt.Z4) v(xnavt.x1.net1) v(xnavt.x1.net2) v(xnavt.x1.net3) v(xnavt.x2.net1) v(xnavt.x2.net2) v(xnavt.x2.net3) v(xnavt.x3.net1) v(xnavt.x3.net2) v(xnavt.x3.net3) v(xnavt.x4.net1) v(xnavt.x4.net2) v(xnavt.x4.net3)
alter Vdip = 1
alter Vrad = 6000
alter Vtilt = 60
alter Voff = 200e-6
dc Vang 0 360 5
wrdata s031.txt v(S1P) v(S1N) v(S2P) v(S2N) v(S3P) v(S3N) v(S4P) v(S4N) v(XPv) v(Xv) v(XNv) v(YPv) v(Yv) v(YNv) v(ZPv) v(Zv) v(ZNv) v(xnav2.X1) v(xnav2.X2) v(xnav2.X3) v(xnav2.X4) v(xnav2.Y1) v(xnav2.Y2) v(xnav2.Y3) v(xnav2.Y4) v(xnav2.Z1) v(xnav2.Z2) v(xnav2.Z3) v(xnav2.Z4) v(XPt) v(Xt) v(XNt) v(YPt) v(Yt) v(YNt) v(ZPt) v(Zt) v(ZNt) v(xnavt.X1) v(xnavt.X2) v(xnavt.X3) v(xnavt.X4) v(xnavt.Y1) v(xnavt.Y2) v(xnavt.Y3) v(xnavt.Y4) v(xnavt.Z1) v(xnavt.Z2) v(xnavt.Z3) v(xnavt.Z4) v(xnavt.x1.net1) v(xnavt.x1.net2) v(xnavt.x1.net3) v(xnavt.x2.net1) v(xnavt.x2.net2) v(xnavt.x2.net3) v(xnavt.x3.net1) v(xnavt.x3.net2) v(xnavt.x3.net3) v(xnavt.x4.net1) v(xnavt.x4.net2) v(xnavt.x4.net3)
alter Vdip = 1
alter Vrad = 6000
alter Vtilt = 90
alter Voff = 200e-6
dc Vang 0 360 5
wrdata s032.txt v(S1P) v(S1N) v(S2P) v(S2N) v(S3P) v(S3N) v(S4P) v(S4N) v(XPv) v(Xv) v(XNv) v(YPv) v(Yv) v(YNv) v(ZPv) v(Zv) v(ZNv) v(xnav2.X1) v(xnav2.X2) v(xnav2.X3) v(xnav2.X4) v(xnav2.Y1) v(xnav2.Y2) v(xnav2.Y3) v(xnav2.Y4) v(xnav2.Z1) v(xnav2.Z2) v(xnav2.Z3) v(xnav2.Z4) v(XPt) v(Xt) v(XNt) v(YPt) v(Yt) v(YNt) v(ZPt) v(Zt) v(ZNt) v(xnavt.X1) v(xnavt.X2) v(xnavt.X3) v(xnavt.X4) v(xnavt.Y1) v(xnavt.Y2) v(xnavt.Y3) v(xnavt.Y4) v(xnavt.Z1) v(xnavt.Z2) v(xnavt.Z3) v(xnavt.Z4) v(xnavt.x1.net1) v(xnavt.x1.net2) v(xnavt.x1.net3) v(xnavt.x2.net1) v(xnavt.x2.net2) v(xnavt.x2.net3) v(xnavt.x3.net1) v(xnavt.x3.net2) v(xnavt.x3.net3) v(xnavt.x4.net1) v(xnavt.x4.net2) v(xnavt.x4.net3)
alter Vdip = 1
alter Vrad = 6000
alter Vtilt = 120
alter Voff = 200e-6
dc Vang 0 360 5
wrdata s033.txt v(S1P) v(S1N) v(S2P) v(S2N) v(S3P) v(S3N) v(S4P) v(S4N) v(XPv) v(Xv) v(XNv) v(YPv) v(Yv) v(YNv) v(ZPv) v(Zv) v(ZNv) v(xnav2.X1) v(xnav2.X2) v(xnav2.X3) v(xnav2.X4) v(xnav2.Y1) v(xnav2.Y2) v(xnav2.Y3) v(xnav2.Y4) v(xnav2.Z1) v(xnav2.Z2) v(xnav2.Z3) v(xnav2.Z4) v(XPt) v(Xt) v(XNt) v(YPt) v(Yt) v(YNt) v(ZPt) v(Zt) v(ZNt) v(xnavt.X1) v(xnavt.X2) v(xnavt.X3) v(xnavt.X4) v(xnavt.Y1) v(xnavt.Y2) v(xnavt.Y3) v(xnavt.Y4) v(xnavt.Z1) v(xnavt.Z2) v(xnavt.Z3) v(xnavt.Z4) v(xnavt.x1.net1) v(xnavt.x1.net2) v(xnavt.x1.net3) v(xnavt.x2.net1) v(xnavt.x2.net2) v(xnavt.x2.net3) v(xnavt.x3.net1) v(xnavt.x3.net2) v(xnavt.x3.net3) v(xnavt.x4.net1) v(xnavt.x4.net2) v(xnavt.x4.net3)
alter Vdip = 1
alter Vrad = 6000
alter Vtilt = 150
alter Voff = 200e-6
dc Vang 0 360 5
wrdata s034.txt v(S1P) v(S1N) v(S2P) v(S2N) v(S3P) v(S3N) v(S4P) v(S4N) v(XPv) v(Xv) v(XNv) v(YPv) v(Yv) v(YNv) v(ZPv) v(Zv) v(ZNv) v(xnav2.X1) v(xnav2.X2) v(xnav2.X3) v(xnav2.X4) v(xnav2.Y1) v(xnav2.Y2) v(xnav2.Y3) v(xnav2.Y4) v(xnav2.Z1) v(xnav2.Z2) v(xnav2.Z3) v(xnav2.Z4) v(XPt) v(Xt) v(XNt) v(YPt) v(Yt) v(YNt) v(ZPt) v(Zt) v(ZNt) v(xnavt.X1) v(xnavt.X2) v(xnavt.X3) v(xnavt.X4) v(xnavt.Y1) v(xnavt.Y2) v(xnavt.Y3) v(xnavt.Y4) v(xnavt.Z1) v(xnavt.Z2) v(xnavt.Z3) v(xnavt.Z4) v(xnavt.x1.net1) v(xnavt.x1.net2) v(xnavt.x1.net3) v(xnavt.x2.net1) v(xnavt.x2.net2) v(xnavt.x2.net3) v(xnavt.x3.net1) v(xnavt.x3.net2) v(xnavt.x3.net3) v(xnavt.x4.net1) v(xnavt.x4.net2) v(xnavt.x4.net3)
alter Vdip = 1
alter Vrad = 6000
alter Vtilt = 180
alter Voff = 200e-6
dc Vang 0 360 5
wrdata s035.txt v(S1P) v(S1N) v(S2P) v(S2N) v(S3P) v(S3N) v(S4P) v(S4N) v(XPv) v(Xv) v(XNv) v(YPv) v(Yv) v(YNv) v(ZPv) v(Zv) v(ZNv) v(xnav2.X1) v(xnav2.X2) v(xnav2.X3) v(xnav2.X4) v(xnav2.Y1) v(xnav2.Y2) v(xnav2.Y3) v(xnav2.Y4) v(xnav2.Z1) v(xnav2.Z2) v(xnav2.Z3) v(xnav2.Z4) v(XPt) v(Xt) v(XNt) v(YPt) v(Yt) v(YNt) v(ZPt) v(Zt) v(ZNt) v(xnavt.X1) v(xnavt.X2) v(xnavt.X3) v(xnavt.X4) v(xnavt.Y1) v(xnavt.Y2) v(xnavt.Y3) v(xnavt.Y4) v(xnavt.Z1) v(xnavt.Z2) v(xnavt.Z3) v(xnavt.Z4) v(xnavt.x1.net1) v(xnavt.x1.net2) v(xnavt.x1.net3) v(xnavt.x2.net1) v(xnavt.x2.net2) v(xnavt.x2.net3) v(xnavt.x3.net1) v(xnavt.x3.net2) v(xnavt.x3.net3) v(xnavt.x4.net1) v(xnavt.x4.net2) v(xnavt.x4.net3)
alter Vdip = 1
alter Vrad = 12000
alter Vtilt = 0
alter Voff = 200e-6
dc Vang 0 360 5
wrdata s036.txt v(S1P) v(S1N) v(S2P) v(S2N) v(S3P) v(S3N) v(S4P) v(S4N) v(XPv) v(Xv) v(XNv) v(YPv) v(Yv) v(YNv) v(ZPv) v(Zv) v(ZNv) v(xnav2.X1) v(xnav2.X2) v(xnav2.X3) v(xnav2.X4) v(xnav2.Y1) v(xnav2.Y2) v(xnav2.Y3) v(xnav2.Y4) v(xnav2.Z1) v(xnav2.Z2) v(xnav2.Z3) v(xnav2.Z4) v(XPt) v(Xt) v(XNt) v(YPt) v(Yt) v(YNt) v(ZPt) v(Zt) v(ZNt) v(xnavt.X1) v(xnavt.X2) v(xnavt.X3) v(xnavt.X4) v(xnavt.Y1) v(xnavt.Y2) v(xnavt.Y3) v(xnavt.Y4) v(xnavt.Z1) v(xnavt.Z2) v(xnavt.Z3) v(xnavt.Z4) v(xnavt.x1.net1) v(xnavt.x1.net2) v(xnavt.x1.net3) v(xnavt.x2.net1) v(xnavt.x2.net2) v(xnavt.x2.net3) v(xnavt.x3.net1) v(xnavt.x3.net2) v(xnavt.x3.net3) v(xnavt.x4.net1) v(xnavt.x4.net2) v(xnavt.x4.net3)
alter Vdip = 1
alter Vrad = 12000
alter Vtilt = 30
alter Voff = 200e-6
dc Vang 0 360 5
wrdata s037.txt v(S1P) v(S1N) v(S2P) v(S2N) v(S3P) v(S3N) v(S4P) v(S4N) v(XPv) v(Xv) v(XNv) v(YPv) v(Yv) v(YNv) v(ZPv) v(Zv) v(ZNv) v(xnav2.X1) v(xnav2.X2) v(xnav2.X3) v(xnav2.X4) v(xnav2.Y1) v(xnav2.Y2) v(xnav2.Y3) v(xnav2.Y4) v(xnav2.Z1) v(xnav2.Z2) v(xnav2.Z3) v(xnav2.Z4) v(XPt) v(Xt) v(XNt) v(YPt) v(Yt) v(YNt) v(ZPt) v(Zt) v(ZNt) v(xnavt.X1) v(xnavt.X2) v(xnavt.X3) v(xnavt.X4) v(xnavt.Y1) v(xnavt.Y2) v(xnavt.Y3) v(xnavt.Y4) v(xnavt.Z1) v(xnavt.Z2) v(xnavt.Z3) v(xnavt.Z4) v(xnavt.x1.net1) v(xnavt.x1.net2) v(xnavt.x1.net3) v(xnavt.x2.net1) v(xnavt.x2.net2) v(xnavt.x2.net3) v(xnavt.x3.net1) v(xnavt.x3.net2) v(xnavt.x3.net3) v(xnavt.x4.net1) v(xnavt.x4.net2) v(xnavt.x4.net3)
alter Vdip = 1
alter Vrad = 12000
alter Vtilt = 60
alter Voff = 200e-6
dc Vang 0 360 5
wrdata s038.txt v(S1P) v(S1N) v(S2P) v(S2N) v(S3P) v(S3N) v(S4P) v(S4N) v(XPv) v(Xv) v(XNv) v(YPv) v(Yv) v(YNv) v(ZPv) v(Zv) v(ZNv) v(xnav2.X1) v(xnav2.X2) v(xnav2.X3) v(xnav2.X4) v(xnav2.Y1) v(xnav2.Y2) v(xnav2.Y3) v(xnav2.Y4) v(xnav2.Z1) v(xnav2.Z2) v(xnav2.Z3) v(xnav2.Z4) v(XPt) v(Xt) v(XNt) v(YPt) v(Yt) v(YNt) v(ZPt) v(Zt) v(ZNt) v(xnavt.X1) v(xnavt.X2) v(xnavt.X3) v(xnavt.X4) v(xnavt.Y1) v(xnavt.Y2) v(xnavt.Y3) v(xnavt.Y4) v(xnavt.Z1) v(xnavt.Z2) v(xnavt.Z3) v(xnavt.Z4) v(xnavt.x1.net1) v(xnavt.x1.net2) v(xnavt.x1.net3) v(xnavt.x2.net1) v(xnavt.x2.net2) v(xnavt.x2.net3) v(xnavt.x3.net1) v(xnavt.x3.net2) v(xnavt.x3.net3) v(xnavt.x4.net1) v(xnavt.x4.net2) v(xnavt.x4.net3)
alter Vdip = 1
alter Vrad = 12000
alter Vtilt = 90
alter Voff = 200e-6
dc Vang 0 360 5
wrdata s039.txt v(S1P) v(S1N) v(S2P) v(S2N) v(S3P) v(S3N) v(S4P) v(S4N) v(XPv) v(Xv) v(XNv) v(YPv) v(Yv) v(YNv) v(ZPv) v(Zv) v(ZNv) v(xnav2.X1) v(xnav2.X2) v(xnav2.X3) v(xnav2.X4) v(xnav2.Y1) v(xnav2.Y2) v(xnav2.Y3) v(xnav2.Y4) v(xnav2.Z1) v(xnav2.Z2) v(xnav2.Z3) v(xnav2.Z4) v(XPt) v(Xt) v(XNt) v(YPt) v(Yt) v(YNt) v(ZPt) v(Zt) v(ZNt) v(xnavt.X1) v(xnavt.X2) v(xnavt.X3) v(xnavt.X4) v(xnavt.Y1) v(xnavt.Y2) v(xnavt.Y3) v(xnavt.Y4) v(xnavt.Z1) v(xnavt.Z2) v(xnavt.Z3) v(xnavt.Z4) v(xnavt.x1.net1) v(xnavt.x1.net2) v(xnavt.x1.net3) v(xnavt.x2.net1) v(xnavt.x2.net2) v(xnavt.x2.net3) v(xnavt.x3.net1) v(xnavt.x3.net2) v(xnavt.x3.net3) v(xnavt.x4.net1) v(xnavt.x4.net2) v(xnavt.x4.net3)
alter Vdip = 1
alter Vrad = 12000
alter Vtilt = 120
alter Voff = 200e-6
dc Vang 0 360 5
wrdata s040.txt v(S1P) v(S1N) v(S2P) v(S2N) v(S3P) v(S3N) v(S4P) v(S4N) v(XPv) v(Xv) v(XNv) v(YPv) v(Yv) v(YNv) v(ZPv) v(Zv) v(ZNv) v(xnav2.X1) v(xnav2.X2) v(xnav2.X3) v(xnav2.X4) v(xnav2.Y1) v(xnav2.Y2) v(xnav2.Y3) v(xnav2.Y4) v(xnav2.Z1) v(xnav2.Z2) v(xnav2.Z3) v(xnav2.Z4) v(XPt) v(Xt) v(XNt) v(YPt) v(Yt) v(YNt) v(ZPt) v(Zt) v(ZNt) v(xnavt.X1) v(xnavt.X2) v(xnavt.X3) v(xnavt.X4) v(xnavt.Y1) v(xnavt.Y2) v(xnavt.Y3) v(xnavt.Y4) v(xnavt.Z1) v(xnavt.Z2) v(xnavt.Z3) v(xnavt.Z4) v(xnavt.x1.net1) v(xnavt.x1.net2) v(xnavt.x1.net3) v(xnavt.x2.net1) v(xnavt.x2.net2) v(xnavt.x2.net3) v(xnavt.x3.net1) v(xnavt.x3.net2) v(xnavt.x3.net3) v(xnavt.x4.net1) v(xnavt.x4.net2) v(xnavt.x4.net3)
alter Vdip = 1
alter Vrad = 12000
alter Vtilt = 150
alter Voff = 200e-6
dc Vang 0 360 5
wrdata s041.txt v(S1P) v(S1N) v(S2P) v(S2N) v(S3P) v(S3N) v(S4P) v(S4N) v(XPv) v(Xv) v(XNv) v(YPv) v(Yv) v(YNv) v(ZPv) v(Zv) v(ZNv) v(xnav2.X1) v(xnav2.X2) v(xnav2.X3) v(xnav2.X4) v(xnav2.Y1) v(xnav2.Y2) v(xnav2.Y3) v(xnav2.Y4) v(xnav2.Z1) v(xnav2.Z2) v(xnav2.Z3) v(xnav2.Z4) v(XPt) v(Xt) v(XNt) v(YPt) v(Yt) v(YNt) v(ZPt) v(Zt) v(ZNt) v(xnavt.X1) v(xnavt.X2) v(xnavt.X3) v(xnavt.X4) v(xnavt.Y1) v(xnavt.Y2) v(xnavt.Y3) v(xnavt.Y4) v(xnavt.Z1) v(xnavt.Z2) v(xnavt.Z3) v(xnavt.Z4) v(xnavt.x1.net1) v(xnavt.x1.net2) v(xnavt.x1.net3) v(xnavt.x2.net1) v(xnavt.x2.net2) v(xnavt.x2.net3) v(xnavt.x3.net1) v(xnavt.x3.net2) v(xnavt.x3.net3) v(xnavt.x4.net1) v(xnavt.x4.net2) v(xnavt.x4.net3)
alter Vdip = 1
alter Vrad = 12000
alter Vtilt = 180
alter Voff = 200e-6
dc Vang 0 360 5
wrdata s042.txt v(S1P) v(S1N) v(S2P) v(S2N) v(S3P) v(S3N) v(S4P) v(S4N) v(XPv) v(Xv) v(XNv) v(YPv) v(Yv) v(YNv) v(ZPv) v(Zv) v(ZNv) v(xnav2.X1) v(xnav2.X2) v(xnav2.X3) v(xnav2.X4) v(xnav2.Y1) v(xnav2.Y2) v(xnav2.Y3) v(xnav2.Y4) v(xnav2.Z1) v(xnav2.Z2) v(xnav2.Z3) v(xnav2.Z4) v(XPt) v(Xt) v(XNt) v(YPt) v(Yt) v(YNt) v(ZPt) v(Zt) v(ZNt) v(xnavt.X1) v(xnavt.X2) v(xnavt.X3) v(xnavt.X4) v(xnavt.Y1) v(xnavt.Y2) v(xnavt.Y3) v(xnavt.Y4) v(xnavt.Z1) v(xnavt.Z2) v(xnavt.Z3) v(xnavt.Z4) v(xnavt.x1.net1) v(xnavt.x1.net2) v(xnavt.x1.net3) v(xnavt.x2.net1) v(xnavt.x2.net2) v(xnavt.x2.net3) v(xnavt.x3.net1) v(xnavt.x3.net2) v(xnavt.x3.net3) v(xnavt.x4.net1) v(xnavt.x4.net2) v(xnavt.x4.net3)
.endc
.end
