** sch_path: /foss/designs/a_zonetic2026/XSCHEM/DECAP/DECAP.sch
**.subckt DECAP VDD VSS
*.iopin VDD
*.iopin VSS
XMN VSS VDD VSS VSS nfet_06v0 L=2.0u W=8.0u nf=4 ad='int((nf+1)/2) * W/nf * 0.18u' as='int((nf+2)/2) * W/nf * 0.18u' pd='2*int((nf+1)/2) * (W/nf + 0.18u)'
+ ps='2*int((nf+2)/2) * (W/nf + 0.18u)' nrd='0.18u / W' nrs='0.18u / W' sa=0 sb=0 sd=0
XMP VDD VSS VDD VDD pfet_06v0 L=2.0u W=8.0u nf=4 ad='int((nf+1)/2) * W/nf * 0.18u' as='int((nf+2)/2) * W/nf * 0.18u' pd='2*int((nf+1)/2) * (W/nf + 0.18u)'
+ ps='2*int((nf+2)/2) * (W/nf + 0.18u)' nrd='0.18u / W' nrs='0.18u / W' sa=0 sb=0 sd=0
**.ends
.end
