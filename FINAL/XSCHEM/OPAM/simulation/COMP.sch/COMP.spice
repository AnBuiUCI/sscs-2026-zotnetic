** sch_path: /foss/designs/a_zonetic2026/XSCHEM/OPAM/COMP.sch
.subckt COMP VDD IN- OUT IN+ VSS
*.PININFO IN-:I IN+:I VDD:B VSS:B OUT:B
x1 VDD net4 net3 net2 net1 VSS bias
x2 VDD net4 net3 IN- OUT IN+ net2 net1 VSS sub_diff
.ends

* expanding   symbol:  DESIGN/FINAL/OPAM/bias.sym # of pins=6
** sym_path: /foss/designs/DESIGN/FINAL/OPAM/bias.sym
** sch_path: /foss/designs/DESIGN/FINAL/OPAM/bias.sch
.subckt bias vdd bias1 bias2 bias3 bias4 vss
*.PININFO bias1:O bias2:O bias3:O bias4:O vdd:B vss:B
M4 net3 bias1 vdd vdd pfet_06v0 L=1.0u W=10.0u nf=1
M5 bias3 bias2 net3 vdd pfet_06v0 L=1.0u W=10.0u nf=1
M6 bias3 bias3 vss vss nfet_06v0 L=1.0u W=1.0u nf=1
M7 net2 bias1 vdd vdd pfet_06v0 L=1.0u W=10.0u nf=1
M8 bias4 bias2 net2 vdd pfet_06v0 L=1.0u W=10.0u nf=1
M9 bias4 bias3 net1 vss nfet_06v0 L=1.0u W=5.0u nf=1
M10 net1 bias4 vss vss nfet_06v0 L=1.0u W=5.0u nf=1
M1 bias2 bias2 vdd vdd pfet_06v0 L=1.0u W=2u nf=1
M2 net4 bias1 vdd vdd pfet_06v0 L=1.0u W=10.0u nf=1
M3 bias1 bias2 net4 vdd pfet_06v0 L=1.0u W=10.0u nf=1
M47 net5 bias2 vss vss nfet_06v0 L=1.0u W=1.0u nf=1
M48 net6 bias2 vss vss nfet_06v0 L=1.0u W=1.0u nf=1
M49 bias2 bias2 net6 vss nfet_06v0 L=1.0u W=1.0u nf=1
M50 bias1 bias2 net5 vss nfet_06v0 L=1.0u W=1.0u nf=1
.ends

* expanding   symbol:  DESIGN/FINAL/OPAM/sub_diff.sym # of pins=9
** sym_path: /foss/designs/DESIGN/FINAL/OPAM/sub_diff.sym
** sch_path: /foss/designs/DESIGN/FINAL/OPAM/sub_diff.sch
.subckt sub_diff vdd bias1 bias2 vinn out vinp bias3 bias4 vss
*.PININFO out:O vdd:B vss:B vinp:I vinn:I bias1:I bias2:I bias3:I bias4:I
M11 net2 bias1 vdd vdd pfet_06v0 L=1.0u W=10.0u nf=1
M12 net7 bias2 net2 vdd pfet_06v0 L=1.0u W=10.0u nf=1
M13 net19 bias1 vdd vdd pfet_06v0 L=1.0u W=10.0u nf=1
M14 net7 bias2 net19 vdd pfet_06v0 L=1.0u W=10.0u nf=1
M15 net5 vinp net7 vdd pfet_06v0 L=1.0u W=10.0u nf=1 m=2
M16 net4 vinn net7 vdd pfet_06v0 L=1.0u W=10.0u nf=1 m=2
M17 net8 bias3 net1 vss nfet_06v0 L=1.0u W=5.0u nf=1
M18 net1 bias4 vss vss nfet_06v0 L=1.0u W=5.0u nf=1
M19 net8 bias3 net20 vss nfet_06v0 L=1.0u W=5.0u nf=1
M20 net20 bias4 vss vss nfet_06v0 L=1.0u W=5.0u nf=1
M21 net6 vinp net8 vss nfet_06v0 L=1.0u W=5u nf=1 m=2
M22 net3 vinn net8 vss nfet_06v0 L=1.0u W=5u nf=1 m=2
M29 net9 bias2 net3 vdd pfet_06v0 L=1.0u W=5u nf=1 m=2
M30 net12 bias2 net6 vdd pfet_06v0 L=1.0u W=5.0u nf=1 m=2
M31 net3 net9 vdd vdd pfet_06v0 L=1.0u W=5u nf=1 m=4
M35 net6 net9 vdd vdd pfet_06v0 L=1.0u W=5.0u nf=1 m=4
M32 net10 net21 net9 vdd pfet_06v0 L=1.0u W=5u nf=1
M33 net22 net21 net12 vdd pfet_06v0 L=1.0u W=5.0u nf=1
M23 net10 bias3 net4 vss nfet_06v0 L=1.0u W=2.5u nf=1 m=2
M24 net22 bias3 net5 vss nfet_06v0 L=1.0u W=2.5u nf=1 m=2
M25 net4 net10 vss vss nfet_06v0 L=1.0u W=2.5u nf=1 m=4
M26 net5 net10 vss vss nfet_06v0 L=1.0u W=2.5u nf=1 m=4
M27 net9 net11 net10 vss nfet_06v0 L=1.0u W=2.5u nf=1
M28 net12 net11 net22 vss nfet_06v0 L=1.0u W=2.5u nf=1
M34 net13 net14 vdd vdd pfet_06v0 L=1.0u W=10.0u nf=1
M36 net14 bias2 net13 vdd pfet_06v0 L=1.0u W=10.0u nf=1
M37 net21 net21 net14 vdd pfet_06v0 L=1.0u W=10.0u nf=1
M38 net21 bias3 net15 vss nfet_06v0 L=1.0u W=5.0u nf=1
M39 net15 bias4 vss vss nfet_06v0 L=1.0u W=5.0u nf=1
M45 net16 bias1 vdd vdd pfet_06v0 L=1.0u W=10.0u nf=1
M46 net11 bias2 net16 vdd pfet_06v0 L=1.0u W=10.0u nf=1
M40 net11 net11 net18 vss nfet_06v0 L=1.0u W=5.0u nf=1
M41 net18 bias3 net17 vss nfet_06v0 L=1.0u W=5.0u nf=1
M42 net17 net18 vss vss nfet_06v0 L=1.0u W=5.0u nf=1
M43 out net12 vdd vdd pfet_06v0 L=1.0u W=10u nf=1 m=3
M44 out net22 vss vss nfet_06v0 L=1.0u W=5u nf=1 m=3
XC2 out net5 cap_mim_2f0fF c_width=20e-6 c_length=10e-6
XC3 net6 out cap_mim_2f0fF c_width=20e-6 c_length=10e-6
.ends
