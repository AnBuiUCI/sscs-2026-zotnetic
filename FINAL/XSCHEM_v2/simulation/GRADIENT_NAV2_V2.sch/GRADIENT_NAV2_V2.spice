** sch_path: /foss/designs/a_zonetic2026/XSCHEM_v2/GRADIENT_NAV2_V2.sch
**.subckt GRADIENT_NAV2_V2 VDD VSS XP X XN YP Y YN ZP Z ZN S2P S2N S4P S4N S3P S3N S1P S1N
*.ipin S1N
*.iopin VDD
*.opin XN
*.iopin VSS
*.ipin S1P
*.ipin S2N
*.ipin S2P
*.ipin S3N
*.ipin S3P
*.ipin S4N
*.ipin S4P
*.opin XP
*.opin YN
*.opin YP
*.opin ZN
*.opin ZP
*.opin X
*.opin Y
*.opin Z
x5 VDD VSS X X1 X2 X3 X4 WEIGHT
x6 VDD VSS Y Y1 Y2 Y3 Y4 WEIGHT
x7 VDD VSS Z Z1 Z2 Z3 Z4 WEIGHT
x1 S1N S1P VDD X1 S2N Y1 Z1 S2P VSS S3N S3P GRADIENT2
x2 S4N S4P VDD X2 S1N Y2 Z2 S1P VSS S2N S2P GRADIENT2
x3 S3N S3P VDD X3 S4N Y3 Z3 S4P VSS S1N S1P GRADIENT2
x4 S2N S2P VDD X4 S3N Y4 Z4 S3P VSS S4N S4P GRADIENT2
**** begin user architecture code

* Condensadores de desacople: NMOS y PMOS en inversion metidos en
* the gaps between macros. WRITTEN BY scripts/decap_fill.py -- do
* not edit by hand: it must be exactly what is in the GDS.
XMdecn0 VSS VDD VSS VSS nfet_06v0 L=2.0u W=1.5u nf=1
XMdecn1 VSS VDD VSS VSS nfet_06v0 L=2.0u W=1.5u nf=1
XMdecn2 VSS VDD VSS VSS nfet_06v0 L=2.0u W=1.5u nf=1
XMdecn3 VSS VDD VSS VSS nfet_06v0 L=2.0u W=1.5u nf=1
XMdecn4 VSS VDD VSS VSS nfet_06v0 L=2.0u W=1.5u nf=1
XMdecn5 VSS VDD VSS VSS nfet_06v0 L=2.0u W=1.5u nf=1
XMdecn6 VSS VDD VSS VSS nfet_06v0 L=2.0u W=1.5u nf=1
XMdecn7 VSS VDD VSS VSS nfet_06v0 L=2.0u W=1.5u nf=1
XMdecn8 VSS VDD VSS VSS nfet_06v0 L=2.0u W=1.5u nf=1
XMdecn9 VSS VDD VSS VSS nfet_06v0 L=2.0u W=1.5u nf=1
XMdecn10 VSS VDD VSS VSS nfet_06v0 L=2.0u W=1.5u nf=1
XMdecn11 VSS VDD VSS VSS nfet_06v0 L=2.0u W=1.5u nf=1
XMdecn12 VSS VDD VSS VSS nfet_06v0 L=2.0u W=1.5u nf=1
XMdecn13 VSS VDD VSS VSS nfet_06v0 L=2.0u W=1.5u nf=1
XMdecn14 VSS VDD VSS VSS nfet_06v0 L=2.0u W=1.5u nf=1
XMdecn15 VSS VDD VSS VSS nfet_06v0 L=2.0u W=1.5u nf=1
XMdecn16 VSS VDD VSS VSS nfet_06v0 L=2.0u W=1.5u nf=1
XMdecn17 VSS VDD VSS VSS nfet_06v0 L=2.0u W=1.5u nf=1
XMdecn18 VSS VDD VSS VSS nfet_06v0 L=2.0u W=1.5u nf=1
XMdecn19 VSS VDD VSS VSS nfet_06v0 L=2.0u W=1.5u nf=1
XMdecn20 VSS VDD VSS VSS nfet_06v0 L=2.0u W=1.5u nf=1
XMdecn21 VSS VDD VSS VSS nfet_06v0 L=2.0u W=1.5u nf=1
XMdecn22 VSS VDD VSS VSS nfet_06v0 L=2.0u W=1.5u nf=1
XMdecn23 VSS VDD VSS VSS nfet_06v0 L=2.0u W=1.5u nf=1
XMdecn24 VSS VDD VSS VSS nfet_06v0 L=2.0u W=1.5u nf=1
XMdecn25 VSS VDD VSS VSS nfet_06v0 L=2.0u W=1.5u nf=1
XMdecn26 VSS VDD VSS VSS nfet_06v0 L=2.0u W=1.5u nf=1
XMdecn27 VSS VDD VSS VSS nfet_06v0 L=2.0u W=1.5u nf=1
XMdecn28 VSS VDD VSS VSS nfet_06v0 L=2.0u W=1.5u nf=1
XMdecn29 VSS VDD VSS VSS nfet_06v0 L=2.0u W=1.5u nf=1
XMdecn30 VSS VDD VSS VSS nfet_06v0 L=2.0u W=1.5u nf=1
XMdecn31 VSS VDD VSS VSS nfet_06v0 L=2.0u W=1.5u nf=1
XMdecn32 VSS VDD VSS VSS nfet_06v0 L=2.0u W=1.5u nf=1
XMdecn33 VSS VDD VSS VSS nfet_06v0 L=2.0u W=1.5u nf=1
XMdecn34 VSS VDD VSS VSS nfet_06v0 L=2.0u W=1.5u nf=1
XMdecn35 VSS VDD VSS VSS nfet_06v0 L=2.0u W=1.5u nf=1
XMdecn36 VSS VDD VSS VSS nfet_06v0 L=2.0u W=1.5u nf=1
XMdecn37 VSS VDD VSS VSS nfet_06v0 L=2.0u W=1.5u nf=1
XMdecn38 VSS VDD VSS VSS nfet_06v0 L=2.0u W=1.5u nf=1
XMdecn39 VSS VDD VSS VSS nfet_06v0 L=2.0u W=1.5u nf=1
XMdecn40 VSS VDD VSS VSS nfet_06v0 L=2.0u W=1.5u nf=1
XMdecn41 VSS VDD VSS VSS nfet_06v0 L=2.0u W=1.5u nf=1
XMdecn42 VSS VDD VSS VSS nfet_06v0 L=2.0u W=1.5u nf=1
XMdecn43 VSS VDD VSS VSS nfet_06v0 L=2.0u W=1.5u nf=1
XMdecn44 VSS VDD VSS VSS nfet_06v0 L=2.0u W=1.5u nf=1
XMdecn45 VSS VDD VSS VSS nfet_06v0 L=2.0u W=1.5u nf=1
XMdecn46 VSS VDD VSS VSS nfet_06v0 L=2.0u W=1.5u nf=1
XMdecn47 VSS VDD VSS VSS nfet_06v0 L=2.0u W=1.5u nf=1
XMdecn48 VSS VDD VSS VSS nfet_06v0 L=2.0u W=1.5u nf=1
XMdecn49 VSS VDD VSS VSS nfet_06v0 L=2.0u W=1.5u nf=1
XMdecn50 VSS VDD VSS VSS nfet_06v0 L=2.0u W=1.5u nf=1
XMdecn51 VSS VDD VSS VSS nfet_06v0 L=2.0u W=1.5u nf=1
XMdecn52 VSS VDD VSS VSS nfet_06v0 L=2.0u W=1.5u nf=1
XMdecp53 VDD VSS VDD VDD pfet_06v0 L=2.0u W=1.5u nf=1
XMdecp54 VDD VSS VDD VDD pfet_06v0 L=2.0u W=1.5u nf=1
XMdecp55 VDD VSS VDD VDD pfet_06v0 L=2.0u W=1.5u nf=1
XMdecp56 VDD VSS VDD VDD pfet_06v0 L=2.0u W=1.5u nf=1
XMdecp57 VDD VSS VDD VDD pfet_06v0 L=2.0u W=1.5u nf=1
XMdecp58 VDD VSS VDD VDD pfet_06v0 L=2.0u W=1.5u nf=1
XMdecp59 VDD VSS VDD VDD pfet_06v0 L=2.0u W=1.5u nf=1
XMdecp60 VDD VSS VDD VDD pfet_06v0 L=2.0u W=1.5u nf=1
XMdecp61 VDD VSS VDD VDD pfet_06v0 L=2.0u W=1.5u nf=1
XMdecp62 VDD VSS VDD VDD pfet_06v0 L=2.0u W=1.5u nf=1
XMdecp63 VDD VSS VDD VDD pfet_06v0 L=2.0u W=1.5u nf=1
XMdecp64 VDD VSS VDD VDD pfet_06v0 L=2.0u W=1.5u nf=1
XMdecp65 VDD VSS VDD VDD pfet_06v0 L=2.0u W=1.5u nf=1
XMdecp66 VDD VSS VDD VDD pfet_06v0 L=2.0u W=1.5u nf=1
XMdecp67 VDD VSS VDD VDD pfet_06v0 L=2.0u W=1.5u nf=1
XMdecp68 VDD VSS VDD VDD pfet_06v0 L=2.0u W=1.5u nf=1
XMdecp69 VDD VSS VDD VDD pfet_06v0 L=2.0u W=1.5u nf=1
XMdecp70 VDD VSS VDD VDD pfet_06v0 L=2.0u W=1.5u nf=1
XMdecp71 VDD VSS VDD VDD pfet_06v0 L=2.0u W=1.5u nf=1
XMdecp72 VDD VSS VDD VDD pfet_06v0 L=2.0u W=1.5u nf=1
XMdecp73 VDD VSS VDD VDD pfet_06v0 L=2.0u W=1.5u nf=1
XMdecp74 VDD VSS VDD VDD pfet_06v0 L=2.0u W=1.5u nf=1
XMdecp75 VDD VSS VDD VDD pfet_06v0 L=2.0u W=1.5u nf=1
XMdecp76 VDD VSS VDD VDD pfet_06v0 L=2.0u W=1.5u nf=1
XMdecp77 VDD VSS VDD VDD pfet_06v0 L=2.0u W=1.5u nf=1
XMdecp78 VDD VSS VDD VDD pfet_06v0 L=2.0u W=1.5u nf=1
XMdecp79 VDD VSS VDD VDD pfet_06v0 L=2.0u W=1.5u nf=1
XMdecp80 VDD VSS VDD VDD pfet_06v0 L=2.0u W=1.5u nf=1
XMdecp81 VDD VSS VDD VDD pfet_06v0 L=2.0u W=1.5u nf=1
XMdecp82 VDD VSS VDD VDD pfet_06v0 L=2.0u W=1.5u nf=1
XMdecp83 VDD VSS VDD VDD pfet_06v0 L=2.0u W=1.5u nf=1
XMdecp84 VDD VSS VDD VDD pfet_06v0 L=2.0u W=1.5u nf=1
XMdecp85 VDD VSS VDD VDD pfet_06v0 L=2.0u W=1.5u nf=1
XMdecp86 VDD VSS VDD VDD pfet_06v0 L=2.0u W=1.5u nf=1
XMdecp87 VDD VSS VDD VDD pfet_06v0 L=2.0u W=1.5u nf=1
XMdecp88 VDD VSS VDD VDD pfet_06v0 L=2.0u W=1.5u nf=1
XMdecp89 VDD VSS VDD VDD pfet_06v0 L=2.0u W=1.5u nf=1
XMdecp90 VDD VSS VDD VDD pfet_06v0 L=2.0u W=1.5u nf=1
XMdecp91 VDD VSS VDD VDD pfet_06v0 L=2.0u W=1.5u nf=1
XMdecp92 VDD VSS VDD VDD pfet_06v0 L=2.0u W=1.5u nf=1
XMdecp93 VDD VSS VDD VDD pfet_06v0 L=2.0u W=1.5u nf=1
XMdecp94 VDD VSS VDD VDD pfet_06v0 L=2.0u W=1.5u nf=1
XMdecp95 VDD VSS VDD VDD pfet_06v0 L=2.0u W=1.5u nf=1
XMdecp96 VDD VSS VDD VDD pfet_06v0 L=2.0u W=1.5u nf=1
XMdecp97 VDD VSS VDD VDD pfet_06v0 L=2.0u W=1.5u nf=1
XMdecp98 VDD VSS VDD VDD pfet_06v0 L=2.0u W=1.5u nf=1
XMdecp99 VDD VSS VDD VDD pfet_06v0 L=2.0u W=1.5u nf=1
XMdecp100 VDD VSS VDD VDD pfet_06v0 L=2.0u W=1.5u nf=1
XMdecp101 VDD VSS VDD VDD pfet_06v0 L=2.0u W=1.5u nf=1
XMdecn102 VSS VDD VSS VSS nfet_06v0 L=2.0u W=18.0u nf=1
XMdecn103 VSS VDD VSS VSS nfet_06v0 L=2.0u W=18.0u nf=1
XMdecp104 VDD VSS VDD VDD pfet_06v0 L=2.0u W=18.0u nf=1
XMdecp105 VDD VSS VDD VDD pfet_06v0 L=2.0u W=18.0u nf=1
XMdecn106 VSS VDD VSS VSS nfet_06v0 L=2.0u W=18.0u nf=1
XMdecn107 VSS VDD VSS VSS nfet_06v0 L=2.0u W=18.0u nf=1
XMdecp108 VDD VSS VDD VDD pfet_06v0 L=2.0u W=18.0u nf=1
XMdecp109 VDD VSS VDD VDD pfet_06v0 L=2.0u W=18.0u nf=1
XMdecn110 VSS VDD VSS VSS nfet_06v0 L=2.0u W=18.0u nf=1
XMdecn111 VSS VDD VSS VSS nfet_06v0 L=2.0u W=18.0u nf=1
XMdecp112 VDD VSS VDD VDD pfet_06v0 L=2.0u W=18.0u nf=1
XMdecp113 VDD VSS VDD VDD pfet_06v0 L=2.0u W=18.0u nf=1
XMdecn114 VSS VDD VSS VSS nfet_06v0 L=2.0u W=18.0u nf=1
XMdecn115 VSS VDD VSS VSS nfet_06v0 L=2.0u W=18.0u nf=1
XMdecp116 VDD VSS VDD VDD pfet_06v0 L=2.0u W=18.0u nf=1
XMdecp117 VDD VSS VDD VDD pfet_06v0 L=2.0u W=18.0u nf=1
XMdecn118 VSS VDD VSS VSS nfet_06v0 L=2.0u W=18.0u nf=1
XMdecn119 VSS VDD VSS VSS nfet_06v0 L=2.0u W=18.0u nf=1
XMdecp120 VDD VSS VDD VDD pfet_06v0 L=2.0u W=18.0u nf=1
XMdecp121 VDD VSS VDD VDD pfet_06v0 L=2.0u W=18.0u nf=1
XMdecn122 VSS VDD VSS VSS nfet_06v0 L=2.0u W=18.0u nf=1
XMdecn123 VSS VDD VSS VSS nfet_06v0 L=2.0u W=18.0u nf=1
XMdecp124 VDD VSS VDD VDD pfet_06v0 L=2.0u W=18.0u nf=1
XMdecp125 VDD VSS VDD VDD pfet_06v0 L=2.0u W=18.0u nf=1
XMdecn126 VSS VDD VSS VSS nfet_06v0 L=2.0u W=18.0u nf=1
XMdecn127 VSS VDD VSS VSS nfet_06v0 L=2.0u W=18.0u nf=1
XMdecp128 VDD VSS VDD VDD pfet_06v0 L=2.0u W=18.0u nf=1
XMdecp129 VDD VSS VDD VDD pfet_06v0 L=2.0u W=18.0u nf=1
XMdecn130 VSS VDD VSS VSS nfet_06v0 L=2.0u W=18.0u nf=1
XMdecn131 VSS VDD VSS VSS nfet_06v0 L=2.0u W=18.0u nf=1
XMdecp132 VDD VSS VDD VDD pfet_06v0 L=2.0u W=18.0u nf=1
XMdecp133 VDD VSS VDD VDD pfet_06v0 L=2.0u W=18.0u nf=1
XMdecn134 VSS VDD VSS VSS nfet_06v0 L=2.0u W=18.0u nf=1
XMdecn135 VSS VDD VSS VSS nfet_06v0 L=2.0u W=18.0u nf=1
XMdecp136 VDD VSS VDD VDD pfet_06v0 L=2.0u W=18.0u nf=1
XMdecp137 VDD VSS VDD VDD pfet_06v0 L=2.0u W=18.0u nf=1
XMdecn138 VSS VDD VSS VSS nfet_06v0 L=2.0u W=18.0u nf=1
XMdecp139 VDD VSS VDD VDD pfet_06v0 L=2.0u W=18.0u nf=1
XMdecn140 VSS VDD VSS VSS nfet_06v0 L=2.0u W=18.0u nf=1
XMdecp141 VDD VSS VDD VDD pfet_06v0 L=2.0u W=18.0u nf=1
XMdecn142 VSS VDD VSS VSS nfet_06v0 L=2.0u W=18.0u nf=1
XMdecp143 VDD VSS VDD VDD pfet_06v0 L=2.0u W=18.0u nf=1
XMdecn144 VSS VDD VSS VSS nfet_06v0 L=2.0u W=9.75u nf=1
XMdecn145 VSS VDD VSS VSS nfet_06v0 L=2.0u W=9.75u nf=1
XMdecp146 VDD VSS VDD VDD pfet_06v0 L=2.0u W=9.75u nf=1
XMdecp147 VDD VSS VDD VDD pfet_06v0 L=2.0u W=9.75u nf=1
XMdecn148 VSS VDD VSS VSS nfet_06v0 L=2.0u W=9.75u nf=1
XMdecn149 VSS VDD VSS VSS nfet_06v0 L=2.0u W=9.75u nf=1
XMdecp150 VDD VSS VDD VDD pfet_06v0 L=2.0u W=9.75u nf=1
XMdecp151 VDD VSS VDD VDD pfet_06v0 L=2.0u W=9.75u nf=1
XMdecn152 VSS VDD VSS VSS nfet_06v0 L=2.0u W=9.75u nf=1
XMdecn153 VSS VDD VSS VSS nfet_06v0 L=2.0u W=9.75u nf=1
XMdecp154 VDD VSS VDD VDD pfet_06v0 L=2.0u W=9.75u nf=1
XMdecp155 VDD VSS VDD VDD pfet_06v0 L=2.0u W=9.75u nf=1
XMdecn156 VSS VDD VSS VSS nfet_06v0 L=2.0u W=9.75u nf=1
XMdecn157 VSS VDD VSS VSS nfet_06v0 L=2.0u W=9.75u nf=1
XMdecp158 VDD VSS VDD VDD pfet_06v0 L=2.0u W=9.75u nf=1
XMdecp159 VDD VSS VDD VDD pfet_06v0 L=2.0u W=9.75u nf=1
XMdecn160 VSS VDD VSS VSS nfet_06v0 L=2.0u W=9.75u nf=1
XMdecn161 VSS VDD VSS VSS nfet_06v0 L=2.0u W=9.75u nf=1
XMdecp162 VDD VSS VDD VDD pfet_06v0 L=2.0u W=9.75u nf=1
XMdecp163 VDD VSS VDD VDD pfet_06v0 L=2.0u W=9.75u nf=1
XMdecn164 VSS VDD VSS VSS nfet_06v0 L=2.0u W=9.75u nf=1
XMdecn165 VSS VDD VSS VSS nfet_06v0 L=2.0u W=9.75u nf=1
XMdecp166 VDD VSS VDD VDD pfet_06v0 L=2.0u W=9.75u nf=1
XMdecp167 VDD VSS VDD VDD pfet_06v0 L=2.0u W=9.75u nf=1
XMdecn168 VSS VDD VSS VSS nfet_06v0 L=2.0u W=9.75u nf=1
XMdecn169 VSS VDD VSS VSS nfet_06v0 L=2.0u W=9.75u nf=1
XMdecp170 VDD VSS VDD VDD pfet_06v0 L=2.0u W=9.75u nf=1
XMdecp171 VDD VSS VDD VDD pfet_06v0 L=2.0u W=9.75u nf=1
XMdecn172 VSS VDD VSS VSS nfet_06v0 L=2.0u W=9.75u nf=1
XMdecn173 VSS VDD VSS VSS nfet_06v0 L=2.0u W=9.75u nf=1
XMdecp174 VDD VSS VDD VDD pfet_06v0 L=2.0u W=9.75u nf=1
XMdecp175 VDD VSS VDD VDD pfet_06v0 L=2.0u W=9.75u nf=1
XMdecn176 VSS VDD VSS VSS nfet_06v0 L=2.0u W=9.75u nf=1
XMdecn177 VSS VDD VSS VSS nfet_06v0 L=2.0u W=9.75u nf=1
XMdecp178 VDD VSS VDD VDD pfet_06v0 L=2.0u W=9.75u nf=1
XMdecp179 VDD VSS VDD VDD pfet_06v0 L=2.0u W=9.75u nf=1
XMdecn180 VSS VDD VSS VSS nfet_06v0 L=2.0u W=9.75u nf=1
XMdecn181 VSS VDD VSS VSS nfet_06v0 L=2.0u W=9.75u nf=1
XMdecp182 VDD VSS VDD VDD pfet_06v0 L=2.0u W=9.75u nf=1
XMdecp183 VDD VSS VDD VDD pfet_06v0 L=2.0u W=9.75u nf=1
XMdecn184 VSS VDD VSS VSS nfet_06v0 L=2.0u W=9.75u nf=1
XMdecn185 VSS VDD VSS VSS nfet_06v0 L=2.0u W=9.75u nf=1
XMdecp186 VDD VSS VDD VDD pfet_06v0 L=2.0u W=9.75u nf=1
XMdecp187 VDD VSS VDD VDD pfet_06v0 L=2.0u W=9.75u nf=1
XMdecn188 VSS VDD VSS VSS nfet_06v0 L=2.0u W=9.75u nf=1
XMdecn189 VSS VDD VSS VSS nfet_06v0 L=2.0u W=9.75u nf=1
XMdecp190 VDD VSS VDD VDD pfet_06v0 L=2.0u W=9.75u nf=1
XMdecp191 VDD VSS VDD VDD pfet_06v0 L=2.0u W=9.75u nf=1
XMdecn192 VSS VDD VSS VSS nfet_06v0 L=2.0u W=18.0u nf=1
XMdecp193 VDD VSS VDD VDD pfet_06v0 L=2.0u W=18.0u nf=1
XMdecn194 VSS VDD VSS VSS nfet_06v0 L=2.0u W=18.0u nf=1
XMdecp195 VDD VSS VDD VDD pfet_06v0 L=2.0u W=18.0u nf=1
XMdecn196 VSS VDD VSS VSS nfet_06v0 L=2.0u W=18.0u nf=1
XMdecp197 VDD VSS VDD VDD pfet_06v0 L=2.0u W=18.0u nf=1
XMdecn198 VSS VDD VSS VSS nfet_06v0 L=2.0u W=1.5u nf=1
XMdecn199 VSS VDD VSS VSS nfet_06v0 L=2.0u W=1.5u nf=1
XMdecn200 VSS VDD VSS VSS nfet_06v0 L=2.0u W=1.5u nf=1
XMdecn201 VSS VDD VSS VSS nfet_06v0 L=2.0u W=1.5u nf=1
XMdecp202 VDD VSS VDD VDD pfet_06v0 L=2.0u W=1.5u nf=1
XMdecp203 VDD VSS VDD VDD pfet_06v0 L=2.0u W=1.5u nf=1
XMdecp204 VDD VSS VDD VDD pfet_06v0 L=2.0u W=1.5u nf=1
XMdecp205 VDD VSS VDD VDD pfet_06v0 L=2.0u W=1.5u nf=1
XMdecn206 VSS VDD VSS VSS nfet_06v0 L=2.0u W=9.75u nf=1
XMdecp207 VDD VSS VDD VDD pfet_06v0 L=2.0u W=9.75u nf=1
XMdecn208 VSS VDD VSS VSS nfet_06v0 L=2.0u W=9.75u nf=1
XMdecp209 VDD VSS VDD VDD pfet_06v0 L=2.0u W=9.75u nf=1
XMdecn210 VSS VDD VSS VSS nfet_06v0 L=2.0u W=9.75u nf=1
XMdecp211 VDD VSS VDD VDD pfet_06v0 L=2.0u W=9.75u nf=1
XMdecn212 VSS VDD VSS VSS nfet_06v0 L=2.0u W=9.75u nf=1
XMdecp213 VDD VSS VDD VDD pfet_06v0 L=2.0u W=9.75u nf=1
XMdecn214 VSS VDD VSS VSS nfet_06v0 L=2.0u W=1.5u nf=1
XMdecn215 VSS VDD VSS VSS nfet_06v0 L=2.0u W=1.5u nf=1
XMdecp216 VDD VSS VDD VDD pfet_06v0 L=2.0u W=1.5u nf=1
XMdecp217 VDD VSS VDD VDD pfet_06v0 L=2.0u W=1.5u nf=1
XMdecn218 VSS VDD VSS VSS nfet_06v0 L=2.0u W=1.5u nf=1
XMdecn219 VSS VDD VSS VSS nfet_06v0 L=2.0u W=1.5u nf=1
XMdecp220 VDD VSS VDD VDD pfet_06v0 L=2.0u W=1.5u nf=1
XMdecp221 VDD VSS VDD VDD pfet_06v0 L=2.0u W=1.5u nf=1
XMdecn222 VSS VDD VSS VSS nfet_06v0 L=2.0u W=1.5u nf=1
XMdecp223 VDD VSS VDD VDD pfet_06v0 L=2.0u W=1.5u nf=1

* THE OUTPUT DECISION, REDONE. Replaces the three COMP_OUT of today's top.
*
* WHAT WAS WRONG. The weight block is an ANALOGUE VOTE COUNTER and also
* INVERSOR: medido, 0/1/2/3 cadenas votando dan 3.035 / 2.579 / 2.178 / 1.814 V,
* escalones iguales de 0.4 V y correlacion -0.999. Detras iba un par de
* inverters, i.e. a NON-inverting buffer with its trip point wherever it fell:
*
*   * the output called 'P' was high when the axis does NOT win, the opposite of
*     nombre;
*   * and the trip point fell at ~2.0 V, i.e. between 2 and 3 votes, when the
*     decision correcta es a partir de DOS. Medido: X e Y disparaban el 22.5 %
*     of the sweep when they were due 47.7 % and 52.3 %.
*
* WHY A SKEWED INVERTER WILL NOT DO. It was tried: with the PMOS at 3.0/0.5 the
* de disparo cae en 2.365 V a 27 C y 5 V, justo en medio de la ventana. Pero es
* a ratio divider, so it **follows VDD**: 2.110 V at 4.5 V and 2.620 V at
* 5.5 V. The window between steps is 2.178..2.579, so with VDD +-10 % it goes
* out on both sides. Temperature does not matter (+-0.02 V); VDD does.
*
* WHAT GOES IN. A comparator against a reference taken from TWO REPLICAS OF THE
* WEIGHT BLOCK ITSELF, one loaded with 1 vote and one with 2, averaged. The
* reference moves with process, VDD and temperature just like the signal, which
* is exactly what an inverter's trip point does not do. And the comparator is
* the COMP cell that already exists, already drawn and with clean DRC and LVS.
*
* THIS IS A CODE BLOCK ON PURPOSE: it instantiates cells already in the design,
* so the idea can be measured before drawing it. If the numbers convince,
* it gets drawn as a cell (REF_VOTOS + COMP_OUT_v2) and then the two resistors
* pasan a ser ppolyf de verdad.
*
*   .subckt WEIGHT   VDD GND OUT VA VC VB VD
*   .subckt COMP     VDD INN OUT INP VSS
*   .subckt invertor VDD output In VSS
XREF1 VDD VSS VREFA VDD VSS VSS VSS WEIGHT
XREF2 VDD VSS VREFB VDD VDD VSS VSS WEIGHT
RREF1 VREFA VREF 100k
RREF2 VREF VREFB 100k
XCMPX VDD X XP VREF VSS COMP
XCMPY VDD Y YP VREF VSS COMP
XCMPZ VDD Z ZP VREF VSS COMP
XINVX VDD XN XP VSS invertor
XINVY VDD YN YP VSS invertor
XINVZ VDD ZN ZP VSS invertor

**** end user architecture code
**.ends

* expanding   symbol:  a_zonetic2026/XSCHEM/WEIGTH/WEIGHT.sym # of pins=7
** sym_path: /foss/designs/a_zonetic2026/XSCHEM/WEIGTH/WEIGHT.sym
** sch_path: /foss/designs/a_zonetic2026/XSCHEM/WEIGTH/WEIGHT.sch
.subckt WEIGHT VDD GND OUT VA VC VB VD
*.iopin VDD
*.iopin GND
*.ipin VA
*.ipin VB
*.ipin VC
*.ipin VD
*.iopin OUT
XM2 OUT OUT VDD VDD pfet_06v0 L=1u W=2u nf=1 ad='int((nf+1)/2) * W/nf * 0.18u' as='int((nf+2)/2) * W/nf * 0.18u' pd='2*int((nf+1)/2) * (W/nf + 0.18u)'
+ ps='2*int((nf+2)/2) * (W/nf + 0.18u)' nrd='0.18u / W' nrs='0.18u / W' sa=0 sb=0 sd=0 m=6
XM3 OUT VD net1 GND nfet_06v0 L=1u W=2.48u nf=1 ad='int((nf+1)/2) * W/nf * 0.18u' as='int((nf+2)/2) * W/nf * 0.18u' pd='2*int((nf+1)/2) * (W/nf + 0.18u)'
+ ps='2*int((nf+2)/2) * (W/nf + 0.18u)' nrd='0.18u / W' nrs='0.18u / W' sa=0 sb=0 sd=0 m=2
XM5 OUT VC net2 GND nfet_06v0 L=1u W=2.48u nf=1 ad='int((nf+1)/2) * W/nf * 0.18u' as='int((nf+2)/2) * W/nf * 0.18u' pd='2*int((nf+1)/2) * (W/nf + 0.18u)'
+ ps='2*int((nf+2)/2) * (W/nf + 0.18u)' nrd='0.18u / W' nrs='0.18u / W' sa=0 sb=0 sd=0 m=2
XM6 net2 IN net10 GND nfet_06v0 L=1u W=1.24u nf=1 ad='int((nf+1)/2) * W/nf * 0.18u' as='int((nf+2)/2) * W/nf * 0.18u' pd='2*int((nf+1)/2) * (W/nf + 0.18u)'
+ ps='2*int((nf+2)/2) * (W/nf + 0.18u)' nrd='0.18u / W' nrs='0.18u / W' sa=0 sb=0 sd=0
XM1 OUT OUT net3 GND nfet_06v0 L=1u W=2u nf=1 ad='int((nf+1)/2) * W/nf * 0.18u' as='int((nf+2)/2) * W/nf * 0.18u' pd='2*int((nf+1)/2) * (W/nf + 0.18u)'
+ ps='2*int((nf+2)/2) * (W/nf + 0.18u)' nrd='0.18u / W' nrs='0.18u / W' sa=0 sb=0 sd=0 m=2
XM7 net3 OUT net4 GND nfet_06v0 L=1u W=2u nf=1 ad='int((nf+1)/2) * W/nf * 0.18u' as='int((nf+2)/2) * W/nf * 0.18u' pd='2*int((nf+1)/2) * (W/nf + 0.18u)'
+ ps='2*int((nf+2)/2) * (W/nf + 0.18u)' nrd='0.18u / W' nrs='0.18u / W' sa=0 sb=0 sd=0
XM8 net4 OUT GND GND nfet_06v0 L=1u W=2u nf=1 ad='int((nf+1)/2) * W/nf * 0.18u' as='int((nf+2)/2) * W/nf * 0.18u' pd='2*int((nf+1)/2) * (W/nf + 0.18u)'
+ ps='2*int((nf+2)/2) * (W/nf + 0.18u)' nrd='0.18u / W' nrs='0.18u / W' sa=0 sb=0 sd=0
XM9 OUT VA net5 GND nfet_06v0 L=1u W=2.48u nf=1 ad='int((nf+1)/2) * W/nf * 0.18u' as='int((nf+2)/2) * W/nf * 0.18u' pd='2*int((nf+1)/2) * (W/nf + 0.18u)'
+ ps='2*int((nf+2)/2) * (W/nf + 0.18u)' nrd='0.18u / W' nrs='0.18u / W' sa=0 sb=0 sd=0 m=2
XM10 net5 IN net11 GND nfet_06v0 L=1u W=1.24u nf=1 ad='int((nf+1)/2) * W/nf * 0.18u' as='int((nf+2)/2) * W/nf * 0.18u' pd='2*int((nf+1)/2) * (W/nf + 0.18u)'
+ ps='2*int((nf+2)/2) * (W/nf + 0.18u)' nrd='0.18u / W' nrs='0.18u / W' sa=0 sb=0 sd=0
XM11 OUT VB net6 GND nfet_06v0 L=1u W=2.48u nf=1 ad='int((nf+1)/2) * W/nf * 0.18u' as='int((nf+2)/2) * W/nf * 0.18u' pd='2*int((nf+1)/2) * (W/nf + 0.18u)'
+ ps='2*int((nf+2)/2) * (W/nf + 0.18u)' nrd='0.18u / W' nrs='0.18u / W' sa=0 sb=0 sd=0 m=2
XM12 net6 IN net12 GND nfet_06v0 L=1u W=1.24u nf=1 ad='int((nf+1)/2) * W/nf * 0.18u' as='int((nf+2)/2) * W/nf * 0.18u' pd='2*int((nf+1)/2) * (W/nf + 0.18u)'
+ ps='2*int((nf+2)/2) * (W/nf + 0.18u)' nrd='0.18u / W' nrs='0.18u / W' sa=0 sb=0 sd=0
XM4 net1 IN net13 GND nfet_06v0 L=1u W=1.24u nf=1 ad='int((nf+1)/2) * W/nf * 0.18u' as='int((nf+2)/2) * W/nf * 0.18u' pd='2*int((nf+1)/2) * (W/nf + 0.18u)'
+ ps='2*int((nf+2)/2) * (W/nf + 0.18u)' nrd='0.18u / W' nrs='0.18u / W' sa=0 sb=0 sd=0
XM13 IN IN VDD VDD pfet_06v0 L=1u W=2u nf=1 ad='int((nf+1)/2) * W/nf * 0.18u' as='int((nf+2)/2) * W/nf * 0.18u' pd='2*int((nf+1)/2) * (W/nf + 0.18u)'
+ ps='2*int((nf+2)/2) * (W/nf + 0.18u)' nrd='0.18u / W' nrs='0.18u / W' sa=0 sb=0 sd=0
XM14 net8 IN net9 GND nfet_06v0 L=1u W=0.7u nf=1 ad='int((nf+1)/2) * W/nf * 0.18u' as='int((nf+2)/2) * W/nf * 0.18u' pd='2*int((nf+1)/2) * (W/nf + 0.18u)'
+ ps='2*int((nf+2)/2) * (W/nf + 0.18u)' nrd='0.18u / W' nrs='0.18u / W' sa=0 sb=0 sd=0
XM15 net7 IN net8 GND nfet_06v0 L=1u W=0.7u nf=1 ad='int((nf+1)/2) * W/nf * 0.18u' as='int((nf+2)/2) * W/nf * 0.18u' pd='2*int((nf+1)/2) * (W/nf + 0.18u)'
+ ps='2*int((nf+2)/2) * (W/nf + 0.18u)' nrd='0.18u / W' nrs='0.18u / W' sa=0 sb=0 sd=0
XM16 IN IN net7 GND nfet_06v0 L=1u W=0.7u nf=1 ad='int((nf+1)/2) * W/nf * 0.18u' as='int((nf+2)/2) * W/nf * 0.18u' pd='2*int((nf+1)/2) * (W/nf + 0.18u)'
+ ps='2*int((nf+2)/2) * (W/nf + 0.18u)' nrd='0.18u / W' nrs='0.18u / W' sa=0 sb=0 sd=0
XM17 net9 IN GND GND nfet_06v0 L=1u W=0.7u nf=1 ad='int((nf+1)/2) * W/nf * 0.18u' as='int((nf+2)/2) * W/nf * 0.18u' pd='2*int((nf+1)/2) * (W/nf + 0.18u)'
+ ps='2*int((nf+2)/2) * (W/nf + 0.18u)' nrd='0.18u / W' nrs='0.18u / W' sa=0 sb=0 sd=0
Vmeas net11 GND 0
.save i(vmeas)
Vmeas1 net12 GND 0
.save i(vmeas1)
Vmeas2 net10 GND 0
.save i(vmeas2)
Vmeas3 net13 GND 0
.save i(vmeas3)
.ends

* expanding   symbol:  a_zonetic2026/XSCHEM/COMBINATION/GRADIENT2.sym # of pins=11
** sym_path: /foss/designs/a_zonetic2026/XSCHEM/COMBINATION/GRADIENT2.sym
** sch_path: /foss/designs/a_zonetic2026/XSCHEM/COMBINATION/GRADIENT2.sch
.subckt GRADIENT2 SXN SXP VDD X SYN Y Z SYP VSS SZN SZP
*.ipin SXN
*.ipin SXP
*.iopin VDD
*.iopin VSS
*.iopin X
*.iopin Y
*.iopin Z
*.ipin SYN
*.ipin SYP
*.ipin SZN
*.ipin SZP
x4 VDD SX net1 SY VSS COMP
x5 VDD SX net2 SZ VSS COMP
x6 VDD SY net3 SZ VSS COMP
x7 VDD net1 net2 X Y net3 Z VSS DECODER
x8 VDD SXN SX SXP VSS OPAM_LIN
x1 VDD SYN SY SYP VSS OPAM_LIN
x2 VDD SZN SZ SZP VSS OPAM_LIN
.ends

* expanding   symbol:  a_zonetic2026/XSCHEM/OPAM/COMP.sym # of pins=5
** sym_path: /foss/designs/a_zonetic2026/XSCHEM/OPAM/COMP.sym
** sch_path: /foss/designs/a_zonetic2026/XSCHEM/OPAM/COMP.sch
.subckt COMP VDD INN OUT INP VSS
*.ipin INN
*.ipin INP
*.iopin VDD
*.iopin VSS
*.iopin OUT
x1 VDD net4 net3 net2 net1 VSS bias
x2 VDD net4 net3 INN OUT INP net2 net1 VSS sub_diff
.ends

* expanding   symbol:  a_zonetic2026/XSCHEM/DECODER/DECODER.sym # of pins=8
** sym_path: /foss/designs/a_zonetic2026/XSCHEM/DECODER/DECODER.sym
** sch_path: /foss/designs/a_zonetic2026/XSCHEM/DECODER/DECODER.sch
.subckt DECODER VDD XY XZ X Y YZ Z VSS
*.ipin XY
*.ipin XZ
*.iopin VDD
*.iopin VSS
*.iopin X
*.ipin YZ
*.iopin Y
*.iopin Z
x2 YZ XY VDD Y VSS yGates
x1 VSS VDD XZ YZ Z Z
x3 VDD XY X XZ VSS xGates
.ends

* expanding   symbol:  a_zonetic2026/XSCHEM/OPAM/OPAM_LIN.sym # of pins=5
** sym_path: /foss/designs/a_zonetic2026/XSCHEM/OPAM/OPAM_LIN.sym
** sch_path: /foss/designs/a_zonetic2026/XSCHEM/OPAM/OPAM_LIN.sch
.subckt OPAM_LIN VDD INN OUT INP VSS
*.ipin INN
*.ipin INP
*.iopin VDD
*.iopin VSS
*.iopin OUT
x1 VDD net3 net4 net2 net1 VSS bias
x2 VDD net3 net4 OUT INN INP net2 net1 VSS sub_diff_2_LIN
.ends

* expanding   symbol:  a_zonetic2026/XSCHEM/OPAM/bias.sym # of pins=6
** sym_path: /foss/designs/a_zonetic2026/XSCHEM/OPAM/bias.sym
** sch_path: /foss/designs/a_zonetic2026/XSCHEM/OPAM/bias.sch
.subckt bias vdd bias1 bias2 bias3 bias4 vss
*.opin bias1
*.opin bias2
*.opin bias3
*.opin bias4
*.iopin vdd
*.iopin vss
XM4 net3 bias1 vdd vdd pfet_06v0 L=1.0u W=10.0u nf=1 ad='int((nf+1)/2) * W/nf * 0.18u' as='int((nf+2)/2) * W/nf * 0.18u' pd='2*int((nf+1)/2) * (W/nf + 0.18u)'
+ ps='2*int((nf+2)/2) * (W/nf + 0.18u)' nrd='0.18u / W' nrs='0.18u / W' sa=0 sb=0 sd=0
XM5 bias3 bias2 net3 vdd pfet_06v0 L=1.0u W=10.0u nf=1 ad='int((nf+1)/2) * W/nf * 0.18u' as='int((nf+2)/2) * W/nf * 0.18u' pd='2*int((nf+1)/2) * (W/nf + 0.18u)'
+ ps='2*int((nf+2)/2) * (W/nf + 0.18u)' nrd='0.18u / W' nrs='0.18u / W' sa=0 sb=0 sd=0
XM6 bias3 bias3 vss vss nfet_06v0 L=1.0u W=1.0u nf=1 ad='int((nf+1)/2) * W/nf * 0.18u' as='int((nf+2)/2) * W/nf * 0.18u' pd='2*int((nf+1)/2) * (W/nf + 0.18u)'
+ ps='2*int((nf+2)/2) * (W/nf + 0.18u)' nrd='0.18u / W' nrs='0.18u / W' sa=0 sb=0 sd=0
XM7 net2 bias1 vdd vdd pfet_06v0 L=1.0u W=10.0u nf=1 ad='int((nf+1)/2) * W/nf * 0.18u' as='int((nf+2)/2) * W/nf * 0.18u' pd='2*int((nf+1)/2) * (W/nf + 0.18u)'
+ ps='2*int((nf+2)/2) * (W/nf + 0.18u)' nrd='0.18u / W' nrs='0.18u / W' sa=0 sb=0 sd=0
XM8 bias4 bias2 net2 vdd pfet_06v0 L=1.0u W=10.0u nf=1 ad='int((nf+1)/2) * W/nf * 0.18u' as='int((nf+2)/2) * W/nf * 0.18u' pd='2*int((nf+1)/2) * (W/nf + 0.18u)'
+ ps='2*int((nf+2)/2) * (W/nf + 0.18u)' nrd='0.18u / W' nrs='0.18u / W' sa=0 sb=0 sd=0
XM9 bias4 bias3 net1 vss nfet_06v0 L=1.0u W=5.0u nf=1 ad='int((nf+1)/2) * W/nf * 0.18u' as='int((nf+2)/2) * W/nf * 0.18u' pd='2*int((nf+1)/2) * (W/nf + 0.18u)'
+ ps='2*int((nf+2)/2) * (W/nf + 0.18u)' nrd='0.18u / W' nrs='0.18u / W' sa=0 sb=0 sd=0
XM10 net1 bias4 vss vss nfet_06v0 L=1.0u W=5.0u nf=1 ad='int((nf+1)/2) * W/nf * 0.18u' as='int((nf+2)/2) * W/nf * 0.18u' pd='2*int((nf+1)/2) * (W/nf + 0.18u)'
+ ps='2*int((nf+2)/2) * (W/nf + 0.18u)' nrd='0.18u / W' nrs='0.18u / W' sa=0 sb=0 sd=0
XM1 bias2 bias2 vdd vdd pfet_06v0 L=1.0u W=2u nf=1 ad='int((nf+1)/2) * W/nf * 0.18u' as='int((nf+2)/2) * W/nf * 0.18u' pd='2*int((nf+1)/2) * (W/nf + 0.18u)'
+ ps='2*int((nf+2)/2) * (W/nf + 0.18u)' nrd='0.18u / W' nrs='0.18u / W' sa=0 sb=0 sd=0
XM2 net4 bias1 vdd vdd pfet_06v0 L=1.0u W=10.0u nf=1 ad='int((nf+1)/2) * W/nf * 0.18u' as='int((nf+2)/2) * W/nf * 0.18u' pd='2*int((nf+1)/2) * (W/nf + 0.18u)'
+ ps='2*int((nf+2)/2) * (W/nf + 0.18u)' nrd='0.18u / W' nrs='0.18u / W' sa=0 sb=0 sd=0
XM3 bias1 bias2 net4 vdd pfet_06v0 L=1.0u W=10.0u nf=1 ad='int((nf+1)/2) * W/nf * 0.18u' as='int((nf+2)/2) * W/nf * 0.18u' pd='2*int((nf+1)/2) * (W/nf + 0.18u)'
+ ps='2*int((nf+2)/2) * (W/nf + 0.18u)' nrd='0.18u / W' nrs='0.18u / W' sa=0 sb=0 sd=0
XM47 net5 bias2 vss vss nfet_06v0 L=1.0u W=1.0u nf=1 ad='int((nf+1)/2) * W/nf * 0.18u' as='int((nf+2)/2) * W/nf * 0.18u' pd='2*int((nf+1)/2) * (W/nf + 0.18u)'
+ ps='2*int((nf+2)/2) * (W/nf + 0.18u)' nrd='0.18u / W' nrs='0.18u / W' sa=0 sb=0 sd=0
XM48 net6 bias2 vss vss nfet_06v0 L=1.0u W=1.0u nf=1 ad='int((nf+1)/2) * W/nf * 0.18u' as='int((nf+2)/2) * W/nf * 0.18u' pd='2*int((nf+1)/2) * (W/nf + 0.18u)'
+ ps='2*int((nf+2)/2) * (W/nf + 0.18u)' nrd='0.18u / W' nrs='0.18u / W' sa=0 sb=0 sd=0
XM49 bias2 bias2 net6 vss nfet_06v0 L=1.0u W=1.0u nf=1 ad='int((nf+1)/2) * W/nf * 0.18u' as='int((nf+2)/2) * W/nf * 0.18u' pd='2*int((nf+1)/2) * (W/nf + 0.18u)'
+ ps='2*int((nf+2)/2) * (W/nf + 0.18u)' nrd='0.18u / W' nrs='0.18u / W' sa=0 sb=0 sd=0
XM50 bias1 bias2 net5 vss nfet_06v0 L=1.0u W=1.0u nf=1 ad='int((nf+1)/2) * W/nf * 0.18u' as='int((nf+2)/2) * W/nf * 0.18u' pd='2*int((nf+1)/2) * (W/nf + 0.18u)'
+ ps='2*int((nf+2)/2) * (W/nf + 0.18u)' nrd='0.18u / W' nrs='0.18u / W' sa=0 sb=0 sd=0
.ends

* expanding   symbol:  a_zonetic2026/XSCHEM/OPAM/sub_diff.sym # of pins=9
** sym_path: /foss/designs/a_zonetic2026/XSCHEM/OPAM/sub_diff.sym
** sch_path: /foss/designs/a_zonetic2026/XSCHEM/OPAM/sub_diff.sch
.subckt sub_diff vdd bias1 bias2 vinn out vinp bias3 bias4 vss
*.opin out
*.iopin vdd
*.iopin vss
*.ipin vinp
*.ipin vinn
*.ipin bias1
*.ipin bias2
*.ipin bias3
*.ipin bias4
XM11 net2 bias1 vdd vdd pfet_06v0 L=1.0u W=10.0u nf=1 ad='int((nf+1)/2) * W/nf * 0.18u' as='int((nf+2)/2) * W/nf * 0.18u' pd='2*int((nf+1)/2) * (W/nf + 0.18u)'
+ ps='2*int((nf+2)/2) * (W/nf + 0.18u)' nrd='0.18u / W' nrs='0.18u / W' sa=0 sb=0 sd=0
XM12 net7 bias2 net2 vdd pfet_06v0 L=1.0u W=10.0u nf=1 ad='int((nf+1)/2) * W/nf * 0.18u' as='int((nf+2)/2) * W/nf * 0.18u' pd='2*int((nf+1)/2) * (W/nf + 0.18u)'
+ ps='2*int((nf+2)/2) * (W/nf + 0.18u)' nrd='0.18u / W' nrs='0.18u / W' sa=0 sb=0 sd=0
XM13 net19 bias1 vdd vdd pfet_06v0 L=1.0u W=10.0u nf=1 ad='int((nf+1)/2) * W/nf * 0.18u' as='int((nf+2)/2) * W/nf * 0.18u' pd='2*int((nf+1)/2) * (W/nf + 0.18u)'
+ ps='2*int((nf+2)/2) * (W/nf + 0.18u)' nrd='0.18u / W' nrs='0.18u / W' sa=0 sb=0 sd=0
XM14 net7 bias2 net19 vdd pfet_06v0 L=1.0u W=10.0u nf=1 ad='int((nf+1)/2) * W/nf * 0.18u' as='int((nf+2)/2) * W/nf * 0.18u' pd='2*int((nf+1)/2) * (W/nf + 0.18u)'
+ ps='2*int((nf+2)/2) * (W/nf + 0.18u)' nrd='0.18u / W' nrs='0.18u / W' sa=0 sb=0 sd=0
XM15 net5 vinp net7 vdd pfet_06v0 L=1.0u W=10.0u nf=1 ad='int((nf+1)/2) * W/nf * 0.18u' as='int((nf+2)/2) * W/nf * 0.18u' pd='2*int((nf+1)/2) * (W/nf + 0.18u)'
+ ps='2*int((nf+2)/2) * (W/nf + 0.18u)' nrd='0.18u / W' nrs='0.18u / W' sa=0 sb=0 sd=0 m=2
XM16 net4 vinn net7 vdd pfet_06v0 L=1.0u W=10.0u nf=1 ad='int((nf+1)/2) * W/nf * 0.18u' as='int((nf+2)/2) * W/nf * 0.18u' pd='2*int((nf+1)/2) * (W/nf + 0.18u)'
+ ps='2*int((nf+2)/2) * (W/nf + 0.18u)' nrd='0.18u / W' nrs='0.18u / W' sa=0 sb=0 sd=0 m=2
XM17 net8 bias3 net1 vss nfet_06v0 L=1.0u W=5.0u nf=1 ad='int((nf+1)/2) * W/nf * 0.18u' as='int((nf+2)/2) * W/nf * 0.18u' pd='2*int((nf+1)/2) * (W/nf + 0.18u)'
+ ps='2*int((nf+2)/2) * (W/nf + 0.18u)' nrd='0.18u / W' nrs='0.18u / W' sa=0 sb=0 sd=0
XM18 net1 bias4 vss vss nfet_06v0 L=1.0u W=5.0u nf=1 ad='int((nf+1)/2) * W/nf * 0.18u' as='int((nf+2)/2) * W/nf * 0.18u' pd='2*int((nf+1)/2) * (W/nf + 0.18u)'
+ ps='2*int((nf+2)/2) * (W/nf + 0.18u)' nrd='0.18u / W' nrs='0.18u / W' sa=0 sb=0 sd=0
XM19 net8 bias3 net20 vss nfet_06v0 L=1.0u W=5.0u nf=1 ad='int((nf+1)/2) * W/nf * 0.18u' as='int((nf+2)/2) * W/nf * 0.18u' pd='2*int((nf+1)/2) * (W/nf + 0.18u)'
+ ps='2*int((nf+2)/2) * (W/nf + 0.18u)' nrd='0.18u / W' nrs='0.18u / W' sa=0 sb=0 sd=0
XM20 net20 bias4 vss vss nfet_06v0 L=1.0u W=5.0u nf=1 ad='int((nf+1)/2) * W/nf * 0.18u' as='int((nf+2)/2) * W/nf * 0.18u' pd='2*int((nf+1)/2) * (W/nf + 0.18u)'
+ ps='2*int((nf+2)/2) * (W/nf + 0.18u)' nrd='0.18u / W' nrs='0.18u / W' sa=0 sb=0 sd=0
XM21 net6 vinp net8 vss nfet_06v0 L=1.0u W=5u nf=1 ad='int((nf+1)/2) * W/nf * 0.18u' as='int((nf+2)/2) * W/nf * 0.18u' pd='2*int((nf+1)/2) * (W/nf + 0.18u)'
+ ps='2*int((nf+2)/2) * (W/nf + 0.18u)' nrd='0.18u / W' nrs='0.18u / W' sa=0 sb=0 sd=0 m=2
XM22 net3 vinn net8 vss nfet_06v0 L=1.0u W=5u nf=1 ad='int((nf+1)/2) * W/nf * 0.18u' as='int((nf+2)/2) * W/nf * 0.18u' pd='2*int((nf+1)/2) * (W/nf + 0.18u)'
+ ps='2*int((nf+2)/2) * (W/nf + 0.18u)' nrd='0.18u / W' nrs='0.18u / W' sa=0 sb=0 sd=0 m=2
XM29 net9 bias2 net3 vdd pfet_06v0 L=1.0u W=5u nf=1 ad='int((nf+1)/2) * W/nf * 0.18u' as='int((nf+2)/2) * W/nf * 0.18u' pd='2*int((nf+1)/2) * (W/nf + 0.18u)'
+ ps='2*int((nf+2)/2) * (W/nf + 0.18u)' nrd='0.18u / W' nrs='0.18u / W' sa=0 sb=0 sd=0 m=2
XM30 net12 bias2 net6 vdd pfet_06v0 L=1.0u W=5.0u nf=1 ad='int((nf+1)/2) * W/nf * 0.18u' as='int((nf+2)/2) * W/nf * 0.18u' pd='2*int((nf+1)/2) * (W/nf + 0.18u)'
+ ps='2*int((nf+2)/2) * (W/nf + 0.18u)' nrd='0.18u / W' nrs='0.18u / W' sa=0 sb=0 sd=0 m=2
XM31 net3 net9 vdd vdd pfet_06v0 L=1.0u W=5u nf=1 ad='int((nf+1)/2) * W/nf * 0.18u' as='int((nf+2)/2) * W/nf * 0.18u' pd='2*int((nf+1)/2) * (W/nf + 0.18u)'
+ ps='2*int((nf+2)/2) * (W/nf + 0.18u)' nrd='0.18u / W' nrs='0.18u / W' sa=0 sb=0 sd=0 m=4
XM35 net6 net9 vdd vdd pfet_06v0 L=1.0u W=5.0u nf=1 ad='int((nf+1)/2) * W/nf * 0.18u' as='int((nf+2)/2) * W/nf * 0.18u' pd='2*int((nf+1)/2) * (W/nf + 0.18u)'
+ ps='2*int((nf+2)/2) * (W/nf + 0.18u)' nrd='0.18u / W' nrs='0.18u / W' sa=0 sb=0 sd=0 m=4
XM32 net10 net21 net9 vdd pfet_06v0 L=1.0u W=5u nf=1 ad='int((nf+1)/2) * W/nf * 0.18u' as='int((nf+2)/2) * W/nf * 0.18u' pd='2*int((nf+1)/2) * (W/nf + 0.18u)'
+ ps='2*int((nf+2)/2) * (W/nf + 0.18u)' nrd='0.18u / W' nrs='0.18u / W' sa=0 sb=0 sd=0
XM33 net22 net21 net12 vdd pfet_06v0 L=1.0u W=5.0u nf=1 ad='int((nf+1)/2) * W/nf * 0.18u' as='int((nf+2)/2) * W/nf * 0.18u' pd='2*int((nf+1)/2) * (W/nf + 0.18u)'
+ ps='2*int((nf+2)/2) * (W/nf + 0.18u)' nrd='0.18u / W' nrs='0.18u / W' sa=0 sb=0 sd=0
XM23 net10 bias3 net4 vss nfet_06v0 L=1.0u W=2.5u nf=1 ad='int((nf+1)/2) * W/nf * 0.18u' as='int((nf+2)/2) * W/nf * 0.18u' pd='2*int((nf+1)/2) * (W/nf + 0.18u)'
+ ps='2*int((nf+2)/2) * (W/nf + 0.18u)' nrd='0.18u / W' nrs='0.18u / W' sa=0 sb=0 sd=0 m=2
XM24 net22 bias3 net5 vss nfet_06v0 L=1.0u W=2.5u nf=1 ad='int((nf+1)/2) * W/nf * 0.18u' as='int((nf+2)/2) * W/nf * 0.18u' pd='2*int((nf+1)/2) * (W/nf + 0.18u)'
+ ps='2*int((nf+2)/2) * (W/nf + 0.18u)' nrd='0.18u / W' nrs='0.18u / W' sa=0 sb=0 sd=0 m=2
XM25 net4 net10 vss vss nfet_06v0 L=1.0u W=2.5u nf=1 ad='int((nf+1)/2) * W/nf * 0.18u' as='int((nf+2)/2) * W/nf * 0.18u' pd='2*int((nf+1)/2) * (W/nf + 0.18u)'
+ ps='2*int((nf+2)/2) * (W/nf + 0.18u)' nrd='0.18u / W' nrs='0.18u / W' sa=0 sb=0 sd=0 m=4
XM26 net5 net10 vss vss nfet_06v0 L=1.0u W=2.5u nf=1 ad='int((nf+1)/2) * W/nf * 0.18u' as='int((nf+2)/2) * W/nf * 0.18u' pd='2*int((nf+1)/2) * (W/nf + 0.18u)'
+ ps='2*int((nf+2)/2) * (W/nf + 0.18u)' nrd='0.18u / W' nrs='0.18u / W' sa=0 sb=0 sd=0 m=4
XM27 net9 net11 net10 vss nfet_06v0 L=1.0u W=2.5u nf=1 ad='int((nf+1)/2) * W/nf * 0.18u' as='int((nf+2)/2) * W/nf * 0.18u' pd='2*int((nf+1)/2) * (W/nf + 0.18u)'
+ ps='2*int((nf+2)/2) * (W/nf + 0.18u)' nrd='0.18u / W' nrs='0.18u / W' sa=0 sb=0 sd=0
XM28 net12 net11 net22 vss nfet_06v0 L=1.0u W=2.5u nf=1 ad='int((nf+1)/2) * W/nf * 0.18u' as='int((nf+2)/2) * W/nf * 0.18u' pd='2*int((nf+1)/2) * (W/nf + 0.18u)'
+ ps='2*int((nf+2)/2) * (W/nf + 0.18u)' nrd='0.18u / W' nrs='0.18u / W' sa=0 sb=0 sd=0
XM34 net13 net14 vdd vdd pfet_06v0 L=1.0u W=10.0u nf=1 ad='int((nf+1)/2) * W/nf * 0.18u' as='int((nf+2)/2) * W/nf * 0.18u' pd='2*int((nf+1)/2) * (W/nf + 0.18u)'
+ ps='2*int((nf+2)/2) * (W/nf + 0.18u)' nrd='0.18u / W' nrs='0.18u / W' sa=0 sb=0 sd=0
XM36 net14 bias2 net13 vdd pfet_06v0 L=1.0u W=10.0u nf=1 ad='int((nf+1)/2) * W/nf * 0.18u' as='int((nf+2)/2) * W/nf * 0.18u' pd='2*int((nf+1)/2) * (W/nf + 0.18u)'
+ ps='2*int((nf+2)/2) * (W/nf + 0.18u)' nrd='0.18u / W' nrs='0.18u / W' sa=0 sb=0 sd=0
XM37 net21 net21 net14 vdd pfet_06v0 L=1.0u W=10.0u nf=1 ad='int((nf+1)/2) * W/nf * 0.18u' as='int((nf+2)/2) * W/nf * 0.18u' pd='2*int((nf+1)/2) * (W/nf + 0.18u)'
+ ps='2*int((nf+2)/2) * (W/nf + 0.18u)' nrd='0.18u / W' nrs='0.18u / W' sa=0 sb=0 sd=0
XM38 net21 bias3 net15 vss nfet_06v0 L=1.0u W=5.0u nf=1 ad='int((nf+1)/2) * W/nf * 0.18u' as='int((nf+2)/2) * W/nf * 0.18u' pd='2*int((nf+1)/2) * (W/nf + 0.18u)'
+ ps='2*int((nf+2)/2) * (W/nf + 0.18u)' nrd='0.18u / W' nrs='0.18u / W' sa=0 sb=0 sd=0
XM39 net15 bias4 vss vss nfet_06v0 L=1.0u W=5.0u nf=1 ad='int((nf+1)/2) * W/nf * 0.18u' as='int((nf+2)/2) * W/nf * 0.18u' pd='2*int((nf+1)/2) * (W/nf + 0.18u)'
+ ps='2*int((nf+2)/2) * (W/nf + 0.18u)' nrd='0.18u / W' nrs='0.18u / W' sa=0 sb=0 sd=0
XM45 net16 bias1 vdd vdd pfet_06v0 L=1.0u W=10.0u nf=1 ad='int((nf+1)/2) * W/nf * 0.18u' as='int((nf+2)/2) * W/nf * 0.18u' pd='2*int((nf+1)/2) * (W/nf + 0.18u)'
+ ps='2*int((nf+2)/2) * (W/nf + 0.18u)' nrd='0.18u / W' nrs='0.18u / W' sa=0 sb=0 sd=0
XM46 net11 bias2 net16 vdd pfet_06v0 L=1.0u W=10.0u nf=1 ad='int((nf+1)/2) * W/nf * 0.18u' as='int((nf+2)/2) * W/nf * 0.18u' pd='2*int((nf+1)/2) * (W/nf + 0.18u)'
+ ps='2*int((nf+2)/2) * (W/nf + 0.18u)' nrd='0.18u / W' nrs='0.18u / W' sa=0 sb=0 sd=0
XM40 net11 net11 net18 vss nfet_06v0 L=1.0u W=5.0u nf=1 ad='int((nf+1)/2) * W/nf * 0.18u' as='int((nf+2)/2) * W/nf * 0.18u' pd='2*int((nf+1)/2) * (W/nf + 0.18u)'
+ ps='2*int((nf+2)/2) * (W/nf + 0.18u)' nrd='0.18u / W' nrs='0.18u / W' sa=0 sb=0 sd=0
XM41 net18 bias3 net17 vss nfet_06v0 L=1.0u W=5.0u nf=1 ad='int((nf+1)/2) * W/nf * 0.18u' as='int((nf+2)/2) * W/nf * 0.18u' pd='2*int((nf+1)/2) * (W/nf + 0.18u)'
+ ps='2*int((nf+2)/2) * (W/nf + 0.18u)' nrd='0.18u / W' nrs='0.18u / W' sa=0 sb=0 sd=0
XM42 net17 net18 vss vss nfet_06v0 L=1.0u W=5.0u nf=1 ad='int((nf+1)/2) * W/nf * 0.18u' as='int((nf+2)/2) * W/nf * 0.18u' pd='2*int((nf+1)/2) * (W/nf + 0.18u)'
+ ps='2*int((nf+2)/2) * (W/nf + 0.18u)' nrd='0.18u / W' nrs='0.18u / W' sa=0 sb=0 sd=0
XM43 out net12 vdd vdd pfet_06v0 L=1.0u W=10u nf=1 ad='int((nf+1)/2) * W/nf * 0.18u' as='int((nf+2)/2) * W/nf * 0.18u' pd='2*int((nf+1)/2) * (W/nf + 0.18u)'
+ ps='2*int((nf+2)/2) * (W/nf + 0.18u)' nrd='0.18u / W' nrs='0.18u / W' sa=0 sb=0 sd=0 m=3
XM44 out net22 vss vss nfet_06v0 L=1.0u W=5u nf=1 ad='int((nf+1)/2) * W/nf * 0.18u' as='int((nf+2)/2) * W/nf * 0.18u' pd='2*int((nf+1)/2) * (W/nf + 0.18u)'
+ ps='2*int((nf+2)/2) * (W/nf + 0.18u)' nrd='0.18u / W' nrs='0.18u / W' sa=0 sb=0 sd=0 m=3
XC2 out net5 cap_mim_2f0fF c_width=20e-6 c_length=10e-6
XC3 net6 out cap_mim_2f0fF c_width=20e-6 c_length=10e-6
.ends

* expanding   symbol:  a_zonetic2026/XSCHEM/DECODER/yGates.sym # of pins=5
** sym_path: /foss/designs/a_zonetic2026/XSCHEM/DECODER/yGates.sym
** sch_path: /foss/designs/a_zonetic2026/XSCHEM/DECODER/yGates.sch
.subckt yGates YZ XY VDD output VSS
*.ipin VDD
*.ipin VSS
*.ipin YZ
*.ipin XY
*.opin output
x2 VDD net1 XY VSS invertor
x3 YZ VDD net1 output VSS andGate
.ends

* expanding   symbol:  a_zonetic2026/XSCHEM/DECODER/Z.sym # of pins=5
** sym_path: /foss/designs/a_zonetic2026/XSCHEM/DECODER/Z.sym
** sch_path: /foss/designs/a_zonetic2026/XSCHEM/DECODER/Z.sch
.subckt Z VSS VDD XZ YZ out
*.iopin VSS
*.iopin VDD
*.ipin XZ
*.ipin YZ
*.opin out
XM4 net1 YZ out VDD pfet_06v0 L=1.0u W=3.0u nf=1 ad='int((nf+1)/2) * W/nf * 0.18u' as='int((nf+2)/2) * W/nf * 0.18u' pd='2*int((nf+1)/2) * (W/nf + 0.18u)'
+ ps='2*int((nf+2)/2) * (W/nf + 0.18u)' nrd='0.18u / W' nrs='0.18u / W' sa=0 sb=0 sd=0
XM5 VDD XZ net1 VDD pfet_06v0 L=1.0u W=3.0u nf=1 ad='int((nf+1)/2) * W/nf * 0.18u' as='int((nf+2)/2) * W/nf * 0.18u' pd='2*int((nf+1)/2) * (W/nf + 0.18u)'
+ ps='2*int((nf+2)/2) * (W/nf + 0.18u)' nrd='0.18u / W' nrs='0.18u / W' sa=0 sb=0 sd=0
XM7 VSS YZ out VSS nfet_06v0 L=1u W=1u nf=1 ad='int((nf+1)/2) * W/nf * 0.18u' as='int((nf+2)/2) * W/nf * 0.18u' pd='2*int((nf+1)/2) * (W/nf + 0.18u)'
+ ps='2*int((nf+2)/2) * (W/nf + 0.18u)' nrd='0.18u / W' nrs='0.18u / W' sa=0 sb=0 sd=0
XM1 VSS XZ out VSS nfet_06v0 L=1u W=1u nf=1 ad='int((nf+1)/2) * W/nf * 0.18u' as='int((nf+2)/2) * W/nf * 0.18u' pd='2*int((nf+1)/2) * (W/nf + 0.18u)'
+ ps='2*int((nf+2)/2) * (W/nf + 0.18u)' nrd='0.18u / W' nrs='0.18u / W' sa=0 sb=0 sd=0
.ends

* expanding   symbol:  a_zonetic2026/XSCHEM/DECODER/xGates.sym # of pins=5
** sym_path: /foss/designs/a_zonetic2026/XSCHEM/DECODER/xGates.sym
** sch_path: /foss/designs/a_zonetic2026/XSCHEM/DECODER/xGates.sch
.subckt xGates VDD XY output XZ VSS
*.ipin XY
*.opin output
*.ipin VDD
*.ipin VSS
*.ipin XZ
x2 XY VDD XZ output VSS andGate
.ends

* expanding   symbol:  a_zonetic2026/XSCHEM/OPAM/sub_diff_2_LIN.sym # of pins=9
** sym_path: /foss/designs/a_zonetic2026/XSCHEM/OPAM/sub_diff_2_LIN.sym
** sch_path: /foss/designs/a_zonetic2026/XSCHEM/OPAM/sub_diff_2_LIN.sch
.subckt sub_diff_2_LIN VDD bias1 bias2 OUT INN INP bias3 bias4 VSS
*.ipin INN
*.ipin INP
*.iopin VDD
*.iopin VSS
*.iopin OUT
*.ipin bias1
*.ipin bias2
*.ipin bias3
*.ipin bias4
XM11 net2 bias1 VDD VDD pfet_06v0 L=1.0u W=10.0u nf=1 ad='int((nf+1)/2) * W/nf * 0.18u' as='int((nf+2)/2) * W/nf * 0.18u' pd='2*int((nf+1)/2) * (W/nf + 0.18u)'
+ ps='2*int((nf+2)/2) * (W/nf + 0.18u)' nrd='0.18u / W' nrs='0.18u / W' sa=0 sb=0 sd=0
XM12 net7 bias2 net2 VDD pfet_06v0 L=1.0u W=10.0u nf=1 ad='int((nf+1)/2) * W/nf * 0.18u' as='int((nf+2)/2) * W/nf * 0.18u' pd='2*int((nf+1)/2) * (W/nf + 0.18u)'
+ ps='2*int((nf+2)/2) * (W/nf + 0.18u)' nrd='0.18u / W' nrs='0.18u / W' sa=0 sb=0 sd=0
XM13 net18 bias1 VDD VDD pfet_06v0 L=1.0u W=10.0u nf=1 ad='int((nf+1)/2) * W/nf * 0.18u' as='int((nf+2)/2) * W/nf * 0.18u' pd='2*int((nf+1)/2) * (W/nf + 0.18u)'
+ ps='2*int((nf+2)/2) * (W/nf + 0.18u)' nrd='0.18u / W' nrs='0.18u / W' sa=0 sb=0 sd=0
XM14 net7 bias2 net18 VDD pfet_06v0 L=1.0u W=10.0u nf=1 ad='int((nf+1)/2) * W/nf * 0.18u' as='int((nf+2)/2) * W/nf * 0.18u' pd='2*int((nf+1)/2) * (W/nf + 0.18u)'
+ ps='2*int((nf+2)/2) * (W/nf + 0.18u)' nrd='0.18u / W' nrs='0.18u / W' sa=0 sb=0 sd=0
XM15 net5 INP net7 VDD pfet_06v0 L=1.0u W=1.1u nf=1 ad='int((nf+1)/2) * W/nf * 0.18u' as='int((nf+2)/2) * W/nf * 0.18u' pd='2*int((nf+1)/2) * (W/nf + 0.18u)'
+ ps='2*int((nf+2)/2) * (W/nf + 0.18u)' nrd='0.18u / W' nrs='0.18u / W' sa=0 sb=0 sd=0
XM16 net4 INN net7 VDD pfet_06v0 L=1.0u W=1.0u nf=1 ad='int((nf+1)/2) * W/nf * 0.18u' as='int((nf+2)/2) * W/nf * 0.18u' pd='2*int((nf+1)/2) * (W/nf + 0.18u)'
+ ps='2*int((nf+2)/2) * (W/nf + 0.18u)' nrd='0.18u / W' nrs='0.18u / W' sa=0 sb=0 sd=0
XM17 net8 bias3 net1 VSS nfet_06v0 L=1.0u W=5.0u nf=1 ad='int((nf+1)/2) * W/nf * 0.18u' as='int((nf+2)/2) * W/nf * 0.18u' pd='2*int((nf+1)/2) * (W/nf + 0.18u)'
+ ps='2*int((nf+2)/2) * (W/nf + 0.18u)' nrd='0.18u / W' nrs='0.18u / W' sa=0 sb=0 sd=0
XM18 net1 bias4 VSS VSS nfet_06v0 L=1.0u W=5.0u nf=1 ad='int((nf+1)/2) * W/nf * 0.18u' as='int((nf+2)/2) * W/nf * 0.18u' pd='2*int((nf+1)/2) * (W/nf + 0.18u)'
+ ps='2*int((nf+2)/2) * (W/nf + 0.18u)' nrd='0.18u / W' nrs='0.18u / W' sa=0 sb=0 sd=0
XM19 net8 bias3 net19 VSS nfet_06v0 L=1.0u W=5.0u nf=1 ad='int((nf+1)/2) * W/nf * 0.18u' as='int((nf+2)/2) * W/nf * 0.18u' pd='2*int((nf+1)/2) * (W/nf + 0.18u)'
+ ps='2*int((nf+2)/2) * (W/nf + 0.18u)' nrd='0.18u / W' nrs='0.18u / W' sa=0 sb=0 sd=0
XM20 net19 bias4 VSS VSS nfet_06v0 L=1.0u W=5.0u nf=1 ad='int((nf+1)/2) * W/nf * 0.18u' as='int((nf+2)/2) * W/nf * 0.18u' pd='2*int((nf+1)/2) * (W/nf + 0.18u)'
+ ps='2*int((nf+2)/2) * (W/nf + 0.18u)' nrd='0.18u / W' nrs='0.18u / W' sa=0 sb=0 sd=0
XM21 net6 INP net8 VSS nfet_06v0 L=1.0u W=1u nf=1 ad='int((nf+1)/2) * W/nf * 0.18u' as='int((nf+2)/2) * W/nf * 0.18u' pd='2*int((nf+1)/2) * (W/nf + 0.18u)'
+ ps='2*int((nf+2)/2) * (W/nf + 0.18u)' nrd='0.18u / W' nrs='0.18u / W' sa=0 sb=0 sd=0
XM22 net3 INN net8 VSS nfet_06v0 L=1.0u W=1u nf=1 ad='int((nf+1)/2) * W/nf * 0.18u' as='int((nf+2)/2) * W/nf * 0.18u' pd='2*int((nf+1)/2) * (W/nf + 0.18u)'
+ ps='2*int((nf+2)/2) * (W/nf + 0.18u)' nrd='0.18u / W' nrs='0.18u / W' sa=0 sb=0 sd=0
XM29 net9 bias2 net3 VDD pfet_06v0 L=1.0u W=5u nf=1 ad='int((nf+1)/2) * W/nf * 0.18u' as='int((nf+2)/2) * W/nf * 0.18u' pd='2*int((nf+1)/2) * (W/nf + 0.18u)'
+ ps='2*int((nf+2)/2) * (W/nf + 0.18u)' nrd='0.18u / W' nrs='0.18u / W' sa=0 sb=0 sd=0
XM30 G_OUT_P bias2 net6 VDD pfet_06v0 L=1.0u W=5u nf=1 ad='int((nf+1)/2) * W/nf * 0.18u' as='int((nf+2)/2) * W/nf * 0.18u' pd='2*int((nf+1)/2) * (W/nf + 0.18u)'
+ ps='2*int((nf+2)/2) * (W/nf + 0.18u)' nrd='0.18u / W' nrs='0.18u / W' sa=0 sb=0 sd=0
XM31 net3 net9 VDD VDD pfet_06v0 L=1.0u W=5u nf=1 ad='int((nf+1)/2) * W/nf * 0.18u' as='int((nf+2)/2) * W/nf * 0.18u' pd='2*int((nf+1)/2) * (W/nf + 0.18u)'
+ ps='2*int((nf+2)/2) * (W/nf + 0.18u)' nrd='0.18u / W' nrs='0.18u / W' sa=0 sb=0 sd=0
XM35 net6 net9 VDD VDD pfet_06v0 L=1.0u W=5u nf=1 ad='int((nf+1)/2) * W/nf * 0.18u' as='int((nf+2)/2) * W/nf * 0.18u' pd='2*int((nf+1)/2) * (W/nf + 0.18u)'
+ ps='2*int((nf+2)/2) * (W/nf + 0.18u)' nrd='0.18u / W' nrs='0.18u / W' sa=0 sb=0 sd=0
XM32 net10 net20 net9 VDD pfet_06v0 L=1.0u W=5.0u nf=1 ad='int((nf+1)/2) * W/nf * 0.18u' as='int((nf+2)/2) * W/nf * 0.18u' pd='2*int((nf+1)/2) * (W/nf + 0.18u)'
+ ps='2*int((nf+2)/2) * (W/nf + 0.18u)' nrd='0.18u / W' nrs='0.18u / W' sa=0 sb=0 sd=0
XM33 net21 net20 G_OUT_P VDD pfet_06v0 L=1.0u W=5.0u nf=1 ad='int((nf+1)/2) * W/nf * 0.18u' as='int((nf+2)/2) * W/nf * 0.18u' pd='2*int((nf+1)/2) * (W/nf + 0.18u)'
+ ps='2*int((nf+2)/2) * (W/nf + 0.18u)' nrd='0.18u / W' nrs='0.18u / W' sa=0 sb=0 sd=0
XM23 net10 bias3 net4 VSS nfet_06v0 L=1.0u W=2.5u nf=1 ad='int((nf+1)/2) * W/nf * 0.18u' as='int((nf+2)/2) * W/nf * 0.18u' pd='2*int((nf+1)/2) * (W/nf + 0.18u)'
+ ps='2*int((nf+2)/2) * (W/nf + 0.18u)' nrd='0.18u / W' nrs='0.18u / W' sa=0 sb=0 sd=0
XM24 net21 bias3 net5 VSS nfet_06v0 L=1.0u W=2.5u nf=1 ad='int((nf+1)/2) * W/nf * 0.18u' as='int((nf+2)/2) * W/nf * 0.18u' pd='2*int((nf+1)/2) * (W/nf + 0.18u)'
+ ps='2*int((nf+2)/2) * (W/nf + 0.18u)' nrd='0.18u / W' nrs='0.18u / W' sa=0 sb=0 sd=0
XM25 net4 net10 VSS VSS nfet_06v0 L=1.0u W=2.5u nf=1 ad='int((nf+1)/2) * W/nf * 0.18u' as='int((nf+2)/2) * W/nf * 0.18u' pd='2*int((nf+1)/2) * (W/nf + 0.18u)'
+ ps='2*int((nf+2)/2) * (W/nf + 0.18u)' nrd='0.18u / W' nrs='0.18u / W' sa=0 sb=0 sd=0
XM26 net5 net10 VSS VSS nfet_06v0 L=1.0u W=2.5u nf=1 ad='int((nf+1)/2) * W/nf * 0.18u' as='int((nf+2)/2) * W/nf * 0.18u' pd='2*int((nf+1)/2) * (W/nf + 0.18u)'
+ ps='2*int((nf+2)/2) * (W/nf + 0.18u)' nrd='0.18u / W' nrs='0.18u / W' sa=0 sb=0 sd=0
XM27 net9 net11 net10 VSS nfet_06v0 L=1.0u W=2.5u nf=1 ad='int((nf+1)/2) * W/nf * 0.18u' as='int((nf+2)/2) * W/nf * 0.18u' pd='2*int((nf+1)/2) * (W/nf + 0.18u)'
+ ps='2*int((nf+2)/2) * (W/nf + 0.18u)' nrd='0.18u / W' nrs='0.18u / W' sa=0 sb=0 sd=0
XM28 G_OUT_P net11 net21 VSS nfet_06v0 L=1.0u W=2.5u nf=1 ad='int((nf+1)/2) * W/nf * 0.18u' as='int((nf+2)/2) * W/nf * 0.18u' pd='2*int((nf+1)/2) * (W/nf + 0.18u)'
+ ps='2*int((nf+2)/2) * (W/nf + 0.18u)' nrd='0.18u / W' nrs='0.18u / W' sa=0 sb=0 sd=0
XM34 net12 net13 VDD VDD pfet_06v0 L=1.0u W=10.0u nf=1 ad='int((nf+1)/2) * W/nf * 0.18u' as='int((nf+2)/2) * W/nf * 0.18u' pd='2*int((nf+1)/2) * (W/nf + 0.18u)'
+ ps='2*int((nf+2)/2) * (W/nf + 0.18u)' nrd='0.18u / W' nrs='0.18u / W' sa=0 sb=0 sd=0
XM36 net13 bias2 net12 VDD pfet_06v0 L=1.0u W=10.0u nf=1 ad='int((nf+1)/2) * W/nf * 0.18u' as='int((nf+2)/2) * W/nf * 0.18u' pd='2*int((nf+1)/2) * (W/nf + 0.18u)'
+ ps='2*int((nf+2)/2) * (W/nf + 0.18u)' nrd='0.18u / W' nrs='0.18u / W' sa=0 sb=0 sd=0
XM37 net20 net20 net13 VDD pfet_06v0 L=1.0u W=10.0u nf=1 ad='int((nf+1)/2) * W/nf * 0.18u' as='int((nf+2)/2) * W/nf * 0.18u' pd='2*int((nf+1)/2) * (W/nf + 0.18u)'
+ ps='2*int((nf+2)/2) * (W/nf + 0.18u)' nrd='0.18u / W' nrs='0.18u / W' sa=0 sb=0 sd=0
XM38 net20 bias3 net14 VSS nfet_06v0 L=1.0u W=5.0u nf=1 ad='int((nf+1)/2) * W/nf * 0.18u' as='int((nf+2)/2) * W/nf * 0.18u' pd='2*int((nf+1)/2) * (W/nf + 0.18u)'
+ ps='2*int((nf+2)/2) * (W/nf + 0.18u)' nrd='0.18u / W' nrs='0.18u / W' sa=0 sb=0 sd=0
XM39 net14 bias4 VSS VSS nfet_06v0 L=1.0u W=5.0u nf=1 ad='int((nf+1)/2) * W/nf * 0.18u' as='int((nf+2)/2) * W/nf * 0.18u' pd='2*int((nf+1)/2) * (W/nf + 0.18u)'
+ ps='2*int((nf+2)/2) * (W/nf + 0.18u)' nrd='0.18u / W' nrs='0.18u / W' sa=0 sb=0 sd=0
XM45 net15 bias1 VDD VDD pfet_06v0 L=1.0u W=10.0u nf=1 ad='int((nf+1)/2) * W/nf * 0.18u' as='int((nf+2)/2) * W/nf * 0.18u' pd='2*int((nf+1)/2) * (W/nf + 0.18u)'
+ ps='2*int((nf+2)/2) * (W/nf + 0.18u)' nrd='0.18u / W' nrs='0.18u / W' sa=0 sb=0 sd=0
XM46 net11 bias2 net15 VDD pfet_06v0 L=1.0u W=10.0u nf=1 ad='int((nf+1)/2) * W/nf * 0.18u' as='int((nf+2)/2) * W/nf * 0.18u' pd='2*int((nf+1)/2) * (W/nf + 0.18u)'
+ ps='2*int((nf+2)/2) * (W/nf + 0.18u)' nrd='0.18u / W' nrs='0.18u / W' sa=0 sb=0 sd=0
XM40 net11 net11 net17 VSS nfet_06v0 L=1.0u W=5.0u nf=1 ad='int((nf+1)/2) * W/nf * 0.18u' as='int((nf+2)/2) * W/nf * 0.18u' pd='2*int((nf+1)/2) * (W/nf + 0.18u)'
+ ps='2*int((nf+2)/2) * (W/nf + 0.18u)' nrd='0.18u / W' nrs='0.18u / W' sa=0 sb=0 sd=0
XM41 net17 bias3 net16 VSS nfet_06v0 L=1.0u W=5.0u nf=1 ad='int((nf+1)/2) * W/nf * 0.18u' as='int((nf+2)/2) * W/nf * 0.18u' pd='2*int((nf+1)/2) * (W/nf + 0.18u)'
+ ps='2*int((nf+2)/2) * (W/nf + 0.18u)' nrd='0.18u / W' nrs='0.18u / W' sa=0 sb=0 sd=0
XM42 net16 net17 VSS VSS nfet_06v0 L=1.0u W=5.0u nf=1 ad='int((nf+1)/2) * W/nf * 0.18u' as='int((nf+2)/2) * W/nf * 0.18u' pd='2*int((nf+1)/2) * (W/nf + 0.18u)'
+ ps='2*int((nf+2)/2) * (W/nf + 0.18u)' nrd='0.18u / W' nrs='0.18u / W' sa=0 sb=0 sd=0
XM43 OUT G_OUT_P VDD VDD pfet_06v0 L=1.0u W=0.5u nf=1 ad='int((nf+1)/2) * W/nf * 0.18u' as='int((nf+2)/2) * W/nf * 0.18u' pd='2*int((nf+1)/2) * (W/nf + 0.18u)'
+ ps='2*int((nf+2)/2) * (W/nf + 0.18u)' nrd='0.18u / W' nrs='0.18u / W' sa=0 sb=0 sd=0 m=4
XM44 OUT net21 VSS VSS nfet_06v0 L=1.0u W=1.0u nf=1 ad='int((nf+1)/2) * W/nf * 0.18u' as='int((nf+2)/2) * W/nf * 0.18u' pd='2*int((nf+1)/2) * (W/nf + 0.18u)'
+ ps='2*int((nf+2)/2) * (W/nf + 0.18u)' nrd='0.18u / W' nrs='0.18u / W' sa=0 sb=0 sd=0
XC3 net6 OUT cap_mim_2f0fF c_width=4e-6 c_length=25e-6
XC1 OUT net5 cap_mim_2f0fF c_width=4e-6 c_length=25e-6
XRFB G_OUT_P OUT VSS ppolyf_u_3k r_width=1e-6 r_length=76.45e-6 m=1 s=5
.ends

* expanding   symbol:  a_zonetic2026/XSCHEM/DECODER/invertor.sym # of pins=4
** sym_path: /foss/designs/a_zonetic2026/XSCHEM/DECODER/invertor.sym
** sch_path: /foss/designs/a_zonetic2026/XSCHEM/DECODER/invertor.sch
.subckt invertor VDD output In VSS
*.opin output
*.ipin In
*.ipin VDD
*.ipin VSS
XM4 output In VDD VDD pfet_06v0 L=1.0u W=3.0u nf=1 ad='int((nf+1)/2) * W/nf * 0.18u' as='int((nf+2)/2) * W/nf * 0.18u' pd='2*int((nf+1)/2) * (W/nf + 0.18u)'
+ ps='2*int((nf+2)/2) * (W/nf + 0.18u)' nrd='0.18u / W' nrs='0.18u / W' sa=0 sb=0 sd=0
XM5 VSS In output VSS nfet_06v0 L=1u W=1u nf=1 ad='int((nf+1)/2) * W/nf * 0.18u' as='int((nf+2)/2) * W/nf * 0.18u' pd='2*int((nf+1)/2) * (W/nf + 0.18u)'
+ ps='2*int((nf+2)/2) * (W/nf + 0.18u)' nrd='0.18u / W' nrs='0.18u / W' sa=0 sb=0 sd=0
.ends

* expanding   symbol:  a_zonetic2026/XSCHEM/DECODER/andGate.sym # of pins=5
** sym_path: /foss/designs/a_zonetic2026/XSCHEM/DECODER/andGate.sym
** sch_path: /foss/designs/a_zonetic2026/XSCHEM/DECODER/andGate.sch
.subckt andGate A VDD B output VSS
*.ipin VDD
*.ipin B
*.ipin A
*.ipin VSS
*.opin output
XM4 output net1 VDD VDD pfet_06v0 L=1.0u W=3.0u nf=1 ad='int((nf+1)/2) * W/nf * 0.18u' as='int((nf+2)/2) * W/nf * 0.18u' pd='2*int((nf+1)/2) * (W/nf + 0.18u)'
+ ps='2*int((nf+2)/2) * (W/nf + 0.18u)' nrd='0.18u / W' nrs='0.18u / W' sa=0 sb=0 sd=0
XM5 VSS net1 output VSS nfet_06v0 L=1u W=1u nf=1 ad='int((nf+1)/2) * W/nf * 0.18u' as='int((nf+2)/2) * W/nf * 0.18u' pd='2*int((nf+1)/2) * (W/nf + 0.18u)'
+ ps='2*int((nf+2)/2) * (W/nf + 0.18u)' nrd='0.18u / W' nrs='0.18u / W' sa=0 sb=0 sd=0
XM2 VDD A net1 VDD pfet_06v0 L=1.0u W=3.0u nf=1 ad='int((nf+1)/2) * W/nf * 0.18u' as='int((nf+2)/2) * W/nf * 0.18u' pd='2*int((nf+1)/2) * (W/nf + 0.18u)'
+ ps='2*int((nf+2)/2) * (W/nf + 0.18u)' nrd='0.18u / W' nrs='0.18u / W' sa=0 sb=0 sd=0
XM1 VDD B net1 VDD pfet_06v0 L=1.0u W=3.0u nf=1 ad='int((nf+1)/2) * W/nf * 0.18u' as='int((nf+2)/2) * W/nf * 0.18u' pd='2*int((nf+1)/2) * (W/nf + 0.18u)'
+ ps='2*int((nf+2)/2) * (W/nf + 0.18u)' nrd='0.18u / W' nrs='0.18u / W' sa=0 sb=0 sd=0
XM3 VSS A net2 VSS nfet_06v0 L=1u W=1u nf=1 ad='int((nf+1)/2) * W/nf * 0.18u' as='int((nf+2)/2) * W/nf * 0.18u' pd='2*int((nf+1)/2) * (W/nf + 0.18u)'
+ ps='2*int((nf+2)/2) * (W/nf + 0.18u)' nrd='0.18u / W' nrs='0.18u / W' sa=0 sb=0 sd=0
XM6 net2 B net1 VSS nfet_06v0 L=1u W=1u nf=1 ad='int((nf+1)/2) * W/nf * 0.18u' as='int((nf+2)/2) * W/nf * 0.18u' pd='2*int((nf+1)/2) * (W/nf + 0.18u)'
+ ps='2*int((nf+2)/2) * (W/nf + 0.18u)' nrd='0.18u / W' nrs='0.18u / W' sa=0 sb=0 sd=0
.ends

.end
