* Extracted by KLayout with GF180MCU LVS runset on : 18/08/2026 18:02

.SUBCKT COMP OUT INP INN VDD VSS
M$1 \$658 \$20 VDD VDD pfet_06v0 L=1U W=10U AS=4.4P AD=2.5P PS=20.88U PD=10.5U
M$2 \$44 \$23 \$658 VDD pfet_06v0 L=1U W=10U AS=2.5P AD=4.4P PS=10.5U PD=20.88U
M$3 \$670 \$104 VDD VDD pfet_06v0 L=1U W=10U AS=4.4P AD=2.5P PS=20.88U PD=10.5U
M$4 \$104 \$23 \$670 VDD pfet_06v0 L=1U W=10U AS=2.5P AD=4.4P PS=10.5U PD=20.88U
M$5 \$704 \$20 VDD VDD pfet_06v0 L=1U W=10U AS=4.4P AD=2.5P PS=20.88U PD=10.5U
M$6 \$164 \$23 \$704 VDD pfet_06v0 L=1U W=10U AS=2.5P AD=4.4P PS=10.5U PD=20.88U
M$7 \$656 \$20 VDD VDD pfet_06v0 L=1U W=10U AS=4.4P AD=2.5P PS=20.88U PD=10.5U
M$8 \$11 \$23 \$656 VDD pfet_06v0 L=1U W=10U AS=2.5P AD=4.4P PS=10.5U PD=20.88U
M$9 \$699 \$20 VDD VDD pfet_06v0 L=1U W=10U AS=4.4P AD=2.5P PS=20.88U PD=10.5U
M$10 \$164 \$23 \$699 VDD pfet_06v0 L=1U W=10U AS=2.5P AD=4.4P PS=10.5U
+ PD=20.88U
M$11 \$657 \$20 VDD VDD pfet_06v0 L=1U W=10U AS=4.4P AD=2.5P PS=20.88U PD=10.5U
M$12 \$15 \$23 \$657 VDD pfet_06v0 L=1U W=10U AS=2.5P AD=4.4P PS=10.5U PD=20.88U
M$13 \$677 \$20 VDD VDD pfet_06v0 L=1U W=10U AS=4.4P AD=2.5P PS=20.88U PD=10.5U
M$14 \$20 \$23 \$677 VDD pfet_06v0 L=1U W=10U AS=2.5P AD=4.4P PS=10.5U PD=20.88U
M$15 \$57 \$52 VSS VSS nfet_06v0 L=1U W=5U AS=2.2P AD=1.25P PS=10.88U PD=5.5U
M$16 \$52 \$11 \$57 VSS nfet_06v0 L=1U W=5U AS=1.25P AD=2.2P PS=5.5U PD=10.88U
M$17 \$48 \$15 VSS VSS nfet_06v0 L=1U W=5U AS=2.2P AD=1.25P PS=10.88U PD=5.5U
M$18 \$54 \$11 \$48 VSS nfet_06v0 L=1U W=5U AS=1.25P AD=2.2P PS=5.5U PD=10.88U
M$19 \$29 \$15 VSS VSS nfet_06v0 L=1U W=5U AS=2.2P AD=1.25P PS=10.88U PD=5.5U
M$20 \$32 \$11 \$29 VSS nfet_06v0 L=1U W=5U AS=1.25P AD=2.2P PS=5.5U PD=10.88U
M$21 \$21 \$23 VSS VSS nfet_06v0 L=1U W=1U AS=0.44P AD=0.25P PS=2.88U PD=1.5U
M$22 \$20 \$23 \$21 VSS nfet_06v0 L=1U W=1U AS=0.25P AD=0.44P PS=1.5U PD=2.88U
M$23 \$16 \$15 VSS VSS nfet_06v0 L=1U W=5U AS=2.2P AD=1.25P PS=10.88U PD=5.5U
M$24 \$15 \$11 \$16 VSS nfet_06v0 L=1U W=5U AS=1.25P AD=2.2P PS=5.5U PD=10.88U
M$25 \$24 \$23 VSS VSS nfet_06v0 L=1U W=1U AS=0.44P AD=0.25P PS=2.88U PD=1.5U
M$26 \$23 \$23 \$24 VSS nfet_06v0 L=1U W=1U AS=0.25P AD=0.44P PS=1.5U PD=2.88U
M$27 \$26 \$15 VSS VSS nfet_06v0 L=1U W=5U AS=2.2P AD=1.25P PS=10.88U PD=5.5U
M$28 \$32 \$11 \$26 VSS nfet_06v0 L=1U W=5U AS=1.25P AD=2.2P PS=5.5U PD=10.88U
C$29 OUT \$7 4e-13 cap_mim_2f0fF A=200P P=60U
C$30 \$3 OUT 4e-13 cap_mim_2f0fF A=200P P=60U
M$31 \$295 \$44 \$238 VSS nfet_06v0 L=1U W=2.5U AS=1.1P AD=1.1P PS=5.88U
+ PD=5.88U
M$32 \$226 \$44 \$167 VSS nfet_06v0 L=1U W=2.5U AS=1.1P AD=1.1P PS=5.88U
+ PD=5.88U
M$33 \$7 \$167 VSS VSS nfet_06v0 L=1U W=2.5U AS=1.1P AD=0.65P PS=5.88U PD=3.02U
M$34 VSS \$167 \$7 VSS nfet_06v0 L=1U W=2.5U AS=0.65P AD=0.65P PS=3.02U PD=3.02U
M$35 \$7 \$167 VSS VSS nfet_06v0 L=1U W=2.5U AS=0.65P AD=0.65P PS=3.02U PD=3.02U
M$36 VSS \$167 \$7 VSS nfet_06v0 L=1U W=2.5U AS=0.65P AD=1.1P PS=3.02U PD=5.88U
M$37 \$87 \$167 VSS VSS nfet_06v0 L=1U W=2.5U AS=1.1P AD=0.65P PS=5.88U PD=3.02U
M$38 VSS \$167 \$87 VSS nfet_06v0 L=1U W=2.5U AS=0.65P AD=0.65P PS=3.02U
+ PD=3.02U
M$39 \$87 \$167 VSS VSS nfet_06v0 L=1U W=2.5U AS=0.65P AD=0.65P PS=3.02U
+ PD=3.02U
M$40 VSS \$167 \$87 VSS nfet_06v0 L=1U W=2.5U AS=0.65P AD=1.1P PS=3.02U PD=5.88U
M$41 OUT \$238 VSS VSS nfet_06v0 L=1U W=5U AS=2.2P AD=1.3P PS=10.88U PD=5.52U
M$42 VSS \$238 OUT VSS nfet_06v0 L=1U W=5U AS=1.3P AD=1.3P PS=5.52U PD=5.52U
M$43 OUT \$238 VSS VSS nfet_06v0 L=1U W=5U AS=1.3P AD=2.2P PS=5.52U PD=10.88U
M$44 \$44 \$44 \$52 VSS nfet_06v0 L=1U W=5U AS=2.2P AD=2.2P PS=10.88U PD=10.88U
M$45 \$167 \$11 \$87 VSS nfet_06v0 L=1U W=2.5U AS=1.1P AD=0.65P PS=5.88U
+ PD=3.02U
M$46 \$87 \$11 \$167 VSS nfet_06v0 L=1U W=2.5U AS=0.65P AD=1.1P PS=3.02U
+ PD=5.88U
M$47 \$238 \$11 \$7 VSS nfet_06v0 L=1U W=2.5U AS=1.1P AD=0.65P PS=5.88U PD=3.02U
M$48 \$7 \$11 \$238 VSS nfet_06v0 L=1U W=2.5U AS=0.65P AD=1.1P PS=3.02U PD=5.88U
M$49 \$11 \$11 VSS VSS nfet_06v0 L=1U W=1U AS=0.44P AD=0.44P PS=2.88U PD=2.88U
M$50 \$86 INN \$32 VSS nfet_06v0 L=1U W=5U AS=2.2P AD=1.3P PS=10.88U PD=5.52U
M$51 \$32 INN \$86 VSS nfet_06v0 L=1U W=5U AS=1.3P AD=2.2P PS=5.52U PD=10.88U
M$52 \$3 INP \$32 VSS nfet_06v0 L=1U W=5U AS=2.2P AD=1.3P PS=10.88U PD=5.52U
M$53 \$32 INP \$3 VSS nfet_06v0 L=1U W=5U AS=1.3P AD=2.2P PS=5.52U PD=10.88U
M$54 \$226 \$23 \$86 VDD pfet_06v0 L=1U W=5U AS=2.2P AD=1.3P PS=10.88U PD=5.52U
M$55 \$86 \$23 \$226 VDD pfet_06v0 L=1U W=5U AS=1.3P AD=2.2P PS=5.52U PD=10.88U
M$56 \$87 INN \$164 VDD pfet_06v0 L=1U W=10U AS=4.4P AD=2.6P PS=20.88U PD=10.52U
M$57 \$164 INN \$87 VDD pfet_06v0 L=1U W=10U AS=2.6P AD=4.4P PS=10.52U PD=20.88U
M$58 \$7 INP \$164 VDD pfet_06v0 L=1U W=10U AS=4.4P AD=2.6P PS=20.88U PD=10.52U
M$59 \$164 INP \$7 VDD pfet_06v0 L=1U W=10U AS=2.6P AD=4.4P PS=10.52U PD=20.88U
M$60 \$23 \$23 VDD VDD pfet_06v0 L=1U W=2U AS=0.88P AD=0.88P PS=4.88U PD=4.88U
M$61 OUT \$295 VDD VDD pfet_06v0 L=1U W=10U AS=4.4P AD=2.6P PS=20.88U PD=10.52U
M$62 VDD \$295 OUT VDD pfet_06v0 L=1U W=10U AS=2.6P AD=2.6P PS=10.52U PD=10.52U
M$63 OUT \$295 VDD VDD pfet_06v0 L=1U W=10U AS=2.6P AD=4.4P PS=10.52U PD=20.88U
M$64 \$54 \$54 \$104 VDD pfet_06v0 L=1U W=10U AS=4.4P AD=4.4P PS=20.88U
+ PD=20.88U
M$65 \$238 \$54 \$295 VDD pfet_06v0 L=1U W=5U AS=2.2P AD=2.2P PS=10.88U
+ PD=10.88U
M$66 \$167 \$54 \$226 VDD pfet_06v0 L=1U W=5U AS=2.2P AD=2.2P PS=10.88U
+ PD=10.88U
M$67 \$3 \$226 VDD VDD pfet_06v0 L=1U W=5U AS=2.2P AD=1.3P PS=10.88U PD=5.52U
M$68 VDD \$226 \$3 VDD pfet_06v0 L=1U W=5U AS=1.3P AD=1.3P PS=5.52U PD=5.52U
M$69 \$3 \$226 VDD VDD pfet_06v0 L=1U W=5U AS=1.3P AD=1.3P PS=5.52U PD=5.52U
M$70 VDD \$226 \$3 VDD pfet_06v0 L=1U W=5U AS=1.3P AD=2.2P PS=5.52U PD=10.88U
M$71 \$86 \$226 VDD VDD pfet_06v0 L=1U W=5U AS=2.2P AD=1.3P PS=10.88U PD=5.52U
M$72 VDD \$226 \$86 VDD pfet_06v0 L=1U W=5U AS=1.3P AD=1.3P PS=5.52U PD=5.52U
M$73 \$86 \$226 VDD VDD pfet_06v0 L=1U W=5U AS=1.3P AD=1.3P PS=5.52U PD=5.52U
M$74 VDD \$226 \$86 VDD pfet_06v0 L=1U W=5U AS=1.3P AD=2.2P PS=5.52U PD=10.88U
M$75 \$295 \$23 \$3 VDD pfet_06v0 L=1U W=5U AS=2.2P AD=1.3P PS=10.88U PD=5.52U
M$76 \$3 \$23 \$295 VDD pfet_06v0 L=1U W=5U AS=1.3P AD=2.2P PS=5.52U PD=10.88U
.ENDS COMP
