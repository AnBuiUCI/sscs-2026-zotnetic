* Extracted by KLayout with GF180MCU LVS runset on : 09/08/2026 01:36

.SUBCKT COMP OUT INP INN VDD VSS
M$1 \$232 \$24 VDD VDD pfet_06v0 L=1U W=10U AS=4.4P AD=2.5P PS=20.88U PD=10.5U
M$2 \$127 \$38 \$232 VDD pfet_06v0 L=1U W=10U AS=2.5P AD=4.4P PS=10.5U PD=20.88U
M$3 \$238 \$129 VDD VDD pfet_06v0 L=1U W=10U AS=4.4P AD=2.5P PS=20.88U PD=10.5U
M$4 \$129 \$38 \$238 VDD pfet_06v0 L=1U W=10U AS=2.5P AD=4.4P PS=10.5U PD=20.88U
M$5 \$247 \$24 VDD VDD pfet_06v0 L=1U W=10U AS=4.4P AD=2.5P PS=20.88U PD=10.5U
M$6 \$169 \$38 \$247 VDD pfet_06v0 L=1U W=10U AS=2.5P AD=4.4P PS=10.5U PD=20.88U
M$7 \$229 \$24 VDD VDD pfet_06v0 L=1U W=10U AS=4.4P AD=2.5P PS=20.88U PD=10.5U
M$8 \$96 \$38 \$229 VDD pfet_06v0 L=1U W=10U AS=2.5P AD=4.4P PS=10.5U PD=20.88U
M$9 \$242 \$24 VDD VDD pfet_06v0 L=1U W=10U AS=4.4P AD=2.5P PS=20.88U PD=10.5U
M$10 \$169 \$38 \$242 VDD pfet_06v0 L=1U W=10U AS=2.5P AD=4.4P PS=10.5U
+ PD=20.88U
M$11 \$231 \$24 VDD VDD pfet_06v0 L=1U W=10U AS=4.4P AD=2.5P PS=20.88U PD=10.5U
M$12 \$15 \$38 \$231 VDD pfet_06v0 L=1U W=10U AS=2.5P AD=4.4P PS=10.5U PD=20.88U
M$13 \$241 \$24 VDD VDD pfet_06v0 L=1U W=10U AS=4.4P AD=2.5P PS=20.88U PD=10.5U
M$14 \$24 \$38 \$241 VDD pfet_06v0 L=1U W=10U AS=2.5P AD=4.4P PS=10.5U PD=20.88U
M$15 \$57 \$61 VSS VSS nfet_06v0 L=1U W=5U AS=2.2P AD=1.25P PS=10.88U PD=5.5U
M$16 \$61 \$96 \$57 VSS nfet_06v0 L=1U W=5U AS=1.25P AD=2.2P PS=5.5U PD=10.88U
M$17 \$87 \$15 VSS VSS nfet_06v0 L=1U W=5U AS=2.2P AD=1.25P PS=10.88U PD=5.5U
M$18 \$68 \$96 \$87 VSS nfet_06v0 L=1U W=5U AS=1.25P AD=2.2P PS=5.5U PD=10.88U
M$19 \$44 \$15 VSS VSS nfet_06v0 L=1U W=5U AS=2.2P AD=1.25P PS=10.88U PD=5.5U
M$20 \$42 \$96 \$44 VSS nfet_06v0 L=1U W=5U AS=1.25P AD=2.2P PS=5.5U PD=10.88U
M$21 \$22 \$38 VSS VSS nfet_06v0 L=1U W=1U AS=0.44P AD=0.25P PS=2.88U PD=1.5U
M$22 \$24 \$38 \$22 VSS nfet_06v0 L=1U W=1U AS=0.25P AD=0.44P PS=1.5U PD=2.88U
M$23 \$13 \$15 VSS VSS nfet_06v0 L=1U W=5U AS=2.2P AD=1.25P PS=10.88U PD=5.5U
M$24 \$15 \$96 \$13 VSS nfet_06v0 L=1U W=5U AS=1.25P AD=2.2P PS=5.5U PD=10.88U
M$25 \$29 \$38 VSS VSS nfet_06v0 L=1U W=1U AS=0.44P AD=0.25P PS=2.88U PD=1.5U
M$26 \$38 \$38 \$29 VSS nfet_06v0 L=1U W=1U AS=0.25P AD=0.44P PS=1.5U PD=2.88U
M$27 \$34 \$15 VSS VSS nfet_06v0 L=1U W=5U AS=2.2P AD=1.25P PS=10.88U PD=5.5U
M$28 \$42 \$96 \$34 VSS nfet_06v0 L=1U W=5U AS=1.25P AD=2.2P PS=5.5U PD=10.88U
C$29 OUT \$91 4e-13 cap_mim_2f0fF A=200P P=60U
C$30 \$118 OUT 4e-13 cap_mim_2f0fF A=200P P=60U
M$31 \$151 \$127 \$149 VSS nfet_06v0 L=1U W=2.5U AS=1.1P AD=1.1P PS=5.88U
+ PD=5.88U
M$32 \$155 \$127 \$158 VSS nfet_06v0 L=1U W=2.5U AS=1.1P AD=1.1P PS=5.88U
+ PD=5.88U
M$33 \$91 \$158 VSS VSS nfet_06v0 L=1U W=2.5U AS=1.1P AD=0.65P PS=5.88U PD=3.02U
M$34 VSS \$158 \$91 VSS nfet_06v0 L=1U W=2.5U AS=0.65P AD=0.65P PS=3.02U
+ PD=3.02U
M$35 \$91 \$158 VSS VSS nfet_06v0 L=1U W=2.5U AS=0.65P AD=0.65P PS=3.02U
+ PD=3.02U
M$36 VSS \$158 \$91 VSS nfet_06v0 L=1U W=2.5U AS=0.65P AD=1.1P PS=3.02U PD=5.88U
M$37 OUT \$149 VSS VSS nfet_06v0 L=1U W=5U AS=2.2P AD=1.3P PS=10.88U PD=5.52U
M$38 VSS \$149 OUT VSS nfet_06v0 L=1U W=5U AS=1.3P AD=1.3P PS=5.52U PD=5.52U
M$39 OUT \$149 VSS VSS nfet_06v0 L=1U W=5U AS=1.3P AD=2.2P PS=5.52U PD=10.88U
M$40 \$127 \$127 \$61 VSS nfet_06v0 L=1U W=5U AS=2.2P AD=2.2P PS=10.88U
+ PD=10.88U
M$41 \$149 \$96 \$91 VSS nfet_06v0 L=1U W=2.5U AS=1.1P AD=0.65P PS=5.88U
+ PD=3.02U
M$42 \$91 \$96 \$149 VSS nfet_06v0 L=1U W=2.5U AS=0.65P AD=1.1P PS=3.02U
+ PD=5.88U
M$43 \$158 \$96 \$160 VSS nfet_06v0 L=1U W=2.5U AS=1.1P AD=0.65P PS=5.88U
+ PD=3.02U
M$44 \$160 \$96 \$158 VSS nfet_06v0 L=1U W=2.5U AS=0.65P AD=1.1P PS=3.02U
+ PD=5.88U
M$45 \$96 \$96 VSS VSS nfet_06v0 L=1U W=1U AS=0.44P AD=0.44P PS=2.88U PD=2.88U
M$46 \$143 INN \$42 VSS nfet_06v0 L=1U W=5U AS=2.2P AD=1.3P PS=10.88U PD=5.52U
M$47 \$42 INN \$143 VSS nfet_06v0 L=1U W=5U AS=1.3P AD=2.2P PS=5.52U PD=10.88U
M$48 \$118 INP \$42 VSS nfet_06v0 L=1U W=5U AS=2.2P AD=1.3P PS=10.88U PD=5.52U
M$49 \$42 INP \$118 VSS nfet_06v0 L=1U W=5U AS=1.3P AD=2.2P PS=5.52U PD=10.88U
M$50 \$38 \$38 VDD VDD pfet_06v0 L=1U W=2U AS=0.88P AD=0.88P PS=4.88U PD=4.88U
M$51 \$155 \$38 \$143 VDD pfet_06v0 L=1U W=5U AS=2.2P AD=1.3P PS=10.88U PD=5.52U
M$52 \$143 \$38 \$155 VDD pfet_06v0 L=1U W=5U AS=1.3P AD=2.2P PS=5.52U PD=10.88U
M$53 \$160 INN \$169 VDD pfet_06v0 L=1U W=10U AS=4.4P AD=2.6P PS=20.88U
+ PD=10.52U
M$54 \$169 INN \$160 VDD pfet_06v0 L=1U W=10U AS=2.6P AD=4.4P PS=10.52U
+ PD=20.88U
M$55 \$91 INP \$169 VDD pfet_06v0 L=1U W=10U AS=4.4P AD=2.6P PS=20.88U PD=10.52U
M$56 \$169 INP \$91 VDD pfet_06v0 L=1U W=10U AS=2.6P AD=4.4P PS=10.52U PD=20.88U
M$57 \$158 \$68 \$155 VDD pfet_06v0 L=1U W=5U AS=2.2P AD=2.2P PS=10.88U
+ PD=10.88U
M$58 \$118 \$155 VDD VDD pfet_06v0 L=1U W=5U AS=2.2P AD=1.3P PS=10.88U PD=5.52U
M$59 VDD \$155 \$118 VDD pfet_06v0 L=1U W=5U AS=1.3P AD=1.3P PS=5.52U PD=5.52U
M$60 \$118 \$155 VDD VDD pfet_06v0 L=1U W=5U AS=1.3P AD=1.3P PS=5.52U PD=5.52U
M$61 VDD \$155 \$118 VDD pfet_06v0 L=1U W=5U AS=1.3P AD=2.2P PS=5.52U PD=10.88U
M$62 \$143 \$155 VDD VDD pfet_06v0 L=1U W=5U AS=2.2P AD=1.3P PS=10.88U PD=5.52U
M$63 VDD \$155 \$143 VDD pfet_06v0 L=1U W=5U AS=1.3P AD=1.3P PS=5.52U PD=5.52U
M$64 \$143 \$155 VDD VDD pfet_06v0 L=1U W=5U AS=1.3P AD=1.3P PS=5.52U PD=5.52U
M$65 VDD \$155 \$143 VDD pfet_06v0 L=1U W=5U AS=1.3P AD=2.2P PS=5.52U PD=10.88U
M$66 OUT \$151 VDD VDD pfet_06v0 L=1U W=10U AS=4.4P AD=2.6P PS=20.88U PD=10.52U
M$67 VDD \$151 OUT VDD pfet_06v0 L=1U W=10U AS=2.6P AD=2.6P PS=10.52U PD=10.52U
M$68 OUT \$151 VDD VDD pfet_06v0 L=1U W=10U AS=2.6P AD=4.4P PS=10.52U PD=20.88U
M$69 \$68 \$68 \$129 VDD pfet_06v0 L=1U W=10U AS=4.4P AD=4.4P PS=20.88U
+ PD=20.88U
M$70 \$149 \$68 \$151 VDD pfet_06v0 L=1U W=5U AS=2.2P AD=2.2P PS=10.88U
+ PD=10.88U
M$71 \$151 \$38 \$118 VDD pfet_06v0 L=1U W=5U AS=2.2P AD=1.3P PS=10.88U PD=5.52U
M$72 \$118 \$38 \$151 VDD pfet_06v0 L=1U W=5U AS=1.3P AD=2.2P PS=5.52U PD=10.88U
M$73 \$160 \$158 VSS VSS nfet_06v0 L=1U W=2.5U AS=1.1P AD=0.65P PS=5.88U
+ PD=3.02U
M$74 VSS \$158 \$160 VSS nfet_06v0 L=1U W=2.5U AS=0.65P AD=0.65P PS=3.02U
+ PD=3.02U
M$75 \$160 \$158 VSS VSS nfet_06v0 L=1U W=2.5U AS=0.65P AD=0.65P PS=3.02U
+ PD=3.02U
M$76 VSS \$158 \$160 VSS nfet_06v0 L=1U W=2.5U AS=0.65P AD=1.1P PS=3.02U
+ PD=5.88U
.ENDS COMP
