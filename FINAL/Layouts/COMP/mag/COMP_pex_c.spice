* Nodos de bulk atados: 1 de pozo n -> VDD, 1 de sustrato -> VSS.
*   magic no extrae los taps de este layout y los dejaba flotando;
*   la conexion si existe (el LVS de KLayout da 'match uniquely').
*   Quien detecta un tap que falte de verdad es el LVS, no esto.
* NGSPICE file created from COMP.ext - technology: gf180mcuD

.subckt COMP VSS VDD OUT INP INN
X0 VSS a_8330_446# a_6626_3846# VSS nfet_06v0 ad=1.1p pd=5.88u as=0.65p ps=3.02u w=2.5u l=1u
X1 a_4702_3846# INN a_7742_3846# VDD pfet_06v0 ad=4.4p pd=20.88u as=2.6p ps=10.52u w=10u l=1u
X2 a_9442_446# a_14338_3730# a_9974_3846# VDD pfet_06v0 ad=2.2p pd=10.88u as=2.2p ps=10.88u w=5u l=1u
X3 a_4342_446# a_14_330# a_5074_446# VSS nfet_06v0 ad=2.2p pd=10.88u as=1.25p ps=5.5u w=5u l=1u
X4 a_4702_3846# a_354_3730# a_5514_3846# VDD pfet_06v0 ad=4.4p pd=20.88u as=2.5p ps=10.5u w=10u l=1u
X5 a_6106_446# a_354_3730# a_9974_3846# VDD pfet_06v0 ad=2.2p pd=10.88u as=1.3p ps=5.52u w=5u l=1u
X6 a_14_330# a_14_330# VSS VSS nfet_06v0 ad=0.44p pd=2.88u as=0.44p ps=2.88u w=1u l=1u
X7 a_7218_446# INN a_4342_446# VSS nfet_06v0 ad=1.3p pd=5.52u as=2.2p ps=10.88u w=5u l=1u
X8 a_7218_446# a_354_3730# a_8858_3846# VDD pfet_06v0 ad=2.2p pd=10.88u as=1.3p ps=5.52u w=5u l=1u
X9 a_5074_446# a_746_330# VSS VSS nfet_06v0 ad=1.25p pd=5.5u as=2.2p ps=10.88u w=5u l=1u
X10 a_9442_446# a_14_330# a_6626_3846# VSS nfet_06v0 ad=0.65p pd=3.02u as=1.1p ps=5.88u w=2.5u l=1u
X11 a_6626_3846# OUT cap_mim_2f0_m4m5_noshield c_width=20u c_length=10u
X12 a_4702_3846# INP a_6626_3846# VDD pfet_06v0 ad=4.4p pd=20.88u as=2.6p ps=10.52u w=10u l=1u
X13 VDD a_8858_3846# a_7218_446# VDD pfet_06v0 ad=1.3p pd=5.52u as=1.3p ps=5.52u w=5u l=1u
X14 a_8330_446# a_14338_3730# a_8858_3846# VDD pfet_06v0 ad=2.2p pd=10.88u as=2.2p ps=10.88u w=5u l=1u
X15 VDD a_9974_3846# OUT VDD pfet_06v0 ad=2.6p pd=10.52u as=2.6p ps=10.52u w=10u l=1u
X16 a_6626_3846# a_8330_446# VSS VSS nfet_06v0 ad=0.65p pd=3.02u as=0.65p ps=3.02u w=2.5u l=1u
X17 a_946_446# a_746_330# VSS VSS nfet_06v0 ad=1.25p pd=5.5u as=2.2p ps=10.88u w=5u l=1u
X18 OUT a_9442_446# VSS VSS nfet_06v0 ad=2.2p pd=10.88u as=1.3p ps=5.52u w=5u l=1u
X19 a_4702_3846# a_354_3730# a_4402_3846# VDD pfet_06v0 ad=4.4p pd=20.88u as=2.5p ps=10.5u w=10u l=1u
X20 a_9974_3846# a_13794_330# a_9442_446# VSS nfet_06v0 ad=1.1p pd=5.88u as=1.1p ps=5.88u w=2.5u l=1u
X21 a_6106_446# a_8858_3846# VDD VDD pfet_06v0 ad=1.3p pd=5.52u as=2.2p ps=10.88u w=5u l=1u
X22 a_16162_3846# a_15962_3730# VDD VDD pfet_06v0 ad=2.5p pd=10.5u as=4.4p ps=20.88u w=10u l=1u
X23 a_4342_446# INP a_6106_446# VSS nfet_06v0 ad=2.2p pd=10.88u as=1.3p ps=5.52u w=5u l=1u
X24 a_7742_3846# a_8330_446# VSS VSS nfet_06v0 ad=0.65p pd=3.02u as=0.65p ps=3.02u w=2.5u l=1u
X25 a_17222_446# a_16202_446# VSS VSS nfet_06v0 ad=1.25p pd=5.5u as=2.2p ps=10.88u w=5u l=1u
X26 a_354_3730# a_354_3730# a_3010_446# VSS nfet_06v0 ad=0.44p pd=2.88u as=0.25p ps=1.5u w=1u l=1u
X27 a_13794_330# a_354_3730# a_18086_3846# VDD pfet_06v0 ad=4.4p pd=20.88u as=2.5p ps=10.5u w=10u l=1u
X28 a_3290_3846# a_54_3730# VDD VDD pfet_06v0 ad=2.5p pd=10.5u as=4.4p ps=20.88u w=10u l=1u
X29 a_6106_446# a_8858_3846# VDD VDD pfet_06v0 ad=1.3p pd=5.52u as=1.3p ps=5.52u w=5u l=1u
X30 a_746_330# a_14_330# a_946_446# VSS nfet_06v0 ad=2.2p pd=10.88u as=1.25p ps=5.5u w=5u l=1u
X31 a_7742_3846# a_14_330# a_8330_446# VSS nfet_06v0 ad=1.1p pd=5.88u as=0.65p ps=3.02u w=2.5u l=1u
X32 VSS a_8330_446# a_6626_3846# VSS nfet_06v0 ad=0.65p pd=3.02u as=0.65p ps=3.02u w=2.5u l=1u
X33 a_16202_446# a_14_330# a_17222_446# VSS nfet_06v0 ad=2.2p pd=10.88u as=1.25p ps=5.5u w=5u l=1u
X34 OUT a_6106_446# cap_mim_2f0_m4m5_noshield c_width=20u c_length=10u
X35 a_7218_446# a_8858_3846# VDD VDD pfet_06v0 ad=1.3p pd=5.52u as=1.3p ps=5.52u w=5u l=1u
X36 OUT a_9974_3846# VDD VDD pfet_06v0 ad=4.4p pd=20.88u as=2.6p ps=10.52u w=10u l=1u
X37 a_14_330# a_354_3730# a_254_3846# VDD pfet_06v0 ad=4.4p pd=20.88u as=2.5p ps=10.5u w=10u l=1u
X38 a_14338_3730# a_14338_3730# a_15962_3730# VDD pfet_06v0 ad=4.4p pd=20.88u as=4.4p ps=20.88u w=10u l=1u
X39 a_3010_446# a_354_3730# VSS VSS nfet_06v0 ad=0.25p pd=1.5u as=0.44p ps=2.88u w=1u l=1u
X40 VSS a_9442_446# OUT VSS nfet_06v0 ad=1.3p pd=5.52u as=1.3p ps=5.52u w=5u l=1u
X41 VSS a_8330_446# a_7742_3846# VSS nfet_06v0 ad=0.65p pd=3.02u as=0.65p ps=3.02u w=2.5u l=1u
X42 a_15458_446# a_746_330# VSS VSS nfet_06v0 ad=1.25p pd=5.5u as=2.2p ps=10.88u w=5u l=1u
X43 a_354_3730# a_354_3730# VDD VDD pfet_06v0 ad=0.88p pd=4.88u as=0.88p ps=4.88u w=2u l=1u
X44 VDD a_8858_3846# a_6106_446# VDD pfet_06v0 ad=1.3p pd=5.52u as=1.3p ps=5.52u w=5u l=1u
X45 a_8858_3846# a_354_3730# a_7218_446# VDD pfet_06v0 ad=1.3p pd=5.52u as=2.2p ps=10.88u w=5u l=1u
X46 a_7218_446# a_8858_3846# VDD VDD pfet_06v0 ad=1.3p pd=5.52u as=2.2p ps=10.88u w=5u l=1u
X47 OUT a_9974_3846# VDD VDD pfet_06v0 ad=2.6p pd=10.52u as=4.4p ps=20.88u w=10u l=1u
X48 a_8330_446# a_14_330# a_7742_3846# VSS nfet_06v0 ad=0.65p pd=3.02u as=1.1p ps=5.88u w=2.5u l=1u
X49 a_6626_3846# a_8330_446# VSS VSS nfet_06v0 ad=0.65p pd=3.02u as=1.1p ps=5.88u w=2.5u l=1u
X50 a_14338_3730# a_14_330# a_15458_446# VSS nfet_06v0 ad=2.2p pd=10.88u as=1.25p ps=5.5u w=5u l=1u
X51 VDD a_8858_3846# a_6106_446# VDD pfet_06v0 ad=2.2p pd=10.88u as=1.3p ps=5.52u w=5u l=1u
X52 a_54_3730# a_354_3730# a_3290_3846# VDD pfet_06v0 ad=4.4p pd=20.88u as=2.5p ps=10.5u w=10u l=1u
X53 a_4342_446# a_14_330# a_4042_446# VSS nfet_06v0 ad=2.2p pd=10.88u as=1.25p ps=5.5u w=5u l=1u
X54 OUT a_9442_446# VSS VSS nfet_06v0 ad=1.3p pd=5.52u as=2.2p ps=10.88u w=5u l=1u
X55 a_1366_3846# a_54_3730# VDD VDD pfet_06v0 ad=2.5p pd=10.5u as=4.4p ps=20.88u w=10u l=1u
X56 a_6626_3846# INP a_4702_3846# VDD pfet_06v0 ad=2.6p pd=10.52u as=4.4p ps=20.88u w=10u l=1u
X57 a_9974_3846# a_354_3730# a_6106_446# VDD pfet_06v0 ad=1.3p pd=5.52u as=2.2p ps=10.88u w=5u l=1u
X58 VDD a_8858_3846# a_7218_446# VDD pfet_06v0 ad=2.2p pd=10.88u as=1.3p ps=5.52u w=5u l=1u
X59 a_7742_3846# a_8330_446# VSS VSS nfet_06v0 ad=0.65p pd=3.02u as=1.1p ps=5.88u w=2.5u l=1u
X60 a_18086_3846# a_54_3730# VDD VDD pfet_06v0 ad=2.5p pd=10.5u as=4.4p ps=20.88u w=10u l=1u
X61 a_54_3730# a_354_3730# a_1978_446# VSS nfet_06v0 ad=0.44p pd=2.88u as=0.25p ps=1.5u w=1u l=1u
X62 a_8858_3846# a_13794_330# a_8330_446# VSS nfet_06v0 ad=1.1p pd=5.88u as=1.1p ps=5.88u w=2.5u l=1u
X63 a_7742_3846# INN a_4702_3846# VDD pfet_06v0 ad=2.6p pd=10.52u as=4.4p ps=20.88u w=10u l=1u
X64 a_6106_446# INP a_4342_446# VSS nfet_06v0 ad=1.3p pd=5.52u as=2.2p ps=10.88u w=5u l=1u
X65 a_13794_330# a_13794_330# a_16202_446# VSS nfet_06v0 ad=2.2p pd=10.88u as=2.2p ps=10.88u w=5u l=1u
X66 a_4042_446# a_746_330# VSS VSS nfet_06v0 ad=1.25p pd=5.5u as=2.2p ps=10.88u w=5u l=1u
X67 a_254_3846# a_54_3730# VDD VDD pfet_06v0 ad=2.5p pd=10.5u as=4.4p ps=20.88u w=10u l=1u
X68 a_5514_3846# a_54_3730# VDD VDD pfet_06v0 ad=2.5p pd=10.5u as=4.4p ps=20.88u w=10u l=1u
X69 a_4342_446# INN a_7218_446# VSS nfet_06v0 ad=2.2p pd=10.88u as=1.3p ps=5.52u w=5u l=1u
X70 VSS a_8330_446# a_7742_3846# VSS nfet_06v0 ad=1.1p pd=5.88u as=0.65p ps=3.02u w=2.5u l=1u
X71 a_15962_3730# a_354_3730# a_16162_3846# VDD pfet_06v0 ad=4.4p pd=20.88u as=2.5p ps=10.5u w=10u l=1u
X72 a_1978_446# a_354_3730# VSS VSS nfet_06v0 ad=0.25p pd=1.5u as=0.44p ps=2.88u w=1u l=1u
X73 a_746_330# a_354_3730# a_1366_3846# VDD pfet_06v0 ad=4.4p pd=20.88u as=2.5p ps=10.5u w=10u l=1u
X74 a_4402_3846# a_54_3730# VDD VDD pfet_06v0 ad=2.5p pd=10.5u as=4.4p ps=20.88u w=10u l=1u
X75 a_6626_3846# a_14_330# a_9442_446# VSS nfet_06v0 ad=1.1p pd=5.88u as=0.65p ps=3.02u w=2.5u l=1u
C0 a_15962_3730# VDD 0.59934f
C1 VSS a_7742_3846# 1.36068f
C2 a_9442_446# OUT 1.27096f
C3 a_6106_446# INP 1.41181f
C4 a_14338_3730# a_9974_3846# 1.62645f
C5 a_13794_330# a_15962_3730# 0.43475f
C6 a_4702_3846# a_7742_3846# 2.48508f
C7 a_746_330# a_354_3730# 1.49f
C8 a_6626_3846# a_8330_446# 1.57763f
C9 INN a_746_330# 0.02834f
C10 a_6626_3846# a_14_330# 0.76818f
C11 a_54_3730# a_746_330# 0.25573f
C12 VSS a_746_330# 1.26176f
C13 a_354_3730# OUT 1.00366f
C14 INN OUT 0.07236f
C15 a_54_3730# OUT 0.83759f
C16 a_14_330# VDD 0.37462f
C17 INP a_354_3730# 0.04f
C18 a_6626_3846# a_6106_446# 2.47709f
C19 VSS OUT 0.80751f
C20 a_8330_446# a_13794_330# 0.61226f
C21 INN INP 0.04234f
C22 INP a_54_3730# 0.03046f
C23 a_14_330# a_13794_330# 0.28729f
C24 a_4342_446# a_746_330# 1.17127f
C25 a_6626_3846# a_9442_446# 1.26538f
C26 a_4702_3846# OUT 0.6869f
C27 INP VSS 0.12369f
C28 a_6106_446# VDD 1.8806f
C29 a_4702_3846# INP 2.06595f
C30 a_4342_446# OUT 0.11403f
C31 VDD a_7742_3846# 0.4962f
C32 a_9442_446# VDD 0.09917f
C33 a_6106_446# a_13794_330# 0.08285f
C34 a_6626_3846# a_354_3730# 0.5046f
C35 INP a_4342_446# 1.12718f
C36 a_9442_446# a_13794_330# 1.16007f
C37 INN a_6626_3846# 0.23596f
C38 a_6626_3846# a_54_3730# 0.27844f
C39 a_6626_3846# VSS 1.23082f
C40 VDD a_746_330# 0.29876f
C41 a_14_330# a_16202_446# 1.03426f
C42 a_354_3730# VDD 1.70085f
C43 a_8330_446# a_7218_446# 0.27241f
C44 a_6626_3846# a_4702_3846# 3.15074f
C45 a_14_330# a_7218_446# 0.08487f
C46 INN VDD 0.19777f
C47 a_54_3730# VDD 2.77898f
C48 a_8858_3846# a_746_330# 0.0202f
C49 a_13794_330# a_354_3730# 0.43702f
C50 VDD OUT 1.12743f
C51 a_946_446# VSS 0.0407f
C52 a_54_3730# a_13794_330# 0.07219f
C53 a_6626_3846# a_4342_446# 0.03333f
C54 a_4702_3846# VDD 0.70048f
C55 a_9974_3846# a_746_330# 0.06533f
C56 VSS a_13794_330# 0.42843f
C57 VDD INP 0.62781f
C58 a_6106_446# a_7218_446# 1.77202f
C59 a_8858_3846# OUT 0.03692f
C60 a_9442_446# a_16202_446# 0.02898f
C61 a_4402_3846# OUT 0.01822f
C62 a_9442_446# a_7218_446# 0.04888f
C63 a_1978_446# VSS 0.01078f
C64 a_9974_3846# OUT 2.08299f
C65 a_5514_3846# OUT 0.01822f
C66 a_9442_446# a_15962_3730# 0.22926f
C67 a_14_330# a_8330_446# 0.75488f
C68 VSS a_15458_446# 0.04658f
C69 a_6626_3846# VDD 0.79356f
C70 a_354_3730# a_7218_446# 1.09037f
C71 VSS a_16202_446# 0.60905f
C72 INN a_7218_446# 1.0264f
C73 a_54_3730# a_7218_446# 0.062f
C74 a_6626_3846# a_8858_3846# 0.02783f
C75 VSS a_7218_446# 0.04503f
C76 a_6106_446# a_8330_446# 0.56635f
C77 a_354_3730# a_15962_3730# 0.68913f
C78 a_54_3730# a_3290_3846# 0.05253f
C79 VDD VDD 11.6433f
C80 a_14_330# a_6106_446# 0.16157f
C81 a_54_3730# a_15962_3730# 0.06852f
C82 a_8330_446# a_9442_446# 0.36749f
C83 a_6626_3846# a_9974_3846# 0.41181f
C84 VDD a_13794_330# 0.26427f
C85 a_14_330# a_9442_446# 0.67159f
C86 a_8858_3846# VDD 2.81338f
C87 a_4342_446# a_7218_446# 1.29732f
C88 a_4402_3846# VDD 0.06858f
C89 a_13794_330# a_8858_3846# 0.56301f
C90 a_9974_3846# VDD 2.43944f
C91 a_5514_3846# VDD 0.07134f
C92 a_8330_446# a_354_3730# 0.03395f
C93 a_6106_446# a_9442_446# 0.16895f
C94 a_14_330# a_354_3730# 0.61635f
C95 a_18086_3846# OUT 0.0112f
C96 a_9974_3846# a_13794_330# 0.64684f
C97 a_8330_446# a_54_3730# 0.05867f
C98 INN a_14_330# 0.05792f
C99 a_8330_446# VSS 2.41943f
C100 a_14_330# a_54_3730# 0.1928f
C101 a_14_330# VSS 1.26713f
C102 a_6106_446# a_354_3730# 1.33321f
C103 VDD a_7218_446# 0.71248f
C104 INN a_6106_446# 0.20142f
C105 a_6106_446# a_54_3730# 0.23677f
C106 a_9442_446# a_354_3730# 0.04283f
C107 a_6106_446# VSS 0.05469f
C108 a_14338_3730# a_746_330# 0.04417f
C109 a_14_330# a_4342_446# 0.81367f
C110 a_8858_3846# a_7218_446# 2.75163f
C111 VDD a_15962_3730# 0.95811f
C112 a_9442_446# a_54_3730# 0.08618f
C113 a_6106_446# a_4702_3846# 0.17514f
C114 a_9442_446# VSS 1.60874f
C115 a_6626_3846# a_18086_3846# 0.01077f
C116 a_9974_3846# a_7218_446# 0.03369f
C117 a_14338_3730# OUT 0.11249f
C118 a_6106_446# a_4342_446# 2.01705f
C119 INN a_354_3730# 0.03763f
C120 a_54_3730# a_354_3730# 9.97459f
C121 a_18086_3846# VDD 0.06915f
C122 a_9974_3846# a_15962_3730# 0.0701f
C123 VSS a_354_3730# 0.7105f
C124 a_254_3846# VDD 0.07506f
C125 INN a_54_3730# 0.05776f
C126 VDD a_8330_446# 0.186f
C127 INN VSS 0.12481f
C128 a_18086_3846# a_13794_330# 0.05253f
C129 VSS a_54_3730# 0.06042f
C130 a_4702_3846# a_354_3730# 1.17978f
C131 a_14_330# VDD 0.29863f
C132 INN a_4702_3846# 2.05111f
C133 a_4702_3846# a_54_3730# 0.49066f
C134 a_8330_446# a_8858_3846# 2.26727f
C135 a_14_330# a_8858_3846# 0.02788f
C136 a_16162_3846# OUT 0.01091f
C137 VDD a_6106_446# 1.0275f
C138 a_8330_446# a_9974_3846# 0.34052f
C139 a_6626_3846# a_14338_3730# 0.36299f
C140 INN a_4342_446# 0.93234f
C141 a_4342_446# a_54_3730# 0.01731f
C142 a_14_330# a_9974_3846# 0.02906f
C143 VSS a_4342_446# 0.58362f
C144 VDD a_9442_446# 0.19055f
C145 a_6106_446# a_8858_3846# 2.28796f
C146 a_17222_446# OUT 0.01114f
C147 a_4702_3846# a_4342_446# 0.09387f
C148 a_14338_3730# VDD 0.33864f
C149 a_9442_446# a_8858_3846# 2.10553f
C150 a_7742_3846# a_746_330# 0.04856f
C151 a_6106_446# a_9974_3846# 1.34564f
C152 a_14338_3730# a_13794_330# 0.05296f
C153 VDD a_354_3730# 5.46305f
C154 a_9974_3846# a_9442_446# 3.41638f
C155 INN VDD 0.63091f
C156 a_16162_3846# a_6626_3846# 0.01077f
C157 a_7742_3846# OUT 0.06743f
C158 VDD a_54_3730# 2.52564f
C159 a_8858_3846# a_354_3730# 1.03453f
C160 VDD a_4702_3846# 1.56792f
C161 a_54_3730# a_8858_3846# 0.17132f
C162 a_16162_3846# VDD 0.06858f
C163 a_9974_3846# a_354_3730# 0.9614f
C164 VSS a_8858_3846# 0.01955f
C165 a_14338_3730# a_15458_446# 0.02626f
C166 a_746_330# OUT 0.31979f
C167 a_9974_3846# a_54_3730# 0.89248f
C168 a_14338_3730# a_16202_446# 0.19002f
C169 a_9974_3846# VSS 0.13909f
C170 INP a_746_330# 0.0304f
C171 a_4402_3846# a_4702_3846# 0.05253f
C172 a_14_330# a_254_3846# 0.05253f
C173 a_4702_3846# a_5514_3846# 0.0531f
C174 a_6626_3846# a_7742_3846# 0.06784f
C175 INP OUT 0.2691f
C176 a_14338_3730# a_15962_3730# 1.21941f
C177 a_7742_3846# VDD 0.07141f
C178 a_4042_446# VSS 0.0407f
C179 a_6626_3846# a_746_330# 2.44027f
C180 a_3010_446# VSS 0.01185f
C181 VDD a_8858_3846# 3.2189f
C182 a_6626_3846# OUT 3.12787f
C183 a_14338_3730# a_8330_446# 0.43531f
C184 a_746_330# VDD 0.37549f
C185 a_946_446# a_746_330# 0.02626f
C186 a_17222_446# a_16202_446# 0.02626f
C187 a_14_330# a_14338_3730# 0.35408f
C188 a_4042_446# a_4342_446# 0.02633f
C189 a_16162_3846# a_15962_3730# 0.05253f
C190 a_6626_3846# INP 1.59929f
C191 VDD a_9974_3846# 1.48215f
C192 a_13794_330# a_746_330# 0.61825f
C193 VDD OUT 1.20423f
C194 a_9974_3846# a_8858_3846# 0.13349f
C195 VSS a_5074_446# 0.04614f
C196 a_6106_446# a_14338_3730# 0.01111f
C197 INP VDD 0.19648f
C198 a_13794_330# OUT 0.24821f
C199 a_14338_3730# a_9442_446# 0.51724f
C200 a_1366_3846# a_746_330# 0.05253f
C201 a_7742_3846# a_7218_446# 2.36923f
C202 a_4342_446# a_5074_446# 0.02692f
C203 a_14338_3730# a_354_3730# 0.16636f
C204 a_746_330# a_7218_446# 0.02258f
C205 a_15458_446# OUT 0.01081f
C206 a_6626_3846# VDD 0.19132f
C207 a_14338_3730# a_54_3730# 1.23727f
C208 a_16202_446# OUT 0.19238f
C209 a_14338_3730# VSS 0.10152f
C210 a_6626_3846# a_13794_330# 0.49669f
C211 a_7218_446# OUT 0.04526f
C212 a_3290_3846# OUT 0.01822f
C213 a_8330_446# a_7742_3846# 2.84996f
C214 a_13794_330# VDD 0.45504f
C215 a_14_330# a_7742_3846# 0.73316f
C216 a_15962_3730# OUT 0.06118f
C217 a_8330_446# a_746_330# 0.09971f
C218 a_6106_446# a_7742_3846# 0.0812f
C219 a_14_330# a_746_330# 6.71982f
C220 a_6626_3846# a_16202_446# 0.02507f
C221 a_1366_3846# VDD 0.06858f
C222 a_6626_3846# a_7218_446# 0.02475f
C223 a_9442_446# a_7742_3846# 0.02869f
C224 a_8330_446# OUT 0.14218f
C225 a_14_330# OUT 0.56307f
C226 a_17222_446# VSS 0.04136f
C227 a_6106_446# a_746_330# 0.30566f
C228 VDD a_14338_3730# 1.48861f
C229 a_6626_3846# a_15962_3730# 0.415f
C230 a_14_330# INP 0.06198f
C231 a_7218_446# VDD 2.04322f
C232 a_13794_330# a_16202_446# 1.21284f
C233 a_9442_446# a_746_330# 0.04775f
C234 a_7742_3846# a_354_3730# 0.03264f
C235 a_3290_3846# VDD 0.06858f
C236 a_14338_3730# a_8858_3846# 0.42025f
C237 a_6106_446# OUT 1.64741f
C238 INN a_7742_3846# 1.62399f
C239 a_7742_3846# a_54_3730# 0.07899f
C240 VSS VSS 18.3146f
C241 OUT VSS 8.87847f
C242 VDD VSS 10.3358f
C243 INN VSS 1.42878f
C244 INP VSS 1.52214f
C245 a_4342_446# VSS 1.75122f
C246 a_16202_446# VSS 1.04782f
C247 a_13794_330# VSS 2.7923f
C248 a_9442_446# VSS 3.36475f
C249 a_8330_446# VSS 5.38192f
C250 a_6106_446# VSS 3.02055f
C251 a_7218_446# VSS 1.41237f
C252 a_8858_3846# VSS 1.99977f
C253 a_7742_3846# VSS 1.93215f
C254 a_6626_3846# VSS 3.77297f
C255 a_4702_3846# VSS 1.4319f
C256 a_746_330# VSS 3.58509f
C257 a_14_330# VSS 8.05773f
C258 a_9974_3846# VSS 1.95877f
C259 a_14338_3730# VSS 1.10362f
C260 a_15962_3730# VSS 1.22769f
C261 a_354_3730# VSS 6.3417f
C262 a_54_3730# VSS 3.16696f
C263 VDD VSS 0.16751p
.ends
