* Nodos de bulk atados: 1 de pozo n -> VDD, 1 de sustrato -> VSS.
*   magic no extrae los taps de este layout y los dejaba flotando;
*   la conexion si existe (el LVS de KLayout da 'match uniquely').
*   Quien detecta un tap que falte de verdad es el LVS, no esto.
* NGSPICE file created from COMP.ext - technology: gf180mcuD

.subckt COMP VSS VDD OUT INP INN
X0 VSS a_8330_446# a_6626_3846# VSS nfet_06v0 ad=1.1p pd=5.88u as=0.65p ps=3.02u w=2.5u l=1u
X1 a_4702_3846# INN a_7742_3846# VDD pfet_06v0 ad=4.4p pd=20.88u as=2.6p ps=10.52u w=10u l=1u
X2 a_9442_446# a_14338_3730# a_9974_3846# VDD pfet_06v0 ad=2.2p pd=10.88u as=2.2p ps=10.88u w=5u l=1u
X3 a_4342_446# a_14_330# a_5074_446# VSS nfet_06v0 ad=2.2p pd=10.88u as=1.25p ps=5.5u w=5u l=1u
X4 a_4702_3846# a_354_3730# a_5514_3846# VDD pfet_06v0 ad=4.4p pd=20.88u as=2.5p ps=10.5u w=10u l=1u
X5 a_6106_446# a_354_3730# a_9974_3846# VDD pfet_06v0 ad=2.2p pd=10.88u as=1.3p ps=5.52u w=5u l=1u
X6 a_14_330# a_14_330# VSS VSS nfet_06v0 ad=0.44p pd=2.88u as=0.44p ps=2.88u w=1u l=1u
X7 a_7218_446# INN a_4342_446# VSS nfet_06v0 ad=1.3p pd=5.52u as=2.2p ps=10.88u w=5u l=1u
X8 a_7218_446# a_354_3730# a_8858_3846# VDD pfet_06v0 ad=2.2p pd=10.88u as=1.3p ps=5.52u w=5u l=1u
X9 a_5074_446# a_746_330# VSS VSS nfet_06v0 ad=1.25p pd=5.5u as=2.2p ps=10.88u w=5u l=1u
X10 a_9442_446# a_14_330# a_6626_3846# VSS nfet_06v0 ad=0.65p pd=3.02u as=1.1p ps=5.88u w=2.5u l=1u
X11 a_6626_3846# OUT cap_mim_2f0_m4m5_noshield c_width=20u c_length=10u
X12 a_4702_3846# INP a_6626_3846# VDD pfet_06v0 ad=4.4p pd=20.88u as=2.6p ps=10.52u w=10u l=1u
X13 VDD a_8858_3846# a_7218_446# VDD pfet_06v0 ad=1.3p pd=5.52u as=1.3p ps=5.52u w=5u l=1u
X14 a_8330_446# a_14338_3730# a_8858_3846# VDD pfet_06v0 ad=2.2p pd=10.88u as=2.2p ps=10.88u w=5u l=1u
X15 VDD a_9974_3846# OUT VDD pfet_06v0 ad=2.6p pd=10.52u as=2.6p ps=10.52u w=10u l=1u
X16 a_6626_3846# a_8330_446# VSS VSS nfet_06v0 ad=0.65p pd=3.02u as=0.65p ps=3.02u w=2.5u l=1u
X17 a_946_446# a_746_330# VSS VSS nfet_06v0 ad=1.25p pd=5.5u as=2.2p ps=10.88u w=5u l=1u
X18 OUT a_9442_446# VSS VSS nfet_06v0 ad=2.2p pd=10.88u as=1.3p ps=5.52u w=5u l=1u
X19 a_4702_3846# a_354_3730# a_4402_3846# VDD pfet_06v0 ad=4.4p pd=20.88u as=2.5p ps=10.5u w=10u l=1u
X20 a_9974_3846# a_13794_330# a_9442_446# VSS nfet_06v0 ad=1.1p pd=5.88u as=1.1p ps=5.88u w=2.5u l=1u
X21 a_6106_446# a_8858_3846# VDD VDD pfet_06v0 ad=1.3p pd=5.52u as=2.2p ps=10.88u w=5u l=1u
X22 a_16162_3846# a_15962_3730# VDD VDD pfet_06v0 ad=2.5p pd=10.5u as=4.4p ps=20.88u w=10u l=1u
X23 a_4342_446# INP a_6106_446# VSS nfet_06v0 ad=2.2p pd=10.88u as=1.3p ps=5.52u w=5u l=1u
X24 a_7742_3846# a_8330_446# VSS VSS nfet_06v0 ad=0.65p pd=3.02u as=0.65p ps=3.02u w=2.5u l=1u
X25 a_17222_446# a_16202_446# VSS VSS nfet_06v0 ad=1.25p pd=5.5u as=2.2p ps=10.88u w=5u l=1u
X26 a_354_3730# a_354_3730# a_3010_446# VSS nfet_06v0 ad=0.44p pd=2.88u as=0.25p ps=1.5u w=1u l=1u
X27 a_13794_330# a_354_3730# a_18086_3846# VDD pfet_06v0 ad=4.4p pd=20.88u as=2.5p ps=10.5u w=10u l=1u
X28 a_3290_3846# a_54_3730# VDD VDD pfet_06v0 ad=2.5p pd=10.5u as=4.4p ps=20.88u w=10u l=1u
X29 a_6106_446# a_8858_3846# VDD VDD pfet_06v0 ad=1.3p pd=5.52u as=1.3p ps=5.52u w=5u l=1u
X30 a_746_330# a_14_330# a_946_446# VSS nfet_06v0 ad=2.2p pd=10.88u as=1.25p ps=5.5u w=5u l=1u
X31 a_7742_3846# a_14_330# a_8330_446# VSS nfet_06v0 ad=1.1p pd=5.88u as=0.65p ps=3.02u w=2.5u l=1u
X32 VSS a_8330_446# a_6626_3846# VSS nfet_06v0 ad=0.65p pd=3.02u as=0.65p ps=3.02u w=2.5u l=1u
X33 a_16202_446# a_14_330# a_17222_446# VSS nfet_06v0 ad=2.2p pd=10.88u as=1.25p ps=5.5u w=5u l=1u
X34 OUT a_6106_446# cap_mim_2f0_m4m5_noshield c_width=20u c_length=10u
X35 a_7218_446# a_8858_3846# VDD VDD pfet_06v0 ad=1.3p pd=5.52u as=1.3p ps=5.52u w=5u l=1u
X36 OUT a_9974_3846# VDD VDD pfet_06v0 ad=4.4p pd=20.88u as=2.6p ps=10.52u w=10u l=1u
X37 a_14_330# a_354_3730# a_254_3846# VDD pfet_06v0 ad=4.4p pd=20.88u as=2.5p ps=10.5u w=10u l=1u
X38 a_14338_3730# a_14338_3730# a_15962_3730# VDD pfet_06v0 ad=4.4p pd=20.88u as=4.4p ps=20.88u w=10u l=1u
X39 a_3010_446# a_354_3730# VSS VSS nfet_06v0 ad=0.25p pd=1.5u as=0.44p ps=2.88u w=1u l=1u
X40 VSS a_9442_446# OUT VSS nfet_06v0 ad=1.3p pd=5.52u as=1.3p ps=5.52u w=5u l=1u
X41 VSS a_8330_446# a_7742_3846# VSS nfet_06v0 ad=0.65p pd=3.02u as=0.65p ps=3.02u w=2.5u l=1u
X42 a_15458_446# a_746_330# VSS VSS nfet_06v0 ad=1.25p pd=5.5u as=2.2p ps=10.88u w=5u l=1u
X43 a_354_3730# a_354_3730# VDD VDD pfet_06v0 ad=0.88p pd=4.88u as=0.88p ps=4.88u w=2u l=1u
X44 VDD a_8858_3846# a_6106_446# VDD pfet_06v0 ad=1.3p pd=5.52u as=1.3p ps=5.52u w=5u l=1u
X45 a_8858_3846# a_354_3730# a_7218_446# VDD pfet_06v0 ad=1.3p pd=5.52u as=2.2p ps=10.88u w=5u l=1u
X46 a_7218_446# a_8858_3846# VDD VDD pfet_06v0 ad=1.3p pd=5.52u as=2.2p ps=10.88u w=5u l=1u
X47 OUT a_9974_3846# VDD VDD pfet_06v0 ad=2.6p pd=10.52u as=4.4p ps=20.88u w=10u l=1u
X48 a_8330_446# a_14_330# a_7742_3846# VSS nfet_06v0 ad=0.65p pd=3.02u as=1.1p ps=5.88u w=2.5u l=1u
X49 a_6626_3846# a_8330_446# VSS VSS nfet_06v0 ad=0.65p pd=3.02u as=1.1p ps=5.88u w=2.5u l=1u
X50 a_14338_3730# a_14_330# a_15458_446# VSS nfet_06v0 ad=2.2p pd=10.88u as=1.25p ps=5.5u w=5u l=1u
X51 VDD a_8858_3846# a_6106_446# VDD pfet_06v0 ad=2.2p pd=10.88u as=1.3p ps=5.52u w=5u l=1u
X52 a_54_3730# a_354_3730# a_3290_3846# VDD pfet_06v0 ad=4.4p pd=20.88u as=2.5p ps=10.5u w=10u l=1u
X53 a_4342_446# a_14_330# a_4042_446# VSS nfet_06v0 ad=2.2p pd=10.88u as=1.25p ps=5.5u w=5u l=1u
X54 OUT a_9442_446# VSS VSS nfet_06v0 ad=1.3p pd=5.52u as=2.2p ps=10.88u w=5u l=1u
X55 a_1366_3846# a_54_3730# VDD VDD pfet_06v0 ad=2.5p pd=10.5u as=4.4p ps=20.88u w=10u l=1u
X56 a_6626_3846# INP a_4702_3846# VDD pfet_06v0 ad=2.6p pd=10.52u as=4.4p ps=20.88u w=10u l=1u
X57 a_9974_3846# a_354_3730# a_6106_446# VDD pfet_06v0 ad=1.3p pd=5.52u as=2.2p ps=10.88u w=5u l=1u
X58 VDD a_8858_3846# a_7218_446# VDD pfet_06v0 ad=2.2p pd=10.88u as=1.3p ps=5.52u w=5u l=1u
X59 a_7742_3846# a_8330_446# VSS VSS nfet_06v0 ad=0.65p pd=3.02u as=1.1p ps=5.88u w=2.5u l=1u
X60 a_18086_3846# a_54_3730# VDD VDD pfet_06v0 ad=2.5p pd=10.5u as=4.4p ps=20.88u w=10u l=1u
X61 a_54_3730# a_354_3730# a_1978_446# VSS nfet_06v0 ad=0.44p pd=2.88u as=0.25p ps=1.5u w=1u l=1u
X62 a_8858_3846# a_13794_330# a_8330_446# VSS nfet_06v0 ad=1.1p pd=5.88u as=1.1p ps=5.88u w=2.5u l=1u
X63 a_7742_3846# INN a_4702_3846# VDD pfet_06v0 ad=2.6p pd=10.52u as=4.4p ps=20.88u w=10u l=1u
X64 a_6106_446# INP a_4342_446# VSS nfet_06v0 ad=1.3p pd=5.52u as=2.2p ps=10.88u w=5u l=1u
X65 a_13794_330# a_13794_330# a_16202_446# VSS nfet_06v0 ad=2.2p pd=10.88u as=2.2p ps=10.88u w=5u l=1u
X66 a_4042_446# a_746_330# VSS VSS nfet_06v0 ad=1.25p pd=5.5u as=2.2p ps=10.88u w=5u l=1u
X67 a_254_3846# a_54_3730# VDD VDD pfet_06v0 ad=2.5p pd=10.5u as=4.4p ps=20.88u w=10u l=1u
X68 a_5514_3846# a_54_3730# VDD VDD pfet_06v0 ad=2.5p pd=10.5u as=4.4p ps=20.88u w=10u l=1u
X69 a_4342_446# INN a_7218_446# VSS nfet_06v0 ad=2.2p pd=10.88u as=1.3p ps=5.52u w=5u l=1u
X70 VSS a_8330_446# a_7742_3846# VSS nfet_06v0 ad=1.1p pd=5.88u as=0.65p ps=3.02u w=2.5u l=1u
X71 a_15962_3730# a_354_3730# a_16162_3846# VDD pfet_06v0 ad=4.4p pd=20.88u as=2.5p ps=10.5u w=10u l=1u
X72 a_1978_446# a_354_3730# VSS VSS nfet_06v0 ad=0.25p pd=1.5u as=0.44p ps=2.88u w=1u l=1u
X73 a_746_330# a_354_3730# a_1366_3846# VDD pfet_06v0 ad=4.4p pd=20.88u as=2.5p ps=10.5u w=10u l=1u
X74 a_4402_3846# a_54_3730# VDD VDD pfet_06v0 ad=2.5p pd=10.5u as=4.4p ps=20.88u w=10u l=1u
X75 a_6626_3846# a_14_330# a_9442_446# VSS nfet_06v0 ad=1.1p pd=5.88u as=0.65p ps=3.02u w=2.5u l=1u
C0 a_14_330# VSS 1.26713f
C1 a_15458_446# a_14338_3730# 0.02626f
C2 a_746_330# a_354_3730# 1.49f
C3 a_6106_446# a_14_330# 0.16157f
C4 VSS a_5074_446# 0.04614f
C5 a_254_3846# a_14_330# 0.05253f
C6 VSS a_13794_330# 0.42843f
C7 a_15962_3730# a_16162_3846# 0.05253f
C8 a_6626_3846# a_7742_3846# 0.06784f
C9 a_15962_3730# a_9974_3846# 0.0701f
C10 a_6106_446# a_13794_330# 0.08285f
C11 VSS a_8858_3846# 0.01955f
C12 a_5514_3846# OUT 0.01822f
C13 a_54_3730# INN 0.05815f
C14 a_6106_446# a_8858_3846# 2.28796f
C15 a_14338_3730# a_6626_3846# 0.36299f
C16 VSS a_746_330# 1.26176f
C17 a_7218_446# a_14_330# 0.08487f
C18 a_4702_3846# a_6626_3846# 3.15074f
C19 INP INN 0.04686f
C20 a_6106_446# a_746_330# 0.30566f
C21 VDD INN 0.63321f
C22 VSS a_354_3730# 0.7105f
C23 OUT INN 0.0785f
C24 a_8330_446# a_14_330# 0.75488f
C25 a_16202_446# OUT 0.19238f
C26 a_6106_446# a_354_3730# 1.33321f
C27 OUT a_18086_3846# 0.0112f
C28 a_7218_446# a_8858_3846# 2.75163f
C29 a_7742_3846# VDD 0.07141f
C30 a_8330_446# a_13794_330# 0.61226f
C31 a_9442_446# a_9974_3846# 3.41638f
C32 a_7218_446# a_746_330# 0.02258f
C33 a_3290_3846# VDD 0.06858f
C34 a_8330_446# a_8858_3846# 2.26727f
C35 a_14_330# a_54_3730# 0.1928f
C36 a_14338_3730# VDD 0.33864f
C37 a_7218_446# a_354_3730# 1.09037f
C38 a_4702_3846# VDD 0.70048f
C39 INP a_14_330# 0.06209f
C40 a_6106_446# VSS 0.05469f
C41 a_8330_446# a_746_330# 0.09971f
C42 a_14_330# VDD 0.29863f
C43 OUT a_14_330# 0.56307f
C44 a_8330_446# a_354_3730# 0.03395f
C45 a_54_3730# a_13794_330# 0.07219f
C46 a_54_3730# a_8858_3846# 0.17132f
C47 VDD a_13794_330# 0.26427f
C48 OUT a_13794_330# 0.24821f
C49 a_54_3730# a_746_330# 0.25573f
C50 a_7218_446# VSS 0.04503f
C51 VDD a_8858_3846# 3.2189f
C52 OUT a_8858_3846# 0.03692f
C53 INP a_746_330# 0.03059f
C54 a_7218_446# a_6106_446# 1.77202f
C55 a_16162_3846# a_6626_3846# 0.01077f
C56 a_54_3730# a_354_3730# 9.97459f
C57 VDD a_746_330# 0.29876f
C58 a_8330_446# VSS 2.41943f
C59 a_9974_3846# a_6626_3846# 0.41181f
C60 a_6626_3846# a_4342_446# 0.03333f
C61 a_9442_446# a_15962_3730# 0.22926f
C62 OUT a_746_330# 0.31979f
C63 INP a_354_3730# 0.04002f
C64 VDD a_354_3730# 5.46305f
C65 a_6106_446# a_8330_446# 0.56635f
C66 a_5514_3846# a_4702_3846# 0.0531f
C67 OUT a_354_3730# 1.00366f
C68 a_7742_3846# INN 1.6238f
C69 VSS a_54_3730# 0.06042f
C70 a_16202_446# a_14338_3730# 0.19002f
C71 a_4702_3846# INN 2.06262f
C72 INP VSS 0.12369f
C73 a_6106_446# a_54_3730# 0.23677f
C74 a_7218_446# a_8330_446# 0.27241f
C75 a_16162_3846# VDD 0.06858f
C76 OUT VSS 0.81341f
C77 INP a_6106_446# 1.41613f
C78 a_6106_446# VDD 1.0275f
C79 a_9974_3846# VDD 2.43944f
C80 a_6106_446# OUT 1.64741f
C81 a_15962_3730# a_6626_3846# 0.415f
C82 a_14_330# a_7742_3846# 0.73316f
C83 a_7218_446# a_54_3730# 0.062f
C84 a_4042_446# VSS 0.0407f
C85 a_14338_3730# a_14_330# 0.35408f
C86 a_7218_446# VDD 0.71248f
C87 a_8330_446# a_54_3730# 0.05867f
C88 a_7218_446# OUT 0.04526f
C89 a_8330_446# VDD 0.186f
C90 a_14338_3730# a_13794_330# 0.05296f
C91 a_8330_446# OUT 0.14218f
C92 a_7742_3846# a_746_330# 0.04856f
C93 a_14338_3730# a_8858_3846# 0.42025f
C94 a_15962_3730# VDD 0.59934f
C95 a_7742_3846# a_354_3730# 0.03264f
C96 a_9442_446# a_6626_3846# 1.26538f
C97 a_14338_3730# a_746_330# 0.04417f
C98 INP a_54_3730# 0.03049f
C99 VDD a_54_3730# 2.52564f
C100 a_14338_3730# a_354_3730# 0.16636f
C101 OUT a_54_3730# 0.83759f
C102 a_4702_3846# a_354_3730# 1.17978f
C103 INP VDD 0.62781f
C104 a_4342_446# INN 0.9337f
C105 INP OUT 0.27283f
C106 OUT VDD 1.12743f
C107 VSS a_7742_3846# 1.36068f
C108 a_6106_446# a_7742_3846# 0.0812f
C109 a_4402_3846# OUT 0.01822f
C110 a_14338_3730# VSS 0.10152f
C111 a_9442_446# VDD 0.09917f
C112 a_6106_446# a_14338_3730# 0.01111f
C113 a_6106_446# a_4702_3846# 0.17509f
C114 a_9974_3846# a_14_330# 0.02906f
C115 a_14_330# a_4342_446# 0.81367f
C116 a_7218_446# a_7742_3846# 2.36923f
C117 a_4342_446# a_5074_446# 0.02692f
C118 a_9974_3846# a_13794_330# 0.64684f
C119 a_8330_446# a_7742_3846# 2.84996f
C120 a_3010_446# VSS 0.01185f
C121 a_9974_3846# a_8858_3846# 0.13349f
C122 a_14338_3730# a_8330_446# 0.43531f
C123 a_9974_3846# a_746_330# 0.06533f
C124 a_4342_446# a_746_330# 1.17127f
C125 a_1978_446# VSS 0.01078f
C126 a_6626_3846# VDD 0.19132f
C127 a_9974_3846# a_354_3730# 0.9614f
C128 a_7742_3846# a_54_3730# 0.07899f
C129 a_3290_3846# a_54_3730# 0.05253f
C130 VDD a_7742_3846# 0.4962f
C131 a_14338_3730# a_54_3730# 1.23727f
C132 OUT a_7742_3846# 0.06743f
C133 a_9442_446# a_16202_446# 0.02898f
C134 a_4702_3846# a_54_3730# 0.49066f
C135 a_1366_3846# VDD 0.06858f
C136 a_3290_3846# OUT 0.01822f
C137 INP a_4702_3846# 2.06846f
C138 a_14338_3730# VDD 1.48861f
C139 a_4702_3846# VDD 1.56792f
C140 a_15962_3730# a_13794_330# 0.43475f
C141 a_9974_3846# VSS 0.13909f
C142 a_14338_3730# OUT 0.11249f
C143 VSS a_4342_446# 0.58362f
C144 a_4702_3846# OUT 0.6869f
C145 a_6106_446# a_9974_3846# 1.34564f
C146 a_6106_446# a_4342_446# 2.01702f
C147 a_4402_3846# a_4702_3846# 0.05253f
C148 a_15962_3730# a_354_3730# 0.68913f
C149 a_9442_446# a_14_330# 0.67159f
C150 a_7218_446# a_9974_3846# 0.03369f
C151 a_7218_446# a_4342_446# 1.29732f
C152 a_6626_3846# INN 0.23769f
C153 a_16202_446# a_6626_3846# 0.02507f
C154 a_9442_446# a_13794_330# 1.16007f
C155 a_8330_446# a_9974_3846# 0.34052f
C156 a_6626_3846# a_18086_3846# 0.01077f
C157 a_9442_446# a_8858_3846# 2.10553f
C158 a_9442_446# a_746_330# 0.04775f
C159 a_5514_3846# VDD 0.07134f
C160 a_9442_446# a_354_3730# 0.04283f
C161 a_9974_3846# a_54_3730# 0.89248f
C162 a_4342_446# a_54_3730# 0.01731f
C163 a_6626_3846# a_14_330# 0.76818f
C164 INP a_4342_446# 1.12825f
C165 INN VDD 0.19777f
C166 OUT a_16162_3846# 0.01091f
C167 a_9974_3846# VDD 1.48215f
C168 a_9974_3846# OUT 2.08059f
C169 OUT a_4342_446# 0.11403f
C170 a_4702_3846# a_7742_3846# 2.48508f
C171 a_18086_3846# VDD 0.06915f
C172 a_16202_446# a_17222_446# 0.02626f
C173 a_6626_3846# a_13794_330# 0.49669f
C174 a_9442_446# VSS 1.60874f
C175 a_6626_3846# a_8858_3846# 0.02783f
C176 a_9442_446# a_6106_446# 0.16895f
C177 a_6626_3846# a_746_330# 2.44027f
C178 a_4042_446# a_4342_446# 0.02633f
C179 a_6626_3846# a_354_3730# 0.5046f
C180 a_15458_446# VSS 0.04658f
C181 a_14_330# VDD 0.37462f
C182 a_15962_3730# a_54_3730# 0.06852f
C183 a_9442_446# a_7218_446# 0.04888f
C184 a_15962_3730# VDD 0.95811f
C185 a_1366_3846# a_746_330# 0.05253f
C186 a_13794_330# VDD 0.45504f
C187 a_15962_3730# OUT 0.06118f
C188 a_9442_446# a_8330_446# 0.36749f
C189 a_8858_3846# VDD 2.81338f
C190 a_6626_3846# VSS 1.23082f
C191 a_746_330# VDD 0.37549f
C192 a_6106_446# a_6626_3846# 2.47708f
C193 a_354_3730# VDD 1.70085f
C194 a_9442_446# a_54_3730# 0.08618f
C195 a_9442_446# VDD 0.19055f
C196 a_9442_446# OUT 1.27084f
C197 a_7218_446# a_6626_3846# 0.02475f
C198 a_14338_3730# a_9974_3846# 1.62645f
C199 a_4702_3846# a_4342_446# 0.09387f
C200 a_14_330# INN 0.0585f
C201 a_16202_446# a_14_330# 1.03426f
C202 a_8330_446# a_6626_3846# 1.57763f
C203 a_6106_446# VDD 1.8806f
C204 a_17222_446# VSS 0.04136f
C205 a_254_3846# VDD 0.07506f
C206 a_15458_446# OUT 0.01081f
C207 a_16202_446# a_13794_330# 1.21284f
C208 a_18086_3846# a_13794_330# 0.05253f
C209 a_6626_3846# a_54_3730# 0.27844f
C210 a_746_330# INN 0.02923f
C211 a_7218_446# VDD 2.04322f
C212 INP a_6626_3846# 1.59929f
C213 a_6626_3846# VDD 0.79356f
C214 a_354_3730# INN 0.03792f
C215 OUT a_6626_3846# 3.12786f
C216 a_15962_3730# a_14338_3730# 1.21941f
C217 a_14_330# a_13794_330# 0.28729f
C218 a_946_446# a_746_330# 0.02626f
C219 a_14_330# a_8858_3846# 0.02788f
C220 VSS INN 0.12481f
C221 a_14_330# a_746_330# 6.71982f
C222 a_16202_446# VSS 0.60905f
C223 a_54_3730# VDD 2.77898f
C224 a_6106_446# INN 0.21646f
C225 a_9442_446# a_7742_3846# 0.02869f
C226 INP VDD 0.19648f
C227 a_13794_330# a_8858_3846# 0.56301f
C228 a_14_330# a_354_3730# 0.61635f
C229 VDD VDD 11.6433f
C230 OUT VDD 1.20423f
C231 a_13794_330# a_746_330# 0.61825f
C232 a_9442_446# a_14338_3730# 0.51724f
C233 a_4402_3846# VDD 0.06858f
C234 a_17222_446# OUT 0.01114f
C235 a_8858_3846# a_746_330# 0.0202f
C236 a_13794_330# a_354_3730# 0.43702f
C237 a_946_446# VSS 0.0407f
C238 a_7218_446# INN 1.02637f
C239 a_8858_3846# a_354_3730# 1.03453f
C240 VSS VSS 18.3146f
C241 OUT VSS 8.89507f
C242 VDD VSS 10.3358f
C243 INN VSS 1.46835f
C244 INP VSS 1.52588f
C245 a_4342_446# VSS 1.75118f
C246 a_16202_446# VSS 1.04782f
C247 a_13794_330# VSS 2.7923f
C248 a_9442_446# VSS 3.36475f
C249 a_8330_446# VSS 5.38192f
C250 a_6106_446# VSS 3.02014f
C251 a_7218_446# VSS 1.41237f
C252 a_8858_3846# VSS 1.99977f
C253 a_7742_3846# VSS 1.93215f
C254 a_6626_3846# VSS 3.77297f
C255 a_4702_3846# VSS 1.43172f
C256 a_746_330# VSS 3.58509f
C257 a_14_330# VSS 8.05773f
C258 a_9974_3846# VSS 1.9588f
C259 a_14338_3730# VSS 1.10362f
C260 a_15962_3730# VSS 1.22769f
C261 a_354_3730# VSS 6.3417f
C262 a_54_3730# VSS 3.16696f
C263 VDD VSS 0.16751p
.ends
