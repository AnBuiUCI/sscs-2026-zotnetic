* Nodos de bulk atados: 1 de pozo n -> VDD, 1 de sustrato -> VSS.
*   magic no extrae los taps de este layout y los dejaba flotando;
*   la conexion si existe (el LVS de KLayout da 'match uniquely').
*   Quien detecta un tap que falte de verdad es el LVS, no esto.
* NGSPICE file created from COMP.ext - technology: gf180mcuD

.subckt COMP VSS VDD OUT IN+ IN-
X0 VSS a_8330_446# a_6626_3846# VSS nfet_06v0 ad=1.1p pd=5.88u as=0.65p ps=3.02u w=2.5u l=1u
X1 a_4702_3846# IN- a_7742_3846# VDD pfet_06v0 ad=4.4p pd=20.88u as=2.6p ps=10.52u w=10u l=1u
X2 a_9442_446# a_14338_3730# a_9974_3846# VDD pfet_06v0 ad=2.2p pd=10.88u as=2.2p ps=10.88u w=5u l=1u
X3 a_4342_446# a_14_330# a_5074_446# VSS nfet_06v0 ad=2.2p pd=10.88u as=1.25p ps=5.5u w=5u l=1u
X4 a_4702_3846# a_354_3730# a_5514_3846# VDD pfet_06v0 ad=4.4p pd=20.88u as=2.5p ps=10.5u w=10u l=1u
X5 a_6106_446# a_354_3730# a_9974_3846# VDD pfet_06v0 ad=2.2p pd=10.88u as=1.3p ps=5.52u w=5u l=1u
X6 a_14_330# a_14_330# VSS VSS nfet_06v0 ad=0.44p pd=2.88u as=0.44p ps=2.88u w=1u l=1u
X7 a_7218_446# IN- a_4342_446# VSS nfet_06v0 ad=1.3p pd=5.52u as=2.2p ps=10.88u w=5u l=1u
X8 a_7218_446# a_354_3730# a_8858_3846# VDD pfet_06v0 ad=2.2p pd=10.88u as=1.3p ps=5.52u w=5u l=1u
X9 a_5074_446# a_746_330# VSS VSS nfet_06v0 ad=1.25p pd=5.5u as=2.2p ps=10.88u w=5u l=1u
X10 a_9442_446# a_14_330# a_6626_3846# VSS nfet_06v0 ad=0.65p pd=3.02u as=1.1p ps=5.88u w=2.5u l=1u
X11 a_4702_3846# IN+ a_6626_3846# VDD pfet_06v0 ad=4.4p pd=20.88u as=2.6p ps=10.52u w=10u l=1u
X12 VDD a_8858_3846# a_7218_446# VDD pfet_06v0 ad=1.3p pd=5.52u as=1.3p ps=5.52u w=5u l=1u
X13 a_8330_446# a_14338_3730# a_8858_3846# VDD pfet_06v0 ad=2.2p pd=10.88u as=2.2p ps=10.88u w=5u l=1u
X14 VDD a_9974_3846# OUT VDD pfet_06v0 ad=2.6p pd=10.52u as=2.6p ps=10.52u w=10u l=1u
X15 a_6626_3846# a_8330_446# VSS VSS nfet_06v0 ad=0.65p pd=3.02u as=0.65p ps=3.02u w=2.5u l=1u
X16 a_946_446# a_746_330# VSS VSS nfet_06v0 ad=1.25p pd=5.5u as=2.2p ps=10.88u w=5u l=1u
X17 OUT a_9442_446# VSS VSS nfet_06v0 ad=2.2p pd=10.88u as=1.3p ps=5.52u w=5u l=1u
X18 a_4702_3846# a_354_3730# a_4402_3846# VDD pfet_06v0 ad=4.4p pd=20.88u as=2.5p ps=10.5u w=10u l=1u
X19 a_9974_3846# a_13794_330# a_9442_446# VSS nfet_06v0 ad=1.1p pd=5.88u as=1.1p ps=5.88u w=2.5u l=1u
X20 a_6106_446# a_8858_3846# VDD VDD pfet_06v0 ad=1.3p pd=5.52u as=2.2p ps=10.88u w=5u l=1u
X21 a_16162_3846# a_15962_3730# VDD VDD pfet_06v0 ad=2.5p pd=10.5u as=4.4p ps=20.88u w=10u l=1u
X22 a_4342_446# IN+ a_6106_446# VSS nfet_06v0 ad=2.2p pd=10.88u as=1.3p ps=5.52u w=5u l=1u
X23 a_7742_3846# a_8330_446# VSS VSS nfet_06v0 ad=0.65p pd=3.02u as=0.65p ps=3.02u w=2.5u l=1u
X24 a_17222_446# a_16202_446# VSS VSS nfet_06v0 ad=1.25p pd=5.5u as=2.2p ps=10.88u w=5u l=1u
X25 a_354_3730# a_354_3730# a_3010_446# VSS nfet_06v0 ad=0.44p pd=2.88u as=0.25p ps=1.5u w=1u l=1u
X26 a_13794_330# a_354_3730# a_18086_3846# VDD pfet_06v0 ad=4.4p pd=20.88u as=2.5p ps=10.5u w=10u l=1u
X27 a_3290_3846# a_54_3730# VDD VDD pfet_06v0 ad=2.5p pd=10.5u as=4.4p ps=20.88u w=10u l=1u
X28 a_6106_446# a_8858_3846# VDD VDD pfet_06v0 ad=1.3p pd=5.52u as=1.3p ps=5.52u w=5u l=1u
X29 a_746_330# a_14_330# a_946_446# VSS nfet_06v0 ad=2.2p pd=10.88u as=1.25p ps=5.5u w=5u l=1u
X30 a_7742_3846# a_14_330# a_8330_446# VSS nfet_06v0 ad=1.1p pd=5.88u as=0.65p ps=3.02u w=2.5u l=1u
X31 VSS a_8330_446# a_6626_3846# VSS nfet_06v0 ad=0.65p pd=3.02u as=0.65p ps=3.02u w=2.5u l=1u
X32 a_16202_446# a_14_330# a_17222_446# VSS nfet_06v0 ad=2.2p pd=10.88u as=1.25p ps=5.5u w=5u l=1u
X33 m4_2716_2430# a_6106_446# cap_mim_2f0_m4m5_noshield c_width=20u c_length=10u
X34 a_7218_446# a_8858_3846# VDD VDD pfet_06v0 ad=1.3p pd=5.52u as=1.3p ps=5.52u w=5u l=1u
X35 OUT a_9974_3846# VDD VDD pfet_06v0 ad=4.4p pd=20.88u as=2.6p ps=10.52u w=10u l=1u
X36 a_14_330# a_354_3730# a_254_3846# VDD pfet_06v0 ad=4.4p pd=20.88u as=2.5p ps=10.5u w=10u l=1u
X37 a_14338_3730# a_14338_3730# a_15962_3730# VDD pfet_06v0 ad=4.4p pd=20.88u as=4.4p ps=20.88u w=10u l=1u
X38 a_3010_446# a_354_3730# VSS VSS nfet_06v0 ad=0.25p pd=1.5u as=0.44p ps=2.88u w=1u l=1u
X39 VSS a_9442_446# OUT VSS nfet_06v0 ad=1.3p pd=5.52u as=1.3p ps=5.52u w=5u l=1u
X40 VSS a_8330_446# a_7742_3846# VSS nfet_06v0 ad=0.65p pd=3.02u as=0.65p ps=3.02u w=2.5u l=1u
X41 a_15458_446# a_746_330# VSS VSS nfet_06v0 ad=1.25p pd=5.5u as=2.2p ps=10.88u w=5u l=1u
X42 a_354_3730# a_354_3730# VDD VDD pfet_06v0 ad=0.88p pd=4.88u as=0.88p ps=4.88u w=2u l=1u
X43 VDD a_8858_3846# a_6106_446# VDD pfet_06v0 ad=1.3p pd=5.52u as=1.3p ps=5.52u w=5u l=1u
X44 a_8858_3846# a_354_3730# a_7218_446# VDD pfet_06v0 ad=1.3p pd=5.52u as=2.2p ps=10.88u w=5u l=1u
X45 a_7218_446# a_8858_3846# VDD VDD pfet_06v0 ad=1.3p pd=5.52u as=2.2p ps=10.88u w=5u l=1u
X46 OUT a_9974_3846# VDD VDD pfet_06v0 ad=2.6p pd=10.52u as=4.4p ps=20.88u w=10u l=1u
X47 a_8330_446# a_14_330# a_7742_3846# VSS nfet_06v0 ad=0.65p pd=3.02u as=1.1p ps=5.88u w=2.5u l=1u
X48 a_6626_3846# a_8330_446# VSS VSS nfet_06v0 ad=0.65p pd=3.02u as=1.1p ps=5.88u w=2.5u l=1u
X49 a_14338_3730# a_14_330# a_15458_446# VSS nfet_06v0 ad=2.2p pd=10.88u as=1.25p ps=5.5u w=5u l=1u
X50 VDD a_8858_3846# a_6106_446# VDD pfet_06v0 ad=2.2p pd=10.88u as=1.3p ps=5.52u w=5u l=1u
X51 a_54_3730# a_354_3730# a_3290_3846# VDD pfet_06v0 ad=4.4p pd=20.88u as=2.5p ps=10.5u w=10u l=1u
X52 a_4342_446# a_14_330# a_4042_446# VSS nfet_06v0 ad=2.2p pd=10.88u as=1.25p ps=5.5u w=5u l=1u
X53 OUT a_9442_446# VSS VSS nfet_06v0 ad=1.3p pd=5.52u as=2.2p ps=10.88u w=5u l=1u
X54 a_1366_3846# a_54_3730# VDD VDD pfet_06v0 ad=2.5p pd=10.5u as=4.4p ps=20.88u w=10u l=1u
X55 a_6626_3846# IN+ a_4702_3846# VDD pfet_06v0 ad=2.6p pd=10.52u as=4.4p ps=20.88u w=10u l=1u
X56 a_9974_3846# a_354_3730# a_6106_446# VDD pfet_06v0 ad=1.3p pd=5.52u as=2.2p ps=10.88u w=5u l=1u
X57 VDD a_8858_3846# a_7218_446# VDD pfet_06v0 ad=2.2p pd=10.88u as=1.3p ps=5.52u w=5u l=1u
X58 a_7742_3846# a_8330_446# VSS VSS nfet_06v0 ad=0.65p pd=3.02u as=1.1p ps=5.88u w=2.5u l=1u
X59 a_18086_3846# a_54_3730# VDD VDD pfet_06v0 ad=2.5p pd=10.5u as=4.4p ps=20.88u w=10u l=1u
X60 a_54_3730# a_354_3730# a_1978_446# VSS nfet_06v0 ad=0.44p pd=2.88u as=0.25p ps=1.5u w=1u l=1u
X61 a_8858_3846# a_13794_330# a_8330_446# VSS nfet_06v0 ad=1.1p pd=5.88u as=1.1p ps=5.88u w=2.5u l=1u
X62 a_7742_3846# IN- a_4702_3846# VDD pfet_06v0 ad=2.6p pd=10.52u as=4.4p ps=20.88u w=10u l=1u
X63 a_6106_446# IN+ a_4342_446# VSS nfet_06v0 ad=1.3p pd=5.52u as=2.2p ps=10.88u w=5u l=1u
X64 a_13794_330# a_13794_330# a_16202_446# VSS nfet_06v0 ad=2.2p pd=10.88u as=2.2p ps=10.88u w=5u l=1u
X65 a_4042_446# a_746_330# VSS VSS nfet_06v0 ad=1.25p pd=5.5u as=2.2p ps=10.88u w=5u l=1u
X66 a_254_3846# a_54_3730# VDD VDD pfet_06v0 ad=2.5p pd=10.5u as=4.4p ps=20.88u w=10u l=1u
X67 a_5514_3846# a_54_3730# VDD VDD pfet_06v0 ad=2.5p pd=10.5u as=4.4p ps=20.88u w=10u l=1u
X68 a_4342_446# IN- a_7218_446# VSS nfet_06v0 ad=2.2p pd=10.88u as=1.3p ps=5.52u w=5u l=1u
X69 VSS a_8330_446# a_7742_3846# VSS nfet_06v0 ad=1.1p pd=5.88u as=0.65p ps=3.02u w=2.5u l=1u
X70 a_15962_3730# a_354_3730# a_16162_3846# VDD pfet_06v0 ad=4.4p pd=20.88u as=2.5p ps=10.5u w=10u l=1u
X71 a_1978_446# a_354_3730# VSS VSS nfet_06v0 ad=0.25p pd=1.5u as=0.44p ps=2.88u w=1u l=1u
X72 a_746_330# a_354_3730# a_1366_3846# VDD pfet_06v0 ad=4.4p pd=20.88u as=2.5p ps=10.5u w=10u l=1u
X73 a_4402_3846# a_54_3730# VDD VDD pfet_06v0 ad=2.5p pd=10.5u as=4.4p ps=20.88u w=10u l=1u
X74 a_6626_3846# a_14_330# a_9442_446# VSS nfet_06v0 ad=1.1p pd=5.88u as=0.65p ps=3.02u w=2.5u l=1u
X75 m4_15168_2034# OUT cap_mim_2f0_m4m5_noshield c_width=20u c_length=10u
C0 a_9442_446# m4_15168_2034# 0.40878f
C1 a_14_330# a_6106_446# 0.16157f
C2 a_9974_3846# a_14338_3730# 1.62645f
C3 a_16162_3846# VDD 0.06089f
C4 a_7742_3846# a_746_330# 0.04856f
C5 a_354_3730# m4_15168_2034# 0.37393f
C6 a_14_330# a_14338_3730# 0.35408f
C7 OUT a_4342_446# 0.01782f
C8 a_8330_446# OUT 0.02524f
C9 a_8330_446# a_8858_3846# 2.26727f
C10 a_746_330# IN- 0.02552f
C11 OUT IN+ 0.05455f
C12 a_6626_3846# a_13794_330# 0.10621f
C13 a_8330_446# VDD 0.186f
C14 VDD IN+ 0.62166f
C15 a_7218_446# OUT 0.07768f
C16 a_8858_3846# a_7218_446# 2.75163f
C17 VDD a_7218_446# 0.71248f
C18 VDD OUT 1.20913f
C19 a_8858_3846# VDD 2.78362f
C20 a_14338_3730# m4_15168_2034# 0.26206f
C21 VDD VDD 10.0635f
C22 a_9442_446# OUT 1.20716f
C23 a_9442_446# a_8858_3846# 2.10553f
C24 a_54_3730# a_3290_3846# 0.05253f
C25 a_9442_446# VDD 0.19055f
C26 a_9442_446# a_16202_446# 0.02898f
C27 a_54_3730# a_9974_3846# 0.89248f
C28 a_354_3730# OUT 0.45506f
C29 a_8858_3846# a_354_3730# 1.03453f
C30 VDD a_354_3730# 5.46305f
C31 a_54_3730# a_14_330# 0.1928f
C32 a_6106_446# OUT 1.42168f
C33 a_8858_3846# a_6106_446# 2.28796f
C34 VDD a_6106_446# 1.0275f
C35 a_7742_3846# VSS 1.28564f
C36 a_9974_3846# a_6626_3846# 0.10323f
C37 a_54_3730# m4_15168_2034# 0.18717f
C38 a_14338_3730# OUT 0.17792f
C39 a_8858_3846# a_14338_3730# 0.42025f
C40 VDD a_14338_3730# 1.48861f
C41 a_14_330# a_6626_3846# 0.83568f
C42 a_16202_446# a_14338_3730# 0.19002f
C43 IN- VSS 0.08991f
C44 a_746_330# m4_2716_2430# 0.06257f
C45 a_7742_3846# a_8330_446# 2.84996f
C46 a_6626_3846# m4_15168_2034# 7.02179f
C47 a_7742_3846# a_7218_446# 2.36923f
C48 a_17222_446# a_16202_446# 0.02626f
C49 IN- a_4342_446# 0.93185f
C50 a_7742_3846# VDD 0.03228f
C51 a_746_330# VSS 1.17019f
C52 a_54_3730# OUT 0.24393f
C53 a_54_3730# a_8858_3846# 0.17132f
C54 a_7218_446# IN- 0.9549f
C55 a_54_3730# VDD 2.52564f
C56 a_254_3846# a_14_330# 0.05253f
C57 a_7742_3846# a_9442_446# 0.02869f
C58 a_1366_3846# a_746_330# 0.05253f
C59 VDD IN- 0.15399f
C60 a_9974_3846# a_13794_330# 0.64684f
C61 a_7742_3846# a_354_3730# 0.03264f
C62 a_4702_3846# OUT 0.18046f
C63 a_14_330# a_13794_330# 0.28729f
C64 a_4702_3846# VDD 1.56792f
C65 a_746_330# a_4342_446# 1.17127f
C66 a_8330_446# a_746_330# 0.09971f
C67 a_6626_3846# OUT 3.56309f
C68 a_354_3730# IN- 0.03679f
C69 a_6626_3846# a_8858_3846# 0.05418f
C70 a_7742_3846# a_6106_446# 0.08118f
C71 a_746_330# IN+ 0.026f
C72 a_6626_3846# VDD 0.50352f
C73 a_6626_3846# a_16202_446# 0.0225f
C74 a_746_330# a_7218_446# 0.02258f
C75 VSS a_5074_446# 0.03406f
C76 a_746_330# VDD 0.36771f
C77 a_6106_446# IN- 0.1271f
C78 a_13794_330# m4_15168_2034# 0.40234f
C79 a_18086_3846# a_13794_330# 0.05253f
C80 a_9442_446# a_746_330# 0.04775f
C81 a_746_330# a_354_3730# 1.49f
C82 a_4342_446# a_5074_446# 0.02692f
C83 a_15962_3730# VDD 0.56348f
C84 a_746_330# a_946_446# 0.02626f
C85 m4_2716_2430# a_4342_446# 0.04453f
C86 a_9442_446# a_15962_3730# 0.22926f
C87 a_746_330# a_6106_446# 0.30566f
C88 IN+ m4_2716_2430# 0.10878f
C89 a_9974_3846# a_14_330# 0.02906f
C90 a_354_3730# a_15962_3730# 0.68913f
C91 VDD m4_2716_2430# 0.11524f
C92 a_7742_3846# a_54_3730# 0.07899f
C93 a_13794_330# OUT 0.20442f
C94 a_13794_330# a_8858_3846# 0.56301f
C95 a_746_330# a_14338_3730# 0.04417f
C96 VDD a_13794_330# 0.26427f
C97 a_13794_330# a_16202_446# 1.21284f
C98 VSS a_4342_446# 0.44577f
C99 a_8330_446# VSS 2.28622f
C100 a_9974_3846# m4_15168_2034# 0.33921f
C101 a_54_3730# IN- 0.04582f
C102 VSS IN+ 0.08991f
C103 a_354_3730# m4_2716_2430# 0.68213f
C104 a_7218_446# VSS 0.03093f
C105 a_7742_3846# a_4702_3846# 2.48508f
C106 a_14_330# m4_15168_2034# 0.01909f
C107 a_15962_3730# a_14338_3730# 1.21941f
C108 a_7742_3846# a_6626_3846# 0.12103f
C109 a_4702_3846# IN- 1.88652f
C110 a_9442_446# VSS 1.51621f
C111 a_1366_3846# VDD 0.06089f
C112 a_4402_3846# m4_2716_2430# 0.01058f
C113 IN+ a_4342_446# 1.04593f
C114 a_6626_3846# IN- 0.23472f
C115 a_354_3730# VSS 0.64596f
C116 a_7218_446# a_4342_446# 1.29732f
C117 a_54_3730# a_746_330# 0.25573f
C118 a_8330_446# a_7218_446# 0.27241f
C119 a_946_446# VSS 0.03406f
C120 a_9974_3846# OUT 2.22214f
C121 VDD IN+ 0.15399f
C122 a_9974_3846# a_8858_3846# 0.13349f
C123 a_6106_446# VSS 0.04059f
C124 a_9974_3846# VDD 1.48215f
C125 a_7218_446# VDD 2.02935f
C126 a_8330_446# a_9442_446# 0.36749f
C127 a_14_330# OUT 0.25254f
C128 a_14_330# a_8858_3846# 0.02788f
C129 a_54_3730# a_15962_3730# 0.06852f
C130 a_14_330# VDD 0.29863f
C131 a_14_330# a_16202_446# 1.03426f
C132 a_9442_446# a_7218_446# 0.04888f
C133 a_8330_446# a_354_3730# 0.03395f
C134 a_14338_3730# VSS 0.09406f
C135 a_6626_3846# a_746_330# 2.49575f
C136 a_354_3730# IN+ 0.03929f
C137 a_9442_446# VDD 0.09839f
C138 a_354_3730# a_7218_446# 1.09037f
C139 a_6106_446# a_4342_446# 2.02134f
C140 a_5514_3846# m4_2716_2430# 0.0114f
C141 a_354_3730# VDD 1.51024f
C142 a_8330_446# a_6106_446# 0.56635f
C143 m4_15168_2034# OUT 0.04271f
C144 a_6106_446# IN+ 1.09881f
C145 a_54_3730# m4_2716_2430# 0.63785f
C146 VDD m4_15168_2034# 0.2082f
C147 a_16202_446# m4_15168_2034# 0.02311f
C148 a_7218_446# a_6106_446# 1.77255f
C149 a_18086_3846# OUT 0.02156f
C150 a_6626_3846# a_15962_3730# 0.05336f
C151 a_9442_446# a_354_3730# 0.04283f
C152 a_6106_446# VDD 1.86739f
C153 a_8330_446# a_14338_3730# 0.43531f
C154 a_16162_3846# OUT 0.02075f
C155 a_17222_446# VSS 0.03472f
C156 a_4402_3846# VDD 0.06089f
C157 a_9442_446# a_6106_446# 0.16895f
C158 a_4702_3846# m4_2716_2430# 0.56386f
C159 a_14338_3730# VDD 0.29688f
C160 a_54_3730# VSS 0.05248f
C161 a_354_3730# a_6106_446# 1.33331f
C162 a_6626_3846# m4_2716_2430# 0.02562f
C163 a_9442_446# a_14338_3730# 0.51724f
C164 a_8858_3846# OUT 0.20653f
C165 a_13794_330# a_746_330# 0.61825f
C166 a_354_3730# a_14338_3730# 0.16636f
C167 VDD OUT 1.59265f
C168 VDD a_8858_3846# 3.2189f
C169 a_16202_446# OUT 0.15424f
C170 a_54_3730# a_4342_446# 0.01731f
C171 a_54_3730# a_8330_446# 0.05867f
C172 a_6626_3846# VSS 1.18635f
C173 a_54_3730# IN+ 0.02962f
C174 a_6106_446# a_14338_3730# 0.01111f
C175 a_7742_3846# a_14_330# 0.73316f
C176 a_54_3730# a_7218_446# 0.07119f
C177 a_13794_330# a_15962_3730# 0.43475f
C178 a_5514_3846# VDD 0.06089f
C179 a_54_3730# VDD 2.62501f
C180 a_4702_3846# a_4342_446# 0.12791f
C181 a_14_330# IN- 0.05627f
C182 a_4702_3846# IN+ 1.92664f
C183 a_54_3730# a_9442_446# 0.08618f
C184 a_6626_3846# a_4342_446# 0.04259f
C185 a_4042_446# VSS 0.03406f
C186 a_8330_446# a_6626_3846# 1.65664f
C187 a_6626_3846# IN+ 1.59468f
C188 a_54_3730# a_354_3730# 9.97459f
C189 a_4702_3846# VDD 0.62978f
C190 a_15458_446# VSS 0.03406f
C191 a_6626_3846# a_7218_446# 0.0812f
C192 a_6626_3846# VDD 0.04632f
C193 a_9974_3846# a_746_330# 0.06533f
C194 a_54_3730# a_6106_446# 0.23677f
C195 a_14_330# a_746_330# 6.71982f
C196 a_9442_446# a_6626_3846# 0.89077f
C197 a_4702_3846# a_354_3730# 1.17978f
C198 a_4042_446# a_4342_446# 0.02633f
C199 a_13794_330# VSS 0.35303f
C200 a_6626_3846# a_354_3730# 0.10453f
C201 a_54_3730# a_14338_3730# 1.23727f
C202 a_9974_3846# a_15962_3730# 0.0701f
C203 a_4702_3846# a_6106_446# 0.27112f
C204 a_4702_3846# a_4402_3846# 0.05253f
C205 a_7742_3846# OUT 0.03541f
C206 a_6626_3846# a_6106_446# 2.55532f
C207 a_7742_3846# VDD 0.4962f
C208 a_254_3846# VDD 0.06089f
C209 a_8330_446# a_13794_330# 0.61226f
C210 IN- OUT 0.06905f
C211 a_6626_3846# a_14338_3730# 0.0618f
C212 VDD IN- 0.62402f
C213 a_15962_3730# m4_15168_2034# 0.33591f
C214 a_13794_330# VDD 0.44726f
C215 a_9442_446# a_13794_330# 1.16007f
C216 a_16162_3846# a_15962_3730# 0.05253f
C217 a_9974_3846# VSS 0.13157f
C218 a_746_330# OUT 0.10792f
C219 a_13794_330# a_354_3730# 0.43702f
C220 a_8858_3846# a_746_330# 0.0202f
C221 a_4702_3846# a_5514_3846# 0.0531f
C222 a_14_330# VSS 1.08182f
C223 VDD a_746_330# 0.29876f
C224 a_54_3730# a_4702_3846# 0.49066f
C225 a_15458_446# a_14338_3730# 0.02626f
C226 a_54_3730# a_6626_3846# 0.08724f
C227 a_13794_330# a_6106_446# 0.08285f
C228 a_15962_3730# OUT 0.10991f
C229 a_8330_446# a_9974_3846# 0.34052f
C230 VDD a_15962_3730# 0.95811f
C231 a_13794_330# a_14338_3730# 0.05296f
C232 a_14_330# a_4342_446# 0.81367f
C233 a_8330_446# a_14_330# 0.75488f
C234 a_3290_3846# VDD 0.06089f
C235 a_9974_3846# a_7218_446# 0.03369f
C236 a_4702_3846# a_6626_3846# 3.16086f
C237 a_14_330# IN+ 0.05943f
C238 a_9974_3846# VDD 2.36727f
C239 a_14_330# a_7218_446# 0.08487f
C240 OUT m4_2716_2430# 7.02179f
C241 a_14_330# VDD 0.36684f
C242 a_9974_3846# a_9442_446# 3.41638f
C243 VDD m4_2716_2430# 0.3011f
C244 a_9442_446# a_14_330# 0.67159f
C245 a_7742_3846# IN- 1.60385f
C246 a_9974_3846# a_354_3730# 0.9614f
C247 a_14_330# a_354_3730# 0.61635f
C248 VDD m4_15168_2034# 0.098f
C249 VSS OUT 0.55809f
C250 a_8858_3846# VSS 0.0131f
C251 a_9974_3846# a_6106_446# 1.34564f
C252 a_54_3730# a_13794_330# 0.07219f
C253 a_16202_446# VSS 0.56372f
C254 a_18086_3846# VDD 0.06146f
C255 VSS VSS 11.9206f
C256 OUT VSS 7.38005f
C257 VDD VSS 5.23875f
C258 IN- VSS 1.27725f
C259 IN+ VSS 1.35045f
C260 m4_15168_2034# VSS 0.77912f
C261 m4_2716_2430# VSS 0.62466f
C262 a_4342_446# VSS 1.79678f
C263 a_16202_446# VSS 1.04782f
C264 a_13794_330# VSS 2.7923f
C265 a_9442_446# VSS 3.37033f
C266 a_8330_446# VSS 5.38374f
C267 a_6106_446# VSS 3.05701f
C268 a_7218_446# VSS 1.43819f
C269 a_8858_3846# VSS 2.00339f
C270 a_7742_3846# VSS 1.95779f
C271 a_6626_3846# VSS 4.63976f
C272 a_4702_3846# VSS 1.46248f
C273 a_746_330# VSS 3.58514f
C274 a_14_330# VSS 8.05789f
C275 a_9974_3846# VSS 1.96371f
C276 a_14338_3730# VSS 1.10362f
C277 a_15962_3730# VSS 1.22769f
C278 a_354_3730# VSS 6.3417f
C279 a_54_3730# VSS 3.16855f
C280 VDD VSS 0.16751p
.ends
