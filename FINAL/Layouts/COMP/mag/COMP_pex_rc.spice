* Nodos de bulk atados: 38 de pozo n -> VDD, 39 de sustrato -> VSS.
*   magic no extrae los taps de este layout y los dejaba flotando;
*   la conexion si existe (el LVS de KLayout da 'match uniquely').
*   Quien detecta un tap que falte de verdad es el LVS, no esto.
* NGSPICE file created from COMP.ext - technology: gf180mcuD

.subckt COMP VSS VDD OUT IN+ IN-
X0 VSS.t9 a_8330_446.t4 a_6626_3846.t6 VSS nfet_06v0 ad=1.1p pd=5.88u as=0.65p ps=3.02u w=2.5u l=1u
X1 a_4702_3846.t5 IN-.t2 a_7742_3846.t6 VDD pfet_06v0 ad=4.4p pd=20.88u as=2.6p ps=10.52u w=10u l=1u
X2 a_9442_446.t1 a_14338_3730.t3 a_9974_3846.t0 VDD pfet_06v0 ad=2.2p pd=10.88u as=2.2p ps=10.88u w=5u l=1u
X3 a_4342_446.t2 a_14_330.t9 a_5074_446.t1 VSS nfet_06v0 ad=2.2p pd=10.88u as=1.25p ps=5.5u w=5u l=1u
X4 a_4702_3846.t3 a_354_3730.t13 a_5514_3846.t0 VDD pfet_06v0 ad=4.4p pd=20.88u as=2.5p ps=10.5u w=10u l=1u
X5 a_6106_446.t7 a_354_3730.t9 a_9974_3846.t2 VDD pfet_06v0 ad=2.2p pd=10.88u as=1.3p ps=5.52u w=5u l=1u
X6 a_14_330.t1 a_14_330.t0 VSS.t18 VSS nfet_06v0 ad=0.44p pd=2.88u as=0.44p ps=2.88u w=1u l=1u
X7 a_7218_446.t6 IN-.t1 a_4342_446.t4 VSS nfet_06v0 ad=1.3p pd=5.52u as=2.2p ps=10.88u w=5u l=1u
X8 a_7218_446.t4 a_354_3730.t11 a_8858_3846.t1 VDD pfet_06v0 ad=2.2p pd=10.88u as=1.3p ps=5.52u w=5u l=1u
X9 a_5074_446.t0 a_746_330.t3 VSS.t2 VSS nfet_06v0 ad=1.25p pd=5.5u as=2.2p ps=10.88u w=5u l=1u
X10 a_9442_446.t0 a_14_330.t6 a_6626_3846.t0 VSS nfet_06v0 ad=0.65p pd=3.02u as=1.1p ps=5.88u w=2.5u l=1u
X11 a_4702_3846.t1 IN+.t2 a_6626_3846.t2 VDD pfet_06v0 ad=4.4p pd=20.88u as=2.6p ps=10.52u w=10u l=1u
X12 VDD.t5 a_8858_3846.t10 a_7218_446.t2 VDD pfet_06v0 ad=1.3p pd=5.52u as=1.3p ps=5.52u w=5u l=1u
X13 a_8330_446.t2 a_14338_3730.t4 a_8858_3846.t0 VDD pfet_06v0 ad=2.2p pd=10.88u as=2.2p ps=10.88u w=5u l=1u
X14 VDD.t1 a_9974_3846.t5 OUT.t1 VDD pfet_06v0 ad=2.6p pd=10.52u as=2.6p ps=10.52u w=10u l=1u
X15 a_6626_3846.t5 a_8330_446.t5 VSS.t5 VSS nfet_06v0 ad=0.65p pd=3.02u as=0.65p ps=3.02u w=2.5u l=1u
X16 a_946_446.t0 a_746_330.t5 VSS.t3 VSS nfet_06v0 ad=1.25p pd=5.5u as=2.2p ps=10.88u w=5u l=1u
X17 OUT.t5 a_9442_446.t4 VSS.t10 VSS nfet_06v0 ad=2.2p pd=10.88u as=1.3p ps=5.52u w=5u l=1u
X18 a_4702_3846.t2 a_354_3730.t14 a_4402_3846.t0 VDD pfet_06v0 ad=4.4p pd=20.88u as=2.5p ps=10.5u w=10u l=1u
X19 a_9974_3846.t1 a_13794_330.t3 a_9442_446.t2 VSS nfet_06v0 ad=1.1p pd=5.88u as=1.1p ps=5.88u w=2.5u l=1u
X20 a_6106_446.t4 a_8858_3846.t7 VDD.t13 VDD pfet_06v0 ad=1.3p pd=5.52u as=2.2p ps=10.88u w=5u l=1u
X21 a_16162_3846.t0 a_15962_3730.t2 VDD.t6 VDD pfet_06v0 ad=2.5p pd=10.5u as=4.4p ps=20.88u w=10u l=1u
X22 a_4342_446.t1 IN+.t0 a_6106_446.t1 VSS nfet_06v0 ad=2.2p pd=10.88u as=1.3p ps=5.52u w=5u l=1u
X23 a_7742_3846.t4 a_8330_446.t9 VSS.t16 VSS nfet_06v0 ad=0.65p pd=3.02u as=0.65p ps=3.02u w=2.5u l=1u
X24 a_17222_446.t0 a_16202_446.t2 VSS.t13 VSS nfet_06v0 ad=1.25p pd=5.5u as=2.2p ps=10.88u w=5u l=1u
X25 a_354_3730.t3 a_354_3730.t2 a_3010_446.t0 VSS nfet_06v0 ad=0.44p pd=2.88u as=0.25p ps=1.5u w=1u l=1u
X26 a_13794_330.t0 a_354_3730.t7 a_18086_3846.t1 VDD pfet_06v0 ad=4.4p pd=20.88u as=2.5p ps=10.5u w=10u l=1u
X27 a_3290_3846.t0 a_54_3730.t5 VDD.t8 VDD pfet_06v0 ad=2.5p pd=10.5u as=4.4p ps=20.88u w=10u l=1u
X28 a_6106_446.t2 a_8858_3846.t5 VDD.t11 VDD pfet_06v0 ad=1.3p pd=5.52u as=1.3p ps=5.52u w=5u l=1u
X29 a_746_330.t0 a_14_330.t11 a_946_446.t1 VSS nfet_06v0 ad=2.2p pd=10.88u as=1.25p ps=5.5u w=5u l=1u
X30 a_7742_3846.t0 a_14_330.t7 a_8330_446.t0 VSS nfet_06v0 ad=1.1p pd=5.88u as=0.65p ps=3.02u w=2.5u l=1u
X31 VSS.t6 a_8330_446.t6 a_6626_3846.t4 VSS nfet_06v0 ad=0.65p pd=3.02u as=0.65p ps=3.02u w=2.5u l=1u
X32 a_16202_446.t1 a_14_330.t3 a_17222_446.t1 VSS nfet_06v0 ad=2.2p pd=10.88u as=1.25p ps=5.5u w=5u l=1u
X33 m4_2716_2430# a_6106_446.t6 cap_mim_2f0_m4m5_noshield c_width=20u c_length=10u
X34 a_7218_446.t1 a_8858_3846.t9 VDD.t4 VDD pfet_06v0 ad=1.3p pd=5.52u as=1.3p ps=5.52u w=5u l=1u
X35 OUT.t0 a_9974_3846.t4 VDD.t0 VDD pfet_06v0 ad=4.4p pd=20.88u as=2.6p ps=10.52u w=10u l=1u
X36 a_14_330.t2 a_354_3730.t17 a_254_3846.t1 VDD pfet_06v0 ad=4.4p pd=20.88u as=2.5p ps=10.5u w=10u l=1u
X37 a_14338_3730.t1 a_14338_3730.t0 a_15962_3730.t0 VDD pfet_06v0 ad=4.4p pd=20.88u as=4.4p ps=20.88u w=10u l=1u
X38 a_3010_446.t1 a_354_3730.t4 VSS.t0 VSS nfet_06v0 ad=0.25p pd=1.5u as=0.44p ps=2.88u w=1u l=1u
X39 VSS.t7 a_9442_446.t5 OUT.t3 VSS nfet_06v0 ad=1.3p pd=5.52u as=1.3p ps=5.52u w=5u l=1u
X40 VSS.t11 a_8330_446.t10 a_7742_3846.t3 VSS nfet_06v0 ad=0.65p pd=3.02u as=0.65p ps=3.02u w=2.5u l=1u
X41 a_15458_446.t1 a_746_330.t2 VSS.t17 VSS nfet_06v0 ad=1.25p pd=5.5u as=2.2p ps=10.88u w=5u l=1u
X42 a_354_3730.t1 a_354_3730.t0 VDD.t7 VDD pfet_06v0 ad=0.88p pd=4.88u as=0.88p ps=4.88u w=2u l=1u
X43 VDD.t12 a_8858_3846.t6 a_6106_446.t3 VDD pfet_06v0 ad=1.3p pd=5.52u as=1.3p ps=5.52u w=5u l=1u
X44 a_8858_3846.t2 a_354_3730.t12 a_7218_446.t5 VDD pfet_06v0 ad=1.3p pd=5.52u as=2.2p ps=10.88u w=5u l=1u
X45 a_7218_446.t3 a_8858_3846.t11 VDD.t10 VDD pfet_06v0 ad=1.3p pd=5.52u as=2.2p ps=10.88u w=5u l=1u
X46 OUT.t6 a_9974_3846.t6 VDD.t18 VDD pfet_06v0 ad=2.6p pd=10.52u as=4.4p ps=20.88u w=10u l=1u
X47 a_8330_446.t1 a_14_330.t8 a_7742_3846.t1 VSS nfet_06v0 ad=0.65p pd=3.02u as=1.1p ps=5.88u w=2.5u l=1u
X48 a_6626_3846.t3 a_8330_446.t7 VSS.t14 VSS nfet_06v0 ad=0.65p pd=3.02u as=1.1p ps=5.88u w=2.5u l=1u
X49 a_14338_3730.t2 a_14_330.t4 a_15458_446.t0 VSS nfet_06v0 ad=2.2p pd=10.88u as=1.25p ps=5.5u w=5u l=1u
X50 VDD.t14 a_8858_3846.t4 a_6106_446.t5 VDD pfet_06v0 ad=2.2p pd=10.88u as=1.3p ps=5.52u w=5u l=1u
X51 a_54_3730.t1 a_354_3730.t15 a_3290_3846.t1 VDD pfet_06v0 ad=4.4p pd=20.88u as=2.5p ps=10.5u w=10u l=1u
X52 a_4342_446.t3 a_14_330.t10 a_4042_446.t1 VSS nfet_06v0 ad=2.2p pd=10.88u as=1.25p ps=5.5u w=5u l=1u
X53 OUT.t4 a_9442_446.t6 VSS.t8 VSS nfet_06v0 ad=1.3p pd=5.52u as=2.2p ps=10.88u w=5u l=1u
X54 a_1366_3846.t1 a_54_3730.t6 VDD.t17 VDD pfet_06v0 ad=2.5p pd=10.5u as=4.4p ps=20.88u w=10u l=1u
X55 a_6626_3846.t1 IN+.t3 a_4702_3846.t0 VDD pfet_06v0 ad=2.6p pd=10.52u as=4.4p ps=20.88u w=10u l=1u
X56 a_9974_3846.t3 a_354_3730.t10 a_6106_446.t8 VDD pfet_06v0 ad=1.3p pd=5.52u as=2.2p ps=10.88u w=5u l=1u
X57 VDD.t3 a_8858_3846.t8 a_7218_446.t0 VDD pfet_06v0 ad=2.2p pd=10.88u as=1.3p ps=5.52u w=5u l=1u
X58 a_7742_3846.t2 a_8330_446.t11 VSS.t12 VSS nfet_06v0 ad=0.65p pd=3.02u as=1.1p ps=5.88u w=2.5u l=1u
X59 a_18086_3846.t0 a_54_3730.t2 VDD.t9 VDD pfet_06v0 ad=2.5p pd=10.5u as=4.4p ps=20.88u w=10u l=1u
X60 a_54_3730.t0 a_354_3730.t5 a_1978_446.t1 VSS nfet_06v0 ad=0.44p pd=2.88u as=0.25p ps=1.5u w=1u l=1u
X61 a_8858_3846.t3 a_13794_330.t4 a_8330_446.t3 VSS nfet_06v0 ad=1.1p pd=5.88u as=1.1p ps=5.88u w=2.5u l=1u
X62 a_7742_3846.t7 IN-.t3 a_4702_3846.t4 VDD pfet_06v0 ad=2.6p pd=10.52u as=4.4p ps=20.88u w=10u l=1u
X63 a_6106_446.t0 IN+.t1 a_4342_446.t0 VSS nfet_06v0 ad=1.3p pd=5.52u as=2.2p ps=10.88u w=5u l=1u
X64 a_13794_330.t2 a_13794_330.t1 a_16202_446.t0 VSS nfet_06v0 ad=2.2p pd=10.88u as=2.2p ps=10.88u w=5u l=1u
X65 a_4042_446.t0 a_746_330.t4 VSS.t1 VSS nfet_06v0 ad=1.25p pd=5.5u as=2.2p ps=10.88u w=5u l=1u
X66 a_254_3846.t0 a_54_3730.t7 VDD.t2 VDD pfet_06v0 ad=2.5p pd=10.5u as=4.4p ps=20.88u w=10u l=1u
X67 a_5514_3846.t1 a_54_3730.t3 VDD.t16 VDD pfet_06v0 ad=2.5p pd=10.5u as=4.4p ps=20.88u w=10u l=1u
X68 a_4342_446.t5 IN-.t0 a_7218_446.t7 VSS nfet_06v0 ad=2.2p pd=10.88u as=1.3p ps=5.52u w=5u l=1u
X69 VSS.t15 a_8330_446.t8 a_7742_3846.t5 VSS nfet_06v0 ad=1.1p pd=5.88u as=0.65p ps=3.02u w=2.5u l=1u
X70 a_15962_3730.t1 a_354_3730.t8 a_16162_3846.t1 VDD pfet_06v0 ad=4.4p pd=20.88u as=2.5p ps=10.5u w=10u l=1u
X71 a_1978_446.t0 a_354_3730.t6 VSS.t4 VSS nfet_06v0 ad=0.25p pd=1.5u as=0.44p ps=2.88u w=1u l=1u
X72 a_746_330.t1 a_354_3730.t16 a_1366_3846.t0 VDD pfet_06v0 ad=4.4p pd=20.88u as=2.5p ps=10.5u w=10u l=1u
X73 a_4402_3846.t1 a_54_3730.t4 VDD.t15 VDD pfet_06v0 ad=2.5p pd=10.5u as=4.4p ps=20.88u w=10u l=1u
X74 a_6626_3846.t7 a_14_330.t5 a_9442_446.t3 VSS nfet_06v0 ad=1.1p pd=5.88u as=0.65p ps=3.02u w=2.5u l=1u
X75 m4_15168_2034# OUT.t2 cap_mim_2f0_m4m5_noshield c_width=20u c_length=10u
R0 VSS.n1 VSS.t9 7.46776
R1 VSS.n9 VSS.t15 7.46776
R2 VSS.n2 VSS.t14 6.6657
R3 VSS.n10 VSS.t12 6.6657
R4 VSS.n4 VSS.n3 6.60756
R5 VSS.n1 VSS.n0 6.0605
R6 VSS.n9 VSS.n8 6.0605
R7 VSS.n4 VSS.t8 6.0206
R8 VSS.n11 VSS.t18 5.79212
R9 VSS.n5 VSS.n4 5.66401
R10 VSS.n13 VSS.t0 5.42612
R11 VSS.n12 VSS.t4 5.42612
R12 VSS.n7 VSS.n2 5.19651
R13 VSS.n16 VSS.n10 5.19651
R14 VSS.n16 VSS.n15 2.692
R15 VSS.n5 VSS.t13 2.05582
R16 VSS.n6 VSS.t17 2.05582
R17 VSS.n15 VSS.t2 2.05582
R18 VSS.n14 VSS.t1 2.05582
R19 VSS.n11 VSS.t3 2.05582
R20 VSS.n7 VSS.n6 1.641
R21 VSS.n6 VSS.n5 0.8825
R22 VSS VSS.n7 0.8535
R23 VSS.n2 VSS.n1 0.802559
R24 VSS.n10 VSS.n9 0.802559
R25 VSS.n0 VSS.t5 0.6557
R26 VSS.n0 VSS.t6 0.6557
R27 VSS.n8 VSS.t16 0.6557
R28 VSS.n8 VSS.t11 0.6557
R29 VSS.n15 VSS.n14 0.5165
R30 VSS.n14 VSS.n13 0.5165
R31 VSS.n13 VSS.n12 0.5165
R32 VSS.n12 VSS.n11 0.5165
R33 VSS.n3 VSS.t10 0.3281
R34 VSS.n3 VSS.t7 0.3281
R35 VSS VSS.n16 0.0075
R36 OUT OUT.n1 11.4019
R37 OUT.n4 OUT.n3 10.1425
R38 OUT.n4 OUT.t2 9.07125
R39 OUT.n1 OUT.n0 6.97518
R40 OUT.n3 OUT.n2 6.60756
R41 OUT.n1 OUT.t0 6.11762
R42 OUT.n3 OUT.t5 6.0206
R43 OUT OUT.n4 5.71871
R44 OUT.n2 OUT.t3 0.3281
R45 OUT.n2 OUT.t4 0.3281
R46 OUT.n0 OUT.t1 0.1825
R47 OUT.n0 OUT.t6 0.1825
R48 VDD.n8 VDD.n7 8.55401
R49 VDD.n11 VDD.n2 8.50303
R50 VDD.n10 VDD.n5 8.50303
R51 VDD.n7 VDD.n6 6.97518
R52 VDD.n1 VDD.t3 6.74906
R53 VDD.n4 VDD.t14 6.74906
R54 VDD.n7 VDD.t18 6.11762
R55 VDD.n13 VDD.t7 6.09214
R56 VDD.n2 VDD.t10 5.947
R57 VDD.n5 VDD.t13 5.947
R58 VDD.n1 VDD.n0 5.6955
R59 VDD.n4 VDD.n3 5.6955
R60 VDD.n12 VDD.t2 2.6604
R61 VDD VDD.n16 2.479
R62 VDD.n12 VDD.t17 2.1044
R63 VDD.n14 VDD.t8 2.1044
R64 VDD.n15 VDD.t15 2.1044
R65 VDD.n16 VDD.t16 2.1044
R66 VDD.n9 VDD.t6 2.1044
R67 VDD.n8 VDD.t9 2.1044
R68 VDD.n10 VDD.n9 1.723
R69 VDD.n9 VDD.n8 0.9625
R70 VDD.n11 VDD.n10 0.8625
R71 VDD.n2 VDD.n1 0.802559
R72 VDD.n5 VDD.n4 0.802559
R73 VDD.n16 VDD.n15 0.5565
R74 VDD.n15 VDD.n14 0.5565
R75 VDD.n13 VDD.n12 0.5565
R76 VDD.n14 VDD.n13 0.4065
R77 VDD.n0 VDD.t4 0.3645
R78 VDD.n0 VDD.t5 0.3645
R79 VDD.n3 VDD.t11 0.3645
R80 VDD.n3 VDD.t12 0.3645
R81 VDD VDD.n11 0.2615
R82 VDD.n6 VDD.t0 0.1825
R83 VDD.n6 VDD.t1 0.1825
R84 IN-.n0 IN-.t2 47.1724
R85 IN-.n0 IN-.t3 43.4205
R86 IN-.n1 IN-.t1 27.1253
R87 IN-.n1 IN-.t0 25.3605
R88 IN- IN-.n1 11.4073
R89 IN- IN-.n0 2.37431
R90 IN+.n0 IN+.t2 47.1724
R91 IN+.n0 IN+.t3 43.4205
R92 IN+.n1 IN+.t1 27.1253
R93 IN+.n1 IN+.t0 25.3605
R94 IN+ IN+.n1 11.1426
R95 IN+ IN+.n0 2.63257
R96 a_17222_446.t0 a_17222_446.t1 0.6305
R97 a_15458_446.t0 a_15458_446.t1 0.6305
R98 a_5074_446.t0 a_5074_446.t1 0.6305
R99 a_4342_446.t0 a_4342_446.n3 6.0206
R100 a_4342_446.n3 a_4342_446.n2 11.8193
R101 a_4342_446.n2 a_4342_446.n1 13.5743
R102 a_4342_446.n1 a_4342_446.t5 6.82001
R103 a_4342_446.n1 a_4342_446.t4 6.0206
R104 a_4342_446.n2 a_4342_446.n0 0.445679
R105 a_4342_446.n0 a_4342_446.t3 8.95471
R106 a_4342_446.n0 a_4342_446.t2 7.32828
R107 a_4342_446.n3 a_4342_446.t1 6.82001
R108 a_4042_446.t0 a_4042_446.t1 0.6305
R109 a_3010_446.t0 a_3010_446.t1 3.1505
R110 a_1978_446.t0 a_1978_446.t1 3.1505
R111 a_946_446.t0 a_946_446.t1 0.6305
R112 a_16202_446.t0 a_16202_446.n0 8.48592
R113 a_16202_446.n0 a_16202_446.t1 7.79163
R114 a_16202_446.n0 a_16202_446.t2 30.4947
R115 a_13794_330.t2 a_13794_330.n2 7.32828
R116 a_13794_330.n2 a_13794_330.t0 12.4585
R117 a_13794_330.n2 a_13794_330.n0 0.239964
R118 a_13794_330.n0 a_13794_330.n1 2.80336
R119 a_13794_330.n1 a_13794_330.t4 23.7506
R120 a_13794_330.n1 a_13794_330.t3 22.6063
R121 a_13794_330.n0 a_13794_330.t1 30.753
R122 a_18086_3846.t0 a_18086_3846.t1 0.3505
R123 a_16162_3846.t0 a_16162_3846.t1 0.3505
R124 a_9442_446.t0 a_9442_446.n0 0.6557
R125 a_9442_446.n0 a_9442_446.t3 0.6557
R126 a_9442_446.n0 a_9442_446.n1 26.7292
R127 a_9442_446.n1 a_9442_446.n2 1.51443
R128 a_9442_446.n2 a_9442_446.n4 11.724
R129 a_9442_446.n4 a_9442_446.n3 1.93907
R130 a_9442_446.n3 a_9442_446.t4 25.9305
R131 a_9442_446.n3 a_9442_446.t6 25.1705
R132 a_9442_446.n4 a_9442_446.t5 25.3605
R133 a_9442_446.n2 a_9442_446.t1 7.77157
R134 a_9442_446.n1 a_9442_446.t2 10.5252
R135 a_8330_446.n0 a_8330_446.t1 0.6557
R136 a_8330_446.t0 a_8330_446.n0 0.6557
R137 a_8330_446.n0 a_8330_446.n4 22.2993
R138 a_8330_446.n4 a_8330_446.n8 2.73264
R139 a_8330_446.n8 a_8330_446.n9 1.72818
R140 a_8330_446.n9 a_8330_446.t2 9.67345
R141 a_8330_446.n9 a_8330_446.t3 10.0087
R142 a_8330_446.n8 a_8330_446.n7 7.57811
R143 a_8330_446.n7 a_8330_446.n5 0.1905
R144 a_8330_446.n5 a_8330_446.n6 1.3255
R145 a_8330_446.n6 a_8330_446.t5 16.8055
R146 a_8330_446.n6 a_8330_446.t7 16.0455
R147 a_8330_446.n7 a_8330_446.t4 16.6155
R148 a_8330_446.n5 a_8330_446.t6 16.0455
R149 a_8330_446.n4 a_8330_446.n3 7.57811
R150 a_8330_446.n3 a_8330_446.n1 0.1905
R151 a_8330_446.n1 a_8330_446.n2 1.3255
R152 a_8330_446.n2 a_8330_446.t9 16.8055
R153 a_8330_446.n2 a_8330_446.t11 16.0455
R154 a_8330_446.n3 a_8330_446.t8 16.6155
R155 a_8330_446.n1 a_8330_446.t10 16.0455
R156 a_6106_446.n0 a_6106_446.t0 0.3281
R157 a_6106_446.t1 a_6106_446.n0 0.3281
R158 a_6106_446.n0 a_6106_446.n1 17.1219
R159 a_6106_446.n1 a_6106_446.n3 4.613
R160 a_6106_446.n3 a_6106_446.n6 20.8797
R161 a_6106_446.n6 a_6106_446.n5 5.6955
R162 a_6106_446.n5 a_6106_446.t2 0.3645
R163 a_6106_446.n5 a_6106_446.t5 0.3645
R164 a_6106_446.n6 a_6106_446.n4 6.50021
R165 a_6106_446.n4 a_6106_446.t4 0.3645
R166 a_6106_446.n4 a_6106_446.t3 0.3645
R167 a_6106_446.n3 a_6106_446.n2 12.2772
R168 a_6106_446.n2 a_6106_446.t7 6.74641
R169 a_6106_446.n2 a_6106_446.t8 5.947
R170 a_6106_446.n1 a_6106_446.t6 9.07125
R171 a_7218_446.t6 a_7218_446.n0 0.3281
R172 a_7218_446.n0 a_7218_446.t7 0.3281
R173 a_7218_446.n0 a_7218_446.n2 18.4506
R174 a_7218_446.n2 a_7218_446.n5 19.6443
R175 a_7218_446.n5 a_7218_446.n4 5.6955
R176 a_7218_446.n4 a_7218_446.t1 0.3645
R177 a_7218_446.n4 a_7218_446.t0 0.3645
R178 a_7218_446.n5 a_7218_446.n3 6.50021
R179 a_7218_446.n3 a_7218_446.t3 0.3645
R180 a_7218_446.n3 a_7218_446.t2 0.3645
R181 a_7218_446.n2 a_7218_446.n1 12.0189
R182 a_7218_446.n1 a_7218_446.t4 6.74641
R183 a_7218_446.n1 a_7218_446.t5 5.947
R184 a_8858_3846.t3 a_8858_3846.n9 10.267
R185 a_8858_3846.n9 a_8858_3846.t0 8.32876
R186 a_8858_3846.n9 a_8858_3846.n3 1.64782
R187 a_8858_3846.n3 a_8858_3846.n7 2.73907
R188 a_8858_3846.n7 a_8858_3846.n8 21.8163
R189 a_8858_3846.n8 a_8858_3846.t2 0.3645
R190 a_8858_3846.n8 a_8858_3846.t1 0.3645
R191 a_8858_3846.n7 a_8858_3846.n6 6.34159
R192 a_8858_3846.n6 a_8858_3846.n5 0.3805
R193 a_8858_3846.n6 a_8858_3846.t9 25.5505
R194 a_8858_3846.n5 a_8858_3846.n4 2.12907
R195 a_8858_3846.n4 a_8858_3846.t8 25.9305
R196 a_8858_3846.n4 a_8858_3846.t10 25.1705
R197 a_8858_3846.n5 a_8858_3846.t11 25.1705
R198 a_8858_3846.n3 a_8858_3846.n2 6.34159
R199 a_8858_3846.n2 a_8858_3846.n1 0.3805
R200 a_8858_3846.n2 a_8858_3846.t5 25.5505
R201 a_8858_3846.n1 a_8858_3846.n0 2.12907
R202 a_8858_3846.n0 a_8858_3846.t4 25.9305
R203 a_8858_3846.n0 a_8858_3846.t6 25.1705
R204 a_8858_3846.n1 a_8858_3846.t7 25.1705
R205 a_7742_3846.n0 a_7742_3846.t4 0.6557
R206 a_7742_3846.t5 a_7742_3846.n0 0.6557
R207 a_7742_3846.n0 a_7742_3846.n5 6.0605
R208 a_7742_3846.n5 a_7742_3846.n4 6.86521
R209 a_7742_3846.n4 a_7742_3846.t2 0.6557
R210 a_7742_3846.n4 a_7742_3846.t3 0.6557
R211 a_7742_3846.n5 a_7742_3846.n2 18.0864
R212 a_7742_3846.n2 a_7742_3846.n3 13.1888
R213 a_7742_3846.n3 a_7742_3846.t0 7.46511
R214 a_7742_3846.n3 a_7742_3846.t1 6.6657
R215 a_7742_3846.n2 a_7742_3846.n1 21.183
R216 a_7742_3846.n1 a_7742_3846.t7 0.1825
R217 a_7742_3846.n1 a_7742_3846.t6 0.1825
R218 a_6626_3846.n0 a_6626_3846.t5 0.6557
R219 a_6626_3846.t6 a_6626_3846.n0 0.6557
R220 a_6626_3846.n0 a_6626_3846.n5 6.0605
R221 a_6626_3846.n5 a_6626_3846.n4 6.86521
R222 a_6626_3846.n4 a_6626_3846.t3 0.6557
R223 a_6626_3846.n4 a_6626_3846.t4 0.6557
R224 a_6626_3846.n5 a_6626_3846.n2 18.6873
R225 a_6626_3846.n2 a_6626_3846.n3 25.0692
R226 a_6626_3846.n3 a_6626_3846.t1 0.1825
R227 a_6626_3846.n3 a_6626_3846.t2 0.1825
R228 a_6626_3846.n2 a_6626_3846.n1 12.0476
R229 a_6626_3846.n1 a_6626_3846.t7 7.46511
R230 a_6626_3846.n1 a_6626_3846.t0 6.6657
R231 a_5514_3846.t0 a_5514_3846.t1 0.3505
R232 a_4702_3846.t1 a_4702_3846.n0 6.91703
R233 a_4702_3846.n0 a_4702_3846.n3 11.5024
R234 a_4702_3846.n3 a_4702_3846.n2 13.2638
R235 a_4702_3846.n2 a_4702_3846.t5 6.91703
R236 a_4702_3846.n2 a_4702_3846.t4 6.11762
R237 a_4702_3846.n3 a_4702_3846.n1 0.57425
R238 a_4702_3846.n1 a_4702_3846.t2 10.1654
R239 a_4702_3846.n1 a_4702_3846.t3 8.41045
R240 a_4702_3846.n0 a_4702_3846.t0 6.11762
R241 a_4402_3846.t0 a_4402_3846.t1 0.3505
R242 a_3290_3846.t0 a_3290_3846.t1 0.3505
R243 a_746_330.t0 a_746_330.n3 7.07002
R244 a_746_330.n3 a_746_330.n0 0.643357
R245 a_746_330.n0 a_746_330.n1 3.51532
R246 a_746_330.n1 a_746_330.n2 1.62693
R247 a_746_330.n2 a_746_330.t2 47.1512
R248 a_746_330.n2 a_746_330.t3 30.4947
R249 a_746_330.n1 a_746_330.t4 30.4947
R250 a_746_330.n0 a_746_330.t1 9.70175
R251 a_746_330.n3 a_746_330.t5 31.2164
R252 a_1366_3846.t0 a_1366_3846.t1 0.3505
R253 a_14_330.t1 a_14_330.n9 11.7458
R254 a_14_330.n9 a_14_330.n0 0.514786
R255 a_14_330.n0 a_14_330.n1 0.808893
R256 a_14_330.n1 a_14_330.n2 4.94407
R257 a_14_330.n2 a_14_330.n3 1.62693
R258 a_14_330.n3 a_14_330.n5 4.96336
R259 a_14_330.n5 a_14_330.n7 1.7555
R260 a_14_330.n7 a_14_330.n8 9.87479
R261 a_14_330.n8 a_14_330.t3 33.0393
R262 a_14_330.n8 a_14_330.t4 30.2365
R263 a_14_330.n7 a_14_330.n6 6.02854
R264 a_14_330.n6 a_14_330.t6 17.1967
R265 a_14_330.n6 a_14_330.t5 16.2355
R266 a_14_330.n5 a_14_330.n4 6.02854
R267 a_14_330.n4 a_14_330.t8 17.1967
R268 a_14_330.n4 a_14_330.t7 16.2355
R269 a_14_330.n3 a_14_330.t9 30.2365
R270 a_14_330.n2 a_14_330.t10 30.2365
R271 a_14_330.n1 a_14_330.t11 30.2365
R272 a_14_330.n0 a_14_330.t2 9.96001
R273 a_14_330.n9 a_14_330.t0 17.4412
R274 a_254_3846.t0 a_254_3846.t1 0.3505
R275 a_9974_3846.t1 a_9974_3846.n4 10.7835
R276 a_9974_3846.n4 a_9974_3846.n1 0.428
R277 a_9974_3846.n1 a_9974_3846.n3 12.7374
R278 a_9974_3846.n3 a_9974_3846.n2 0.3805
R279 a_9974_3846.n3 a_9974_3846.t4 43.8005
R280 a_9974_3846.n2 a_9974_3846.t5 47.1562
R281 a_9974_3846.n2 a_9974_3846.t6 43.4205
R282 a_9974_3846.n1 a_9974_3846.t0 7.5133
R283 a_9974_3846.n4 a_9974_3846.n0 25.1328
R284 a_9974_3846.n0 a_9974_3846.t3 0.3645
R285 a_9974_3846.n0 a_9974_3846.t2 0.3645
R286 a_14338_3730.t2 a_14338_3730.n2 9.39437
R287 a_14338_3730.n2 a_14338_3730.n1 2.13318
R288 a_14338_3730.n1 a_14338_3730.t1 7.61687
R289 a_14338_3730.n1 a_14338_3730.t0 49.003
R290 a_14338_3730.n2 a_14338_3730.n0 0.895679
R291 a_14338_3730.n0 a_14338_3730.t4 32.0259
R292 a_14338_3730.n0 a_14338_3730.t3 30.753
R293 a_15962_3730.t0 a_15962_3730.n0 9.91488
R294 a_15962_3730.n0 a_15962_3730.t2 51.5324
R295 a_15962_3730.n0 a_15962_3730.t1 9.18523
R296 a_354_3730.t3 a_354_3730.n15 14.845
R297 a_354_3730.n15 a_354_3730.n7 0.1805
R298 a_354_3730.n7 a_354_3730.n8 1.72175
R299 a_354_3730.n8 a_354_3730.n9 1.7555
R300 a_354_3730.n9 a_354_3730.n11 4.8605
R301 a_354_3730.n11 a_354_3730.n13 1.76193
R302 a_354_3730.n13 a_354_3730.n14 10.3955
R303 a_354_3730.n14 a_354_3730.t7 51.5465
R304 a_354_3730.n14 a_354_3730.t8 48.4865
R305 a_354_3730.n13 a_354_3730.n12 5.06648
R306 a_354_3730.n12 a_354_3730.t9 27.3153
R307 a_354_3730.n12 a_354_3730.t10 25.1705
R308 a_354_3730.n11 a_354_3730.n10 5.06648
R309 a_354_3730.n10 a_354_3730.t11 27.3153
R310 a_354_3730.n10 a_354_3730.t12 25.1705
R311 a_354_3730.n9 a_354_3730.t13 48.4865
R312 a_354_3730.n8 a_354_3730.t14 48.4865
R313 a_354_3730.n7 a_354_3730.t15 48.4865
R314 a_354_3730.n15 a_354_3730.n0 0.230321
R315 a_354_3730.n0 a_354_3730.n1 0.460143
R316 a_354_3730.n1 a_354_3730.n2 0.55175
R317 a_354_3730.n2 a_354_3730.n3 0.239964
R318 a_354_3730.n3 a_354_3730.n4 0.289786
R319 a_354_3730.n4 a_354_3730.n5 0.4505
R320 a_354_3730.n5 a_354_3730.n6 0.469786
R321 a_354_3730.n6 a_354_3730.t17 50.2415
R322 a_354_3730.n6 a_354_3730.t16 48.4865
R323 a_354_3730.n5 a_354_3730.t6 20.3008
R324 a_354_3730.n4 a_354_3730.t5 20.3008
R325 a_354_3730.n3 a_354_3730.t0 19.2865
R326 a_354_3730.n2 a_354_3730.t1 7.71891
R327 a_354_3730.n1 a_354_3730.t4 20.3008
R328 a_354_3730.n0 a_354_3730.t2 20.3008
R329 a_54_3730.t0 a_54_3730.n5 14.5867
R330 a_54_3730.n5 a_54_3730.n1 1.19943
R331 a_54_3730.n1 a_54_3730.n2 0.845857
R332 a_54_3730.n2 a_54_3730.n3 1.00175
R333 a_54_3730.n3 a_54_3730.n4 1.7555
R334 a_54_3730.n4 a_54_3730.t2 68.9176
R335 a_54_3730.n4 a_54_3730.t3 48.7447
R336 a_54_3730.n3 a_54_3730.t4 48.7447
R337 a_54_3730.n2 a_54_3730.t1 7.11915
R338 a_54_3730.n1 a_54_3730.t5 48.8248
R339 a_54_3730.n5 a_54_3730.n0 1.70568
R340 a_54_3730.n0 a_54_3730.t7 50.4997
R341 a_54_3730.n0 a_54_3730.t6 48.7447
R342 VDD VDD 148.067
R343 VDD VDD 109.409
R344 VDD VDD 296.135
R345 VDD VDD 109.409
R346 VDD VDD 296.135
R347 VDD VDD 296.135
R348 VDD VDD 109.409
R349 VDD VDD 296.135
R350 VDD VDD 109.409
R351 VDD VDD 296.135
R352 VDD VDD 109.409
R353 VDD VDD 296.135
R354 VDD VDD 110.868
R355 VDD VDD 296.135
R356 VDD VDD 110.868
R357 VDD VDD 296.135
R358 VDD VDD 110.868
R359 VDD VDD 296.135
R360 VDD VDD 110.868
R361 VDD VDD 296.135
R362 VDD VDD 110.868
R363 VDD VDD 110.868
R364 VDD VDD 110.868
R365 VDD VDD 296.135
R366 VDD VDD 110.868
R367 VDD VDD 110.868
R368 VDD VDD 110.868
R369 VDD VDD 296.135
R370 VDD VDD 296.135
R371 VDD VDD 296.135
R372 VDD VDD 109.409
R373 VDD VDD 296.135
R374 VDD VDD 296.135
R375 VDD VDD 109.409
R376 VDD VDD 296.135
R377 VDD VDD 110.868
R378 VDD VDD 110.868
R379 VSS VSS 335.07
R380 VSS VSS 670.141
R381 VSS VSS 274.649
R382 VSS VSS 670.141
R383 VSS VSS 274.649
R384 VSS VSS 670.141
R385 VSS VSS 274.649
R386 VSS VSS 670.141
R387 VSS VSS 274.649
R388 VSS VSS 670.141
R389 VSS VSS 274.649
R390 VSS VSS 670.141
R391 VSS VSS 278.31
R392 VSS VSS 739.718
R393 VSS VSS 278.31
R394 VSS VSS 739.718
R395 VSS VSS 278.31
R396 VSS VSS 739.718
R397 VSS VSS 278.31
R398 VSS VSS 739.718
R399 VSS VSS 278.31
R400 VSS VSS 278.31
R401 VSS VSS 278.31
R402 VSS VSS 739.718
R403 VSS VSS 278.31
R404 VSS VSS 278.31
R405 VSS VSS 278.31
R406 VSS VSS 739.718
R407 VSS VSS 670.141
R408 VSS VSS 670.141
R409 VSS VSS 274.649
R410 VSS VSS 670.141
R411 VSS VSS 670.141
R412 VSS VSS 274.649
R413 VSS VSS 670.141
R414 VSS VSS 278.31
R415 VSS VSS 278.31
C0 VSS OUT 0.55809f
C1 OUT IN- 0.06905f
C2 OUT m4_2716_2430# 7.02179f
C3 VDD m4_15168_2034# 0.098f
C4 VSS IN+ 0.08991f
C5 IN+ m4_2716_2430# 0.10878f
C6 OUT VDD 1.20913f
C7 VSS IN- 0.08991f
C8 VDD IN+ 0.15399f
C9 OUT m4_15168_2034# 0.04271f
C10 VDD IN- 0.15399f
C11 VDD m4_2716_2430# 0.11524f
C12 OUT IN+ 0.05455f
C13 VSS 0 12.22645f
C14 OUT 0 9.60499f
C15 VDD 0 7.09653f
C16 IN- 0 1.49119f
C17 IN+ 0 1.57172f
C18 m4_15168_2034# 0 0.77912f
C19 m4_2716_2430# 0 0.62466f
C20 VDD 0 0.33987f
C21 VDD 0 0.59101f
C22 VDD 0 0.93088f
C23 VDD 0 0.93088f
C24 VDD 0 0.93088f
C25 VDD 0 1.35949f
C26 VDD 0 0.93088f
C27 VDD 0 0.93088f
C28 VDD 0 0.93088f
C29 VDD 0 0.93088f
C30 VDD 0 0.93088f
C31 VDD 0 0.93088f
C32 VDD 0 0.93423f
C33 VDD 0 0.93423f
C34 VDD 0 0.93423f
C35 VDD 0 0.93423f
C36 VDD 0 0.93423f
C37 VDD 0 0.93423f
C38 VDD 0 0.93423f
C39 VDD 0 0.93423f
C40 VDD 0 0.93423f
C41 VDD 0 0.50897f
C42 VDD 0 0.50897f
C43 VDD 0 0.93423f
C44 VDD 0 0.93423f
C45 VDD 0 0.50897f
C46 VDD 0 0.50897f
C47 VDD 0 0.93423f
C48 VDD 0 1.35949f
C49 VDD 0 1.35949f
C50 VDD 0 0.93088f
C51 VDD 0 0.93088f
C52 VDD 0 1.35949f
C53 VDD 0 0.93088f
C54 VDD 0 0.93088f
C55 VDD 0 0.93423f
C56 VDD 0 0.50897f
C57 VDD 0 0.93423f
C58 a_54_3730.t0 0 0.36277f
C59 a_54_3730.t6 0 1.61593f
C60 a_54_3730.n0 0 1.62579f
C61 a_54_3730.t7 0 1.64234f
C62 a_54_3730.t5 0 1.6167f
C63 a_54_3730.n1 0 0.77535f
C64 a_54_3730.t1 0 1.54148f
C65 a_54_3730.n2 0 0.29168f
C66 a_54_3730.t4 0 1.61593f
C67 a_54_3730.n3 0 0.83461f
C68 a_54_3730.t3 0 1.61593f
C69 a_54_3730.n4 0 4.01749f
C70 a_54_3730.t2 0 2.28127f
C71 a_54_3730.n5 0 0.5656f
C72 a_354_3730.t3 0 0.34488f
C73 a_354_3730.t2 0 0.49393f
C74 a_354_3730.n0 0 0.4866f
C75 a_354_3730.t4 0 0.49393f
C76 a_354_3730.n1 0 0.51076f
C77 a_354_3730.t1 0 0.28957f
C78 a_354_3730.n2 0 0.15685f
C79 a_354_3730.t0 0 0.43656f
C80 a_354_3730.n3 0 0.23124f
C81 a_354_3730.t5 0 0.49393f
C82 a_354_3730.n4 0 0.49034f
C83 a_354_3730.t6 0 0.49393f
C84 a_354_3730.n5 0 0.50388f
C85 a_354_3730.t16 0 1.47354f
C86 a_354_3730.n6 0 1.35338f
C87 a_354_3730.t17 0 1.49709f
C88 a_354_3730.t15 0 1.47354f
C89 a_354_3730.n7 0 0.67844f
C90 a_354_3730.t14 0 1.47354f
C91 a_354_3730.n8 0 0.79686f
C92 a_354_3730.t13 0 1.47354f
C93 a_354_3730.n9 0 1.03285f
C94 a_354_3730.t12 0 0.65062f
C95 a_354_3730.n10 0 0.98285f
C96 a_354_3730.t11 0 0.72697f
C97 a_354_3730.n11 0 0.51419f
C98 a_354_3730.t10 0 0.65062f
C99 a_354_3730.n12 0 0.98285f
C100 a_354_3730.t9 0 0.72697f
C101 a_354_3730.n13 0 0.93034f
C102 a_354_3730.t8 0 1.47354f
C103 a_354_3730.n14 0 2.2736f
C104 a_354_3730.t7 0 1.51939f
C105 a_354_3730.n15 0 0.34333f
C106 a_15962_3730.t0 0 1.26575f
C107 a_15962_3730.t1 0 1.25098f
C108 a_15962_3730.n0 0 1.04385f
C109 a_15962_3730.t2 0 1.23043f
C110 a_14338_3730.t2 0 0.70635f
C111 a_14338_3730.t3 0 0.97361f
C112 a_14338_3730.n0 0 1.12164f
C113 a_14338_3730.t4 0 0.99493f
C114 a_14338_3730.t0 0 1.7226f
C115 a_14338_3730.n1 0 1.05616f
C116 a_14338_3730.t1 0 1.66642f
C117 a_14338_3730.n2 0 0.44052f
C118 a_9974_3846.t1 0 0.63141f
C119 a_9974_3846.t3 0 0.15978f
C120 a_9974_3846.t2 0 0.15978f
C121 a_9974_3846.n0 0 1.3958f
C122 a_9974_3846.t0 0 1.09033f
C123 a_9974_3846.n1 0 1.32195f
C124 a_9974_3846.t6 0 1.8498f
C125 a_9974_3846.t5 0 1.99713f
C126 a_9974_3846.n2 0 2.24523f
C127 a_9974_3846.t4 0 1.85634f
C128 a_9974_3846.n3 0 1.49892f
C129 a_9974_3846.n4 0 2.0013f
C130 a_254_3846.t0 0 0.0595f
C131 a_254_3846.t1 0 0.0595f
C132 a_14_330.t1 0 0.18834f
C133 a_14_330.t0 0 0.36603f
C134 a_14_330.t2 0 1.59256f
C135 a_14_330.n0 0 0.31195f
C136 a_14_330.t11 0 0.81634f
C137 a_14_330.n1 0 0.74414f
C138 a_14_330.t10 0 0.81634f
C139 a_14_330.n2 0 0.80495f
C140 a_14_330.t9 0 0.81634f
C141 a_14_330.n3 0 0.80638f
C142 a_14_330.t7 0 0.36148f
C143 a_14_330.t8 0 0.37807f
C144 a_14_330.n4 0 0.73864f
C145 a_14_330.n5 0 0.53389f
C146 a_14_330.t5 0 0.36148f
C147 a_14_330.t6 0 0.37807f
C148 a_14_330.n6 0 0.73864f
C149 a_14_330.n7 0 0.89898f
C150 a_14_330.t4 0 0.81634f
C151 a_14_330.n8 0 1.74543f
C152 a_14_330.t3 0 0.86144f
C153 a_14_330.n9 0 0.47248f
C154 a_1366_3846.t0 0 0.06277f
C155 a_1366_3846.t1 0 0.06277f
C156 a_746_330.t0 0 0.67498f
C157 a_746_330.t5 0 1.24541f
C158 a_746_330.t1 0 2.35925f
C159 a_746_330.n0 0 0.76865f
C160 a_746_330.t4 0 1.23169f
C161 a_746_330.n1 0 1.07529f
C162 a_746_330.t3 0 1.23169f
C163 a_746_330.n2 0 4.06841f
C164 a_746_330.t2 0 2.06777f
C165 a_746_330.n3 0 0.83294f
C166 a_3290_3846.t0 0 0.07579f
C167 a_3290_3846.t1 0 0.07579f
C168 a_4402_3846.t0 0 0.07439f
C169 a_4402_3846.t1 0 0.07439f
C170 a_4702_3846.t1 0 1.65077f
C171 a_4702_3846.t0 0 1.62298f
C172 a_4702_3846.n0 0 1.06467f
C173 a_4702_3846.t3 0 1.89551f
C174 a_4702_3846.n1 0 0.74044f
C175 a_4702_3846.t2 0 1.96114f
C176 a_4702_3846.t4 0 1.62298f
C177 a_4702_3846.n2 0 1.14904f
C178 a_4702_3846.t5 0 1.65077f
C179 a_4702_3846.n3 0 1.23199f
C180 a_5514_3846.t0 0 0.07482f
C181 a_5514_3846.t1 0 0.07482f
C182 a_6626_3846.t6 0 0.03573f
C183 a_6626_3846.n0 0 0.13452f
C184 a_6626_3846.t0 0 0.18194f
C185 a_6626_3846.n1 0 0.34851f
C186 a_6626_3846.t7 0 0.19281f
C187 a_6626_3846.n2 0 21.1f
C188 a_6626_3846.t1 0 0.14291f
C189 a_6626_3846.t2 0 0.14291f
C190 a_6626_3846.n3 0 3.55252f
C191 a_6626_3846.t3 0 0.03573f
C192 a_6626_3846.t4 0 0.03573f
C193 a_6626_3846.n4 0 0.14413f
C194 a_6626_3846.n5 0 0.53643f
C195 a_6626_3846.t5 0 0.03573f
C196 a_7742_3846.t5 0 0.11041f
C197 a_7742_3846.n0 0 0.41572f
C198 a_7742_3846.t7 0 0.44164f
C199 a_7742_3846.t6 0 0.44164f
C200 a_7742_3846.n1 0 2.65735f
C201 a_7742_3846.n2 0 3.514f
C202 a_7742_3846.t1 0 0.56227f
C203 a_7742_3846.n3 0 1.17356f
C204 a_7742_3846.t0 0 0.59585f
C205 a_7742_3846.t2 0 0.11041f
C206 a_7742_3846.t3 0 0.11041f
C207 a_7742_3846.n4 0 0.44542f
C208 a_7742_3846.n5 0 1.60804f
C209 a_7742_3846.t4 0 0.11041f
C210 a_8858_3846.t3 0 0.55354f
C211 a_8858_3846.t7 0 0.87126f
C212 a_8858_3846.t6 0 0.92211f
C213 a_8858_3846.n0 0 1.20821f
C214 a_8858_3846.t4 0 0.93633f
C215 a_8858_3846.n1 0 0.64797f
C216 a_8858_3846.t5 0 0.87753f
C217 a_8858_3846.n2 0 0.77047f
C218 a_8858_3846.n3 0 0.49912f
C219 a_8858_3846.t11 0 0.87126f
C220 a_8858_3846.t10 0 0.92211f
C221 a_8858_3846.n4 0 1.20821f
C222 a_8858_3846.t8 0 0.93633f
C223 a_8858_3846.n5 0 0.64797f
C224 a_8858_3846.t9 0 0.87753f
C225 a_8858_3846.n6 0 0.77047f
C226 a_8858_3846.n7 0 1.39251f
C227 a_8858_3846.t2 0 0.15026f
C228 a_8858_3846.t1 0 0.15026f
C229 a_8858_3846.n8 0 1.13139f
C230 a_8858_3846.t0 0 1.08314f
C231 a_8858_3846.n9 0 0.64016f
C232 a_7218_446.t6 0 0.21933f
C233 a_7218_446.n0 0 1.50053f
C234 a_7218_446.t5 0 1.21162f
C235 a_7218_446.n1 0 1.3359f
C236 a_7218_446.t4 0 1.25109f
C237 a_7218_446.n2 0 3.55369f
C238 a_7218_446.t3 0 0.21933f
C239 a_7218_446.t2 0 0.21933f
C240 a_7218_446.n3 0 0.91063f
C241 a_7218_446.t1 0 0.21933f
C242 a_7218_446.t0 0 0.21933f
C243 a_7218_446.n4 0 0.87865f
C244 a_7218_446.n5 0 1.75498f
C245 a_7218_446.t7 0 0.21933f
C246 a_6106_446.t1 0 0.11316f
C247 a_6106_446.n0 0 0.73169f
C248 a_6106_446.n1 0 0.81055f
C249 a_6106_446.t6 0 11.0073f
C250 a_6106_446.t8 0 0.62513f
C251 a_6106_446.n2 0 0.70464f
C252 a_6106_446.t7 0 0.64549f
C253 a_6106_446.n3 0 1.73821f
C254 a_6106_446.t4 0 0.11316f
C255 a_6106_446.t3 0 0.11316f
C256 a_6106_446.n4 0 0.46983f
C257 a_6106_446.t2 0 0.11316f
C258 a_6106_446.t5 0 0.11316f
C259 a_6106_446.n5 0 0.45334f
C260 a_6106_446.n6 0 0.97017f
C261 a_6106_446.t0 0 0.11316f
C262 a_8330_446.t0 0 0.07157f
C263 a_8330_446.n0 0 0.776f
C264 a_8330_446.t10 0 0.46365f
C265 a_8330_446.n1 0 0.39239f
C266 a_8330_446.t8 0 0.47381f
C267 a_8330_446.n2 0 0.78306f
C268 a_8330_446.t11 0 0.46365f
C269 a_8330_446.t9 0 0.47841f
C270 a_8330_446.n3 0 0.73561f
C271 a_8330_446.n4 0 1.40726f
C272 a_8330_446.t6 0 0.46365f
C273 a_8330_446.n5 0 0.39239f
C274 a_8330_446.t4 0 0.47381f
C275 a_8330_446.n6 0 0.78306f
C276 a_8330_446.t7 0 0.46365f
C277 a_8330_446.t5 0 0.47841f
C278 a_8330_446.n7 0 0.73561f
C279 a_8330_446.n8 0 0.53113f
C280 a_8330_446.t3 0 0.50796f
C281 a_8330_446.n9 0 0.78304f
C282 a_8330_446.t2 0 1.09406f
C283 a_8330_446.t1 0 0.07157f
C284 a_9442_446.t0 0 0.0887f
C285 a_9442_446.n0 0 1.26477f
C286 a_9442_446.t2 0 0.6774f
C287 a_9442_446.n1 0 2.47f
C288 a_9442_446.t1 0 1.24033f
C289 a_9442_446.n2 0 1.33441f
C290 a_9442_446.t5 0 1.0922f
C291 a_9442_446.n3 0 1.36525f
C292 a_9442_446.t6 0 1.08874f
C293 a_9442_446.t4 0 1.10553f
C294 a_9442_446.n4 0 1.41567f
C295 a_9442_446.t3 0 0.0887f
C296 a_16162_3846.t0 0 0.07305f
C297 a_16162_3846.t1 0 0.07305f
C298 a_18086_3846.t0 0 0.07375f
C299 a_18086_3846.t1 0 0.07375f
C300 a_13794_330.t2 0 0.59783f
C301 a_13794_330.t1 0 1.05772f
C302 a_13794_330.n0 0 0.74191f
C303 a_13794_330.t3 0 0.69231f
C304 a_13794_330.n1 0 1.266f
C305 a_13794_330.t4 0 0.71721f
C306 a_13794_330.t0 0 2.12017f
C307 a_13794_330.n2 0 0.81724f
C308 a_16202_446.t0 0 0.62107f
C309 a_16202_446.t2 0 1.06266f
C310 a_16202_446.n0 0 0.98267f
C311 a_16202_446.t1 0 0.59766f
C312 a_946_446.t0 0 0.03348f
C313 a_946_446.t1 0 0.03348f
C314 a_4042_446.t0 0 0.03667f
C315 a_4042_446.t1 0 0.03667f
C316 a_4342_446.t0 0 0.85444f
C317 a_4342_446.t1 0 0.88225f
C318 a_4342_446.t2 0 0.65488f
C319 a_4342_446.n0 0 0.55361f
C320 a_4342_446.t3 0 0.7065f
C321 a_4342_446.t4 0 0.85444f
C322 a_4342_446.n1 0 0.87179f
C323 a_4342_446.t5 0 0.88225f
C324 a_4342_446.n2 0 0.98373f
C325 a_4342_446.n3 0 0.80635f
C326 a_5074_446.t0 0 0.03713f
C327 a_5074_446.t1 0 0.03713f
C328 a_15458_446.t0 0 0.03833f
C329 a_15458_446.t1 0 0.03833f
C330 a_17222_446.t0 0 0.03883f
C331 a_17222_446.t1 0 0.03883f
C332 IN+.t2 0 1.342f
C333 IN+.t3 0 1.24268f
C334 IN+.n0 0 1.61864f
C335 IN+.t0 0 0.66081f
C336 IN+.t1 0 0.68955f
C337 IN+.n1 0 1.08543f
C338 IN-.t2 0 1.34042f
C339 IN-.t3 0 1.24122f
C340 IN-.n0 0 1.60421f
C341 IN-.t0 0 0.66003f
C342 IN-.t1 0 0.68874f
C343 IN-.n1 0 1.10468f
C344 VDD.t3 0 0.56157f
C345 VDD.t4 0 0.09843f
C346 VDD.t5 0 0.09843f
C347 VDD.n0 0 0.39434f
C348 VDD.n1 0 0.31585f
C349 VDD.t10 0 0.54377f
C350 VDD.n2 0 0.30961f
C351 VDD.t14 0 0.56157f
C352 VDD.t11 0 0.09843f
C353 VDD.t12 0 0.09843f
C354 VDD.n3 0 0.39434f
C355 VDD.n4 0 0.31585f
C356 VDD.t13 0 0.54377f
C357 VDD.n5 0 0.30961f
C358 VDD.t6 0 0.56854f
C359 VDD.t9 0 0.56854f
C360 VDD.t0 0 0.19687f
C361 VDD.t1 0 0.19687f
C362 VDD.n6 0 0.81608f
C363 VDD.t18 0 1.13146f
C364 VDD.n7 0 0.55551f
C365 VDD.n8 0 3.00854f
C366 VDD.n9 0 1.98522f
C367 VDD.n10 0 2.10032f
C368 VDD.n11 0 1.11485f
C369 VDD.t16 0 0.56854f
C370 VDD.t15 0 0.56854f
C371 VDD.t8 0 0.56854f
C372 VDD.t7 0 0.2184f
C373 VDD.t17 0 0.56854f
C374 VDD.t2 0 0.70864f
C375 VDD.n12 0 1.44904f
C376 VDD.n13 0 0.89782f
C377 VDD.n14 0 0.81727f
C378 VDD.n15 0 0.92305f
C379 VDD.n16 0 2.2236f
C380 OUT.t1 0 0.08514f
C381 OUT.t6 0 0.08514f
C382 OUT.n0 0 0.35292f
C383 OUT.t0 0 0.4893f
C384 OUT.n1 0 0.26102f
C385 OUT.t3 0 0.04257f
C386 OUT.t4 0 0.04257f
C387 OUT.n2 0 0.17518f
C388 OUT.t5 0 0.23465f
C389 OUT.n3 0 0.20198f
C390 OUT.t2 0 4.14062f
C391 OUT.n4 0 12.9582f
C392 VSS.t9 0 0.13865f
C393 VSS.t5 0 0.02569f
C394 VSS.t6 0 0.02569f
C395 VSS.n0 0 0.09671f
C396 VSS.n1 0 0.15963f
C397 VSS.t14 0 0.1308f
C398 VSS.n2 0 0.09725f
C399 VSS.t17 0 0.22571f
C400 VSS.t13 0 0.22571f
C401 VSS.t10 0 0.05137f
C402 VSS.t7 0 0.05137f
C403 VSS.n3 0 0.2114f
C404 VSS.t8 0 0.28317f
C405 VSS.n4 0 0.2693f
C406 VSS.n5 0 1.77211f
C407 VSS.n6 0 1.01762f
C408 VSS.n7 0 0.9786f
C409 VSS.t15 0 0.13865f
C410 VSS.t16 0 0.02569f
C411 VSS.t11 0 0.02569f
C412 VSS.n8 0 0.09671f
C413 VSS.n9 0 0.15963f
C414 VSS.t12 0 0.1308f
C415 VSS.n10 0 0.09725f
C416 VSS.t2 0 0.22571f
C417 VSS.t1 0 0.22571f
C418 VSS.t0 0 0.03185f
C419 VSS.t4 0 0.03185f
C420 VSS.t3 0 0.22571f
C421 VSS.t18 0 0.04692f
C422 VSS.n11 0 0.65759f
C423 VSS.n12 0 0.42376f
C424 VSS.n13 0 0.42376f
C425 VSS.n14 0 0.48753f
C426 VSS.n15 0 1.26123f
C427 VSS.n16 0 1.05151f
.ends
