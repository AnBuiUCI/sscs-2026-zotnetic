* Nodos de bulk atados: 38 de pozo n -> VDD, 39 de sustrato -> VSS.
*   magic no extrae los taps de este layout y los dejaba flotando;
*   la conexion si existe (el LVS de KLayout da 'match uniquely').
*   Quien detecta un tap que falte de verdad es el LVS, no esto.
* NGSPICE file created from COMP.ext - technology: gf180mcuD

.subckt COMP VSS VDD OUT INP INN
X0 VSS.t5 a_8330_446.t4 a_6626_3846.t7 VSS nfet_06v0 ad=1.1p pd=5.88u as=0.65p ps=3.02u w=2.5u l=1u
X1 a_4702_3846.t4 INN.t2 a_7742_3846.t1 VDD pfet_06v0 ad=4.4p pd=20.88u as=2.6p ps=10.52u w=10u l=1u
X2 a_9442_446.t0 a_14338_3730.t3 a_9974_3846.t2 VDD pfet_06v0 ad=2.2p pd=10.88u as=2.2p ps=10.88u w=5u l=1u
X3 a_4342_446.t2 a_14_330.t9 a_5074_446.t0 VSS nfet_06v0 ad=2.2p pd=10.88u as=1.25p ps=5.5u w=5u l=1u
X4 a_4702_3846.t5 a_354_3730.t13 a_5514_3846.t1 VDD pfet_06v0 ad=4.4p pd=20.88u as=2.5p ps=10.5u w=10u l=1u
X5 a_6106_446.t3 a_354_3730.t9 a_9974_3846.t0 VDD pfet_06v0 ad=2.2p pd=10.88u as=1.3p ps=5.52u w=5u l=1u
X6 a_14_330.t2 a_14_330.t1 VSS.t0 VSS nfet_06v0 ad=0.44p pd=2.88u as=0.44p ps=2.88u w=1u l=1u
X7 a_7218_446.t5 INN.t1 a_4342_446.t4 VSS nfet_06v0 ad=1.3p pd=5.52u as=2.2p ps=10.88u w=5u l=1u
X8 a_7218_446.t2 a_354_3730.t11 a_8858_3846.t0 VDD pfet_06v0 ad=2.2p pd=10.88u as=1.3p ps=5.52u w=5u l=1u
X9 a_5074_446.t1 a_746_330.t3 VSS.t3 VSS nfet_06v0 ad=1.25p pd=5.5u as=2.2p ps=10.88u w=5u l=1u
X10 a_9442_446.t2 a_14_330.t6 a_6626_3846.t3 VSS nfet_06v0 ad=0.65p pd=3.02u as=1.1p ps=5.88u w=2.5u l=1u
X11 a_6626_3846.t8 OUT.t2 cap_mim_2f0_m4m5_noshield c_width=20u c_length=10u
X12 a_4702_3846.t1 INP.t2 a_6626_3846.t1 VDD pfet_06v0 ad=4.4p pd=20.88u as=2.6p ps=10.52u w=10u l=1u
X13 VDD.t13 a_8858_3846.t10 a_7218_446.t3 VDD pfet_06v0 ad=1.3p pd=5.52u as=1.3p ps=5.52u w=5u l=1u
X14 a_8330_446.t1 a_14338_3730.t4 a_8858_3846.t1 VDD pfet_06v0 ad=2.2p pd=10.88u as=2.2p ps=10.88u w=5u l=1u
X15 VDD.t5 a_9974_3846.t5 OUT.t0 VDD pfet_06v0 ad=2.6p pd=10.52u as=2.6p ps=10.52u w=10u l=1u
X16 a_6626_3846.t6 a_8330_446.t5 VSS.t4 VSS nfet_06v0 ad=0.65p pd=3.02u as=0.65p ps=3.02u w=2.5u l=1u
X17 a_946_446.t0 a_746_330.t5 VSS.t2 VSS nfet_06v0 ad=1.25p pd=5.5u as=2.2p ps=10.88u w=5u l=1u
X18 OUT.t6 a_9442_446.t4 VSS.t18 VSS nfet_06v0 ad=2.2p pd=10.88u as=1.3p ps=5.52u w=5u l=1u
X19 a_4702_3846.t2 a_354_3730.t14 a_4402_3846.t1 VDD pfet_06v0 ad=4.4p pd=20.88u as=2.5p ps=10.5u w=10u l=1u
X20 a_9974_3846.t3 a_13794_330.t3 a_9442_446.t3 VSS nfet_06v0 ad=1.1p pd=5.88u as=1.1p ps=5.88u w=2.5u l=1u
X21 a_6106_446.t2 a_8858_3846.t7 VDD.t1 VDD pfet_06v0 ad=1.3p pd=5.52u as=2.2p ps=10.88u w=5u l=1u
X22 a_16162_3846.t0 a_15962_3730.t2 VDD.t0 VDD pfet_06v0 ad=2.5p pd=10.5u as=4.4p ps=20.88u w=10u l=1u
X23 a_4342_446.t1 INP.t0 a_6106_446.t1 VSS nfet_06v0 ad=2.2p pd=10.88u as=1.3p ps=5.52u w=5u l=1u
X24 a_7742_3846.t6 a_8330_446.t9 VSS.t13 VSS nfet_06v0 ad=0.65p pd=3.02u as=0.65p ps=3.02u w=2.5u l=1u
X25 a_17222_446.t0 a_16202_446.t2 VSS.t1 VSS nfet_06v0 ad=1.25p pd=5.5u as=2.2p ps=10.88u w=5u l=1u
X26 a_354_3730.t3 a_354_3730.t2 a_3010_446.t1 VSS nfet_06v0 ad=0.44p pd=2.88u as=0.25p ps=1.5u w=1u l=1u
X27 a_13794_330.t0 a_354_3730.t7 a_18086_3846.t1 VDD pfet_06v0 ad=4.4p pd=20.88u as=2.5p ps=10.5u w=10u l=1u
X28 a_3290_3846.t1 a_54_3730.t5 VDD.t18 VDD pfet_06v0 ad=2.5p pd=10.5u as=4.4p ps=20.88u w=10u l=1u
X29 a_6106_446.t5 a_8858_3846.t5 VDD.t8 VDD pfet_06v0 ad=1.3p pd=5.52u as=1.3p ps=5.52u w=5u l=1u
X30 a_746_330.t1 a_14_330.t11 a_946_446.t1 VSS nfet_06v0 ad=2.2p pd=10.88u as=1.25p ps=5.5u w=5u l=1u
X31 a_7742_3846.t3 a_14_330.t7 a_8330_446.t2 VSS nfet_06v0 ad=1.1p pd=5.88u as=0.65p ps=3.02u w=2.5u l=1u
X32 VSS.t10 a_8330_446.t6 a_6626_3846.t5 VSS nfet_06v0 ad=0.65p pd=3.02u as=0.65p ps=3.02u w=2.5u l=1u
X33 a_16202_446.t0 a_14_330.t3 a_17222_446.t1 VSS nfet_06v0 ad=2.2p pd=10.88u as=1.25p ps=5.5u w=5u l=1u
X34 OUT.t7 a_6106_446.t8 cap_mim_2f0_m4m5_noshield c_width=20u c_length=10u
X35 a_7218_446.t1 a_8858_3846.t9 VDD.t3 VDD pfet_06v0 ad=1.3p pd=5.52u as=1.3p ps=5.52u w=5u l=1u
X36 OUT.t3 a_9974_3846.t4 VDD.t17 VDD pfet_06v0 ad=4.4p pd=20.88u as=2.6p ps=10.52u w=10u l=1u
X37 a_14_330.t0 a_354_3730.t17 a_254_3846.t1 VDD pfet_06v0 ad=4.4p pd=20.88u as=2.5p ps=10.5u w=10u l=1u
X38 a_14338_3730.t1 a_14338_3730.t0 a_15962_3730.t0 VDD pfet_06v0 ad=4.4p pd=20.88u as=4.4p ps=20.88u w=10u l=1u
X39 a_3010_446.t0 a_354_3730.t4 VSS.t6 VSS nfet_06v0 ad=0.25p pd=1.5u as=0.44p ps=2.88u w=1u l=1u
X40 VSS.t7 a_9442_446.t5 OUT.t4 VSS nfet_06v0 ad=1.3p pd=5.52u as=1.3p ps=5.52u w=5u l=1u
X41 VSS.t14 a_8330_446.t10 a_7742_3846.t5 VSS nfet_06v0 ad=0.65p pd=3.02u as=0.65p ps=3.02u w=2.5u l=1u
X42 a_15458_446.t1 a_746_330.t2 VSS.t17 VSS nfet_06v0 ad=1.25p pd=5.5u as=2.2p ps=10.88u w=5u l=1u
X43 a_354_3730.t1 a_354_3730.t0 VDD.t12 VDD pfet_06v0 ad=0.88p pd=4.88u as=0.88p ps=4.88u w=2u l=1u
X44 VDD.t9 a_8858_3846.t6 a_6106_446.t6 VDD pfet_06v0 ad=1.3p pd=5.52u as=1.3p ps=5.52u w=5u l=1u
X45 a_8858_3846.t2 a_354_3730.t12 a_7218_446.t7 VDD pfet_06v0 ad=1.3p pd=5.52u as=2.2p ps=10.88u w=5u l=1u
X46 a_7218_446.t4 a_8858_3846.t11 VDD.t14 VDD pfet_06v0 ad=1.3p pd=5.52u as=2.2p ps=10.88u w=5u l=1u
X47 OUT.t1 a_9974_3846.t6 VDD.t6 VDD pfet_06v0 ad=2.6p pd=10.52u as=4.4p ps=20.88u w=10u l=1u
X48 a_8330_446.t0 a_14_330.t8 a_7742_3846.t0 VSS nfet_06v0 ad=0.65p pd=3.02u as=1.1p ps=5.88u w=2.5u l=1u
X49 a_6626_3846.t4 a_8330_446.t7 VSS.t11 VSS nfet_06v0 ad=0.65p pd=3.02u as=1.1p ps=5.88u w=2.5u l=1u
X50 a_14338_3730.t2 a_14_330.t4 a_15458_446.t0 VSS nfet_06v0 ad=2.2p pd=10.88u as=1.25p ps=5.5u w=5u l=1u
X51 VDD.t15 a_8858_3846.t4 a_6106_446.t7 VDD pfet_06v0 ad=2.2p pd=10.88u as=1.3p ps=5.52u w=5u l=1u
X52 a_54_3730.t0 a_354_3730.t15 a_3290_3846.t0 VDD pfet_06v0 ad=4.4p pd=20.88u as=2.5p ps=10.5u w=10u l=1u
X53 a_4342_446.t3 a_14_330.t10 a_4042_446.t0 VSS nfet_06v0 ad=2.2p pd=10.88u as=1.25p ps=5.5u w=5u l=1u
X54 OUT.t5 a_9442_446.t6 VSS.t8 VSS nfet_06v0 ad=1.3p pd=5.52u as=2.2p ps=10.88u w=5u l=1u
X55 a_1366_3846.t0 a_54_3730.t6 VDD.t7 VDD pfet_06v0 ad=2.5p pd=10.5u as=4.4p ps=20.88u w=10u l=1u
X56 a_6626_3846.t0 INP.t3 a_4702_3846.t0 VDD pfet_06v0 ad=2.6p pd=10.52u as=4.4p ps=20.88u w=10u l=1u
X57 a_9974_3846.t1 a_354_3730.t10 a_6106_446.t4 VDD pfet_06v0 ad=1.3p pd=5.52u as=2.2p ps=10.88u w=5u l=1u
X58 VDD.t2 a_8858_3846.t8 a_7218_446.t0 VDD pfet_06v0 ad=2.2p pd=10.88u as=1.3p ps=5.52u w=5u l=1u
X59 a_7742_3846.t4 a_8330_446.t11 VSS.t9 VSS nfet_06v0 ad=0.65p pd=3.02u as=1.1p ps=5.88u w=2.5u l=1u
X60 a_18086_3846.t0 a_54_3730.t2 VDD.t16 VDD pfet_06v0 ad=2.5p pd=10.5u as=4.4p ps=20.88u w=10u l=1u
X61 a_54_3730.t1 a_354_3730.t5 a_1978_446.t0 VSS nfet_06v0 ad=0.44p pd=2.88u as=0.25p ps=1.5u w=1u l=1u
X62 a_8858_3846.t3 a_13794_330.t4 a_8330_446.t3 VSS nfet_06v0 ad=1.1p pd=5.88u as=1.1p ps=5.88u w=2.5u l=1u
X63 a_7742_3846.t2 INN.t3 a_4702_3846.t3 VDD pfet_06v0 ad=2.6p pd=10.52u as=4.4p ps=20.88u w=10u l=1u
X64 a_6106_446.t0 INP.t1 a_4342_446.t0 VSS nfet_06v0 ad=1.3p pd=5.52u as=2.2p ps=10.88u w=5u l=1u
X65 a_13794_330.t2 a_13794_330.t1 a_16202_446.t1 VSS nfet_06v0 ad=2.2p pd=10.88u as=2.2p ps=10.88u w=5u l=1u
X66 a_4042_446.t1 a_746_330.t4 VSS.t16 VSS nfet_06v0 ad=1.25p pd=5.5u as=2.2p ps=10.88u w=5u l=1u
X67 a_254_3846.t0 a_54_3730.t7 VDD.t11 VDD pfet_06v0 ad=2.5p pd=10.5u as=4.4p ps=20.88u w=10u l=1u
X68 a_5514_3846.t0 a_54_3730.t3 VDD.t4 VDD pfet_06v0 ad=2.5p pd=10.5u as=4.4p ps=20.88u w=10u l=1u
X69 a_4342_446.t5 INN.t0 a_7218_446.t6 VSS nfet_06v0 ad=2.2p pd=10.88u as=1.3p ps=5.52u w=5u l=1u
X70 VSS.t12 a_8330_446.t8 a_7742_3846.t7 VSS nfet_06v0 ad=1.1p pd=5.88u as=0.65p ps=3.02u w=2.5u l=1u
X71 a_15962_3730.t1 a_354_3730.t8 a_16162_3846.t1 VDD pfet_06v0 ad=4.4p pd=20.88u as=2.5p ps=10.5u w=10u l=1u
X72 a_1978_446.t1 a_354_3730.t6 VSS.t15 VSS nfet_06v0 ad=0.25p pd=1.5u as=0.44p ps=2.88u w=1u l=1u
X73 a_746_330.t0 a_354_3730.t16 a_1366_3846.t1 VDD pfet_06v0 ad=4.4p pd=20.88u as=2.5p ps=10.5u w=10u l=1u
X74 a_4402_3846.t0 a_54_3730.t4 VDD.t10 VDD pfet_06v0 ad=2.5p pd=10.5u as=4.4p ps=20.88u w=10u l=1u
X75 a_6626_3846.t2 a_14_330.t5 a_9442_446.t1 VSS nfet_06v0 ad=1.1p pd=5.88u as=0.65p ps=3.02u w=2.5u l=1u
R0 VSS.n60 VSS.n57 9.0005
R1 VSS.n62 VSS.n61 9.0005
R2 VSS.n63 VSS.n56 9.0005
R3 VSS.n66 VSS.n65 9.0005
R4 VSS.n67 VSS.n55 9.0005
R5 VSS.n69 VSS.n68 9.0005
R6 VSS.n71 VSS.n54 9.0005
R7 VSS.n73 VSS.n72 9.0005
R8 VSS.n75 VSS.n74 9.0005
R9 VSS.n76 VSS.n52 9.0005
R10 VSS.n78 VSS.n77 9.0005
R11 VSS.n80 VSS.n79 9.0005
R12 VSS.n81 VSS.n50 9.0005
R13 VSS.n83 VSS.n82 9.0005
R14 VSS.n84 VSS.n49 9.0005
R15 VSS.n86 VSS.n85 9.0005
R16 VSS.n87 VSS.n48 9.0005
R17 VSS.n89 VSS.n88 9.0005
R18 VSS.n90 VSS.n47 9.0005
R19 VSS.n92 VSS.n91 9.0005
R20 VSS.n93 VSS.n46 9.0005
R21 VSS.n95 VSS.n94 9.0005
R22 VSS.n96 VSS.n4 9.0005
R23 VSS.n98 VSS.n97 9.0005
R24 VSS.n45 VSS.n0 9.0005
R25 VSS.n44 VSS.n43 9.0005
R26 VSS.n42 VSS.n5 9.0005
R27 VSS.n41 VSS.n40 9.0005
R28 VSS.n39 VSS.n9 9.0005
R29 VSS.n38 VSS.n37 9.0005
R30 VSS.n36 VSS.n10 9.0005
R31 VSS.n35 VSS.n34 9.0005
R32 VSS.n33 VSS.n11 9.0005
R33 VSS.n32 VSS.n31 9.0005
R34 VSS.n30 VSS.n12 9.0005
R35 VSS.n29 VSS.n28 9.0005
R36 VSS.n27 VSS.n13 9.0005
R37 VSS.n26 VSS.n25 9.0005
R38 VSS.n23 VSS.n14 9.0005
R39 VSS.n22 VSS.n21 9.0005
R40 VSS.n20 VSS.n15 9.0005
R41 VSS.n7 VSS.t5 7.46776
R42 VSS.n2 VSS.t12 7.46776
R43 VSS.n8 VSS.t11 6.6657
R44 VSS.n3 VSS.t9 6.6657
R45 VSS.n18 VSS.n17 6.60756
R46 VSS.n7 VSS.n6 6.0605
R47 VSS.n2 VSS.n1 6.0605
R48 VSS.n18 VSS.t8 6.0206
R49 VSS.n59 VSS.t0 5.51755
R50 VSS.n70 VSS.t6 5.42612
R51 VSS.n64 VSS.t15 5.42612
R52 VSS.n19 VSS.n18 5.29252
R53 VSS.n9 VSS.n8 5.19651
R54 VSS.n99 VSS.n3 5.19651
R55 VSS.n60 VSS.n59 4.71005
R56 VSS.n16 VSS.t1 2.05582
R57 VSS.n24 VSS.t17 2.05582
R58 VSS.n51 VSS.t3 2.05582
R59 VSS.n53 VSS.t16 2.05582
R60 VSS.n58 VSS.t2 2.05582
R61 VSS.n20 VSS.n19 1.71758
R62 VSS.n8 VSS.n7 0.802559
R63 VSS.n3 VSS.n2 0.802559
R64 VSS.n6 VSS.t4 0.6557
R65 VSS.n6 VSS.t10 0.6557
R66 VSS.n1 VSS.t13 0.6557
R67 VSS.n1 VSS.t14 0.6557
R68 VSS.n19 VSS.n16 0.359811
R69 VSS.n17 VSS.t18 0.3281
R70 VSS.n17 VSS.t7 0.3281
R71 VSS.n59 VSS.n58 0.274277
R72 VSS.n21 VSS.n20 0.2005
R73 VSS.n21 VSS.n14 0.2005
R74 VSS.n26 VSS.n14 0.2005
R75 VSS.n27 VSS.n26 0.2005
R76 VSS.n28 VSS.n27 0.2005
R77 VSS.n28 VSS.n12 0.2005
R78 VSS.n32 VSS.n12 0.2005
R79 VSS.n33 VSS.n32 0.2005
R80 VSS.n34 VSS.n33 0.2005
R81 VSS.n34 VSS.n10 0.2005
R82 VSS.n38 VSS.n10 0.2005
R83 VSS.n39 VSS.n38 0.2005
R84 VSS.n40 VSS.n39 0.2005
R85 VSS.n40 VSS.n5 0.2005
R86 VSS.n44 VSS.n5 0.2005
R87 VSS.n45 VSS.n44 0.2005
R88 VSS.n97 VSS.n45 0.2005
R89 VSS.n97 VSS.n96 0.2005
R90 VSS.n96 VSS.n95 0.2005
R91 VSS.n95 VSS.n46 0.2005
R92 VSS.n91 VSS.n46 0.2005
R93 VSS.n91 VSS.n90 0.2005
R94 VSS.n90 VSS.n89 0.2005
R95 VSS.n89 VSS.n48 0.2005
R96 VSS.n85 VSS.n48 0.2005
R97 VSS.n85 VSS.n84 0.2005
R98 VSS.n84 VSS.n83 0.2005
R99 VSS.n83 VSS.n50 0.2005
R100 VSS.n79 VSS.n50 0.2005
R101 VSS.n79 VSS.n78 0.2005
R102 VSS.n78 VSS.n52 0.2005
R103 VSS.n74 VSS.n52 0.2005
R104 VSS.n74 VSS.n73 0.2005
R105 VSS.n73 VSS.n54 0.2005
R106 VSS.n68 VSS.n54 0.2005
R107 VSS.n68 VSS.n67 0.2005
R108 VSS.n67 VSS.n66 0.2005
R109 VSS.n66 VSS.n56 0.2005
R110 VSS.n61 VSS.n56 0.2005
R111 VSS.n61 VSS.n60 0.2005
R112 VSS.n22 VSS.n15 0.2005
R113 VSS.n23 VSS.n22 0.2005
R114 VSS.n25 VSS.n23 0.2005
R115 VSS.n29 VSS.n13 0.2005
R116 VSS.n30 VSS.n29 0.2005
R117 VSS.n31 VSS.n30 0.2005
R118 VSS.n31 VSS.n11 0.2005
R119 VSS.n35 VSS.n11 0.2005
R120 VSS.n36 VSS.n35 0.2005
R121 VSS.n37 VSS.n36 0.2005
R122 VSS.n37 VSS.n9 0.2005
R123 VSS.n41 VSS.n9 0.2005
R124 VSS.n42 VSS.n41 0.2005
R125 VSS.n43 VSS.n42 0.2005
R126 VSS.n43 VSS.n0 0.2005
R127 VSS.n98 VSS.n4 0.2005
R128 VSS.n94 VSS.n4 0.2005
R129 VSS.n94 VSS.n93 0.2005
R130 VSS.n93 VSS.n92 0.2005
R131 VSS.n92 VSS.n47 0.2005
R132 VSS.n88 VSS.n47 0.2005
R133 VSS.n88 VSS.n87 0.2005
R134 VSS.n87 VSS.n86 0.2005
R135 VSS.n86 VSS.n49 0.2005
R136 VSS.n82 VSS.n49 0.2005
R137 VSS.n82 VSS.n81 0.2005
R138 VSS.n81 VSS.n80 0.2005
R139 VSS.n77 VSS.n76 0.2005
R140 VSS.n76 VSS.n75 0.2005
R141 VSS.n72 VSS.n71 0.2005
R142 VSS.n69 VSS.n55 0.2005
R143 VSS.n65 VSS.n55 0.2005
R144 VSS.n63 VSS.n62 0.2005
R145 VSS.n62 VSS.n57 0.2005
R146 VSS.n71 VSS.n70 0.184
R147 VSS.n25 VSS.n24 0.16
R148 VSS.n80 VSS.n51 0.152
R149 VSS.n99 VSS.n98 0.1405
R150 VSS.n72 VSS.n53 0.133
R151 VSS.n16 VSS.n15 0.123
R152 VSS.n64 VSS.n63 0.101
R153 VSS.n65 VSS.n64 0.1
R154 VSS.n75 VSS.n53 0.068
R155 VSS VSS.n0 0.0535
R156 VSS.n77 VSS.n51 0.049
R157 VSS.n24 VSS.n13 0.041
R158 VSS.n70 VSS.n69 0.017
R159 VSS.n58 VSS.n57 0.016
R160 VSS VSS.n99 0.0075
R161 OUT.n5 OUT.t7 15.9816
R162 OUT OUT.n1 11.4019
R163 OUT.n4 OUT.n3 9.95281
R164 OUT.n4 OUT.t2 9.33359
R165 OUT.n1 OUT.n0 6.97518
R166 OUT.n3 OUT.n2 6.60756
R167 OUT.n1 OUT.t3 6.11762
R168 OUT.n3 OUT.t6 6.0206
R169 OUT OUT.n5 5.06211
R170 OUT.n5 OUT.n4 0.671796
R171 OUT.n2 OUT.t4 0.3281
R172 OUT.n2 OUT.t5 0.3281
R173 OUT.n0 OUT.t0 0.1825
R174 OUT.n0 OUT.t1 0.1825
R175 VDD.n66 VDD.n65 9.0005
R176 VDD.n67 VDD.n62 9.0005
R177 VDD.n69 VDD.n68 9.0005
R178 VDD.n71 VDD.n60 9.0005
R179 VDD.n73 VDD.n72 9.0005
R180 VDD.n74 VDD.n59 9.0005
R181 VDD.n76 VDD.n75 9.0005
R182 VDD.n77 VDD.n58 9.0005
R183 VDD.n80 VDD.n79 9.0005
R184 VDD.n81 VDD.n57 9.0005
R185 VDD.n83 VDD.n82 9.0005
R186 VDD.n85 VDD.n56 9.0005
R187 VDD.n87 VDD.n86 9.0005
R188 VDD.n88 VDD.n55 9.0005
R189 VDD.n90 VDD.n89 9.0005
R190 VDD.n91 VDD.n54 9.0005
R191 VDD.n93 VDD.n92 9.0005
R192 VDD.n94 VDD.n53 9.0005
R193 VDD.n96 VDD.n95 9.0005
R194 VDD.n97 VDD.n52 9.0005
R195 VDD.n99 VDD.n98 9.0005
R196 VDD.n100 VDD.n1 9.0005
R197 VDD.n102 VDD.n101 9.0005
R198 VDD.n51 VDD.n0 9.0005
R199 VDD.n50 VDD.n49 9.0005
R200 VDD.n47 VDD.n2 9.0005
R201 VDD.n46 VDD.n45 9.0005
R202 VDD.n44 VDD.n6 9.0005
R203 VDD.n43 VDD.n42 9.0005
R204 VDD.n40 VDD.n7 9.0005
R205 VDD.n39 VDD.n38 9.0005
R206 VDD.n37 VDD.n11 9.0005
R207 VDD.n36 VDD.n35 9.0005
R208 VDD.n34 VDD.n12 9.0005
R209 VDD.n33 VDD.n32 9.0005
R210 VDD.n31 VDD.n13 9.0005
R211 VDD.n30 VDD.n29 9.0005
R212 VDD.n27 VDD.n14 9.0005
R213 VDD.n26 VDD.n25 9.0005
R214 VDD.n24 VDD.n15 9.0005
R215 VDD.n23 VDD.n22 9.0005
R216 VDD.n21 VDD.n16 9.0005
R217 VDD.n48 VDD.n5 8.50303
R218 VDD.n41 VDD.n10 8.50303
R219 VDD.n19 VDD.n18 8.18407
R220 VDD.n18 VDD.n17 6.97518
R221 VDD.n4 VDD.t2 6.74906
R222 VDD.n9 VDD.t15 6.74906
R223 VDD.n18 VDD.t6 6.11762
R224 VDD.n70 VDD.t12 6.09214
R225 VDD.n5 VDD.t14 5.947
R226 VDD.n10 VDD.t1 5.947
R227 VDD.n4 VDD.n3 5.6955
R228 VDD.n9 VDD.n8 5.6955
R229 VDD.n66 VDD.n63 3.23511
R230 VDD.n63 VDD.t11 2.28071
R231 VDD.n64 VDD.t7 2.1044
R232 VDD.n61 VDD.t18 2.1044
R233 VDD.n78 VDD.t10 2.1044
R234 VDD.n84 VDD.t4 2.1044
R235 VDD.n28 VDD.t0 2.1044
R236 VDD.n20 VDD.t16 2.1044
R237 VDD.n19 VDD.n16 1.81388
R238 VDD.n5 VDD.n4 0.802559
R239 VDD.n10 VDD.n9 0.802559
R240 VDD.n64 VDD.n63 0.37519
R241 VDD.n3 VDD.t3 0.3645
R242 VDD.n3 VDD.t13 0.3645
R243 VDD.n8 VDD.t8 0.3645
R244 VDD.n8 VDD.t9 0.3645
R245 VDD.n20 VDD.n19 0.354477
R246 VDD.n23 VDD.n16 0.2005
R247 VDD.n24 VDD.n23 0.2005
R248 VDD.n25 VDD.n24 0.2005
R249 VDD.n25 VDD.n14 0.2005
R250 VDD.n30 VDD.n14 0.2005
R251 VDD.n31 VDD.n30 0.2005
R252 VDD.n32 VDD.n31 0.2005
R253 VDD.n32 VDD.n12 0.2005
R254 VDD.n36 VDD.n12 0.2005
R255 VDD.n37 VDD.n36 0.2005
R256 VDD.n38 VDD.n37 0.2005
R257 VDD.n38 VDD.n7 0.2005
R258 VDD.n43 VDD.n7 0.2005
R259 VDD.n44 VDD.n43 0.2005
R260 VDD.n45 VDD.n44 0.2005
R261 VDD.n45 VDD.n2 0.2005
R262 VDD.n50 VDD.n2 0.2005
R263 VDD.n51 VDD.n50 0.2005
R264 VDD.n101 VDD.n51 0.2005
R265 VDD.n101 VDD.n100 0.2005
R266 VDD.n100 VDD.n99 0.2005
R267 VDD.n99 VDD.n52 0.2005
R268 VDD.n95 VDD.n52 0.2005
R269 VDD.n95 VDD.n94 0.2005
R270 VDD.n94 VDD.n93 0.2005
R271 VDD.n93 VDD.n54 0.2005
R272 VDD.n89 VDD.n54 0.2005
R273 VDD.n89 VDD.n88 0.2005
R274 VDD.n88 VDD.n87 0.2005
R275 VDD.n87 VDD.n56 0.2005
R276 VDD.n82 VDD.n56 0.2005
R277 VDD.n82 VDD.n81 0.2005
R278 VDD.n81 VDD.n80 0.2005
R279 VDD.n80 VDD.n58 0.2005
R280 VDD.n75 VDD.n58 0.2005
R281 VDD.n75 VDD.n74 0.2005
R282 VDD.n74 VDD.n73 0.2005
R283 VDD.n73 VDD.n60 0.2005
R284 VDD.n68 VDD.n60 0.2005
R285 VDD.n68 VDD.n67 0.2005
R286 VDD.n67 VDD.n66 0.2005
R287 VDD.n22 VDD.n21 0.2005
R288 VDD.n22 VDD.n15 0.2005
R289 VDD.n26 VDD.n15 0.2005
R290 VDD.n27 VDD.n26 0.2005
R291 VDD.n29 VDD.n13 0.2005
R292 VDD.n33 VDD.n13 0.2005
R293 VDD.n34 VDD.n33 0.2005
R294 VDD.n35 VDD.n34 0.2005
R295 VDD.n35 VDD.n11 0.2005
R296 VDD.n39 VDD.n11 0.2005
R297 VDD.n40 VDD.n39 0.2005
R298 VDD.n42 VDD.n6 0.2005
R299 VDD.n46 VDD.n6 0.2005
R300 VDD.n47 VDD.n46 0.2005
R301 VDD.n49 VDD.n0 0.2005
R302 VDD.n102 VDD.n1 0.2005
R303 VDD.n98 VDD.n1 0.2005
R304 VDD.n98 VDD.n97 0.2005
R305 VDD.n97 VDD.n96 0.2005
R306 VDD.n96 VDD.n53 0.2005
R307 VDD.n92 VDD.n53 0.2005
R308 VDD.n92 VDD.n91 0.2005
R309 VDD.n91 VDD.n90 0.2005
R310 VDD.n90 VDD.n55 0.2005
R311 VDD.n86 VDD.n55 0.2005
R312 VDD.n86 VDD.n85 0.2005
R313 VDD.n83 VDD.n57 0.2005
R314 VDD.n79 VDD.n57 0.2005
R315 VDD.n77 VDD.n76 0.2005
R316 VDD.n76 VDD.n59 0.2005
R317 VDD.n72 VDD.n71 0.2005
R318 VDD.n69 VDD.n62 0.2005
R319 VDD.n65 VDD.n62 0.2005
R320 VDD.n29 VDD.n28 0.193
R321 VDD.n48 VDD.n47 0.1925
R322 VDD.n17 VDD.t17 0.1825
R323 VDD.n17 VDD.t5 0.1825
R324 VDD.n72 VDD.n61 0.157
R325 VDD.n21 VDD.n20 0.155
R326 VDD.n70 VDD.n69 0.151
R327 VDD VDD.n102 0.1475
R328 VDD.n85 VDD.n84 0.132
R329 VDD.n41 VDD.n40 0.1305
R330 VDD.n78 VDD.n77 0.113
R331 VDD.n79 VDD.n78 0.088
R332 VDD.n42 VDD.n41 0.0705
R333 VDD.n84 VDD.n83 0.069
R334 VDD VDD.n0 0.0535
R335 VDD.n71 VDD.n70 0.05
R336 VDD.n61 VDD.n59 0.044
R337 VDD.n49 VDD.n48 0.0085
R338 VDD.n28 VDD.n27 0.008
R339 VDD.n65 VDD.n64 0.006
R340 INN.n0 INN.t2 47.1724
R341 INN.n0 INN.t3 43.4205
R342 INN.n1 INN.t1 27.1253
R343 INN.n1 INN.t0 25.3605
R344 INN INN.n1 11.3589
R345 INN INN.n0 2.37431
R346 INP.n0 INP.t2 47.1724
R347 INP.n0 INP.t3 43.4205
R348 INP.n1 INP.t1 27.1253
R349 INP.n1 INP.t0 25.3605
R350 INP INP.n1 11.0977
R351 INP INP.n0 2.63257
R352 a_17222_446.t0 a_17222_446.t1 0.6305
R353 a_15458_446.t0 a_15458_446.t1 0.6305
R354 a_5074_446.t0 a_5074_446.t1 0.6305
R355 a_4342_446.t0 a_4342_446.n3 6.0206
R356 a_4342_446.n3 a_4342_446.n2 11.8193
R357 a_4342_446.n2 a_4342_446.n1 13.5743
R358 a_4342_446.n1 a_4342_446.t5 6.82001
R359 a_4342_446.n1 a_4342_446.t4 6.0206
R360 a_4342_446.n2 a_4342_446.n0 0.445679
R361 a_4342_446.n0 a_4342_446.t3 8.95471
R362 a_4342_446.n0 a_4342_446.t2 7.32828
R363 a_4342_446.n3 a_4342_446.t1 6.82001
R364 a_4042_446.t0 a_4042_446.t1 0.6305
R365 a_3010_446.t0 a_3010_446.t1 3.1505
R366 a_1978_446.t0 a_1978_446.t1 3.1505
R367 a_946_446.t0 a_946_446.t1 0.6305
R368 a_16202_446.t0 a_16202_446.n0 7.79163
R369 a_16202_446.n0 a_16202_446.t1 8.48592
R370 a_16202_446.n0 a_16202_446.t2 30.4947
R371 a_13794_330.t2 a_13794_330.n2 7.32828
R372 a_13794_330.n2 a_13794_330.t0 12.4585
R373 a_13794_330.n2 a_13794_330.n0 0.239964
R374 a_13794_330.n0 a_13794_330.n1 2.80336
R375 a_13794_330.n1 a_13794_330.t4 23.7506
R376 a_13794_330.n1 a_13794_330.t3 22.6063
R377 a_13794_330.n0 a_13794_330.t1 30.753
R378 a_18086_3846.t0 a_18086_3846.t1 0.3505
R379 a_16162_3846.t0 a_16162_3846.t1 0.3505
R380 a_9442_446.n0 a_9442_446.t2 0.6557
R381 a_9442_446.t1 a_9442_446.n0 0.6557
R382 a_9442_446.n0 a_9442_446.n1 26.7292
R383 a_9442_446.n1 a_9442_446.n2 1.51443
R384 a_9442_446.n2 a_9442_446.n4 11.724
R385 a_9442_446.n4 a_9442_446.n3 1.93907
R386 a_9442_446.n3 a_9442_446.t4 25.9305
R387 a_9442_446.n3 a_9442_446.t6 25.1705
R388 a_9442_446.n4 a_9442_446.t5 25.3605
R389 a_9442_446.n2 a_9442_446.t0 7.77157
R390 a_9442_446.n1 a_9442_446.t3 10.5252
R391 a_8330_446.t0 a_8330_446.n0 0.6557
R392 a_8330_446.n0 a_8330_446.t2 0.6557
R393 a_8330_446.n0 a_8330_446.n4 22.2993
R394 a_8330_446.n4 a_8330_446.n8 2.73264
R395 a_8330_446.n8 a_8330_446.n9 1.72818
R396 a_8330_446.n9 a_8330_446.t1 9.67345
R397 a_8330_446.n9 a_8330_446.t3 10.0087
R398 a_8330_446.n8 a_8330_446.n7 7.57811
R399 a_8330_446.n7 a_8330_446.n5 0.1905
R400 a_8330_446.n5 a_8330_446.n6 1.3255
R401 a_8330_446.n6 a_8330_446.t5 16.8055
R402 a_8330_446.n6 a_8330_446.t7 16.0455
R403 a_8330_446.n7 a_8330_446.t4 16.6155
R404 a_8330_446.n5 a_8330_446.t6 16.0455
R405 a_8330_446.n4 a_8330_446.n3 7.57811
R406 a_8330_446.n3 a_8330_446.n1 0.1905
R407 a_8330_446.n1 a_8330_446.n2 1.3255
R408 a_8330_446.n2 a_8330_446.t9 16.8055
R409 a_8330_446.n2 a_8330_446.t11 16.0455
R410 a_8330_446.n3 a_8330_446.t8 16.6155
R411 a_8330_446.n1 a_8330_446.t10 16.0455
R412 a_6106_446.n0 a_6106_446.t0 0.3281
R413 a_6106_446.t1 a_6106_446.n0 0.3281
R414 a_6106_446.n0 a_6106_446.n1 17.1219
R415 a_6106_446.n1 a_6106_446.n3 4.613
R416 a_6106_446.n3 a_6106_446.n6 20.8797
R417 a_6106_446.n6 a_6106_446.n5 5.6955
R418 a_6106_446.n5 a_6106_446.t5 0.3645
R419 a_6106_446.n5 a_6106_446.t7 0.3645
R420 a_6106_446.n6 a_6106_446.n4 6.50021
R421 a_6106_446.n4 a_6106_446.t2 0.3645
R422 a_6106_446.n4 a_6106_446.t6 0.3645
R423 a_6106_446.n3 a_6106_446.n2 12.2772
R424 a_6106_446.n2 a_6106_446.t3 6.74641
R425 a_6106_446.n2 a_6106_446.t4 5.947
R426 a_6106_446.n1 a_6106_446.t8 9.27911
R427 a_7218_446.n0 a_7218_446.t5 0.3281
R428 a_7218_446.t6 a_7218_446.n0 0.3281
R429 a_7218_446.n0 a_7218_446.n2 18.4506
R430 a_7218_446.n2 a_7218_446.n5 19.6443
R431 a_7218_446.n5 a_7218_446.n4 5.6955
R432 a_7218_446.n4 a_7218_446.t1 0.3645
R433 a_7218_446.n4 a_7218_446.t0 0.3645
R434 a_7218_446.n5 a_7218_446.n3 6.50021
R435 a_7218_446.n3 a_7218_446.t4 0.3645
R436 a_7218_446.n3 a_7218_446.t3 0.3645
R437 a_7218_446.n2 a_7218_446.n1 12.0189
R438 a_7218_446.n1 a_7218_446.t2 6.74641
R439 a_7218_446.n1 a_7218_446.t7 5.947
R440 a_8858_3846.t3 a_8858_3846.n9 10.267
R441 a_8858_3846.n9 a_8858_3846.t1 8.32876
R442 a_8858_3846.n9 a_8858_3846.n3 1.64782
R443 a_8858_3846.n3 a_8858_3846.n7 2.73907
R444 a_8858_3846.n7 a_8858_3846.n8 21.8163
R445 a_8858_3846.n8 a_8858_3846.t2 0.3645
R446 a_8858_3846.n8 a_8858_3846.t0 0.3645
R447 a_8858_3846.n7 a_8858_3846.n6 6.34159
R448 a_8858_3846.n6 a_8858_3846.n5 0.3805
R449 a_8858_3846.n6 a_8858_3846.t9 25.5505
R450 a_8858_3846.n5 a_8858_3846.n4 2.12907
R451 a_8858_3846.n4 a_8858_3846.t8 25.9305
R452 a_8858_3846.n4 a_8858_3846.t10 25.1705
R453 a_8858_3846.n5 a_8858_3846.t11 25.1705
R454 a_8858_3846.n3 a_8858_3846.n2 6.34159
R455 a_8858_3846.n2 a_8858_3846.n1 0.3805
R456 a_8858_3846.n2 a_8858_3846.t5 25.5505
R457 a_8858_3846.n1 a_8858_3846.n0 2.12907
R458 a_8858_3846.n0 a_8858_3846.t4 25.9305
R459 a_8858_3846.n0 a_8858_3846.t6 25.1705
R460 a_8858_3846.n1 a_8858_3846.t7 25.1705
R461 a_7742_3846.t6 a_7742_3846.n0 0.6557
R462 a_7742_3846.n0 a_7742_3846.t7 0.6557
R463 a_7742_3846.n0 a_7742_3846.n5 6.0605
R464 a_7742_3846.n5 a_7742_3846.n4 6.86521
R465 a_7742_3846.n4 a_7742_3846.t4 0.6557
R466 a_7742_3846.n4 a_7742_3846.t5 0.6557
R467 a_7742_3846.n5 a_7742_3846.n2 18.0864
R468 a_7742_3846.n2 a_7742_3846.n3 13.1888
R469 a_7742_3846.n3 a_7742_3846.t3 7.46511
R470 a_7742_3846.n3 a_7742_3846.t0 6.6657
R471 a_7742_3846.n2 a_7742_3846.n1 21.183
R472 a_7742_3846.n1 a_7742_3846.t2 0.1825
R473 a_7742_3846.n1 a_7742_3846.t1 0.1825
R474 a_6626_3846.n0 a_6626_3846.t6 0.6557
R475 a_6626_3846.t7 a_6626_3846.n0 0.6557
R476 a_6626_3846.n0 a_6626_3846.n6 6.0605
R477 a_6626_3846.n6 a_6626_3846.n5 6.86521
R478 a_6626_3846.n5 a_6626_3846.t4 0.6557
R479 a_6626_3846.n5 a_6626_3846.t5 0.6557
R480 a_6626_3846.n6 a_6626_3846.n1 12.0305
R481 a_6626_3846.n1 a_6626_3846.n3 6.61871
R482 a_6626_3846.n3 a_6626_3846.n4 25.1077
R483 a_6626_3846.n4 a_6626_3846.t0 0.1825
R484 a_6626_3846.n4 a_6626_3846.t1 0.1825
R485 a_6626_3846.n3 a_6626_3846.n2 12.0476
R486 a_6626_3846.n2 a_6626_3846.t2 7.46511
R487 a_6626_3846.n2 a_6626_3846.t3 6.6657
R488 a_6626_3846.n1 a_6626_3846.t8 14.1473
R489 a_5514_3846.t0 a_5514_3846.t1 0.3505
R490 a_4702_3846.t1 a_4702_3846.n0 6.91703
R491 a_4702_3846.n0 a_4702_3846.n3 11.5024
R492 a_4702_3846.n3 a_4702_3846.n2 13.2638
R493 a_4702_3846.n2 a_4702_3846.t4 6.91703
R494 a_4702_3846.n2 a_4702_3846.t3 6.11762
R495 a_4702_3846.n3 a_4702_3846.n1 0.57425
R496 a_4702_3846.n1 a_4702_3846.t2 10.1654
R497 a_4702_3846.n1 a_4702_3846.t5 8.41045
R498 a_4702_3846.n0 a_4702_3846.t0 6.11762
R499 a_4402_3846.t0 a_4402_3846.t1 0.3505
R500 a_3290_3846.t0 a_3290_3846.t1 0.3505
R501 a_746_330.t1 a_746_330.n3 7.07002
R502 a_746_330.n3 a_746_330.n0 0.643357
R503 a_746_330.n0 a_746_330.n1 3.51532
R504 a_746_330.n1 a_746_330.n2 1.62693
R505 a_746_330.n2 a_746_330.t2 47.1512
R506 a_746_330.n2 a_746_330.t3 30.4947
R507 a_746_330.n1 a_746_330.t4 30.4947
R508 a_746_330.n0 a_746_330.t0 9.70175
R509 a_746_330.n3 a_746_330.t5 31.2164
R510 a_1366_3846.t0 a_1366_3846.t1 0.3505
R511 a_14_330.t2 a_14_330.n9 11.7458
R512 a_14_330.n9 a_14_330.n0 0.514786
R513 a_14_330.n0 a_14_330.n1 0.808893
R514 a_14_330.n1 a_14_330.n2 4.94407
R515 a_14_330.n2 a_14_330.n3 1.62693
R516 a_14_330.n3 a_14_330.n5 4.96336
R517 a_14_330.n5 a_14_330.n7 1.7555
R518 a_14_330.n7 a_14_330.n8 9.87479
R519 a_14_330.n8 a_14_330.t3 33.0393
R520 a_14_330.n8 a_14_330.t4 30.2365
R521 a_14_330.n7 a_14_330.n6 6.02854
R522 a_14_330.n6 a_14_330.t6 17.1967
R523 a_14_330.n6 a_14_330.t5 16.2355
R524 a_14_330.n5 a_14_330.n4 6.02854
R525 a_14_330.n4 a_14_330.t8 17.1967
R526 a_14_330.n4 a_14_330.t7 16.2355
R527 a_14_330.n3 a_14_330.t9 30.2365
R528 a_14_330.n2 a_14_330.t10 30.2365
R529 a_14_330.n1 a_14_330.t11 30.2365
R530 a_14_330.n0 a_14_330.t0 9.96001
R531 a_14_330.n9 a_14_330.t1 17.4412
R532 a_254_3846.t0 a_254_3846.t1 0.3505
R533 a_9974_3846.t3 a_9974_3846.n4 10.7835
R534 a_9974_3846.n4 a_9974_3846.n1 0.428
R535 a_9974_3846.n1 a_9974_3846.n3 12.7374
R536 a_9974_3846.n3 a_9974_3846.n2 0.3805
R537 a_9974_3846.n3 a_9974_3846.t4 43.8005
R538 a_9974_3846.n2 a_9974_3846.t5 47.1562
R539 a_9974_3846.n2 a_9974_3846.t6 43.4205
R540 a_9974_3846.n1 a_9974_3846.t2 7.5133
R541 a_9974_3846.n4 a_9974_3846.n0 25.1328
R542 a_9974_3846.n0 a_9974_3846.t1 0.3645
R543 a_9974_3846.n0 a_9974_3846.t0 0.3645
R544 a_14338_3730.t2 a_14338_3730.n2 9.39437
R545 a_14338_3730.n2 a_14338_3730.n1 2.13318
R546 a_14338_3730.n1 a_14338_3730.t1 7.61687
R547 a_14338_3730.n1 a_14338_3730.t0 49.003
R548 a_14338_3730.n2 a_14338_3730.n0 0.895679
R549 a_14338_3730.n0 a_14338_3730.t4 32.0259
R550 a_14338_3730.n0 a_14338_3730.t3 30.753
R551 a_15962_3730.t0 a_15962_3730.n0 9.91488
R552 a_15962_3730.n0 a_15962_3730.t2 51.5324
R553 a_15962_3730.n0 a_15962_3730.t1 9.18523
R554 a_354_3730.t3 a_354_3730.n15 14.845
R555 a_354_3730.n15 a_354_3730.n7 0.1805
R556 a_354_3730.n7 a_354_3730.n8 1.72175
R557 a_354_3730.n8 a_354_3730.n9 1.7555
R558 a_354_3730.n9 a_354_3730.n11 4.8605
R559 a_354_3730.n11 a_354_3730.n13 1.76193
R560 a_354_3730.n13 a_354_3730.n14 10.3955
R561 a_354_3730.n14 a_354_3730.t7 51.5465
R562 a_354_3730.n14 a_354_3730.t8 48.4865
R563 a_354_3730.n13 a_354_3730.n12 5.06648
R564 a_354_3730.n12 a_354_3730.t9 27.3153
R565 a_354_3730.n12 a_354_3730.t10 25.1705
R566 a_354_3730.n11 a_354_3730.n10 5.06648
R567 a_354_3730.n10 a_354_3730.t11 27.3153
R568 a_354_3730.n10 a_354_3730.t12 25.1705
R569 a_354_3730.n9 a_354_3730.t13 48.4865
R570 a_354_3730.n8 a_354_3730.t14 48.4865
R571 a_354_3730.n7 a_354_3730.t15 48.4865
R572 a_354_3730.n15 a_354_3730.n0 0.230321
R573 a_354_3730.n0 a_354_3730.n1 0.460143
R574 a_354_3730.n1 a_354_3730.n2 0.55175
R575 a_354_3730.n2 a_354_3730.n3 0.239964
R576 a_354_3730.n3 a_354_3730.n4 0.289786
R577 a_354_3730.n4 a_354_3730.n5 0.4505
R578 a_354_3730.n5 a_354_3730.n6 0.469786
R579 a_354_3730.n6 a_354_3730.t17 50.2415
R580 a_354_3730.n6 a_354_3730.t16 48.4865
R581 a_354_3730.n5 a_354_3730.t6 20.3008
R582 a_354_3730.n4 a_354_3730.t5 20.3008
R583 a_354_3730.n3 a_354_3730.t0 19.2865
R584 a_354_3730.n2 a_354_3730.t1 7.71891
R585 a_354_3730.n1 a_354_3730.t4 20.3008
R586 a_354_3730.n0 a_354_3730.t2 20.3008
R587 a_54_3730.t1 a_54_3730.n5 14.5867
R588 a_54_3730.n5 a_54_3730.n1 1.19943
R589 a_54_3730.n1 a_54_3730.n2 0.845857
R590 a_54_3730.n2 a_54_3730.n3 1.00175
R591 a_54_3730.n3 a_54_3730.n4 1.7555
R592 a_54_3730.n4 a_54_3730.t2 68.9176
R593 a_54_3730.n4 a_54_3730.t3 48.7447
R594 a_54_3730.n3 a_54_3730.t4 48.7447
R595 a_54_3730.n2 a_54_3730.t0 7.11915
R596 a_54_3730.n1 a_54_3730.t5 48.8248
R597 a_54_3730.n5 a_54_3730.n0 1.70568
R598 a_54_3730.n0 a_54_3730.t7 50.4997
R599 a_54_3730.n0 a_54_3730.t6 48.7447
R600 VDD VDD 148.067
R601 VDD VDD 109.409
R602 VDD VDD 296.135
R603 VDD VDD 109.409
R604 VDD VDD 296.135
R605 VDD VDD 296.135
R606 VDD VDD 109.409
R607 VDD VDD 296.135
R608 VDD VDD 109.409
R609 VDD VDD 296.135
R610 VDD VDD 109.409
R611 VDD VDD 296.135
R612 VDD VDD 110.868
R613 VDD VDD 296.135
R614 VDD VDD 110.868
R615 VDD VDD 296.135
R616 VDD VDD 110.868
R617 VDD VDD 296.135
R618 VDD VDD 110.868
R619 VDD VDD 296.135
R620 VDD VDD 110.868
R621 VDD VDD 110.868
R622 VDD VDD 110.868
R623 VDD VDD 296.135
R624 VDD VDD 110.868
R625 VDD VDD 110.868
R626 VDD VDD 110.868
R627 VDD VDD 296.135
R628 VDD VDD 296.135
R629 VDD VDD 296.135
R630 VDD VDD 109.409
R631 VDD VDD 296.135
R632 VDD VDD 296.135
R633 VDD VDD 109.409
R634 VDD VDD 296.135
R635 VDD VDD 110.868
R636 VDD VDD 110.868
R637 VSS VSS 335.07
R638 VSS VSS 670.141
R639 VSS VSS 274.649
R640 VSS VSS 670.141
R641 VSS VSS 274.649
R642 VSS VSS 670.141
R643 VSS VSS 274.649
R644 VSS VSS 670.141
R645 VSS VSS 274.649
R646 VSS VSS 670.141
R647 VSS VSS 274.649
R648 VSS VSS 670.141
R649 VSS VSS 278.31
R650 VSS VSS 739.718
R651 VSS VSS 278.31
R652 VSS VSS 739.718
R653 VSS VSS 278.31
R654 VSS VSS 739.718
R655 VSS VSS 278.31
R656 VSS VSS 739.718
R657 VSS VSS 278.31
R658 VSS VSS 278.31
R659 VSS VSS 278.31
R660 VSS VSS 739.718
R661 VSS VSS 278.31
R662 VSS VSS 278.31
R663 VSS VSS 278.31
R664 VSS VSS 739.718
R665 VSS VSS 670.141
R666 VSS VSS 670.141
R667 VSS VSS 274.649
R668 VSS VSS 670.141
R669 VSS VSS 670.141
R670 VSS VSS 274.649
R671 VSS VSS 670.141
R672 VSS VSS 278.31
R673 VSS VSS 278.31
C0 INN VSS 0.12481f
C1 INN INP 0.04234f
C2 VDD OUT 1.20423f
C3 OUT VSS 0.80751f
C4 OUT INP 0.2691f
C5 VDD INP 0.19648f
C6 VSS INP 0.12369f
C7 INN OUT 0.07236f
C8 VDD INN 0.19777f
C9 VSS 0 18.32874f
C10 OUT 0 8.98721f
C11 VDD 0 10.43117f
C12 INN 0 1.7197f
C13 INP 0 1.82079f
C14 VDD 0 0.34893f
C15 VDD 0 0.60675f
C16 VDD 0 0.95568f
C17 VDD 0 0.95568f
C18 VDD 0 0.95568f
C19 VDD 0 1.39571f
C20 VDD 0 0.95568f
C21 VDD 0 0.95568f
C22 VDD 0 0.95568f
C23 VDD 0 0.95568f
C24 VDD 0 0.95568f
C25 VDD 0 0.95568f
C26 VDD 0 0.95912f
C27 VDD 0 0.95912f
C28 VDD 0 0.95912f
C29 VDD 0 0.95912f
C30 VDD 0 0.95912f
C31 VDD 0 0.95912f
C32 VDD 0 0.95912f
C33 VDD 0 0.95912f
C34 VDD 0 0.95912f
C35 VDD 0 0.52253f
C36 VDD 0 0.52253f
C37 VDD 0 0.95912f
C38 VDD 0 0.95912f
C39 VDD 0 0.52253f
C40 VDD 0 0.52253f
C41 VDD 0 0.95912f
C42 VDD 0 1.39571f
C43 VDD 0 1.39571f
C44 VDD 0 0.95568f
C45 VDD 0 0.95568f
C46 VDD 0 1.39571f
C47 VDD 0 0.95568f
C48 VDD 0 0.95568f
C49 VDD 0 0.95912f
C50 VDD 0 0.52253f
C51 VDD 0 0.95912f
C52 a_54_3730.t1 0 0.365f
C53 a_54_3730.t6 0 1.62586f
C54 a_54_3730.n0 0 1.63578f
C55 a_54_3730.t7 0 1.65243f
C56 a_54_3730.t5 0 1.62663f
C57 a_54_3730.n1 0 0.78011f
C58 a_54_3730.t0 0 1.55095f
C59 a_54_3730.n2 0 0.29348f
C60 a_54_3730.t4 0 1.62586f
C61 a_54_3730.n3 0 0.83974f
C62 a_54_3730.t3 0 1.62586f
C63 a_54_3730.n4 0 4.04217f
C64 a_54_3730.t2 0 2.29529f
C65 a_54_3730.n5 0 0.56907f
C66 a_354_3730.t3 0 0.34669f
C67 a_354_3730.t2 0 0.49652f
C68 a_354_3730.n0 0 0.48915f
C69 a_354_3730.t4 0 0.49652f
C70 a_354_3730.n1 0 0.51344f
C71 a_354_3730.t1 0 0.29109f
C72 a_354_3730.n2 0 0.15767f
C73 a_354_3730.t0 0 0.43885f
C74 a_354_3730.n3 0 0.23246f
C75 a_354_3730.t5 0 0.49652f
C76 a_354_3730.n4 0 0.49291f
C77 a_354_3730.t6 0 0.49652f
C78 a_354_3730.n5 0 0.50652f
C79 a_354_3730.t16 0 1.48126f
C80 a_354_3730.n6 0 1.36048f
C81 a_354_3730.t17 0 1.50494f
C82 a_354_3730.t15 0 1.48126f
C83 a_354_3730.n7 0 0.682f
C84 a_354_3730.t14 0 1.48126f
C85 a_354_3730.n8 0 0.80104f
C86 a_354_3730.t13 0 1.48126f
C87 a_354_3730.n9 0 1.03827f
C88 a_354_3730.t12 0 0.65403f
C89 a_354_3730.n10 0 0.98801f
C90 a_354_3730.t11 0 0.73078f
C91 a_354_3730.n11 0 0.51688f
C92 a_354_3730.t10 0 0.65403f
C93 a_354_3730.n12 0 0.98801f
C94 a_354_3730.t9 0 0.73078f
C95 a_354_3730.n13 0 0.93522f
C96 a_354_3730.t8 0 1.48126f
C97 a_354_3730.n14 0 2.28553f
C98 a_354_3730.t7 0 1.52735f
C99 a_354_3730.n15 0 0.34513f
C100 a_15962_3730.t0 0 1.26915f
C101 a_15962_3730.t1 0 1.25433f
C102 a_15962_3730.n0 0 1.04665f
C103 a_15962_3730.t2 0 1.23373f
C104 a_14338_3730.t2 0 0.70822f
C105 a_14338_3730.t3 0 0.97618f
C106 a_14338_3730.n0 0 1.1246f
C107 a_14338_3730.t4 0 0.99755f
C108 a_14338_3730.t0 0 1.72715f
C109 a_14338_3730.n1 0 1.05895f
C110 a_14338_3730.t1 0 1.67081f
C111 a_14338_3730.n2 0 0.44168f
C112 a_9974_3846.t3 0 0.6279f
C113 a_9974_3846.t1 0 0.15889f
C114 a_9974_3846.t0 0 0.15889f
C115 a_9974_3846.n0 0 1.38804f
C116 a_9974_3846.t2 0 1.08427f
C117 a_9974_3846.n1 0 1.3146f
C118 a_9974_3846.t6 0 1.83952f
C119 a_9974_3846.t5 0 1.98603f
C120 a_9974_3846.n2 0 2.23275f
C121 a_9974_3846.t4 0 1.84603f
C122 a_9974_3846.n3 0 1.49059f
C123 a_9974_3846.n4 0 1.99018f
C124 a_254_3846.t0 0 0.06659f
C125 a_254_3846.t1 0 0.06659f
C126 a_14_330.t2 0 0.19334f
C127 a_14_330.t1 0 0.37576f
C128 a_14_330.t0 0 1.63489f
C129 a_14_330.n0 0 0.32024f
C130 a_14_330.t11 0 0.83804f
C131 a_14_330.n1 0 0.76392f
C132 a_14_330.t10 0 0.83804f
C133 a_14_330.n2 0 0.82634f
C134 a_14_330.t9 0 0.83804f
C135 a_14_330.n3 0 0.82782f
C136 a_14_330.t7 0 0.37109f
C137 a_14_330.t8 0 0.38812f
C138 a_14_330.n4 0 0.75827f
C139 a_14_330.n5 0 0.54808f
C140 a_14_330.t5 0 0.37109f
C141 a_14_330.t6 0 0.38812f
C142 a_14_330.n6 0 0.75827f
C143 a_14_330.n7 0 0.92287f
C144 a_14_330.t4 0 0.83804f
C145 a_14_330.n8 0 1.79182f
C146 a_14_330.t3 0 0.88434f
C147 a_14_330.n9 0 0.48504f
C148 a_1366_3846.t0 0 0.06661f
C149 a_1366_3846.t1 0 0.06661f
C150 a_746_330.t1 0 0.6833f
C151 a_746_330.t5 0 1.26076f
C152 a_746_330.t0 0 2.38833f
C153 a_746_330.n0 0 0.77812f
C154 a_746_330.t4 0 1.24688f
C155 a_746_330.n1 0 1.08855f
C156 a_746_330.t3 0 1.24688f
C157 a_746_330.n2 0 4.11856f
C158 a_746_330.t2 0 2.09326f
C159 a_746_330.n3 0 0.84321f
C160 a_3290_3846.t0 0 0.07963f
C161 a_3290_3846.t1 0 0.07963f
C162 a_4402_3846.t0 0 0.07823f
C163 a_4402_3846.t1 0 0.07823f
C164 a_4702_3846.t1 0 1.6708f
C165 a_4702_3846.t0 0 1.64268f
C166 a_4702_3846.n0 0 1.07759f
C167 a_4702_3846.t5 0 1.91851f
C168 a_4702_3846.n1 0 0.74942f
C169 a_4702_3846.t2 0 1.98494f
C170 a_4702_3846.t3 0 1.64268f
C171 a_4702_3846.n2 0 1.16298f
C172 a_4702_3846.t4 0 1.6708f
C173 a_4702_3846.n3 0 1.24694f
C174 a_5514_3846.t0 0 0.08005f
C175 a_5514_3846.t1 0 0.08005f
C176 a_6626_3846.t7 0 0.01572f
C177 a_6626_3846.n0 0 0.05917f
C178 a_6626_3846.n1 0 0.24707f
C179 a_6626_3846.t8 0 19.5879f
C180 a_6626_3846.t3 0 0.08003f
C181 a_6626_3846.n2 0 0.1533f
C182 a_6626_3846.t2 0 0.08481f
C183 a_6626_3846.n3 0 0.48261f
C184 a_6626_3846.t0 0 0.06286f
C185 a_6626_3846.t1 0 0.06286f
C186 a_6626_3846.n4 0 0.42004f
C187 a_6626_3846.t4 0 0.01572f
C188 a_6626_3846.t5 0 0.01572f
C189 a_6626_3846.n5 0 0.0634f
C190 a_6626_3846.n6 0 0.16136f
C191 a_6626_3846.t6 0 0.01572f
C192 a_7742_3846.t6 0 0.11143f
C193 a_7742_3846.n0 0 0.41955f
C194 a_7742_3846.t2 0 0.4457f
C195 a_7742_3846.t1 0 0.4457f
C196 a_7742_3846.n1 0 2.6818f
C197 a_7742_3846.n2 0 3.54634f
C198 a_7742_3846.t0 0 0.56744f
C199 a_7742_3846.n3 0 1.18436f
C200 a_7742_3846.t3 0 0.60133f
C201 a_7742_3846.t4 0 0.11143f
C202 a_7742_3846.t5 0 0.11143f
C203 a_7742_3846.n4 0 0.44952f
C204 a_7742_3846.n5 0 1.62284f
C205 a_7742_3846.t7 0 0.11143f
C206 a_8858_3846.t3 0 0.54861f
C207 a_8858_3846.t7 0 0.8635f
C208 a_8858_3846.t6 0 0.9139f
C209 a_8858_3846.n0 0 1.19745f
C210 a_8858_3846.t4 0 0.92799f
C211 a_8858_3846.n1 0 0.6422f
C212 a_8858_3846.t5 0 0.86972f
C213 a_8858_3846.n2 0 0.76361f
C214 a_8858_3846.n3 0 0.49467f
C215 a_8858_3846.t11 0 0.8635f
C216 a_8858_3846.t10 0 0.9139f
C217 a_8858_3846.n4 0 1.19745f
C218 a_8858_3846.t8 0 0.92799f
C219 a_8858_3846.n5 0 0.6422f
C220 a_8858_3846.t9 0 0.86972f
C221 a_8858_3846.n6 0 0.76361f
C222 a_8858_3846.n7 0 1.38011f
C223 a_8858_3846.t2 0 0.14892f
C224 a_8858_3846.t0 0 0.14892f
C225 a_8858_3846.n8 0 1.12132f
C226 a_8858_3846.t1 0 1.0735f
C227 a_8858_3846.n9 0 0.63446f
C228 a_7218_446.t6 0 0.21937f
C229 a_7218_446.n0 0 1.50078f
C230 a_7218_446.t7 0 1.21182f
C231 a_7218_446.n1 0 1.33612f
C232 a_7218_446.t2 0 1.2513f
C233 a_7218_446.n2 0 3.55429f
C234 a_7218_446.t4 0 0.21937f
C235 a_7218_446.t3 0 0.21937f
C236 a_7218_446.n3 0 0.91078f
C237 a_7218_446.t1 0 0.21937f
C238 a_7218_446.t0 0 0.21937f
C239 a_7218_446.n4 0 0.8788f
C240 a_7218_446.n5 0 1.75527f
C241 a_7218_446.t5 0 0.21937f
C242 a_6106_446.t1 0 0.11588f
C243 a_6106_446.n0 0 0.74926f
C244 a_6106_446.n1 0 0.88008f
C245 a_6106_446.t8 0 11.2214f
C246 a_6106_446.t4 0 0.64013f
C247 a_6106_446.n2 0 0.72155f
C248 a_6106_446.t3 0 0.66099f
C249 a_6106_446.n3 0 1.77993f
C250 a_6106_446.t2 0 0.11588f
C251 a_6106_446.t6 0 0.11588f
C252 a_6106_446.n4 0 0.48111f
C253 a_6106_446.t5 0 0.11588f
C254 a_6106_446.t7 0 0.11588f
C255 a_6106_446.n5 0 0.46422f
C256 a_6106_446.n6 0 0.99346f
C257 a_6106_446.t0 0 0.11588f
C258 a_8330_446.t0 0 0.07251f
C259 a_8330_446.n0 0 0.78625f
C260 a_8330_446.t10 0 0.46978f
C261 a_8330_446.n1 0 0.39758f
C262 a_8330_446.t8 0 0.48008f
C263 a_8330_446.n2 0 0.79341f
C264 a_8330_446.t11 0 0.46978f
C265 a_8330_446.t9 0 0.48473f
C266 a_8330_446.n3 0 0.74533f
C267 a_8330_446.n4 0 1.42585f
C268 a_8330_446.t6 0 0.46978f
C269 a_8330_446.n5 0 0.39758f
C270 a_8330_446.t4 0 0.48008f
C271 a_8330_446.n6 0 0.79341f
C272 a_8330_446.t7 0 0.46978f
C273 a_8330_446.t5 0 0.48473f
C274 a_8330_446.n7 0 0.74533f
C275 a_8330_446.n8 0 0.53815f
C276 a_8330_446.t3 0 0.51467f
C277 a_8330_446.n9 0 0.79339f
C278 a_8330_446.t1 0 1.10852f
C279 a_8330_446.t2 0 0.07251f
C280 a_9442_446.t1 0 0.08953f
C281 a_9442_446.n0 0 1.27652f
C282 a_9442_446.t3 0 0.6837f
C283 a_9442_446.n1 0 2.49295f
C284 a_9442_446.t0 0 1.25185f
C285 a_9442_446.n2 0 1.34681f
C286 a_9442_446.t5 0 1.10234f
C287 a_9442_446.n3 0 1.37793f
C288 a_9442_446.t6 0 1.09886f
C289 a_9442_446.t4 0 1.1158f
C290 a_9442_446.n4 0 1.42883f
C291 a_9442_446.t2 0 0.08953f
C292 a_16162_3846.t0 0 0.07499f
C293 a_16162_3846.t1 0 0.07499f
C294 a_18086_3846.t0 0 0.07542f
C295 a_18086_3846.t1 0 0.07542f
C296 a_13794_330.t2 0 0.60642f
C297 a_13794_330.t1 0 1.07292f
C298 a_13794_330.n0 0 0.75257f
C299 a_13794_330.t3 0 0.70226f
C300 a_13794_330.n1 0 1.2842f
C301 a_13794_330.t4 0 0.72752f
C302 a_13794_330.t0 0 2.15064f
C303 a_13794_330.n2 0 0.82898f
C304 a_16202_446.t0 0 0.60919f
C305 a_16202_446.t2 0 1.08315f
C306 a_16202_446.n0 0 1.00162f
C307 a_16202_446.t1 0 0.63304f
C308 a_946_446.t0 0 0.0368f
C309 a_946_446.t1 0 0.0368f
C310 a_4042_446.t0 0 0.04149f
C311 a_4042_446.t1 0 0.04149f
C312 a_4342_446.t0 0 0.87818f
C313 a_4342_446.t1 0 0.90676f
C314 a_4342_446.t2 0 0.67308f
C315 a_4342_446.n0 0 0.56899f
C316 a_4342_446.t3 0 0.72613f
C317 a_4342_446.t4 0 0.87818f
C318 a_4342_446.n1 0 0.89601f
C319 a_4342_446.t5 0 0.90676f
C320 a_4342_446.n2 0 1.01107f
C321 a_4342_446.n3 0 0.82875f
C322 a_5074_446.t0 0 0.04467f
C323 a_5074_446.t1 0 0.04467f
C324 a_15458_446.t0 0 0.04514f
C325 a_15458_446.t1 0 0.04514f
C326 a_17222_446.t0 0 0.0427f
C327 a_17222_446.t1 0 0.0427f
C328 INP.t2 0 1.47167f
C329 INP.t3 0 1.36275f
C330 INP.n0 0 1.77504f
C331 INP.t0 0 0.72466f
C332 INP.t1 0 0.75618f
C333 INP.n1 0 1.24206f
C334 INN.t2 0 1.40951f
C335 INN.t3 0 1.30519f
C336 INN.n0 0 1.6869f
C337 INN.t0 0 0.69405f
C338 INN.t1 0 0.72424f
C339 INN.n1 0 1.21264f
C340 VDD.n0 0 0.12912f
C341 VDD.n1 0 0.19466f
C342 VDD.n2 0 0.19921f
C343 VDD.t2 0 0.39295f
C344 VDD.t3 0 0.06888f
C345 VDD.t13 0 0.06888f
C346 VDD.n3 0 0.27593f
C347 VDD.n4 0 0.22101f
C348 VDD.t14 0 0.38049f
C349 VDD.n5 0 0.21664f
C350 VDD.n6 0 0.19919f
C351 VDD.n7 0 0.19921f
C352 VDD.t15 0 0.39295f
C353 VDD.t8 0 0.06888f
C354 VDD.t9 0 0.06888f
C355 VDD.n8 0 0.27593f
C356 VDD.n9 0 0.22101f
C357 VDD.t1 0 0.38049f
C358 VDD.n10 0 0.21664f
C359 VDD.n11 0 0.19921f
C360 VDD.n12 0 0.19921f
C361 VDD.n13 0 0.19921f
C362 VDD.n14 0 0.19921f
C363 VDD.t0 0 0.39783f
C364 VDD.n15 0 0.19921f
C365 VDD.n16 0 1.28892f
C366 VDD.t16 0 0.39783f
C367 VDD.t17 0 0.13776f
C368 VDD.t5 0 0.13776f
C369 VDD.n17 0 0.57104f
C370 VDD.t6 0 0.79172f
C371 VDD.n18 0 0.33244f
C372 VDD.n19 0 1.77347f
C373 VDD.n20 0 0.41612f
C374 VDD.n21 0 0.17358f
C375 VDD.n22 0 0.19921f
C376 VDD.n23 0 0.19921f
C377 VDD.n24 0 0.19921f
C378 VDD.n25 0 0.19921f
C379 VDD.n26 0 0.19921f
C380 VDD.n27 0 0.10742f
C381 VDD.n28 0 0.21017f
C382 VDD.n29 0 0.19248f
C383 VDD.n30 0 0.19921f
C384 VDD.n31 0 0.19921f
C385 VDD.n32 0 0.19921f
C386 VDD.n33 0 0.19921f
C387 VDD.n34 0 0.19766f
C388 VDD.n35 0 0.19568f
C389 VDD.n36 0 0.19921f
C390 VDD.n37 0 0.19921f
C391 VDD.n38 0 0.19921f
C392 VDD.n39 0 0.19921f
C393 VDD.n40 0 0.16584f
C394 VDD.n41 0 0.34039f
C395 VDD.n42 0 0.13216f
C396 VDD.n43 0 0.19921f
C397 VDD.n44 0 0.19921f
C398 VDD.n45 0 0.19921f
C399 VDD.n46 0 0.19921f
C400 VDD.n47 0 0.1954f
C401 VDD.n48 0 0.34039f
C402 VDD.n49 0 0.10766f
C403 VDD.n50 0 0.19921f
C404 VDD.n51 0 0.19921f
C405 VDD.n52 0 0.19921f
C406 VDD.n53 0 0.19921f
C407 VDD.n54 0 0.19921f
C408 VDD.n55 0 0.19921f
C409 VDD.n56 0 0.19921f
C410 VDD.t4 0 0.39783f
C411 VDD.n57 0 0.19792f
C412 VDD.n58 0 0.19921f
C413 VDD.t10 0 0.39783f
C414 VDD.n59 0 0.12459f
C415 VDD.n60 0 0.19921f
C416 VDD.t18 0 0.39783f
C417 VDD.n61 0 0.2109f
C418 VDD.t12 0 0.15282f
C419 VDD.n62 0 0.19921f
C420 VDD.t11 0 0.4266f
C421 VDD.n63 0 0.57228f
C422 VDD.t7 0 0.39783f
C423 VDD.n64 0 0.32791f
C424 VDD.n65 0 0.10647f
C425 VDD.n66 0 0.72372f
C426 VDD.n67 0 0.19921f
C427 VDD.n68 0 0.19921f
C428 VDD.n69 0 0.17561f
C429 VDD.n70 0 0.26637f
C430 VDD.n71 0 0.12745f
C431 VDD.n72 0 0.17459f
C432 VDD.n73 0 0.19921f
C433 VDD.n74 0 0.19921f
C434 VDD.n75 0 0.19921f
C435 VDD.n76 0 0.19921f
C436 VDD.n77 0 0.15749f
C437 VDD.n78 0 0.2121f
C438 VDD.n79 0 0.14557f
C439 VDD.n80 0 0.19921f
C440 VDD.n81 0 0.19921f
C441 VDD.n82 0 0.19921f
C442 VDD.n83 0 0.13272f
C443 VDD.n84 0 0.2121f
C444 VDD.n85 0 0.16655f
C445 VDD.n86 0 0.19921f
C446 VDD.n87 0 0.19921f
C447 VDD.n88 0 0.19921f
C448 VDD.n89 0 0.19921f
C449 VDD.n90 0 0.19921f
C450 VDD.n91 0 0.19573f
C451 VDD.n92 0 0.19761f
C452 VDD.n93 0 0.19921f
C453 VDD.n94 0 0.19921f
C454 VDD.n95 0 0.19921f
C455 VDD.n96 0 0.19921f
C456 VDD.n97 0 0.19921f
C457 VDD.n98 0 0.19868f
C458 VDD.n99 0 0.19921f
C459 VDD.n100 0 0.19921f
C460 VDD.n101 0 0.19921f
C461 VDD.n102 0 0.17394f
C462 OUT.t0 0 0.03783f
C463 OUT.t1 0 0.03783f
C464 OUT.n0 0 0.15683f
C465 OUT.t3 0 0.21743f
C466 OUT.n1 0 0.11599f
C467 OUT.t7 0 12.8986f
C468 OUT.t2 0 1.83189f
C469 OUT.t4 0 0.01892f
C470 OUT.t5 0 0.01892f
C471 OUT.n2 0 0.07785f
C472 OUT.t6 0 0.10427f
C473 OUT.n3 0 0.08906f
C474 OUT.n4 0 0.06254f
C475 OUT.n5 0 0.37668f
C476 VSS.n0 0 0.06384f
C477 VSS.t12 0 0.09191f
C478 VSS.t13 0 0.01703f
C479 VSS.t14 0 0.01703f
C480 VSS.n1 0 0.06411f
C481 VSS.n2 0 0.10582f
C482 VSS.t9 0 0.08671f
C483 VSS.n3 0 0.06447f
C484 VSS.n4 0 0.09849f
C485 VSS.n5 0 0.09849f
C486 VSS.t5 0 0.09191f
C487 VSS.t4 0 0.01703f
C488 VSS.t10 0 0.01703f
C489 VSS.n6 0 0.06411f
C490 VSS.n7 0 0.10582f
C491 VSS.t11 0 0.08671f
C492 VSS.n8 0 0.06447f
C493 VSS.n9 0 0.15936f
C494 VSS.n10 0 0.09849f
C495 VSS.n11 0 0.09849f
C496 VSS.n12 0 0.09849f
C497 VSS.n13 0 0.06089f
C498 VSS.n14 0 0.09849f
C499 VSS.n15 0 0.08022f
C500 VSS.t1 0 0.14962f
C501 VSS.n16 0 0.21414f
C502 VSS.t18 0 0.03405f
C503 VSS.t7 0 0.03405f
C504 VSS.n17 0 0.14014f
C505 VSS.t8 0 0.18771f
C506 VSS.n18 0 0.126f
C507 VSS.n19 0 1.10339f
C508 VSS.n20 0 0.77593f
C509 VSS.n21 0 0.09849f
C510 VSS.n22 0 0.09849f
C511 VSS.n23 0 0.09849f
C512 VSS.t17 0 0.14962f
C513 VSS.n24 0 0.12704f
C514 VSS.n25 0 0.08894f
C515 VSS.n26 0 0.09849f
C516 VSS.n27 0 0.09849f
C517 VSS.n28 0 0.09849f
C518 VSS.n29 0 0.09849f
C519 VSS.n30 0 0.09849f
C520 VSS.n31 0 0.09849f
C521 VSS.n32 0 0.09849f
C522 VSS.n33 0 0.09849f
C523 VSS.n34 0 0.09849f
C524 VSS.n35 0 0.09849f
C525 VSS.n36 0 0.09849f
C526 VSS.n37 0 0.09849f
C527 VSS.n38 0 0.09849f
C528 VSS.n39 0 0.09849f
C529 VSS.n40 0 0.09849f
C530 VSS.n41 0 0.09849f
C531 VSS.n42 0 0.09849f
C532 VSS.n43 0 0.09849f
C533 VSS.n44 0 0.09849f
C534 VSS.n45 0 0.09849f
C535 VSS.n46 0 0.09849f
C536 VSS.n47 0 0.09849f
C537 VSS.n48 0 0.09849f
C538 VSS.n49 0 0.09849f
C539 VSS.n50 0 0.09849f
C540 VSS.t3 0 0.14962f
C541 VSS.n51 0 0.12704f
C542 VSS.n52 0 0.09849f
C543 VSS.t16 0 0.14962f
C544 VSS.n53 0 0.12704f
C545 VSS.n54 0 0.09849f
C546 VSS.t6 0 0.02111f
C547 VSS.n55 0 0.09849f
C548 VSS.n56 0 0.09849f
C549 VSS.t15 0 0.02111f
C550 VSS.n57 0 0.055f
C551 VSS.t2 0 0.14962f
C552 VSS.n58 0 0.15654f
C553 VSS.t0 0 0.02311f
C554 VSS.n59 0 0.1875f
C555 VSS.n60 0 0.2763f
C556 VSS.n61 0 0.09849f
C557 VSS.n62 0 0.09849f
C558 VSS.n63 0 0.07503f
C559 VSS.n64 0 0.08476f
C560 VSS.n65 0 0.0748f
C561 VSS.n66 0 0.09849f
C562 VSS.n67 0 0.09849f
C563 VSS.n68 0 0.09849f
C564 VSS.n69 0 0.05523f
C565 VSS.n70 0 0.08476f
C566 VSS.n71 0 0.0946f
C567 VSS.n72 0 0.08258f
C568 VSS.n73 0 0.09849f
C569 VSS.n74 0 0.09849f
C570 VSS.n75 0 0.06725f
C571 VSS.n76 0 0.09849f
C572 VSS.n77 0 0.06278f
C573 VSS.n78 0 0.09849f
C574 VSS.n79 0 0.09849f
C575 VSS.n80 0 0.08706f
C576 VSS.n81 0 0.09849f
C577 VSS.n82 0 0.09849f
C578 VSS.n83 0 0.09849f
C579 VSS.n84 0 0.09849f
C580 VSS.n85 0 0.09849f
C581 VSS.n86 0 0.09849f
C582 VSS.n87 0 0.09849f
C583 VSS.n88 0 0.09849f
C584 VSS.n89 0 0.09849f
C585 VSS.n90 0 0.09849f
C586 VSS.n91 0 0.09849f
C587 VSS.n92 0 0.09849f
C588 VSS.n93 0 0.09849f
C589 VSS.n94 0 0.09849f
C590 VSS.n95 0 0.09849f
C591 VSS.n96 0 0.09849f
C592 VSS.n97 0 0.09849f
C593 VSS.n98 0 0.08435f
C594 VSS.n99 0 0.09552f
.ends
