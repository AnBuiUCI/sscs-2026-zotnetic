* Nodos de bulk atados: 4 de pozo n -> VDD, 7 de sustrato -> VSS.
*   magic no extrae los taps de este layout y los dejaba flotando;
*   la conexion si existe (el LVS de KLayout da 'match uniquely').
*   Quien detecta un tap que falte de verdad es el LVS, no esto.
* NGSPICE file created from ESD_CDM.ext - technology: gf180mcuD

.subckt ESD_CDM VSS VDD PAD CORE
X0 VDD.t7 a_16_6352# CORE.t5 VDD pfet_06v0 ad=3.52p pd=16.88u as=2.08p ps=8.52u w=8u l=1u
X1 CORE.t3 a_14_330# VSS.t3 VSS nfet_06v0 ad=2.34p pd=9.52u as=3.96p ps=18.88u w=9u l=1u
X2 VSS.t9 a_14_330# CORE.t1 VSS nfet_06v0 ad=3.96p pd=18.88u as=2.34p ps=9.52u w=9u l=1u
X3 a_408_4912.t0 a_836_4912.t0 VSS.t12 ppolyf_u_3k r_width=1u r_length=1.5u
X4 PAD.t0 a_14_330# VSS.t1 VSS nfet_06v0 ad=1.04p pd=4.52u as=1.76p ps=8.88u w=4u l=1u
X5 CORE.t0 a_14_330# VSS.t7 VSS nfet_06v0 ad=2.34p pd=9.52u as=2.34p ps=9.52u w=9u l=1u
X6 a_408_5392.t0 a_836_5392.t0 VSS.t12 ppolyf_u_3k r_width=1u r_length=1.5u
X7 VSS.t5 a_14_330# CORE.t2 VSS nfet_06v0 ad=2.34p pd=9.52u as=2.34p ps=9.52u w=9u l=1u
X8 VDD.t3 a_16_6352# CORE.t7 VDD pfet_06v0 ad=3.96p pd=18.88u as=2.34p ps=9.52u w=9u l=1u
X9 CORE.t8 PAD.t2 VSS.t12 ppolyf_u_3k r_width=1u r_length=1.5u
X10 CORE.t6 a_16_6352# VDD.t1 VDD pfet_06v0 ad=2.34p pd=9.52u as=3.96p ps=18.88u w=9u l=1u
X11 CORE.t4 a_16_6352# VDD.t5 VDD pfet_06v0 ad=2.08p pd=8.52u as=3.52p ps=16.88u w=8u l=1u
X12 VSS.t11 a_14_330# PAD.t1 VSS nfet_06v0 ad=1.76p pd=8.88u as=1.04p ps=4.52u w=4u l=1u
R0 PAD PAD.t2 32.3755
R1 PAD PAD.n0 13.6763
R2 PAD.n0 PAD.t1 0.41
R3 PAD.n0 PAD.t0 0.41
R4 CORE.n2 CORE.t8 25.8797
R5 CORE.n3 CORE.n0 25.5585
R6 CORE.n2 CORE.n1 25.29
R7 CORE.n6 CORE.n4 6.91178
R8 CORE CORE.n6 6.22034
R9 CORE.n6 CORE.n5 6.10708
R10 CORE CORE.n3 4.51677
R11 CORE.n3 CORE.n2 0.813679
R12 CORE.n0 CORE.t5 0.228
R13 CORE.n0 CORE.t4 0.228
R14 CORE.n1 CORE.t7 0.202722
R15 CORE.n1 CORE.t6 0.202722
R16 CORE.n4 CORE.t2 0.1825
R17 CORE.n4 CORE.t3 0.1825
R18 CORE.n5 CORE.t1 0.1825
R19 CORE.n5 CORE.t0 0.1825
R20 VDD.n3 VDD 160.505
R21 VDD.n3 VDD 158.93
R22 VDD VDD 119.591
R23 VDD VDD 119.591
R24 VDD.n4 VDD.n3 12.6005
R25 VDD.n5 VDD.n2 7.95768
R26 VDD.n1 VDD.n0 7.83781
R27 VDD.n2 VDD.t3 6.83832
R28 VDD.n0 VDD.t7 6.78991
R29 VDD.n2 VDD.t1 6.03891
R30 VDD.n0 VDD.t5 5.9905
R31 VDD.n6 VDD.n5 5.33225
R32 VDD.n5 VDD.n4 0.269797
R33 VDD.n6 VDD.n1 0.182967
R34 VDD.n4 VDD.n1 0.0715
R35 VDD VDD.n6 0.0415348
R36 VSS.n5 VSS 268.608
R37 VSS VSS.n4 213.788
R38 VSS.n4 VSS 211.683
R39 VSS VSS 160.078
R40 VSS VSS 160.078
R41 VSS VSS 160.078
R42 VSS.t12 VSS 141.121
R43 VSS VSS.t12 18.9571
R44 VSS.n4 VSS.n0 10.4005
R45 VSS.n9 VSS.n8 9.0005
R46 VSS.n6 VSS.t11 6.93441
R47 VSS.n2 VSS.t9 6.87864
R48 VSS.n6 VSS.t1 6.135
R49 VSS.n2 VSS.n1 6.10708
R50 VSS.n3 VSS.t3 6.07658
R51 VSS.n10 VSS.n3 5.50939
R52 VSS.n7 VSS.n6 5.19651
R53 VSS.n9 VSS.n5 3.22961
R54 VSS.n10 VSS.n9 2.50009
R55 VSS.n3 VSS.n2 0.802559
R56 VSS VSS.n10 0.453883
R57 VSS.n7 VSS.n5 0.337193
R58 VSS.n1 VSS.t7 0.1825
R59 VSS.n1 VSS.t5 0.1825
R60 VSS.n8 VSS.n7 0.0495
R61 VSS.n8 VSS.n0 0.0215
R62 VSS VSS.n0 0.0065
C0 a_16_6352# a_14_330# 0.03294f
C1 a_16_6352# VDD 4.33302f
C2 CORE PAD 0.3062f
C3 a_14_330# CORE 2.65882f
C4 VDD CORE 5.4761f
C5 a_16_6352# CORE 3.66482f
C6 a_14_330# PAD 0.89427f
C7 VDD PAD 0.08983f
C8 a_16_6352# PAD 0.08229f
C9 PAD VSS 4.47504f
C10 CORE VSS 8.48929f
C11 VDD VSS 19.34083f
C12 a_14_330# VSS 6.12043f
C13 a_16_6352# VSS 3.04794f
C14 a_408_5392.t0 VSS 0.0937f
C15 a_836_5392.t0 VSS 0.12626f
C16 a_408_4912.t0 VSS 0.07314f
C17 a_836_4912.t0 VSS 0.10637f
C18 VDD.t7 VSS 0.28686f
C19 VDD.t5 VSS 0.28095f
C20 VDD.n0 VSS 0.13857f
C21 VDD.n1 VSS 0.17809f
C22 VDD.t3 VSS 0.32396f
C23 VDD.t1 VSS 0.31798f
C24 VDD.n2 VSS 0.14499f
C25 VDD VSS 1.68278f
C26 VDD VSS 1.0736f
C27 VDD VSS 1.68278f
C28 VDD VSS 1.06757f
C29 VDD.n3 VSS 1.21892f
C30 VDD.n4 VSS 0.08981f
C31 VDD.n5 VSS 0.55889f
C32 VDD.n6 VSS 0.43237f
C33 CORE.t5 VSS 0.21583f
C34 CORE.t4 VSS 0.21583f
C35 CORE.n0 VSS 1.63738f
C36 CORE.t7 VSS 0.24281f
C37 CORE.t6 VSS 0.24281f
C38 CORE.n1 VSS 1.74985f
C39 CORE.t8 VSS 0.48727f
C40 CORE.n2 VSS 1.96363f
C41 CORE.n3 VSS 1.37808f
C42 CORE.t2 VSS 0.24281f
C43 CORE.t3 VSS 0.24281f
C44 CORE.n4 VSS 1.0037f
C45 CORE.t1 VSS 0.24281f
C46 CORE.t0 VSS 0.24281f
C47 CORE.n5 VSS 0.98256f
C48 CORE.n6 VSS 0.60759f
C49 PAD.t2 VSS 0.32122f
C50 PAD.t1 VSS 0.04253f
C51 PAD.t0 VSS 0.04253f
C52 PAD.n0 VSS 0.25108f
.ends
