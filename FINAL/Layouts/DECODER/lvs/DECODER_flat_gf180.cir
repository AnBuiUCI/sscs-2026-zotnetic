* Extracted by KLayout with GF180MCU LVS runset on : 18/08/2026 18:02

.SUBCKT DECODER Z YZ XY XZ Y X VDD VSS
M$1 \$50 YZ Z VDD pfet_06v0 L=1U W=3U AS=1.32P AD=0.75P PS=6.88U PD=3.5U
M$2 VDD XZ \$50 VDD pfet_06v0 L=1U W=3U AS=0.75P AD=1.32P PS=3.5U PD=6.88U
M$3 \$14 XZ \$16 VSS nfet_06v0 L=1U W=1U AS=0.44P AD=0.25P PS=2.88U PD=1.5U
M$4 VSS XY \$14 VSS nfet_06v0 L=1U W=1U AS=0.25P AD=0.44P PS=1.5U PD=2.88U
M$5 \$13 \$37 \$11 VSS nfet_06v0 L=1U W=1U AS=0.44P AD=0.25P PS=2.88U PD=1.5U
M$6 VSS YZ \$13 VSS nfet_06v0 L=1U W=1U AS=0.25P AD=0.44P PS=1.5U PD=2.88U
M$7 VSS \$16 X VSS nfet_06v0 L=1U W=1U AS=0.44P AD=0.44P PS=2.88U PD=2.88U
M$8 VSS \$11 Y VSS nfet_06v0 L=1U W=1U AS=0.44P AD=0.44P PS=2.88U PD=2.88U
M$9 VSS XY \$37 VSS nfet_06v0 L=1U W=1U AS=0.44P AD=0.44P PS=2.88U PD=2.88U
M$10 VSS XZ Z VSS nfet_06v0 L=1U W=1U AS=0.44P AD=0.44P PS=2.88U PD=2.88U
M$11 VSS YZ Z VSS nfet_06v0 L=1U W=1U AS=0.44P AD=0.44P PS=2.88U PD=2.88U
M$12 Y \$11 VDD VDD pfet_06v0 L=1U W=3U AS=1.32P AD=1.32P PS=6.88U PD=6.88U
M$13 \$37 XY VDD VDD pfet_06v0 L=1U W=3U AS=1.32P AD=1.32P PS=6.88U PD=6.88U
M$14 VDD \$37 \$11 VDD pfet_06v0 L=1U W=3U AS=1.32P AD=1.32P PS=6.88U PD=6.88U
M$15 VDD XZ \$16 VDD pfet_06v0 L=1U W=3U AS=1.32P AD=1.32P PS=6.88U PD=6.88U
M$16 VDD XY \$16 VDD pfet_06v0 L=1U W=3U AS=1.32P AD=1.32P PS=6.88U PD=6.88U
M$17 X \$16 VDD VDD pfet_06v0 L=1U W=3U AS=1.32P AD=1.32P PS=6.88U PD=6.88U
M$18 VDD YZ \$11 VDD pfet_06v0 L=1U W=3U AS=1.32P AD=1.32P PS=6.88U PD=6.88U
.ENDS DECODER
