* Extracted by KLayout with GF180MCU LVS runset on : 09/08/2026 01:40

.SUBCKT DECODER Z YZ XY XZ X VDD Y VSS
M$1 \$87 YZ Z VDD pfet_06v0 L=1U W=3U AS=1.32P AD=0.75P PS=6.88U PD=3.5U
M$2 VDD XZ \$87 VDD pfet_06v0 L=1U W=3U AS=0.75P AD=1.32P PS=3.5U PD=6.88U
M$3 \$33 XZ \$35 VSS nfet_06v0 L=1U W=1U AS=0.44P AD=0.25P PS=2.88U PD=1.5U
M$4 VSS XY \$33 VSS nfet_06v0 L=1U W=1U AS=0.25P AD=0.44P PS=1.5U PD=2.88U
M$5 \$23 \$67 \$19 VSS nfet_06v0 L=1U W=1U AS=0.44P AD=0.25P PS=2.88U PD=1.5U
M$6 VSS YZ \$23 VSS nfet_06v0 L=1U W=1U AS=0.25P AD=0.44P PS=1.5U PD=2.88U
M$7 VSS \$35 X VSS nfet_06v0 L=1U W=1U AS=0.44P AD=0.44P PS=2.88U PD=2.88U
M$8 VSS \$19 Y VSS nfet_06v0 L=1U W=1U AS=0.44P AD=0.44P PS=2.88U PD=2.88U
M$9 VSS XY \$67 VSS nfet_06v0 L=1U W=1U AS=0.44P AD=0.44P PS=2.88U PD=2.88U
M$10 VSS XZ Z VSS nfet_06v0 L=1U W=1U AS=0.44P AD=0.44P PS=2.88U PD=2.88U
M$11 VSS YZ Z VSS nfet_06v0 L=1U W=1U AS=0.44P AD=0.44P PS=2.88U PD=2.88U
M$12 VDD YZ \$19 VDD pfet_06v0 L=1U W=3U AS=1.32P AD=1.32P PS=6.88U PD=6.88U
M$13 Y \$19 VDD VDD pfet_06v0 L=1U W=3U AS=1.32P AD=1.32P PS=6.88U PD=6.88U
M$14 \$67 XY VDD VDD pfet_06v0 L=1U W=3U AS=1.32P AD=1.32P PS=6.88U PD=6.88U
M$15 X \$35 VDD VDD pfet_06v0 L=1U W=3U AS=1.32P AD=1.32P PS=6.88U PD=6.88U
M$16 VDD \$67 \$19 VDD pfet_06v0 L=1U W=3U AS=1.32P AD=1.32P PS=6.88U PD=6.88U
M$17 VDD XZ \$35 VDD pfet_06v0 L=1U W=3U AS=1.32P AD=1.32P PS=6.88U PD=6.88U
M$18 VDD XY \$35 VDD pfet_06v0 L=1U W=3U AS=1.32P AD=1.32P PS=6.88U PD=6.88U
.ENDS DECODER
