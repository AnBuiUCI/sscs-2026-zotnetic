* Nodos de bulk atados: 10 de pozo n -> VDD, 11 de sustrato -> VSS.
*   magic no extrae los taps de este layout y los dejaba flotando;
*   la conexion si existe (el LVS de KLayout da 'match uniquely').
*   Quien detecta un tap que falte de verdad es el LVS, no esto.
* NGSPICE file created from DECODER.ext - technology: gf180mcuD

.subckt DECODER VSS VDD YZ Z XY XZ Y X
X0 VDD.t6 XZ.t3 a_326_2122.t0 VDD pfet_06v0 ad=1.32p pd=6.88u as=0.75p ps=3.5u w=3u l=1u
X1 VDD.t4 a_1390_446.t3 a_2210_330.t1 VDD pfet_06v0 ad=1.32p pd=6.88u as=1.32p ps=6.88u w=3u l=1u
X2 VSS.t4 YZ.t1 Z.t1 VSS nfet_06v0 ad=0.44p pd=2.88u as=0.44p ps=2.88u w=1u l=1u
X3 VDD.t1 XZ.t2 a_3974_330.t1 VDD pfet_06v0 ad=1.32p pd=6.88u as=1.32p ps=6.88u w=3u l=1u
X4 VSS.t0 a_3974_330.t3 X.t0 VSS nfet_06v0 ad=0.44p pd=2.88u as=0.44p ps=2.88u w=1u l=1u
X5 VSS.t1 XZ.t1 Z.t0 VSS nfet_06v0 ad=0.44p pd=2.88u as=0.44p ps=2.88u w=1u l=1u
X6 Y.t1 a_2210_330.t4 VDD.t5 VDD pfet_06v0 ad=1.32p pd=6.88u as=1.32p ps=6.88u w=3u l=1u
X7 VDD.t7 XY.t2 a_3974_330.t2 VDD pfet_06v0 ad=1.32p pd=6.88u as=1.32p ps=6.88u w=3u l=1u
X8 VSS.t3 a_2210_330.t3 Y.t0 VSS nfet_06v0 ad=0.44p pd=2.88u as=0.44p ps=2.88u w=1u l=1u
X9 a_1390_446.t1 XY.t3 VDD.t2 VDD pfet_06v0 ad=1.32p pd=6.88u as=1.32p ps=6.88u w=3u l=1u
X10 VSS.t6 XY.t0 a_4906_446.t1 VSS nfet_06v0 ad=0.44p pd=2.88u as=0.25p ps=1.5u w=1u l=1u
X11 VSS.t5 YZ.t0 a_3142_446.t1 VSS nfet_06v0 ad=0.44p pd=2.88u as=0.25p ps=1.5u w=1u l=1u
X12 a_4906_446.t0 XZ.t0 a_3974_330.t0 VSS nfet_06v0 ad=0.25p pd=1.5u as=0.44p ps=2.88u w=1u l=1u
X13 X.t1 a_3974_330.t4 VDD.t3 VDD pfet_06v0 ad=1.32p pd=6.88u as=1.32p ps=6.88u w=3u l=1u
X14 a_3142_446.t0 a_1390_446.t2 a_2210_330.t0 VSS nfet_06v0 ad=0.25p pd=1.5u as=0.44p ps=2.88u w=1u l=1u
X15 a_326_2122.t1 YZ.t3 Z.t2 VDD pfet_06v0 ad=0.75p pd=3.5u as=1.32p ps=6.88u w=3u l=1u
X16 VSS.t2 XY.t1 a_1390_446.t0 VSS nfet_06v0 ad=0.44p pd=2.88u as=0.44p ps=2.88u w=1u l=1u
X17 VDD.t0 YZ.t2 a_2210_330.t2 VDD pfet_06v0 ad=1.32p pd=6.88u as=1.32p ps=6.88u w=3u l=1u
R0 VSS.n11 VSS.n7 9.0005
R1 VSS.n13 VSS.n12 9.0005
R2 VSS.n14 VSS.n6 9.0005
R3 VSS.n16 VSS.n15 9.0005
R4 VSS.n18 VSS.n5 9.0005
R5 VSS.n20 VSS.n19 9.0005
R6 VSS.n22 VSS.n21 9.0005
R7 VSS.n4 VSS.n0 9.0005
R8 VSS.n3 VSS.t6 5.55439
R9 VSS.n9 VSS.t4 5.52159
R10 VSS.n2 VSS.t0 5.42612
R11 VSS.n1 VSS.t5 5.42612
R12 VSS.n17 VSS.t3 5.42612
R13 VSS.n8 VSS.t2 5.42612
R14 VSS.n10 VSS.t1 5.42612
R15 VSS.n9 VSS.n7 3.27379
R16 VSS.n4 VSS.n3 1.73415
R17 VSS.n3 VSS.n2 0.372046
R18 VSS.n10 VSS.n9 0.269511
R19 VSS.n21 VSS.n4 0.2005
R20 VSS.n21 VSS.n20 0.2005
R21 VSS.n20 VSS.n5 0.2005
R22 VSS.n15 VSS.n5 0.2005
R23 VSS.n15 VSS.n14 0.2005
R24 VSS.n14 VSS.n13 0.2005
R25 VSS.n13 VSS.n7 0.2005
R26 VSS.n19 VSS.n18 0.2005
R27 VSS.n16 VSS.n6 0.2005
R28 VSS.n12 VSS.n11 0.2005
R29 VSS VSS.n0 0.186
R30 VSS.n19 VSS.n1 0.176
R31 VSS.n2 VSS.n0 0.142
R32 VSS.n18 VSS.n17 0.141
R33 VSS.n8 VSS.n6 0.107
R34 VSS.n12 VSS.n8 0.094
R35 VSS.n11 VSS.n10 0.073
R36 VSS.n17 VSS.n16 0.06
R37 VSS.n22 VSS.n1 0.025
R38 VSS VSS.n22 0.015
R39 X X.t0 17.084
R40 X X.t1 3.11385
R41 Y Y.t0 16.1433
R42 Y Y.t1 3.11385
R43 VDD.n20 VDD.n17 9.0005
R44 VDD.n22 VDD.n21 9.0005
R45 VDD.n24 VDD.n23 9.0005
R46 VDD.n25 VDD.n15 9.0005
R47 VDD.n27 VDD.n26 9.0005
R48 VDD.n29 VDD.n28 9.0005
R49 VDD.n14 VDD.n0 9.0005
R50 VDD.n13 VDD.n12 9.0005
R51 VDD.n9 VDD.n2 9.0005
R52 VDD.n8 VDD.n7 9.0005
R53 VDD.n6 VDD.n3 9.0005
R54 VDD.n18 VDD.n17 2.62202
R55 VDD.n6 VDD.n5 2.57065
R56 VDD.n5 VDD.t1 2.46878
R57 VDD.n18 VDD.t6 2.41251
R58 VDD.n19 VDD.t2 2.34042
R59 VDD.n16 VDD.t5 2.34042
R60 VDD.n1 VDD.t0 2.34042
R61 VDD.n11 VDD.t4 2.34042
R62 VDD.n10 VDD.t3 2.34042
R63 VDD.n4 VDD.t7 2.34042
R64 VDD.n19 VDD.n18 0.298453
R65 VDD.n5 VDD.n4 0.271826
R66 VDD.n7 VDD.n6 0.2005
R67 VDD.n7 VDD.n2 0.2005
R68 VDD.n13 VDD.n2 0.2005
R69 VDD.n14 VDD.n13 0.2005
R70 VDD.n28 VDD.n14 0.2005
R71 VDD.n28 VDD.n27 0.2005
R72 VDD.n27 VDD.n15 0.2005
R73 VDD.n23 VDD.n15 0.2005
R74 VDD.n23 VDD.n22 0.2005
R75 VDD.n22 VDD.n17 0.2005
R76 VDD.n8 VDD.n3 0.2005
R77 VDD.n9 VDD.n8 0.2005
R78 VDD.n26 VDD.n25 0.2005
R79 VDD.n25 VDD.n24 0.2005
R80 VDD.n21 VDD.n20 0.2005
R81 VDD VDD.n0 0.186
R82 VDD.n12 VDD.n10 0.164
R83 VDD.n21 VDD.n16 0.146
R84 VDD.n4 VDD.n3 0.139
R85 VDD.n11 VDD.n0 0.127
R86 VDD.n26 VDD.n1 0.121
R87 VDD.n29 VDD.n1 0.08
R88 VDD.n12 VDD.n11 0.074
R89 VDD.n20 VDD.n19 0.061
R90 VDD.n24 VDD.n16 0.055
R91 VDD.n10 VDD.n9 0.037
R92 VDD VDD.n29 0.015
R93 Z.n0 Z.t0 11.2661
R94 Z.n0 Z.t1 10.5619
R95 Z Z.n0 4.50598
R96 Z Z.t2 3.63037
R97 XY.n0 XY.t2 24.8406
R98 XY XY.t3 19.4695
R99 XY.n1 XY.t1 16.1548
R100 XY.n0 XY.t0 15.8947
R101 XY.n1 XY.n0 4.80675
R102 XY XY.n1 4.5005
R103 XZ.n0 XZ.t2 26.3385
R104 XZ XZ.t3 19.2113
R105 XZ.n1 XZ.t1 16.153
R106 XZ.n0 XZ.t0 16.153
R107 XZ.n1 XZ.n0 6.2555
R108 XZ XZ.n1 4.98264
R109 YZ.n0 YZ.t2 24.2278
R110 YZ YZ.t3 19.7278
R111 YZ.n1 YZ.t1 15.8165
R112 YZ.n0 YZ.t0 15.8165
R113 YZ YZ.n1 4.5005
R114 YZ.n1 YZ.n0 4.24996
R115 a_4906_446.t0 a_4906_446.t1 3.1505
R116 a_3142_446.t0 a_3142_446.t1 3.1505
R117 a_326_2122.t0 a_326_2122.t1 1.16717
R118 a_3974_330.t0 a_3974_330.n2 11.2137
R119 a_3974_330.n2 a_3974_330.n0 0.320321
R120 a_3974_330.n0 a_3974_330.n1 1.00175
R121 a_3974_330.n1 a_3974_330.t1 8.62844
R122 a_3974_330.n1 a_3974_330.t2 7.35559
R123 a_3974_330.n0 a_3974_330.t4 23.1947
R124 a_3974_330.n2 a_3974_330.t3 17.5422
R125 a_1390_446.t0 a_1390_446.n0 12.0346
R126 a_1390_446.n0 a_1390_446.n1 2.00139
R127 a_1390_446.n1 a_1390_446.t3 24.5147
R128 a_1390_446.n1 a_1390_446.t2 16.9278
R129 a_1390_446.n0 a_1390_446.t1 7.09733
R130 a_2210_330.t0 a_2210_330.n2 11.7302
R131 a_2210_330.n2 a_2210_330.n1 0.273714
R132 a_2210_330.n1 a_2210_330.t1 8.11192
R133 a_2210_330.n1 a_2210_330.t2 6.83907
R134 a_2210_330.n2 a_2210_330.n0 0.696393
R135 a_2210_330.n0 a_2210_330.t3 17.366
R136 a_2210_330.n0 a_2210_330.t4 22.6782
R137 VDD VDD 302.534
R138 VDD VDD 223.548
R139 VDD VDD 806.26
R140 VDD VDD 605.067
R141 VDD VDD 605.067
R142 VDD VDD 605.067
R143 VDD VDD 605.067
R144 VDD VDD 605.067
R145 VDD VDD 605.067
R146 VSS VSS 558.872
R147 VSS VSS 1302.85
R148 VSS VSS 1302.85
R149 VSS VSS 1302.85
R150 VSS VSS 1302.85
R151 VSS VSS 533.955
R152 VSS VSS 1302.85
R153 VSS VSS 1302.85
R154 VSS VSS 533.955
C0 X YZ 0.06012f
C1 VSS XY 0.57128f
C2 VSS YZ 0.57527f
C3 Y XY 0.13777f
C4 YZ Z 1.29749f
C5 XZ XY 2.01584f
C6 Y YZ 0.05845f
C7 XZ YZ 0.41242f
C8 X VDD 0.16221f
C9 VDD Z 0.07216f
C10 XY YZ 0.92917f
C11 Y VDD 0.14976f
C12 X VSS 0.08317f
C13 VDD XZ 0.47963f
C14 VSS Z 0.19688f
C15 X XZ 0.51288f
C16 Y VSS 0.0827f
C17 XZ VSS 0.31939f
C18 VDD XY 0.48698f
C19 XZ Z 0.58742f
C20 Y XZ 0.50445f
C21 VDD YZ 0.34163f
C22 X XY 0.1767f
C23 VSS 0 6.65825f
C24 X 0 1.67395f
C25 Y 0 1.3728f
C26 VDD 0 4.06366f
C27 Z 0 1.37876f
C28 XY 0 2.70589f
C29 XZ 0 2.66094f
C30 YZ 0 2.59651f
C31 VDD 0 0.24635f
C32 VDD 0 0.42838f
C33 VDD 0 0.83855f
C34 VDD 0 1.14921f
C35 VDD 0 0.98539f
C36 VDD 0 0.98539f
C37 VDD 0 0.98539f
C38 VDD 0 0.98539f
C39 VDD 0 0.98539f
C40 VDD 0 0.98539f
C41 a_2210_330.t0 0 0.28945f
C42 a_2210_330.t4 0 0.85275f
C43 a_2210_330.n0 0 0.83253f
C44 a_2210_330.t3 0 0.56242f
C45 a_2210_330.t2 0 0.62577f
C46 a_2210_330.n1 0 0.56582f
C47 a_2210_330.t1 0 0.67215f
C48 a_2210_330.n2 0 0.34251f
C49 a_1390_446.t0 0 0.32605f
C50 a_1390_446.t1 0 0.74139f
C51 a_1390_446.n0 0 0.81625f
C52 a_1390_446.t2 0 0.61394f
C53 a_1390_446.n1 0 1.44338f
C54 a_1390_446.t3 0 1.01736f
C55 a_3974_330.t0 0 0.22621f
C56 a_3974_330.t3 0 0.49611f
C57 a_3974_330.t4 0 0.7909f
C58 a_3974_330.n0 0 0.48552f
C59 a_3974_330.t2 0 0.61822f
C60 a_3974_330.n1 0 0.62473f
C61 a_3974_330.t1 0 0.66046f
C62 a_3974_330.n2 0 0.67128f
C63 a_326_2122.t0 0 0.0259f
C64 a_326_2122.t1 0 0.0259f
C65 a_3142_446.t0 0 0.01156f
C66 a_3142_446.t1 0 0.01156f
C67 YZ.t3 0 0.70236f
C68 YZ.t0 0 0.40629f
C69 YZ.t2 0 0.79699f
C70 YZ.n0 0 1.49809f
C71 YZ.t1 0 0.40629f
C72 YZ.n1 0 1.09884f
C73 XZ.t3 0 0.87598f
C74 XZ.t2 0 1.06737f
C75 XZ.t0 0 0.5448f
C76 XZ.n0 0 2.11967f
C77 XZ.t1 0 0.5448f
C78 XZ.n1 0 1.2047f
C79 XY.t3 0 0.79838f
C80 XY.t2 0 0.92216f
C81 XY.t0 0 0.4776f
C82 XY.n0 0 2.15532f
C83 XY.t1 0 0.481f
C84 XY.n1 0 1.39292f
C85 Z.t2 0 0.58615f
C86 Z.t0 0 0.2286f
C87 Z.t1 0 0.21757f
C88 Z.n0 0 0.8492f
C89 VDD.n0 0 0.12026f
C90 VDD.t0 0 0.08803f
C91 VDD.n1 0 0.12031f
C92 VDD.n2 0 0.15235f
C93 VDD.t3 0 0.08803f
C94 VDD.n3 0 0.12992f
C95 VDD.t1 0 0.11192f
C96 VDD.t7 0 0.08803f
C97 VDD.n4 0 0.22916f
C98 VDD.n5 0 0.55843f
C99 VDD.n6 0 0.68611f
C100 VDD.n7 0 0.15235f
C101 VDD.n8 0 0.15235f
C102 VDD.n9 0 0.09273f
C103 VDD.n10 0 0.11926f
C104 VDD.t4 0 0.08803f
C105 VDD.n11 0 0.12031f
C106 VDD.n12 0 0.09007f
C107 VDD.n13 0 0.15235f
C108 VDD.n14 0 0.15235f
C109 VDD.n15 0 0.15235f
C110 VDD.t5 0 0.08803f
C111 VDD.n16 0 0.12031f
C112 VDD.n17 0 0.67572f
C113 VDD.t2 0 0.08803f
C114 VDD.t6 0 0.10266f
C115 VDD.n18 0 0.60008f
C116 VDD.n19 0 0.19329f
C117 VDD.n20 0 0.10148f
C118 VDD.n21 0 0.13248f
C119 VDD.n22 0 0.15235f
C120 VDD.n23 0 0.15235f
C121 VDD.n24 0 0.09929f
C122 VDD.n25 0 0.14908f
C123 VDD.n26 0 0.12274f
C124 VDD.n27 0 0.15235f
C125 VDD.n28 0 0.15235f
C126 VDD.n29 0 0.04076f
C127 Y.t1 0 0.84038f
C128 Y.t0 0 0.53231f
C129 X.t1 0 0.62229f
C130 X.t0 0 0.67067f
C131 VSS.n0 0 0.04989f
C132 VSS.t5 0 0.01296f
C133 VSS.n1 0 0.05202f
C134 VSS.t0 0 0.01296f
C135 VSS.n2 0 0.11376f
C136 VSS.t6 0 0.02343f
C137 VSS.n3 0 0.54332f
C138 VSS.n4 0 0.41997f
C139 VSS.n5 0 0.06045f
C140 VSS.t3 0 0.01296f
C141 VSS.n6 0 0.04692f
C142 VSS.n7 0 0.22048f
C143 VSS.t2 0 0.01296f
C144 VSS.n8 0 0.05202f
C145 VSS.t1 0 0.01296f
C146 VSS.t4 0 0.01524f
C147 VSS.n9 0 0.17342f
C148 VSS.n10 0 0.08002f
C149 VSS.n11 0 0.042f
C150 VSS.n12 0 0.04504f
C151 VSS.n13 0 0.06045f
C152 VSS.n14 0 0.06045f
C153 VSS.n15 0 0.06045f
C154 VSS.n16 0 0.04012f
C155 VSS.n17 0 0.05202f
C156 VSS.n18 0 0.05184f
C157 VSS.n19 0 0.05691f
C158 VSS.n20 0 0.06045f
C159 VSS.n21 0 0.06045f
.ends
