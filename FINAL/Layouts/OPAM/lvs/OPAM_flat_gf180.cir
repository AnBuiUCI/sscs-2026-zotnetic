* Extracted by KLayout with GF180MCU LVS runset on : 18/08/2026 18:02

.SUBCKT OPAM OUT VDD INP INN VSS
M$1 \$673 \$51 VDD VDD pfet_06v0 L=1U W=10U AS=4.4P AD=2.5P PS=20.88U PD=10.5U
M$2 \$10 \$31 \$673 VDD pfet_06v0 L=1U W=10U AS=2.5P AD=4.4P PS=10.5U PD=20.88U
M$3 \$664 \$51 VDD VDD pfet_06v0 L=1U W=10U AS=4.4P AD=2.5P PS=20.88U PD=10.5U
M$4 \$51 \$31 \$664 VDD pfet_06v0 L=1U W=10U AS=2.5P AD=4.4P PS=10.5U PD=20.88U
M$5 \$677 \$51 VDD VDD pfet_06v0 L=1U W=10U AS=4.4P AD=2.5P PS=20.88U PD=10.5U
M$6 \$13 \$31 \$677 VDD pfet_06v0 L=1U W=10U AS=2.5P AD=4.4P PS=10.5U PD=20.88U
M$7 \$669 \$51 VDD VDD pfet_06v0 L=1U W=10U AS=4.4P AD=2.5P PS=20.88U PD=10.5U
M$8 \$283 \$31 \$669 VDD pfet_06v0 L=1U W=10U AS=2.5P AD=4.4P PS=10.5U PD=20.88U
M$9 \$717 \$181 VDD VDD pfet_06v0 L=1U W=10U AS=4.4P AD=2.5P PS=20.88U PD=10.5U
M$10 \$181 \$31 \$717 VDD pfet_06v0 L=1U W=10U AS=2.5P AD=4.4P PS=10.5U
+ PD=20.88U
M$11 \$670 \$51 VDD VDD pfet_06v0 L=1U W=10U AS=4.4P AD=2.5P PS=20.88U PD=10.5U
M$12 \$283 \$31 \$670 VDD pfet_06v0 L=1U W=10U AS=2.5P AD=4.4P PS=10.5U
+ PD=20.88U
M$13 \$689 \$51 VDD VDD pfet_06v0 L=1U W=10U AS=4.4P AD=2.5P PS=20.88U PD=10.5U
M$14 \$32 \$31 \$689 VDD pfet_06v0 L=1U W=10U AS=2.5P AD=4.4P PS=10.5U PD=20.88U
M$15 \$44 \$42 VSS VSS nfet_06v0 L=1U W=5U AS=2.2P AD=1.25P PS=10.88U PD=5.5U
M$16 \$42 \$13 \$44 VSS nfet_06v0 L=1U W=5U AS=1.25P AD=2.2P PS=5.5U PD=10.88U
M$17 \$33 \$10 VSS VSS nfet_06v0 L=1U W=5U AS=2.2P AD=1.25P PS=10.88U PD=5.5U
M$18 \$37 \$13 \$33 VSS nfet_06v0 L=1U W=5U AS=1.25P AD=2.2P PS=5.5U PD=10.88U
M$19 \$47 \$31 VSS VSS nfet_06v0 L=1U W=1U AS=0.44P AD=0.25P PS=2.88U PD=1.5U
M$20 \$51 \$31 \$47 VSS nfet_06v0 L=1U W=1U AS=0.25P AD=0.44P PS=1.5U PD=2.88U
M$21 \$57 \$10 VSS VSS nfet_06v0 L=1U W=5U AS=2.2P AD=1.25P PS=10.88U PD=5.5U
M$22 \$10 \$13 \$57 VSS nfet_06v0 L=1U W=5U AS=1.25P AD=2.2P PS=5.5U PD=10.88U
M$23 \$30 \$31 VSS VSS nfet_06v0 L=1U W=1U AS=0.44P AD=0.25P PS=2.88U PD=1.5U
M$24 \$31 \$31 \$30 VSS nfet_06v0 L=1U W=1U AS=0.25P AD=0.44P PS=1.5U PD=2.88U
M$25 \$16 \$10 VSS VSS nfet_06v0 L=1U W=5U AS=2.2P AD=1.25P PS=10.88U PD=5.5U
M$26 \$14 \$13 \$16 VSS nfet_06v0 L=1U W=5U AS=1.25P AD=2.2P PS=5.5U PD=10.88U
M$27 \$12 \$10 VSS VSS nfet_06v0 L=1U W=5U AS=2.2P AD=1.25P PS=10.88U PD=5.5U
M$28 \$14 \$13 \$12 VSS nfet_06v0 L=1U W=5U AS=1.25P AD=2.2P PS=5.5U PD=10.88U
C$29 \$60 OUT 4e-13 cap_mim_2f0fF A=200P P=60U
C$30 OUT \$5 4e-13 cap_mim_2f0fF A=200P P=60U
M$31 \$13 \$13 VSS VSS nfet_06v0 L=1U W=1U AS=0.44P AD=0.44P PS=2.88U PD=2.88U
M$32 OUT \$67 VSS VSS nfet_06v0 L=1U W=1U AS=0.44P AD=0.44P PS=2.88U PD=2.88U
M$33 \$32 \$32 \$42 VSS nfet_06v0 L=1U W=5U AS=2.2P AD=2.2P PS=10.88U PD=10.88U
M$34 \$108 \$32 \$67 VSS nfet_06v0 L=1U W=2.5U AS=1.1P AD=1.1P PS=5.88U PD=5.88U
M$35 \$237 \$32 \$146 VSS nfet_06v0 L=1U W=2.5U AS=1.1P AD=1.1P PS=5.88U
+ PD=5.88U
M$36 \$5 \$146 VSS VSS nfet_06v0 L=1U W=2.5U AS=1.1P AD=1.1P PS=5.88U PD=5.88U
M$37 \$26 \$146 VSS VSS nfet_06v0 L=1U W=2.5U AS=1.1P AD=1.1P PS=5.88U PD=5.88U
M$38 \$146 \$13 \$26 VSS nfet_06v0 L=1U W=2.5U AS=1.1P AD=1.1P PS=5.88U PD=5.88U
M$39 \$67 \$13 \$5 VSS nfet_06v0 L=1U W=2.5U AS=1.1P AD=1.1P PS=5.88U PD=5.88U
M$40 \$143 INN \$14 VSS nfet_06v0 L=1U W=5U AS=2.2P AD=2.2P PS=10.88U PD=10.88U
M$41 \$60 INP \$14 VSS nfet_06v0 L=1U W=5U AS=2.2P AD=2.2P PS=10.88U PD=10.88U
M$42 \$237 \$31 \$143 VDD pfet_06v0 L=1U W=5U AS=2.2P AD=2.2P PS=10.88U
+ PD=10.88U
M$43 \$26 INN \$283 VDD pfet_06v0 L=1U W=10U AS=4.4P AD=4.4P PS=20.88U PD=20.88U
M$44 \$5 INP \$283 VDD pfet_06v0 L=1U W=10U AS=4.4P AD=4.4P PS=20.88U PD=20.88U
M$45 \$67 \$37 \$108 VDD pfet_06v0 L=1U W=5U AS=2.2P AD=2.2P PS=10.88U PD=10.88U
M$46 \$146 \$37 \$237 VDD pfet_06v0 L=1U W=5U AS=2.2P AD=2.2P PS=10.88U
+ PD=10.88U
M$47 \$60 \$237 VDD VDD pfet_06v0 L=1U W=5U AS=2.2P AD=2.2P PS=10.88U PD=10.88U
M$48 \$143 \$237 VDD VDD pfet_06v0 L=1U W=5U AS=2.2P AD=2.2P PS=10.88U PD=10.88U
M$49 \$108 \$31 \$60 VDD pfet_06v0 L=1U W=5U AS=2.2P AD=2.2P PS=10.88U PD=10.88U
M$50 \$31 \$31 VDD VDD pfet_06v0 L=1U W=2U AS=0.88P AD=0.88P PS=4.88U PD=4.88U
M$51 \$37 \$37 \$181 VDD pfet_06v0 L=1U W=10U AS=4.4P AD=4.4P PS=20.88U
+ PD=20.88U
M$52 OUT \$108 VDD VDD pfet_06v0 L=20U W=0.7U AS=0.308P AD=0.308P PS=2.28U
+ PD=2.28U
.ENDS OPAM
