* Nodos de bulk atados: 2 de pozo n -> VDD, 1 de sustrato -> VSS.
*   magic no extrae los taps de este layout y los dejaba flotando;
*   la conexion si existe (el LVS de KLayout da 'match uniquely').
*   Quien detecta un tap que falte de verdad es el LVS, no esto.
* NGSPICE file created from OPAM.ext - technology: gf180mcuD

.subckt OPAM VSS VDD OUT INP INN
X0 a_10898_3846# a_54_3730# VDD VDD pfet_06v0 ad=2.5p pd=10.5u as=4.4p ps=20.88u w=10u l=1u
X1 a_214_446# a_14_330# VSS VSS nfet_06v0 ad=1.25p pd=5.5u as=2.2p ps=10.88u w=5u l=1u
X2 a_4492_446# a_314_330# a_2478_3846# VSS nfet_06v0 ad=1.1p pd=5.88u as=1.1p ps=5.88u w=2.5u l=1u
X3 a_2478_3846# a_3760_446# VSS VSS nfet_06v0 ad=1.1p pd=5.88u as=1.1p ps=5.88u w=2.5u l=1u
X4 a_2278_446# a_4102_3846# VDD VDD pfet_06v0 ad=2.2p pd=10.88u as=2.2p ps=10.88u w=5u l=1u
X5 a_7150_3730# a_314_330# a_8152_446# VSS nfet_06v0 ad=2.2p pd=10.88u as=1.25p ps=5.5u w=5u l=1u
X6 a_9916_446# a_8896_446# VSS VSS nfet_06v0 ad=1.25p pd=5.5u as=2.2p ps=10.88u w=5u l=1u
X7 a_12412_446# a_14_330# VSS VSS nfet_06v0 ad=1.25p pd=5.5u as=2.2p ps=10.88u w=5u l=1u
X8 a_15046_3846# a_54_3730# VDD VDD pfet_06v0 ad=2.5p pd=10.5u as=4.4p ps=20.88u w=10u l=1u
X9 a_4492_446# a_7150_3730# a_4914_3846# VDD pfet_06v0 ad=2.2p pd=10.88u as=2.2p ps=10.88u w=5u l=1u
X10 a_8152_446# a_14_330# VSS VSS nfet_06v0 ad=1.25p pd=5.5u as=2.2p ps=10.88u w=5u l=1u
X11 a_14_330# a_314_330# a_12412_446# VSS nfet_06v0 ad=2.2p pd=10.88u as=1.25p ps=5.5u w=5u l=1u
X12 a_6488_330# a_354_3730# a_10898_3846# VDD pfet_06v0 ad=4.4p pd=20.88u as=2.5p ps=10.5u w=10u l=1u
X13 a_4102_3846# a_6488_330# a_3760_446# VSS nfet_06v0 ad=1.1p pd=5.88u as=1.1p ps=5.88u w=2.5u l=1u
X14 a_3290_3846# INN a_554_3846# VDD pfet_06v0 ad=4.4p pd=20.88u as=4.4p ps=20.88u w=10u l=1u
X15 a_4102_3846# a_354_3730# a_3010_446# VDD pfet_06v0 ad=2.2p pd=10.88u as=2.2p ps=10.88u w=5u l=1u
X16 a_14_330# a_354_3730# a_13122_3846# VDD pfet_06v0 ad=4.4p pd=20.88u as=2.5p ps=10.5u w=10u l=1u
X17 a_8774_3730# a_354_3730# a_8974_3846# VDD pfet_06v0 ad=4.4p pd=20.88u as=2.5p ps=10.5u w=10u l=1u
X18 a_1246_446# a_14_330# VSS VSS nfet_06v0 ad=1.25p pd=5.5u as=2.2p ps=10.88u w=5u l=1u
X19 a_2478_3846# OUT cap_mim_2f0_m4m5_noshield c_width=20u c_length=10u
X20 a_554_3846# a_354_3730# a_254_3846# VDD pfet_06v0 ad=4.4p pd=20.88u as=2.5p ps=10.5u w=10u l=1u
X21 a_3010_446# INN a_514_446# VSS nfet_06v0 ad=2.2p pd=10.88u as=2.2p ps=10.88u w=5u l=1u
X22 OUT a_4492_446# VSS VSS nfet_06v0 ad=0.44p pd=2.88u as=0.44p ps=2.88u w=1u l=1u
X23 a_314_330# a_354_3730# a_12010_3846# VDD pfet_06v0 ad=4.4p pd=20.88u as=2.5p ps=10.5u w=10u l=1u
X24 a_514_446# a_314_330# a_1246_446# VSS nfet_06v0 ad=2.2p pd=10.88u as=1.25p ps=5.5u w=5u l=1u
X25 a_13444_446# a_354_3730# VSS VSS nfet_06v0 ad=0.25p pd=1.5u as=0.44p ps=2.88u w=1u l=1u
X26 a_2478_3846# INP a_554_3846# VDD pfet_06v0 ad=4.4p pd=20.88u as=4.4p ps=20.88u w=10u l=1u
X27 a_3010_446# a_4102_3846# VDD VDD pfet_06v0 ad=2.2p pd=10.88u as=2.2p ps=10.88u w=5u l=1u
X28 a_3290_3846# a_3760_446# VSS VSS nfet_06v0 ad=1.1p pd=5.88u as=1.1p ps=5.88u w=2.5u l=1u
X29 a_6488_330# a_6488_330# a_8896_446# VSS nfet_06v0 ad=2.2p pd=10.88u as=2.2p ps=10.88u w=5u l=1u
X30 a_54_3730# a_354_3730# a_13444_446# VSS nfet_06v0 ad=0.44p pd=2.88u as=0.25p ps=1.5u w=1u l=1u
X31 a_7150_3730# a_7150_3730# a_8774_3730# VDD pfet_06v0 ad=4.4p pd=20.88u as=4.4p ps=20.88u w=10u l=1u
X32 a_314_330# a_314_330# VSS VSS nfet_06v0 ad=0.44p pd=2.88u as=0.44p ps=2.88u w=1u l=1u
X33 a_1366_3846# a_54_3730# VDD VDD pfet_06v0 ad=2.5p pd=10.5u as=4.4p ps=20.88u w=10u l=1u
X34 a_13122_3846# a_54_3730# VDD VDD pfet_06v0 ad=2.5p pd=10.5u as=4.4p ps=20.88u w=10u l=1u
X35 a_2278_446# INP a_514_446# VSS nfet_06v0 ad=2.2p pd=10.88u as=2.2p ps=10.88u w=5u l=1u
X36 a_8974_3846# a_8774_3730# VDD VDD pfet_06v0 ad=2.5p pd=10.5u as=4.4p ps=20.88u w=10u l=1u
X37 a_54_3730# a_354_3730# a_15046_3846# VDD pfet_06v0 ad=4.4p pd=20.88u as=2.5p ps=10.5u w=10u l=1u
X38 a_4914_3846# a_6488_330# a_4492_446# VSS nfet_06v0 ad=1.1p pd=5.88u as=1.1p ps=5.88u w=2.5u l=1u
X39 OUT a_2278_446# cap_mim_2f0_m4m5_noshield c_width=20u c_length=10u
X40 a_254_3846# a_54_3730# VDD VDD pfet_06v0 ad=2.5p pd=10.5u as=4.4p ps=20.88u w=10u l=1u
X41 a_514_446# a_314_330# a_214_446# VSS nfet_06v0 ad=2.2p pd=10.88u as=1.25p ps=5.5u w=5u l=1u
X42 a_3760_446# a_314_330# a_3290_3846# VSS nfet_06v0 ad=1.1p pd=5.88u as=1.1p ps=5.88u w=2.5u l=1u
X43 a_14476_446# a_354_3730# VSS VSS nfet_06v0 ad=0.25p pd=1.5u as=0.44p ps=2.88u w=1u l=1u
X44 a_12010_3846# a_54_3730# VDD VDD pfet_06v0 ad=2.5p pd=10.5u as=4.4p ps=20.88u w=10u l=1u
X45 OUT a_4914_3846# VDD VDD pfet_06v0 ad=0.308p pd=2.28u as=0.308p ps=2.28u w=0.7u l=20u
X46 a_554_3846# a_354_3730# a_1366_3846# VDD pfet_06v0 ad=4.4p pd=20.88u as=2.5p ps=10.5u w=10u l=1u
X47 a_4914_3846# a_354_3730# a_2278_446# VDD pfet_06v0 ad=2.2p pd=10.88u as=2.2p ps=10.88u w=5u l=1u
X48 a_354_3730# a_354_3730# VDD VDD pfet_06v0 ad=0.88p pd=4.88u as=0.88p ps=4.88u w=2u l=1u
X49 a_3760_446# a_7150_3730# a_4102_3846# VDD pfet_06v0 ad=2.2p pd=10.88u as=2.2p ps=10.88u w=5u l=1u
X50 a_8896_446# a_314_330# a_9916_446# VSS nfet_06v0 ad=2.2p pd=10.88u as=1.25p ps=5.5u w=5u l=1u
X51 a_354_3730# a_354_3730# a_14476_446# VSS nfet_06v0 ad=0.44p pd=2.88u as=0.25p ps=1.5u w=1u l=1u
C0 VDD OUT 1.09607f
C1 a_314_330# INN 0.02977f
C2 VDD OUT 5.1123f
C3 a_514_446# a_2278_446# 0.42736f
C4 a_10898_3846# VDD 0.06858f
C5 a_314_330# VSS 1.14358f
C6 a_4102_3846# OUT 0.26471f
C7 a_254_3846# VDD 0.07506f
C8 a_354_3730# a_4914_3846# 0.77498f
C9 a_7150_3730# VSS 0.1016f
C10 a_8152_446# VSS 0.0407f
C11 a_3290_3846# a_554_3846# 0.39604f
C12 a_514_446# INP 0.43871f
C13 a_3760_446# a_14_330# 0.12053f
C14 a_8974_3846# VDD 0.06907f
C15 a_3290_3846# a_14_330# 0.05712f
C16 a_3760_446# a_4492_446# 0.18632f
C17 a_6488_330# VDD 0.29987f
C18 a_6488_330# VDD 0.37462f
C19 a_3010_446# a_14_330# 0.02947f
C20 a_3290_3846# a_4492_446# 0.02616f
C21 a_3760_446# a_2478_3846# 1.14154f
C22 a_2278_446# a_314_330# 0.05356f
C23 a_2278_446# a_7150_3730# 0.2556f
C24 a_8774_3730# a_4492_446# 0.0593f
C25 a_3290_3846# a_2478_3846# 0.81134f
C26 a_4102_3846# a_6488_330# 0.56051f
C27 a_354_3730# INN 0.02784f
C28 a_3760_446# a_54_3730# 0.0946f
C29 a_3010_446# a_2478_3846# 0.0226f
C30 a_3290_3846# a_54_3730# 0.0257f
C31 a_354_3730# VSS 0.58649f
C32 a_314_330# INP 0.02951f
C33 VDD VDD 2.27899f
C34 a_3010_446# a_54_3730# 0.02226f
C35 VDD VDD 9.40271f
C36 a_514_446# a_14_330# 0.21437f
C37 OUT a_3760_446# 0.19947f
C38 a_4102_3846# VDD 1.40128f
C39 a_4102_3846# VDD 0.44086f
C40 a_8896_446# a_314_330# 0.60356f
C41 a_514_446# a_2478_3846# 0.10847f
C42 a_8774_3730# OUT 0.49029f
C43 a_3010_446# OUT 0.01305f
C44 a_8896_446# a_7150_3730# 0.22082f
C45 a_2278_446# a_354_3730# 0.7808f
C46 a_314_330# a_14_330# 5.89257f
C47 a_354_3730# INP 0.11559f
C48 a_7150_3730# a_14_330# 0.06284f
C49 a_6488_330# a_3760_446# 0.54988f
C50 a_12412_446# VSS 0.0407f
C51 a_8974_3846# a_8774_3730# 0.05582f
C52 a_314_330# a_4492_446# 0.56038f
C53 a_7150_3730# a_4492_446# 0.66254f
C54 a_314_330# a_2478_3846# 0.926f
C55 a_7150_3730# a_2478_3846# 0.01047f
C56 a_314_330# a_54_3730# 0.17553f
C57 a_354_3730# a_8896_446# 0.55347f
C58 a_7150_3730# a_54_3730# 1.22742f
C59 a_4914_3846# VSS 0.18692f
C60 a_354_3730# a_554_3846# 0.91876f
C61 VDD a_3760_446# 0.19702f
C62 a_3290_3846# VDD 0.34535f
C63 a_3290_3846# VDD 0.0207f
C64 a_8774_3730# VDD 0.99306f
C65 a_314_330# OUT 0.47678f
C66 a_4102_3846# a_3760_446# 0.66769f
C67 a_3010_446# VDD 0.39567f
C68 a_354_3730# a_14_330# 1.52382f
C69 a_8774_3730# VDD 0.60022f
C70 a_7150_3730# OUT 0.43371f
C71 a_3010_446# VDD 0.29701f
C72 a_354_3730# a_4492_446# 2.61173f
C73 a_4102_3846# a_3010_446# 1.28005f
C74 a_354_3730# a_2478_3846# 1.91366f
C75 a_2278_446# a_4914_3846# 1.11364f
C76 VSS INN 0.08091f
C77 a_354_3730# a_54_3730# 5.40037f
C78 a_13444_446# VSS 0.01272f
C79 a_6488_330# a_314_330# 1.88361f
C80 a_6488_330# a_7150_3730# 0.03257f
C81 a_354_3730# OUT 2.48932f
C82 a_2278_446# INN 0.04989f
C83 a_12412_446# a_14_330# 0.0329f
C84 a_514_446# a_1246_446# 0.02626f
C85 a_2278_446# VSS 0.02737f
C86 a_314_330# VDD 0.2997f
C87 INP INN 0.08821f
C88 a_3290_3846# a_3760_446# 0.88965f
C89 a_7150_3730# VDD 1.48487f
C90 VDD a_314_330# 0.37716f
C91 a_7150_3730# VDD 0.33559f
C92 a_3010_446# a_3760_446# 0.82568f
C93 VSS INP 0.08215f
C94 a_4102_3846# a_314_330# 0.01986f
C95 a_4914_3846# a_14_330# 0.09607f
C96 a_4102_3846# a_7150_3730# 0.42777f
C97 a_3290_3846# a_3010_446# 0.58272f
C98 a_354_3730# a_6488_330# 1.40151f
C99 a_4914_3846# a_4492_446# 0.432f
C100 a_554_3846# a_1366_3846# 0.05972f
C101 a_4914_3846# a_2478_3846# 0.98846f
C102 a_8896_446# VSS 0.43398f
C103 a_4914_3846# a_54_3730# 1.27504f
C104 a_554_3846# INN 0.69821f
C105 a_2278_446# INP 0.91982f
C106 a_354_3730# VDD 3.83635f
C107 a_14_330# INN 0.0413f
C108 a_9916_446# VSS 0.04305f
C109 a_354_3730# VDD 1.39401f
C110 a_514_446# a_3010_446# 0.20156f
C111 a_14_330# VSS 1.29191f
C112 a_4914_3846# OUT 3.24027f
C113 a_354_3730# a_4102_3846# 0.43614f
C114 a_2478_3846# INN 0.20265f
C115 a_4492_446# VSS 0.29088f
C116 a_2278_446# a_8896_446# 0.0267f
C117 a_54_3730# INN 0.02595f
C118 a_2478_3846# VSS 0.21122f
C119 a_314_330# a_3760_446# 0.58404f
C120 a_54_3730# VSS 0.05799f
C121 a_7150_3730# a_3760_446# 0.49798f
C122 a_3290_3846# a_314_330# 1.29388f
C123 a_12010_3846# VDD 0.06858f
C124 a_3010_446# a_314_330# 0.02369f
C125 a_8774_3730# a_7150_3730# 0.97815f
C126 a_2278_446# a_14_330# 0.05167f
C127 a_514_446# a_214_446# 0.02626f
C128 a_554_3846# INP 0.56145f
C129 a_6488_330# a_4914_3846# 0.59433f
C130 a_2278_446# a_4492_446# 0.07313f
C131 OUT VSS 0.10019f
C132 a_2278_446# a_2478_3846# 0.21588f
C133 a_14_330# INP 0.04159f
C134 a_2278_446# a_54_3730# 1.89579f
C135 a_13122_3846# a_14_330# 0.05253f
C136 a_514_446# a_314_330# 1.66642f
C137 a_4914_3846# VDD 5.35012f
C138 a_2478_3846# INP 0.66544f
C139 a_354_3730# a_3760_446# 0.48688f
C140 a_15046_3846# a_2478_3846# 0.01822f
C141 a_8896_446# a_9916_446# 0.02626f
C142 a_4914_3846# VDD 0.58699f
C143 a_54_3730# INP 0.15566f
C144 a_3290_3846# a_354_3730# 0.04002f
C145 a_15046_3846# a_54_3730# 0.05253f
C146 VDD a_4914_3846# 1.55584f
C147 a_13122_3846# a_2478_3846# 0.01822f
C148 a_8896_446# a_14_330# 0.10617f
C149 a_354_3730# a_8774_3730# 0.82331f
C150 a_354_3730# a_3010_446# 0.49176f
C151 a_2278_446# OUT 1.7799f
C152 a_8896_446# a_4492_446# 0.13251f
C153 a_4102_3846# a_4914_3846# 0.1048f
C154 a_6488_330# VSS 0.40178f
C155 a_8896_446# a_2478_3846# 0.03942f
C156 VDD a_1366_3846# 0.06858f
C157 a_15046_3846# OUT 0.01007f
C158 a_554_3846# a_2478_3846# 0.66035f
C159 a_7150_3730# a_314_330# 0.3911f
C160 a_14_330# a_4492_446# 0.0864f
C161 a_554_3846# a_54_3730# 0.26598f
C162 a_7150_3730# a_8152_446# 0.02626f
C163 VDD INN 0.44842f
C164 OUT a_13122_3846# 0.01007f
C165 VDD VSS 0.14181f
C166 a_514_446# a_354_3730# 0.3685f
C167 VDD INN 0.08849f
C168 a_14476_446# VSS 0.01078f
C169 a_14_330# a_2478_3846# 0.34725f
C170 VDD VSS 0.10916f
C171 a_2278_446# a_6488_330# 0.05682f
C172 a_4492_446# a_2478_3846# 0.1933f
C173 a_14_330# a_54_3730# 0.14995f
C174 a_8896_446# OUT 0.05732f
C175 a_4492_446# a_54_3730# 2.41707f
C176 a_4102_3846# VSS 0.02219f
C177 a_2478_3846# a_54_3730# 0.59559f
C178 a_254_3846# a_554_3846# 0.05253f
C179 a_1246_446# VSS 0.0407f
C180 OUT a_14_330# 0.25209f
C181 a_354_3730# a_314_330# 0.9639f
C182 a_4914_3846# a_3760_446# 1.31211f
C183 a_2278_446# VDD 0.80685f
C184 a_354_3730# a_7150_3730# 0.11132f
C185 OUT a_4492_446# 0.84558f
C186 a_2278_446# VDD 0.31993f
C187 a_8774_3730# a_4914_3846# 0.39324f
C188 OUT a_2478_3846# 3.14318f
C189 a_8896_446# a_6488_330# 1.29817f
C190 a_3010_446# a_4914_3846# 0.0316f
C191 a_2278_446# a_4102_3846# 1.12101f
C192 VDD INP 0.38936f
C193 OUT a_54_3730# 0.29497f
C194 VDD INP 0.08998f
C195 a_15046_3846# VDD 0.0749f
C196 VDD a_13122_3846# 0.07069f
C197 a_12010_3846# a_314_330# 0.05253f
C198 a_6488_330# a_14_330# 0.13522f
C199 a_3290_3846# INN 0.53193f
C200 a_6488_330# a_4492_446# 0.59489f
C201 a_3760_446# VSS 0.50272f
C202 a_3010_446# INN 1.06187f
C203 a_3290_3846# VSS 0.19897f
C204 a_6488_330# a_2478_3846# 0.08814f
C205 a_554_3846# VDD 1.35699f
C206 VDD a_554_3846# 0.60633f
C207 a_3010_446# VSS 0.02222f
C208 a_6488_330# a_54_3730# 0.1711f
C209 VDD a_14_330# 0.30252f
C210 VDD a_14_330# 0.378f
C211 VDD a_2478_3846# 0.21946f
C212 VDD a_4492_446# 0.191f
C213 a_8974_3846# OUT 0.02681f
C214 VDD a_4492_446# 0.09864f
C215 a_2278_446# a_3760_446# 0.49672f
C216 a_4102_3846# a_14_330# 0.02761f
C217 a_514_446# INN 0.41687f
C218 a_314_330# a_4914_3846# 0.06104f
C219 VDD a_54_3730# 0.02097f
C220 VDD a_2478_3846# 0.67013f
C221 a_6488_330# OUT 0.29545f
C222 a_7150_3730# a_4914_3846# 1.85451f
C223 VDD a_2478_3846# 0.26811f
C224 a_2278_446# a_3290_3846# 0.02724f
C225 a_4102_3846# a_4492_446# 0.275f
C226 a_514_446# VSS 0.36384f
C227 VDD a_54_3730# 2.41029f
C228 a_10898_3846# a_6488_330# 0.05253f
C229 a_2278_446# a_8774_3730# 0.05256f
C230 a_2278_446# a_3010_446# 0.16142f
C231 VDD a_54_3730# 2.73655f
C232 a_4102_3846# a_2478_3846# 0.01238f
C233 a_214_446# VSS 0.04408f
C234 a_4102_3846# a_54_3730# 0.02746f
C235 OUT VDD 1.05997f
C236 VSS VSS 15.4917f
C237 OUT VSS 5.05248f
C238 VDD VSS 10.3702f
C239 INN VSS 1.06929f
C240 INP VSS 1.12125f
C241 a_514_446# VSS 1.22518f
C242 a_8896_446# VSS 1.2712f
C243 a_14_330# VSS 4.59123f
C244 a_314_330# VSS 5.3585f
C245 a_6488_330# VSS 2.45642f
C246 a_4492_446# VSS 2.15404f
C247 a_3760_446# VSS 3.09115f
C248 a_4914_3846# VSS 2.55672f
C249 a_2278_446# VSS 2.30249f
C250 a_3010_446# VSS 0.81718f
C251 a_4102_3846# VSS 1.21933f
C252 a_3290_3846# VSS 1.07438f
C253 a_2478_3846# VSS 4.71991f
C254 a_554_3846# VSS 0.50883f
C255 a_7150_3730# VSS 1.33775f
C256 a_8774_3730# VSS 0.58853f
C257 a_354_3730# VSS 7.56078f
C258 a_54_3730# VSS 3.8411f
C259 VDD VSS 22.0834f
C260 VDD VSS 0.13083p
.ends
