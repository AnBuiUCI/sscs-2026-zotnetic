* Nodos de bulk atados: 2 de pozo n -> VDD, 1 de sustrato -> VSS.
*   magic no extrae los taps de este layout y los dejaba flotando;
*   la conexion si existe (el LVS de KLayout da 'match uniquely').
*   Quien detecta un tap que falte de verdad es el LVS, no esto.
* NGSPICE file created from OPAM.ext - technology: gf180mcuD

.subckt OPAM VSS VDD OUT INP INN
X0 a_10898_3846# a_54_3730# VDD VDD pfet_06v0 ad=2.5p pd=10.5u as=4.4p ps=20.88u w=10u l=1u
X1 a_214_446# a_14_330# VSS VSS nfet_06v0 ad=1.25p pd=5.5u as=2.2p ps=10.88u w=5u l=1u
X2 a_4492_446# a_314_330# a_2478_3846# VSS nfet_06v0 ad=1.1p pd=5.88u as=1.1p ps=5.88u w=2.5u l=1u
X3 a_2478_3846# a_3760_446# VSS VSS nfet_06v0 ad=1.1p pd=5.88u as=1.1p ps=5.88u w=2.5u l=1u
X4 a_2278_446# a_4102_3846# VDD VDD pfet_06v0 ad=2.2p pd=10.88u as=2.2p ps=10.88u w=5u l=1u
X5 a_7150_3730# a_314_330# a_8152_446# VSS nfet_06v0 ad=2.2p pd=10.88u as=1.25p ps=5.5u w=5u l=1u
X6 a_9916_446# a_8896_446# VSS VSS nfet_06v0 ad=1.25p pd=5.5u as=2.2p ps=10.88u w=5u l=1u
X7 a_12412_446# a_14_330# VSS VSS nfet_06v0 ad=1.25p pd=5.5u as=2.2p ps=10.88u w=5u l=1u
X8 a_15046_3846# a_54_3730# VDD VDD pfet_06v0 ad=2.5p pd=10.5u as=4.4p ps=20.88u w=10u l=1u
X9 a_4492_446# a_7150_3730# a_4914_3846# VDD pfet_06v0 ad=2.2p pd=10.88u as=2.2p ps=10.88u w=5u l=1u
X10 a_8152_446# a_14_330# VSS VSS nfet_06v0 ad=1.25p pd=5.5u as=2.2p ps=10.88u w=5u l=1u
X11 a_14_330# a_314_330# a_12412_446# VSS nfet_06v0 ad=2.2p pd=10.88u as=1.25p ps=5.5u w=5u l=1u
X12 a_6488_330# a_354_3730# a_10898_3846# VDD pfet_06v0 ad=4.4p pd=20.88u as=2.5p ps=10.5u w=10u l=1u
X13 a_4102_3846# a_6488_330# a_3760_446# VSS nfet_06v0 ad=1.1p pd=5.88u as=1.1p ps=5.88u w=2.5u l=1u
X14 a_3290_3846# INN a_554_3846# VDD pfet_06v0 ad=4.4p pd=20.88u as=4.4p ps=20.88u w=10u l=1u
X15 a_4102_3846# a_354_3730# a_3010_446# VDD pfet_06v0 ad=2.2p pd=10.88u as=2.2p ps=10.88u w=5u l=1u
X16 a_14_330# a_354_3730# a_13122_3846# VDD pfet_06v0 ad=4.4p pd=20.88u as=2.5p ps=10.5u w=10u l=1u
X17 a_8774_3730# a_354_3730# a_8974_3846# VDD pfet_06v0 ad=4.4p pd=20.88u as=2.5p ps=10.5u w=10u l=1u
X18 a_1246_446# a_14_330# VSS VSS nfet_06v0 ad=1.25p pd=5.5u as=2.2p ps=10.88u w=5u l=1u
X19 a_2478_3846# OUT cap_mim_2f0_m4m5_noshield c_width=20u c_length=10u
X20 a_554_3846# a_354_3730# a_254_3846# VDD pfet_06v0 ad=4.4p pd=20.88u as=2.5p ps=10.5u w=10u l=1u
X21 a_3010_446# INN a_514_446# VSS nfet_06v0 ad=2.2p pd=10.88u as=2.2p ps=10.88u w=5u l=1u
X22 OUT a_4492_446# VSS VSS nfet_06v0 ad=0.44p pd=2.88u as=0.44p ps=2.88u w=1u l=1u
X23 a_314_330# a_354_3730# a_12010_3846# VDD pfet_06v0 ad=4.4p pd=20.88u as=2.5p ps=10.5u w=10u l=1u
X24 a_514_446# a_314_330# a_1246_446# VSS nfet_06v0 ad=2.2p pd=10.88u as=1.25p ps=5.5u w=5u l=1u
X25 a_13444_446# a_354_3730# VSS VSS nfet_06v0 ad=0.25p pd=1.5u as=0.44p ps=2.88u w=1u l=1u
X26 a_2478_3846# INP a_554_3846# VDD pfet_06v0 ad=4.4p pd=20.88u as=4.4p ps=20.88u w=10u l=1u
X27 a_3010_446# a_4102_3846# VDD VDD pfet_06v0 ad=2.2p pd=10.88u as=2.2p ps=10.88u w=5u l=1u
X28 a_3290_3846# a_3760_446# VSS VSS nfet_06v0 ad=1.1p pd=5.88u as=1.1p ps=5.88u w=2.5u l=1u
X29 a_6488_330# a_6488_330# a_8896_446# VSS nfet_06v0 ad=2.2p pd=10.88u as=2.2p ps=10.88u w=5u l=1u
X30 a_54_3730# a_354_3730# a_13444_446# VSS nfet_06v0 ad=0.44p pd=2.88u as=0.25p ps=1.5u w=1u l=1u
X31 a_7150_3730# a_7150_3730# a_8774_3730# VDD pfet_06v0 ad=4.4p pd=20.88u as=4.4p ps=20.88u w=10u l=1u
X32 a_314_330# a_314_330# VSS VSS nfet_06v0 ad=0.44p pd=2.88u as=0.44p ps=2.88u w=1u l=1u
X33 a_1366_3846# a_54_3730# VDD VDD pfet_06v0 ad=2.5p pd=10.5u as=4.4p ps=20.88u w=10u l=1u
X34 a_13122_3846# a_54_3730# VDD VDD pfet_06v0 ad=2.5p pd=10.5u as=4.4p ps=20.88u w=10u l=1u
X35 a_2278_446# INP a_514_446# VSS nfet_06v0 ad=2.2p pd=10.88u as=2.2p ps=10.88u w=5u l=1u
X36 a_8974_3846# a_8774_3730# VDD VDD pfet_06v0 ad=2.5p pd=10.5u as=4.4p ps=20.88u w=10u l=1u
X37 a_54_3730# a_354_3730# a_15046_3846# VDD pfet_06v0 ad=4.4p pd=20.88u as=2.5p ps=10.5u w=10u l=1u
X38 a_4914_3846# a_6488_330# a_4492_446# VSS nfet_06v0 ad=1.1p pd=5.88u as=1.1p ps=5.88u w=2.5u l=1u
X39 OUT a_2278_446# cap_mim_2f0_m4m5_noshield c_width=20u c_length=10u
X40 a_254_3846# a_54_3730# VDD VDD pfet_06v0 ad=2.5p pd=10.5u as=4.4p ps=20.88u w=10u l=1u
X41 a_514_446# a_314_330# a_214_446# VSS nfet_06v0 ad=2.2p pd=10.88u as=1.25p ps=5.5u w=5u l=1u
X42 a_3760_446# a_314_330# a_3290_3846# VSS nfet_06v0 ad=1.1p pd=5.88u as=1.1p ps=5.88u w=2.5u l=1u
X43 a_14476_446# a_354_3730# VSS VSS nfet_06v0 ad=0.25p pd=1.5u as=0.44p ps=2.88u w=1u l=1u
X44 a_12010_3846# a_54_3730# VDD VDD pfet_06v0 ad=2.5p pd=10.5u as=4.4p ps=20.88u w=10u l=1u
X45 OUT a_4914_3846# VDD VDD pfet_06v0 ad=0.308p pd=2.28u as=0.308p ps=2.28u w=0.7u l=20u
X46 a_554_3846# a_354_3730# a_1366_3846# VDD pfet_06v0 ad=4.4p pd=20.88u as=2.5p ps=10.5u w=10u l=1u
X47 a_4914_3846# a_354_3730# a_2278_446# VDD pfet_06v0 ad=2.2p pd=10.88u as=2.2p ps=10.88u w=5u l=1u
X48 a_354_3730# a_354_3730# VDD VDD pfet_06v0 ad=0.88p pd=4.88u as=0.88p ps=4.88u w=2u l=1u
X49 a_3760_446# a_7150_3730# a_4102_3846# VDD pfet_06v0 ad=2.2p pd=10.88u as=2.2p ps=10.88u w=5u l=1u
X50 a_8896_446# a_314_330# a_9916_446# VSS nfet_06v0 ad=2.2p pd=10.88u as=1.25p ps=5.5u w=5u l=1u
X51 a_354_3730# a_354_3730# a_14476_446# VSS nfet_06v0 ad=0.44p pd=2.88u as=0.25p ps=1.5u w=1u l=1u
C0 a_554_3846# a_1366_3846# 0.05972f
C1 a_54_3730# INN 0.02501f
C2 a_3010_446# a_314_330# 0.02369f
C3 a_6488_330# a_10898_3846# 0.05253f
C4 a_2478_3846# a_8896_446# 0.03942f
C5 a_13122_3846# OUT 0.01007f
C6 a_354_3730# a_8896_446# 0.55347f
C7 a_2278_446# VDD 0.31993f
C8 a_54_3730# a_3290_3846# 0.0257f
C9 a_3760_446# OUT 0.19947f
C10 a_7150_3730# a_2278_446# 0.2556f
C11 a_14_330# a_314_330# 5.89257f
C12 a_214_446# VSS 0.04408f
C13 a_6488_330# VDD 0.29987f
C14 a_8774_3730# a_4914_3846# 0.39324f
C15 VDD OUT 1.05999f
C16 VDD a_554_3846# 0.60633f
C17 a_8896_446# VSS 0.43398f
C18 a_4492_446# a_2278_446# 0.07313f
C19 a_354_3730# a_8774_3730# 0.82331f
C20 VDD INP 0.08998f
C21 a_3010_446# a_3760_446# 0.82568f
C22 VDD OUT 5.11232f
C23 a_8974_3846# OUT 0.02681f
C24 a_14_330# a_13122_3846# 0.05253f
C25 a_7150_3730# OUT 0.43371f
C26 a_1246_446# VSS 0.0407f
C27 a_14_330# a_3760_446# 0.12053f
C28 a_2278_446# VDD 0.80685f
C29 a_54_3730# a_4914_3846# 1.27504f
C30 a_314_330# a_3760_446# 0.58404f
C31 a_2478_3846# a_54_3730# 0.59523f
C32 INN a_2278_446# 0.0484f
C33 a_4492_446# OUT 0.84546f
C34 a_54_3730# a_354_3730# 5.40037f
C35 a_54_3730# a_4102_3846# 0.02746f
C36 a_3010_446# VDD 0.29701f
C37 a_554_3846# VDD 1.35699f
C38 a_3290_3846# a_2278_446# 0.02724f
C39 INN a_554_3846# 0.70826f
C40 a_514_446# a_2278_446# 0.42736f
C41 a_14_330# VDD 0.378f
C42 VDD INP 0.38575f
C43 a_54_3730# VSS 0.05799f
C44 a_6488_330# a_4914_3846# 0.59433f
C45 a_3290_3846# a_554_3846# 0.39604f
C46 VDD a_314_330# 0.37716f
C47 VDD OUT 1.09727f
C48 a_6488_330# a_2478_3846# 0.08814f
C49 a_7150_3730# a_14_330# 0.06284f
C50 INN INP 0.13279f
C51 a_6488_330# a_354_3730# 1.40151f
C52 a_6488_330# a_4102_3846# 0.56051f
C53 a_7150_3730# a_314_330# 0.3911f
C54 a_15046_3846# VDD 0.0749f
C55 a_14_330# a_4492_446# 0.0864f
C56 a_254_3846# VDD 0.07506f
C57 a_514_446# INP 0.43934f
C58 a_4492_446# a_314_330# 0.56038f
C59 a_6488_330# VSS 0.40178f
C60 a_3010_446# VDD 0.39567f
C61 VDD a_13122_3846# 0.07069f
C62 a_2278_446# a_4914_3846# 1.11364f
C63 a_7150_3730# a_8152_446# 0.02626f
C64 a_3010_446# INN 1.0506f
C65 a_2478_3846# a_2278_446# 0.21577f
C66 a_6488_330# a_8896_446# 1.29817f
C67 a_354_3730# a_2278_446# 0.7808f
C68 a_9916_446# VSS 0.04305f
C69 VDD a_1366_3846# 0.06858f
C70 a_14_330# VDD 0.30252f
C71 a_4102_3846# a_2278_446# 1.12101f
C72 a_3010_446# a_3290_3846# 0.58315f
C73 a_7150_3730# a_3760_446# 0.49798f
C74 VDD VDD 2.27899f
C75 a_314_330# VDD 0.2997f
C76 a_14_330# INN 0.0411f
C77 a_2478_3846# a_554_3846# 0.66017f
C78 a_9916_446# a_8896_446# 0.02626f
C79 a_3010_446# a_514_446# 0.20156f
C80 a_354_3730# a_554_3846# 0.91876f
C81 INN a_314_330# 0.02954f
C82 a_14_330# a_3290_3846# 0.05712f
C83 a_4492_446# a_3760_446# 0.18632f
C84 a_2278_446# VSS 0.02737f
C85 a_3290_3846# a_314_330# 1.29388f
C86 a_2478_3846# INP 0.66815f
C87 a_4914_3846# OUT 3.24087f
C88 a_354_3730# INP 0.11618f
C89 a_14_330# a_514_446# 0.21437f
C90 a_8974_3846# VDD 0.06907f
C91 a_2478_3846# OUT 3.17113f
C92 a_8896_446# a_2278_446# 0.0267f
C93 a_7150_3730# VDD 0.33559f
C94 a_354_3730# OUT 2.4905f
C95 a_514_446# a_314_330# 1.66642f
C96 a_4102_3846# OUT 0.26471f
C97 VDD a_3760_446# 0.19702f
C98 VSS INP 0.08215f
C99 a_4492_446# VDD 0.09864f
C100 a_3010_446# a_4914_3846# 0.0316f
C101 VSS OUT 0.10023f
C102 a_12412_446# VSS 0.0407f
C103 a_10898_3846# VDD 0.06858f
C104 a_8774_3730# a_2278_446# 0.05256f
C105 a_7150_3730# a_4492_446# 0.66254f
C106 a_3010_446# a_2478_3846# 0.0226f
C107 a_6488_330# a_54_3730# 0.1711f
C108 a_3290_3846# a_3760_446# 0.88965f
C109 a_3010_446# a_354_3730# 0.49176f
C110 a_3010_446# a_4102_3846# 1.28005f
C111 a_14_330# a_4914_3846# 0.09607f
C112 a_8896_446# OUT 0.0569f
C113 a_14_330# a_2478_3846# 0.34725f
C114 VDD VDD 9.40271f
C115 a_314_330# a_4914_3846# 0.06104f
C116 a_14_330# a_354_3730# 1.52382f
C117 a_14_330# a_4102_3846# 0.02761f
C118 a_2478_3846# a_314_330# 0.926f
C119 a_3010_446# VSS 0.02222f
C120 a_7150_3730# VDD 1.48487f
C121 a_354_3730# a_314_330# 0.9639f
C122 INN VDD 0.08849f
C123 a_4102_3846# a_314_330# 0.01986f
C124 a_3290_3846# VDD 0.0207f
C125 a_2478_3846# a_15046_3846# 0.01822f
C126 a_8774_3730# OUT 0.49029f
C127 a_54_3730# a_2278_446# 1.89579f
C128 VSS a_14476_446# 0.01078f
C129 a_14_330# VSS 1.29191f
C130 a_4492_446# VDD 0.191f
C131 a_314_330# VSS 1.14358f
C132 a_54_3730# a_554_3846# 0.26598f
C133 a_2478_3846# a_13122_3846# 0.01822f
C134 a_14_330# a_8896_446# 0.10617f
C135 a_4914_3846# a_3760_446# 1.31211f
C136 a_4492_446# a_3290_3846# 0.02616f
C137 a_2478_3846# a_3760_446# 1.14154f
C138 a_8896_446# a_314_330# 0.60356f
C139 a_354_3730# a_3760_446# 0.48688f
C140 a_4102_3846# a_3760_446# 0.66769f
C141 a_54_3730# INP 0.15793f
C142 a_4914_3846# VDD 5.35012f
C143 a_6488_330# a_2278_446# 0.05682f
C144 a_2478_3846# VDD 0.21946f
C145 a_8152_446# VSS 0.0407f
C146 a_54_3730# OUT 0.29558f
C147 INN VDD 0.45496f
C148 a_12010_3846# a_314_330# 0.05253f
C149 a_3290_3846# VDD 0.34535f
C150 a_3760_446# VSS 0.50272f
C151 VDD a_4914_3846# 1.55584f
C152 a_2478_3846# VDD 0.26811f
C153 a_3290_3846# INN 0.51649f
C154 a_7150_3730# a_4914_3846# 1.85451f
C155 a_354_3730# VDD 1.39401f
C156 VDD VSS 0.14181f
C157 a_4102_3846# VDD 0.44086f
C158 a_3010_446# a_54_3730# 0.02226f
C159 a_7150_3730# a_2478_3846# 0.01047f
C160 a_6488_330# OUT 0.29484f
C161 a_7150_3730# a_354_3730# 0.11132f
C162 INN a_514_446# 0.4164f
C163 a_7150_3730# a_4102_3846# 0.42777f
C164 a_4492_446# a_4914_3846# 0.432f
C165 a_4492_446# a_2478_3846# 0.1933f
C166 a_14_330# a_54_3730# 0.14995f
C167 VDD VSS 0.10916f
C168 a_4492_446# a_354_3730# 2.61173f
C169 a_4492_446# a_4102_3846# 0.275f
C170 a_54_3730# a_314_330# 0.17553f
C171 a_7150_3730# VSS 0.1016f
C172 a_2278_446# INP 0.93362f
C173 a_54_3730# a_15046_3846# 0.05253f
C174 a_4914_3846# VDD 0.58699f
C175 a_7150_3730# a_8896_446# 0.22082f
C176 a_2278_446# OUT 1.7799f
C177 a_4492_446# VSS 0.29088f
C178 a_2478_3846# VDD 0.67013f
C179 a_354_3730# VDD 3.83635f
C180 a_6488_330# a_14_330# 0.13522f
C181 a_4102_3846# VDD 1.40128f
C182 a_554_3846# INP 0.56079f
C183 a_2478_3846# INN 0.2077f
C184 a_12010_3846# VDD 0.06858f
C185 a_6488_330# a_314_330# 1.88361f
C186 a_4492_446# a_8896_446# 0.13251f
C187 a_8774_3730# VDD 0.60022f
C188 a_354_3730# INN 0.02726f
C189 a_2478_3846# a_3290_3846# 0.81134f
C190 a_54_3730# a_3760_446# 0.0946f
C191 a_8974_3846# a_8774_3730# 0.05582f
C192 a_3290_3846# a_354_3730# 0.04002f
C193 a_7150_3730# a_8774_3730# 0.97815f
C194 a_3010_446# a_2278_446# 0.16142f
C195 a_2478_3846# a_514_446# 0.10847f
C196 a_13444_446# VSS 0.01272f
C197 a_54_3730# VDD 0.02097f
C198 a_354_3730# a_514_446# 0.3685f
C199 INN VSS 0.08091f
C200 a_4492_446# a_8774_3730# 0.0593f
C201 a_14_330# a_2278_446# 0.05167f
C202 a_3290_3846# VSS 0.19897f
C203 a_2278_446# a_314_330# 0.05356f
C204 a_6488_330# a_3760_446# 0.54988f
C205 a_54_3730# VDD 2.73655f
C206 a_514_446# VSS 0.36384f
C207 a_214_446# a_514_446# 0.02626f
C208 a_7150_3730# a_54_3730# 1.22742f
C209 a_3010_446# OUT 0.01305f
C210 a_8774_3730# VDD 0.99306f
C211 a_2478_3846# a_4914_3846# 0.98819f
C212 a_14_330# INP 0.04182f
C213 a_354_3730# a_4914_3846# 0.77498f
C214 a_4492_446# a_54_3730# 2.41707f
C215 a_4102_3846# a_4914_3846# 0.1048f
C216 a_314_330# INP 0.0298f
C217 a_14_330# OUT 0.25272f
C218 a_14_330# a_12412_446# 0.0329f
C219 a_2478_3846# a_354_3730# 1.91318f
C220 a_2478_3846# a_4102_3846# 0.01238f
C221 a_6488_330# VDD 0.37462f
C222 a_314_330# OUT 0.47814f
C223 a_254_3846# a_554_3846# 0.05253f
C224 a_354_3730# a_4102_3846# 0.43614f
C225 a_2278_446# a_3760_446# 0.49672f
C226 a_6488_330# a_7150_3730# 0.03257f
C227 a_514_446# a_1246_446# 0.02626f
C228 a_4914_3846# VSS 0.18692f
C229 a_15046_3846# OUT 0.01007f
C230 a_2478_3846# VSS 0.21122f
C231 a_54_3730# VDD 2.41029f
C232 a_354_3730# VSS 0.58649f
C233 a_6488_330# a_4492_446# 0.59489f
C234 a_3010_446# a_14_330# 0.02947f
C235 a_4102_3846# VSS 0.02219f
C236 VSS VSS 15.4917f
C237 OUT VSS 5.07339f
C238 VDD VSS 10.3702f
C239 INN VSS 1.0448f
C240 INP VSS 1.14037f
C241 a_514_446# VSS 1.22518f
C242 a_8896_446# VSS 1.2712f
C243 a_14_330# VSS 4.59123f
C244 a_314_330# VSS 5.3585f
C245 a_6488_330# VSS 2.45642f
C246 a_4492_446# VSS 2.15404f
C247 a_3760_446# VSS 3.09115f
C248 a_4914_3846# VSS 2.55672f
C249 a_2278_446# VSS 2.30236f
C250 a_3010_446# VSS 0.81725f
C251 a_4102_3846# VSS 1.2195f
C252 a_3290_3846# VSS 1.07438f
C253 a_2478_3846# VSS 4.70796f
C254 a_554_3846# VSS 0.50882f
C255 a_7150_3730# VSS 1.33775f
C256 a_8774_3730# VSS 0.58853f
C257 a_354_3730# VSS 7.56078f
C258 a_54_3730# VSS 3.84124f
C259 VDD VSS 22.0834f
C260 VDD VSS 0.13083p
.ends
