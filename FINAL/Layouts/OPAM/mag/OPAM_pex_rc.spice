* Nodos de bulk atados: 27 de pozo n -> VDD, 27 de sustrato -> VSS.
*   magic no extrae los taps de este layout y los dejaba flotando;
*   la conexion si existe (el LVS de KLayout da 'match uniquely').
*   Quien detecta un tap que falte de verdad es el LVS, no esto.
* NGSPICE file created from OPAM.ext - technology: gf180mcuD

.subckt OPAM VSS VDD OUT INP INN
X0 a_10898_3846.t1 a_54_3730.t5 VDD.t3 VDD pfet_06v0 ad=2.5p pd=10.5u as=4.4p ps=20.88u w=10u l=1u
X1 a_214_446.t1 a_14_330.t5 VSS.t7 VSS nfet_06v0 ad=1.25p pd=5.5u as=2.2p ps=10.88u w=5u l=1u
X2 a_4492_446.t2 a_314_330.t6 a_2478_3846.t1 VSS nfet_06v0 ad=1.1p pd=5.88u as=1.1p ps=5.88u w=2.5u l=1u
X3 a_2478_3846.t2 a_3760_446.t3 VSS.t0 VSS nfet_06v0 ad=1.1p pd=5.88u as=1.1p ps=5.88u w=2.5u l=1u
X4 a_2278_446.t0 a_4102_3846.t3 VDD.t2 VDD pfet_06v0 ad=2.2p pd=10.88u as=2.2p ps=10.88u w=5u l=1u
X5 a_7150_3730.t2 a_314_330.t5 a_8152_446.t0 VSS nfet_06v0 ad=2.2p pd=10.88u as=1.25p ps=5.5u w=5u l=1u
X6 a_9916_446.t1 a_8896_446.t2 VSS.t3 VSS nfet_06v0 ad=1.25p pd=5.5u as=2.2p ps=10.88u w=5u l=1u
X7 a_12412_446.t1 a_14_330.t2 VSS.t10 VSS nfet_06v0 ad=1.25p pd=5.5u as=2.2p ps=10.88u w=5u l=1u
X8 a_15046_3846.t1 a_54_3730.t2 VDD.t4 VDD pfet_06v0 ad=2.5p pd=10.5u as=4.4p ps=20.88u w=10u l=1u
X9 a_4492_446.t0 a_7150_3730.t3 a_4914_3846.t0 VDD pfet_06v0 ad=2.2p pd=10.88u as=2.2p ps=10.88u w=5u l=1u
X10 a_8152_446.t1 a_14_330.t3 VSS.t4 VSS nfet_06v0 ad=1.25p pd=5.5u as=2.2p ps=10.88u w=5u l=1u
X11 a_14_330.t0 a_314_330.t3 a_12412_446.t0 VSS nfet_06v0 ad=2.2p pd=10.88u as=1.25p ps=5.5u w=5u l=1u
X12 a_6488_330.t0 a_354_3730.t10 a_10898_3846.t0 VDD pfet_06v0 ad=4.4p pd=20.88u as=2.5p ps=10.5u w=10u l=1u
X13 a_4102_3846.t1 a_6488_330.t4 a_3760_446.t1 VSS nfet_06v0 ad=1.1p pd=5.88u as=1.1p ps=5.88u w=2.5u l=1u
X14 a_3290_3846.t0 INN.t1 a_554_3846.t0 VDD pfet_06v0 ad=4.4p pd=20.88u as=4.4p ps=20.88u w=10u l=1u
X15 a_4102_3846.t2 a_354_3730.t13 a_3010_446.t2 VDD pfet_06v0 ad=2.2p pd=10.88u as=2.2p ps=10.88u w=5u l=1u
X16 a_14_330.t1 a_354_3730.t8 a_13122_3846.t0 VDD pfet_06v0 ad=4.4p pd=20.88u as=2.5p ps=10.5u w=10u l=1u
X17 a_8774_3730.t1 a_354_3730.t11 a_8974_3846.t0 VDD pfet_06v0 ad=4.4p pd=20.88u as=2.5p ps=10.5u w=10u l=1u
X18 a_1246_446.t1 a_14_330.t4 VSS.t1 VSS nfet_06v0 ad=1.25p pd=5.5u as=2.2p ps=10.88u w=5u l=1u
X19 a_2478_3846.t3 OUT.t0 cap_mim_2f0_m4m5_noshield c_width=20u c_length=10u
X20 a_554_3846.t3 a_354_3730.t15 a_254_3846.t0 VDD pfet_06v0 ad=4.4p pd=20.88u as=2.5p ps=10.5u w=10u l=1u
X21 a_3010_446.t0 INN.t0 a_514_446.t0 VSS nfet_06v0 ad=2.2p pd=10.88u as=2.2p ps=10.88u w=5u l=1u
X22 OUT.t2 a_4492_446.t3 VSS.t5 VSS nfet_06v0 ad=0.44p pd=2.88u as=0.44p ps=2.88u w=1u l=1u
X23 a_314_330.t0 a_354_3730.t9 a_12010_3846.t1 VDD pfet_06v0 ad=4.4p pd=20.88u as=2.5p ps=10.5u w=10u l=1u
X24 a_514_446.t1 a_314_330.t8 a_1246_446.t0 VSS nfet_06v0 ad=2.2p pd=10.88u as=1.25p ps=5.5u w=5u l=1u
X25 a_13444_446.t0 a_354_3730.t6 VSS.t2 VSS nfet_06v0 ad=0.25p pd=1.5u as=0.44p ps=2.88u w=1u l=1u
X26 a_2478_3846.t0 INP.t1 a_554_3846.t1 VDD pfet_06v0 ad=4.4p pd=20.88u as=4.4p ps=20.88u w=10u l=1u
X27 a_3010_446.t1 a_4102_3846.t4 VDD.t1 VDD pfet_06v0 ad=2.2p pd=10.88u as=2.2p ps=10.88u w=5u l=1u
X28 a_3290_3846.t2 a_3760_446.t4 VSS.t9 VSS nfet_06v0 ad=1.1p pd=5.88u as=1.1p ps=5.88u w=2.5u l=1u
X29 a_6488_330.t2 a_6488_330.t1 a_8896_446.t1 VSS nfet_06v0 ad=2.2p pd=10.88u as=2.2p ps=10.88u w=5u l=1u
X30 a_54_3730.t1 a_354_3730.t5 a_13444_446.t1 VSS nfet_06v0 ad=0.44p pd=2.88u as=0.25p ps=1.5u w=1u l=1u
X31 a_7150_3730.t1 a_7150_3730.t0 a_8774_3730.t0 VDD pfet_06v0 ad=4.4p pd=20.88u as=4.4p ps=20.88u w=10u l=1u
X32 a_314_330.t2 a_314_330.t1 VSS.t6 VSS nfet_06v0 ad=0.44p pd=2.88u as=0.44p ps=2.88u w=1u l=1u
X33 a_1366_3846.t1 a_54_3730.t6 VDD.t8 VDD pfet_06v0 ad=2.5p pd=10.5u as=4.4p ps=20.88u w=10u l=1u
X34 a_13122_3846.t1 a_54_3730.t3 VDD.t7 VDD pfet_06v0 ad=2.5p pd=10.5u as=4.4p ps=20.88u w=10u l=1u
X35 a_2278_446.t1 INP.t0 a_514_446.t3 VSS nfet_06v0 ad=2.2p pd=10.88u as=2.2p ps=10.88u w=5u l=1u
X36 a_8974_3846.t1 a_8774_3730.t2 VDD.t6 VDD pfet_06v0 ad=2.5p pd=10.5u as=4.4p ps=20.88u w=10u l=1u
X37 a_54_3730.t0 a_354_3730.t7 a_15046_3846.t0 VDD pfet_06v0 ad=4.4p pd=20.88u as=2.5p ps=10.5u w=10u l=1u
X38 a_4914_3846.t1 a_6488_330.t3 a_4492_446.t1 VSS nfet_06v0 ad=1.1p pd=5.88u as=1.1p ps=5.88u w=2.5u l=1u
X39 OUT.t3 a_2278_446.t3 cap_mim_2f0_m4m5_noshield c_width=20u c_length=10u
X40 a_254_3846.t1 a_54_3730.t7 VDD.t9 VDD pfet_06v0 ad=2.5p pd=10.5u as=4.4p ps=20.88u w=10u l=1u
X41 a_514_446.t2 a_314_330.t9 a_214_446.t0 VSS nfet_06v0 ad=2.2p pd=10.88u as=1.25p ps=5.5u w=5u l=1u
X42 a_3760_446.t2 a_314_330.t7 a_3290_3846.t1 VSS nfet_06v0 ad=1.1p pd=5.88u as=1.1p ps=5.88u w=2.5u l=1u
X43 a_14476_446.t1 a_354_3730.t4 VSS.t8 VSS nfet_06v0 ad=0.25p pd=1.5u as=0.44p ps=2.88u w=1u l=1u
X44 a_12010_3846.t0 a_54_3730.t4 VDD.t0 VDD pfet_06v0 ad=2.5p pd=10.5u as=4.4p ps=20.88u w=10u l=1u
X45 OUT.t1 a_4914_3846.t3 VDD.t5 VDD pfet_06v0 ad=0.308p pd=2.28u as=0.308p ps=2.28u w=0.7u l=20u
X46 a_554_3846.t2 a_354_3730.t14 a_1366_3846.t0 VDD pfet_06v0 ad=4.4p pd=20.88u as=2.5p ps=10.5u w=10u l=1u
X47 a_4914_3846.t2 a_354_3730.t12 a_2278_446.t2 VDD pfet_06v0 ad=2.2p pd=10.88u as=2.2p ps=10.88u w=5u l=1u
X48 a_354_3730.t3 a_354_3730.t2 VDD.t10 VDD pfet_06v0 ad=0.88p pd=4.88u as=0.88p ps=4.88u w=2u l=1u
X49 a_3760_446.t0 a_7150_3730.t4 a_4102_3846.t0 VDD pfet_06v0 ad=2.2p pd=10.88u as=2.2p ps=10.88u w=5u l=1u
X50 a_8896_446.t0 a_314_330.t4 a_9916_446.t0 VSS nfet_06v0 ad=2.2p pd=10.88u as=1.25p ps=5.5u w=5u l=1u
X51 a_354_3730.t1 a_354_3730.t0 a_14476_446.t0 VSS nfet_06v0 ad=0.44p pd=2.88u as=0.25p ps=1.5u w=1u l=1u
R0 VSS.n43 VSS.n40 9.0005
R1 VSS.n45 VSS.n44 9.0005
R2 VSS.n46 VSS.n39 9.0005
R3 VSS.n48 VSS.n47 9.0005
R4 VSS.n49 VSS.n38 9.0005
R5 VSS.n51 VSS.n50 9.0005
R6 VSS.n52 VSS.n37 9.0005
R7 VSS.n54 VSS.n53 9.0005
R8 VSS.n55 VSS.n36 9.0005
R9 VSS.n57 VSS.n56 9.0005
R10 VSS.n59 VSS.n58 9.0005
R11 VSS.n60 VSS.n34 9.0005
R12 VSS.n63 VSS.n62 9.0005
R13 VSS.n64 VSS.n33 9.0005
R14 VSS.n66 VSS.n65 9.0005
R15 VSS.n67 VSS.n31 9.0005
R16 VSS.n69 VSS.n68 9.0005
R17 VSS.n70 VSS.n1 9.0005
R18 VSS.n72 VSS.n71 9.0005
R19 VSS.n30 VSS.n0 9.0005
R20 VSS.n29 VSS.n28 9.0005
R21 VSS.n27 VSS.n2 9.0005
R22 VSS.n25 VSS.n24 9.0005
R23 VSS.n23 VSS.n3 9.0005
R24 VSS.n22 VSS.n21 9.0005
R25 VSS.n19 VSS.n4 9.0005
R26 VSS.n17 VSS.n16 9.0005
R27 VSS.n15 VSS.n5 9.0005
R28 VSS.n14 VSS.n13 9.0005
R29 VSS.n11 VSS.n6 9.0005
R30 VSS.n10 VSS.n9 9.0005
R31 VSS.n8 VSS.t8 5.5087
R32 VSS.n7 VSS.t2 5.42612
R33 VSS.n18 VSS.t6 5.42612
R34 VSS.n20 VSS.t5 5.42612
R35 VSS.n41 VSS.n40 3.22882
R36 VSS.n61 VSS.t0 2.72532
R37 VSS.n35 VSS.t9 2.72532
R38 VSS.n41 VSS.t7 2.24507
R39 VSS.n12 VSS.t10 2.05582
R40 VSS.n26 VSS.t3 2.05582
R41 VSS.n32 VSS.t4 2.05582
R42 VSS.n42 VSS.t1 2.05582
R43 VSS.n9 VSS.n8 1.71086
R44 VSS.n8 VSS.n7 0.424777
R45 VSS.n42 VSS.n41 0.32148
R46 VSS.n9 VSS.n6 0.2005
R47 VSS.n14 VSS.n6 0.2005
R48 VSS.n15 VSS.n14 0.2005
R49 VSS.n16 VSS.n15 0.2005
R50 VSS.n16 VSS.n4 0.2005
R51 VSS.n22 VSS.n4 0.2005
R52 VSS.n23 VSS.n22 0.2005
R53 VSS.n24 VSS.n23 0.2005
R54 VSS.n24 VSS.n2 0.2005
R55 VSS.n29 VSS.n2 0.2005
R56 VSS.n30 VSS.n29 0.2005
R57 VSS.n71 VSS.n30 0.2005
R58 VSS.n71 VSS.n70 0.2005
R59 VSS.n70 VSS.n69 0.2005
R60 VSS.n69 VSS.n31 0.2005
R61 VSS.n65 VSS.n31 0.2005
R62 VSS.n65 VSS.n64 0.2005
R63 VSS.n64 VSS.n63 0.2005
R64 VSS.n63 VSS.n34 0.2005
R65 VSS.n58 VSS.n34 0.2005
R66 VSS.n58 VSS.n57 0.2005
R67 VSS.n57 VSS.n36 0.2005
R68 VSS.n53 VSS.n36 0.2005
R69 VSS.n53 VSS.n52 0.2005
R70 VSS.n52 VSS.n51 0.2005
R71 VSS.n51 VSS.n38 0.2005
R72 VSS.n47 VSS.n38 0.2005
R73 VSS.n47 VSS.n46 0.2005
R74 VSS.n46 VSS.n45 0.2005
R75 VSS.n45 VSS.n40 0.2005
R76 VSS.n11 VSS.n10 0.2005
R77 VSS.n13 VSS.n11 0.2005
R78 VSS.n17 VSS.n5 0.2005
R79 VSS.n21 VSS.n19 0.2005
R80 VSS.n25 VSS.n3 0.2005
R81 VSS.n28 VSS.n27 0.2005
R82 VSS.n28 VSS.n0 0.2005
R83 VSS.n72 VSS.n1 0.2005
R84 VSS.n68 VSS.n67 0.2005
R85 VSS.n67 VSS.n66 0.2005
R86 VSS.n66 VSS.n33 0.2005
R87 VSS.n62 VSS.n33 0.2005
R88 VSS.n60 VSS.n59 0.2005
R89 VSS.n56 VSS.n55 0.2005
R90 VSS.n55 VSS.n54 0.2005
R91 VSS.n54 VSS.n37 0.2005
R92 VSS.n50 VSS.n37 0.2005
R93 VSS.n50 VSS.n49 0.2005
R94 VSS.n49 VSS.n48 0.2005
R95 VSS.n48 VSS.n39 0.2005
R96 VSS.n44 VSS.n39 0.2005
R97 VSS.n44 VSS.n43 0.2005
R98 VSS.n68 VSS.n32 0.188
R99 VSS.n20 VSS.n3 0.186
R100 VSS.n19 VSS.n18 0.152
R101 VSS VSS.n72 0.1355
R102 VSS.n26 VSS.n25 0.131
R103 VSS.n56 VSS.n35 0.124
R104 VSS.n12 VSS.n5 0.118
R105 VSS.n62 VSS.n61 0.111
R106 VSS.n61 VSS.n60 0.09
R107 VSS.n13 VSS.n12 0.083
R108 VSS.n59 VSS.n35 0.077
R109 VSS.n27 VSS.n26 0.07
R110 VSS.n43 VSS.n42 0.066
R111 VSS VSS.n0 0.0655
R112 VSS.n18 VSS.n17 0.049
R113 VSS.n10 VSS.n7 0.034
R114 VSS.n21 VSS.n20 0.015
R115 VSS.n32 VSS.n1 0.013
R116 OUT.n0 OUT.t3 15.3907
R117 OUT.n0 OUT.t2 13.0638
R118 OUT OUT.t1 12.8474
R119 OUT.n1 OUT.t0 9.27911
R120 OUT.n1 OUT.n0 7.66664
R121 OUT OUT.n1 4.70461
R122 VDD.n11 VDD.t5 17.6944
R123 VDD.n52 VDD.n51 9.0005
R124 VDD.n53 VDD.n48 9.0005
R125 VDD.n55 VDD.n54 9.0005
R126 VDD.n56 VDD.n47 9.0005
R127 VDD.n58 VDD.n57 9.0005
R128 VDD.n59 VDD.n46 9.0005
R129 VDD.n61 VDD.n60 9.0005
R130 VDD.n62 VDD.n45 9.0005
R131 VDD.n64 VDD.n63 9.0005
R132 VDD.n65 VDD.n44 9.0005
R133 VDD.n67 VDD.n66 9.0005
R134 VDD.n69 VDD.n42 9.0005
R135 VDD.n71 VDD.n70 9.0005
R136 VDD.n72 VDD.n41 9.0005
R137 VDD.n74 VDD.n73 9.0005
R138 VDD.n75 VDD.n40 9.0005
R139 VDD.n77 VDD.n76 9.0005
R140 VDD.n78 VDD.n1 9.0005
R141 VDD.n80 VDD.n79 9.0005
R142 VDD.n39 VDD.n38 9.0005
R143 VDD.n37 VDD.n2 9.0005
R144 VDD.n36 VDD.n35 9.0005
R145 VDD.n34 VDD.n3 9.0005
R146 VDD.n33 VDD.n32 9.0005
R147 VDD.n30 VDD.n4 9.0005
R148 VDD.n29 VDD.n28 9.0005
R149 VDD.n27 VDD.n5 9.0005
R150 VDD.n26 VDD.n25 9.0005
R151 VDD.n23 VDD.n6 9.0005
R152 VDD.n22 VDD.n21 9.0005
R153 VDD.n20 VDD.n19 9.0005
R154 VDD.n18 VDD.n8 9.0005
R155 VDD.n17 VDD.n16 9.0005
R156 VDD.n15 VDD.n14 9.0005
R157 VDD.n13 VDD.n10 9.0005
R158 VDD.n9 VDD.t10 6.09214
R159 VDD.n68 VDD.t1 3.93838
R160 VDD.n43 VDD.t2 3.93838
R161 VDD.n52 VDD.n49 3.23511
R162 VDD.n49 VDD.t9 2.28071
R163 VDD.n50 VDD.t8 2.1044
R164 VDD.n0 VDD.t6 2.1044
R165 VDD.n31 VDD.t3 2.1044
R166 VDD.n24 VDD.t0 2.1044
R167 VDD.n7 VDD.t7 2.1044
R168 VDD.n12 VDD.t4 2.1044
R169 VDD.n11 VDD.n10 1.89059
R170 VDD.n12 VDD.n11 0.517981
R171 VDD.n50 VDD.n49 0.37519
R172 VDD.n15 VDD.n10 0.2005
R173 VDD.n16 VDD.n15 0.2005
R174 VDD.n16 VDD.n8 0.2005
R175 VDD.n20 VDD.n8 0.2005
R176 VDD.n21 VDD.n20 0.2005
R177 VDD.n21 VDD.n6 0.2005
R178 VDD.n26 VDD.n6 0.2005
R179 VDD.n27 VDD.n26 0.2005
R180 VDD.n28 VDD.n27 0.2005
R181 VDD.n28 VDD.n4 0.2005
R182 VDD.n33 VDD.n4 0.2005
R183 VDD.n34 VDD.n33 0.2005
R184 VDD.n35 VDD.n34 0.2005
R185 VDD.n35 VDD.n2 0.2005
R186 VDD.n39 VDD.n2 0.2005
R187 VDD.n79 VDD.n39 0.2005
R188 VDD.n79 VDD.n78 0.2005
R189 VDD.n78 VDD.n77 0.2005
R190 VDD.n77 VDD.n40 0.2005
R191 VDD.n73 VDD.n40 0.2005
R192 VDD.n73 VDD.n72 0.2005
R193 VDD.n72 VDD.n71 0.2005
R194 VDD.n71 VDD.n42 0.2005
R195 VDD.n66 VDD.n42 0.2005
R196 VDD.n66 VDD.n65 0.2005
R197 VDD.n65 VDD.n64 0.2005
R198 VDD.n64 VDD.n45 0.2005
R199 VDD.n60 VDD.n45 0.2005
R200 VDD.n60 VDD.n59 0.2005
R201 VDD.n59 VDD.n58 0.2005
R202 VDD.n58 VDD.n47 0.2005
R203 VDD.n54 VDD.n47 0.2005
R204 VDD.n54 VDD.n53 0.2005
R205 VDD.n53 VDD.n52 0.2005
R206 VDD.n14 VDD.n13 0.2005
R207 VDD.n18 VDD.n17 0.2005
R208 VDD.n19 VDD.n18 0.2005
R209 VDD.n23 VDD.n22 0.2005
R210 VDD.n25 VDD.n23 0.2005
R211 VDD.n29 VDD.n5 0.2005
R212 VDD.n30 VDD.n29 0.2005
R213 VDD.n32 VDD.n3 0.2005
R214 VDD.n36 VDD.n3 0.2005
R215 VDD.n37 VDD.n36 0.2005
R216 VDD.n38 VDD.n37 0.2005
R217 VDD.n80 VDD.n1 0.2005
R218 VDD.n76 VDD.n1 0.2005
R219 VDD.n76 VDD.n75 0.2005
R220 VDD.n75 VDD.n74 0.2005
R221 VDD.n74 VDD.n41 0.2005
R222 VDD.n70 VDD.n69 0.2005
R223 VDD.n67 VDD.n44 0.2005
R224 VDD.n63 VDD.n44 0.2005
R225 VDD.n63 VDD.n62 0.2005
R226 VDD.n62 VDD.n61 0.2005
R227 VDD.n61 VDD.n46 0.2005
R228 VDD.n57 VDD.n46 0.2005
R229 VDD.n57 VDD.n56 0.2005
R230 VDD.n56 VDD.n55 0.2005
R231 VDD.n55 VDD.n48 0.2005
R232 VDD.n51 VDD.n48 0.2005
R233 VDD.n70 VDD.n43 0.181
R234 VDD.n68 VDD.n67 0.175
R235 VDD.n14 VDD.n9 0.172
R236 VDD.n32 VDD.n31 0.161
R237 VDD VDD.n80 0.1355
R238 VDD.n19 VDD.n7 0.128
R239 VDD.n24 VDD.n5 0.117
R240 VDD.n25 VDD.n24 0.084
R241 VDD.n22 VDD.n7 0.073
R242 VDD VDD.n0 0.064
R243 VDD.n31 VDD.n30 0.04
R244 VDD.n13 VDD.n12 0.035
R245 VDD.n17 VDD.n9 0.029
R246 VDD.n69 VDD.n68 0.026
R247 VDD.n43 VDD.n41 0.02
R248 VDD.n51 VDD.n50 0.006
R249 VDD.n38 VDD.n0 0.002
R250 INN INN.t1 44.2447
R251 INN INN.t0 37.9725
R252 INP INP.t1 45.0195
R253 INP INP.t0 37.0558
R254 a_14476_446.t0 a_14476_446.t1 3.1505
R255 a_13444_446.t0 a_13444_446.t1 3.1505
R256 a_12412_446.t0 a_12412_446.t1 0.6305
R257 a_9916_446.t0 a_9916_446.t1 0.6305
R258 a_8152_446.t0 a_8152_446.t1 0.6305
R259 a_1246_446.t0 a_1246_446.t1 0.6305
R260 a_514_446.t0 a_514_446.n0 8.47257
R261 a_514_446.n0 a_514_446.n1 0.601571
R262 a_514_446.n1 a_514_446.t2 8.95471
R263 a_514_446.n1 a_514_446.t1 7.32828
R264 a_514_446.n0 a_514_446.t3 7.32828
R265 a_214_446.t0 a_214_446.t1 0.6305
R266 a_8896_446.t0 a_8896_446.n0 8.30815
R267 a_8896_446.n0 a_8896_446.t1 9.00244
R268 a_8896_446.n0 a_8896_446.t2 31.0113
R269 a_15046_3846.t0 a_15046_3846.t1 0.3505
R270 a_14_330.t0 a_14_330.n3 6.81176
R271 a_14_330.n3 a_14_330.t1 11.0689
R272 a_14_330.n3 a_14_330.n0 0.722107
R273 a_14_330.n0 a_14_330.n1 6.81479
R274 a_14_330.n1 a_14_330.n2 11.0673
R275 a_14_330.n2 a_14_330.t5 31.8629
R276 a_14_330.n2 a_14_330.t4 30.2365
R277 a_14_330.n1 a_14_330.t3 30.2365
R278 a_14_330.n0 a_14_330.t2 30.2365
R279 a_13122_3846.t0 a_13122_3846.t1 0.3505
R280 a_314_330.t2 a_314_330.n7 12.0041
R281 a_314_330.n7 a_314_330.n6 0.980857
R282 a_314_330.n6 a_314_330.t3 30.8371
R283 a_314_330.n6 a_314_330.t0 9.70175
R284 a_314_330.n7 a_314_330.n0 0.239964
R285 a_314_330.n0 a_314_330.n1 2.32121
R286 a_314_330.n1 a_314_330.n2 2.80336
R287 a_314_330.n2 a_314_330.n3 6.33264
R288 a_314_330.n3 a_314_330.n4 1.14479
R289 a_314_330.n4 a_314_330.n5 3.52657
R290 a_314_330.n5 a_314_330.t9 32.1212
R291 a_314_330.n5 a_314_330.t8 30.4947
R292 a_314_330.n4 a_314_330.t7 22.348
R293 a_314_330.n3 a_314_330.t6 22.348
R294 a_314_330.n2 a_314_330.t5 30.4947
R295 a_314_330.n1 a_314_330.t4 30.4947
R296 a_314_330.n0 a_314_330.t1 17.46
R297 a_12010_3846.t0 a_12010_3846.t1 0.3505
R298 a_6488_330.t2 a_6488_330.n2 7.32828
R299 a_6488_330.n2 a_6488_330.t0 12.6481
R300 a_6488_330.n2 a_6488_330.n0 0.239964
R301 a_6488_330.n0 a_6488_330.n1 2.80336
R302 a_6488_330.n1 a_6488_330.t4 23.7506
R303 a_6488_330.n1 a_6488_330.t3 22.6063
R304 a_6488_330.n0 a_6488_330.t1 30.753
R305 a_10898_3846.t0 a_10898_3846.t1 0.3505
R306 a_8974_3846.t0 a_8974_3846.t1 0.3505
R307 a_4492_446.t1 a_4492_446.n1 9.75047
R308 a_4492_446.n1 a_4492_446.n0 1.70407
R309 a_4492_446.n0 a_4492_446.t3 22.6668
R310 a_4492_446.n0 a_4492_446.t0 8.54635
R311 a_4492_446.n1 a_4492_446.t2 13.8808
R312 a_3760_446.t1 a_3760_446.n2 10.7835
R313 a_3760_446.n2 a_3760_446.t0 9.0883
R314 a_3760_446.n2 a_3760_446.n0 0.873179
R315 a_3760_446.n0 a_3760_446.n1 1.14479
R316 a_3760_446.n1 a_3760_446.t2 12.8326
R317 a_3760_446.n1 a_3760_446.t4 24.4141
R318 a_3760_446.n0 a_3760_446.t3 24.4141
R319 a_4914_3846.t1 a_4914_3846.n1 10.5252
R320 a_4914_3846.n1 a_4914_3846.n0 0.617643
R321 a_4914_3846.n0 a_4914_3846.t3 20.0828
R322 a_4914_3846.n0 a_4914_3846.t0 7.77157
R323 a_4914_3846.n1 a_4914_3846.t2 11.7669
R324 a_2278_446.t0 a_2278_446.n0 8.21947
R325 a_2278_446.n0 a_2278_446.n1 2.89336
R326 a_2278_446.n1 a_2278_446.t1 12.2807
R327 a_2278_446.n1 a_2278_446.t2 8.02983
R328 a_2278_446.n0 a_2278_446.t3 9.27811
R329 a_3010_446.t0 a_3010_446.n0 10.574
R330 a_3010_446.n0 a_3010_446.t1 10.3761
R331 a_3010_446.n0 a_3010_446.t2 7.25504
R332 a_4102_3846.t1 a_4102_3846.n2 11.3
R333 a_4102_3846.n2 a_4102_3846.t0 7.48535
R334 a_4102_3846.n2 a_4102_3846.n0 0.481036
R335 a_4102_3846.n0 a_4102_3846.n1 1.27336
R336 a_4102_3846.n1 a_4102_3846.t2 9.30303
R337 a_4102_3846.n1 a_4102_3846.t4 30.4947
R338 a_4102_3846.n0 a_4102_3846.t3 30.4947
R339 a_3290_3846.t1 a_3290_3846.n0 8.97568
R340 a_3290_3846.n0 a_3290_3846.t2 11.8396
R341 a_3290_3846.n0 a_3290_3846.t0 9.62349
R342 a_2478_3846.t1 a_2478_3846.n1 9.23394
R343 a_2478_3846.n1 a_2478_3846.n0 2.63943
R344 a_2478_3846.n0 a_2478_3846.t2 9.42037
R345 a_2478_3846.n0 a_2478_3846.t3 16.3347
R346 a_2478_3846.n1 a_2478_3846.t0 11.8467
R347 a_1366_3846.t0 a_1366_3846.t1 0.3505
R348 a_554_3846.t0 a_554_3846.n0 8.13374
R349 a_554_3846.n0 a_554_3846.n1 0.730143
R350 a_554_3846.n1 a_554_3846.t3 8.61589
R351 a_554_3846.n1 a_554_3846.t2 6.86088
R352 a_554_3846.n0 a_554_3846.t1 6.86088
R353 a_254_3846.t0 a_254_3846.t1 0.3505
R354 a_7150_3730.t2 a_7150_3730.n2 8.61959
R355 a_7150_3730.n2 a_7150_3730.n1 2.32282
R356 a_7150_3730.n1 a_7150_3730.t1 8.39165
R357 a_7150_3730.n1 a_7150_3730.t0 49.7778
R358 a_7150_3730.n2 a_7150_3730.n0 0.706036
R359 a_7150_3730.n0 a_7150_3730.t4 32.8006
R360 a_7150_3730.n0 a_7150_3730.t3 31.5278
R361 a_8774_3730.t0 a_8774_3730.n0 8.36531
R362 a_8774_3730.n0 a_8774_3730.t2 49.9829
R363 a_8774_3730.n0 a_8774_3730.t1 7.63567
R364 a_354_3730.t1 a_354_3730.n13 12.7789
R365 a_354_3730.n13 a_354_3730.t7 51.1649
R366 a_354_3730.n13 a_354_3730.n0 0.239964
R367 a_354_3730.n2 a_354_3730.n1 4.5005
R368 a_354_3730.n0 a_354_3730.n2 0.46175
R369 a_354_3730.n2 a_354_3730.n3 0.346036
R370 a_354_3730.n3 a_354_3730.n4 0.755857
R371 a_354_3730.n4 a_354_3730.n5 0.397464
R372 a_354_3730.n5 a_354_3730.n6 0.1805
R373 a_354_3730.n6 a_354_3730.n7 1.63175
R374 a_354_3730.n7 a_354_3730.n8 1.7555
R375 a_354_3730.n8 a_354_3730.n9 3.0605
R376 a_354_3730.n9 a_354_3730.n10 6.9755
R377 a_354_3730.n10 a_354_3730.n11 1.27336
R378 a_354_3730.n11 a_354_3730.n12 3.88336
R379 a_354_3730.n12 a_354_3730.t15 52.3076
R380 a_354_3730.n12 a_354_3730.t14 50.5526
R381 a_354_3730.n11 a_354_3730.t13 32.3026
R382 a_354_3730.n10 a_354_3730.t12 32.3026
R383 a_354_3730.n9 a_354_3730.t11 50.5526
R384 a_354_3730.n8 a_354_3730.t10 50.5526
R385 a_354_3730.n7 a_354_3730.t9 50.5526
R386 a_354_3730.n6 a_354_3730.t8 50.6326
R387 a_354_3730.n5 a_354_3730.t6 18.2347
R388 a_354_3730.n4 a_354_3730.t5 18.2347
R389 a_354_3730.n3 a_354_3730.t2 21.3526
R390 a_354_3730.n1 a_354_3730.t4 13.8346
R391 a_354_3730.n1 a_354_3730.t3 5.32735
R392 a_354_3730.n0 a_354_3730.t0 18.2347
R393 a_54_3730.t1 a_54_3730.n5 13.2954
R394 a_54_3730.n5 a_54_3730.n4 1.78925
R395 a_54_3730.n4 a_54_3730.t0 9.13206
R396 a_54_3730.n4 a_54_3730.t2 50.036
R397 a_54_3730.n5 a_54_3730.n0 1.23961
R398 a_54_3730.n0 a_54_3730.n1 1.7555
R399 a_54_3730.n1 a_54_3730.n2 1.7555
R400 a_54_3730.n2 a_54_3730.n3 15.2876
R401 a_54_3730.n3 a_54_3730.t7 51.791
R402 a_54_3730.n3 a_54_3730.t6 50.036
R403 a_54_3730.n2 a_54_3730.t5 50.036
R404 a_54_3730.n1 a_54_3730.t4 50.036
R405 a_54_3730.n0 a_54_3730.t3 50.036
R406 VDD VDD 1935.38
R407 VDD VDD 148.067
R408 VDD VDD 109.409
R409 VDD VDD 296.135
R410 VDD VDD 109.409
R411 VDD VDD 296.135
R412 VDD VDD 296.135
R413 VDD VDD 296.135
R414 VDD VDD 296.135
R415 VDD VDD 296.135
R416 VDD VDD 296.135
R417 VDD VDD 296.135
R418 VDD VDD 296.135
R419 VDD VDD 296.135
R420 VDD VDD 109.409
R421 VDD VDD 296.135
R422 VDD VDD 296.135
R423 VDD VDD 109.409
R424 VDD VDD 296.135
R425 VDD VDD 109.409
R426 VDD VDD 296.135
R427 VDD VDD 109.409
R428 VDD VDD 296.135
R429 VDD VDD 296.135
R430 VDD VDD 109.409
R431 VSS VSS 335.07
R432 VSS VSS 274.649
R433 VSS VSS 670.141
R434 VSS VSS 274.649
R435 VSS VSS 670.141
R436 VSS VSS 670.141
R437 VSS VSS 686.62
R438 VSS VSS 670.141
R439 VSS VSS 670.141
R440 VSS VSS 670.141
R441 VSS VSS 670.141
R442 VSS VSS 670.141
R443 VSS VSS 670.141
R444 VSS VSS 274.649
R445 VSS VSS 670.141
R446 VSS VSS 670.141
R447 VSS VSS 274.649
R448 VSS VSS 670.141
R449 VSS VSS 670.141
R450 VSS VSS 670.141
R451 VSS VSS 274.649
R452 VSS VSS 670.141
R453 VSS VSS 274.649
R454 VSS VSS 670.141
R455 VSS VSS 274.649
C0 VSS INN 0.08091f
C1 VSS OUT 0.10019f
C2 VDD INN 0.08849f
C3 VSS VDD 0.10916f
C4 OUT VDD 5.1123f
C5 INP INN 0.08821f
C6 VSS INP 0.08215f
C7 VDD INP 0.08998f
C8 VSS 0 15.52188f
C9 OUT 0 5.12713f
C10 VDD 0 10.48926f
C11 INN 0 2.41646f
C12 INP 0 2.35149f
C13 VDD 0 0.34356f
C14 VDD 0 0.59742f
C15 VDD 0 0.94097f
C16 VDD 0 0.94097f
C17 VDD 0 0.94097f
C18 VDD 0 1.37423f
C19 VDD 0 1.37423f
C20 VDD 0 1.37423f
C21 VDD 0 1.37423f
C22 VDD 0 1.37423f
C23 VDD 0 1.37423f
C24 VDD 0 1.37423f
C25 VDD 0 1.37423f
C26 VDD 0 0.94097f
C27 VDD 0 0.94097f
C28 VDD 0 1.37423f
C29 VDD 0 0.94097f
C30 VDD 0 0.94097f
C31 VDD 0 0.94097f
C32 VDD 0 0.94097f
C33 VDD 0 0.94097f
C34 VDD 0 0.94097f
C35 VDD 0 1.37423f
C36 VDD 0 0.94097f
C37 VDD 0 0.94097f
C38 VDD 0 1.82945f
C39 VDD 0 7.25062f
C40 a_54_3730.t1 0 0.27711f
C41 a_54_3730.t3 0 1.55981f
C42 a_54_3730.n0 0 0.91723f
C43 a_54_3730.t4 0 1.55981f
C44 a_54_3730.n1 0 0.9574f
C45 a_54_3730.t5 0 1.55981f
C46 a_54_3730.n2 0 2.01129f
C47 a_54_3730.t6 0 1.55981f
C48 a_54_3730.n3 0 2.81097f
C49 a_54_3730.t7 0 1.58786f
C50 a_54_3730.t2 0 1.55981f
C51 a_54_3730.n4 0 1.09362f
C52 a_54_3730.t0 0 1.57864f
C53 a_54_3730.n5 0 0.47679f
C54 a_354_3730.t1 0 0.25587f
C55 a_354_3730.t0 0 0.43157f
C56 a_354_3730.n0 0 0.38507f
C57 a_354_3730.t3 0 0.3041f
C58 a_354_3730.t4 0 0.32912f
C59 a_354_3730.n1 0 0.74792f
C60 a_354_3730.n2 0 0.07624f
C61 a_354_3730.t2 0 0.53631f
C62 a_354_3730.n3 0 0.4377f
C63 a_354_3730.t5 0 0.43157f
C64 a_354_3730.n4 0 0.421f
C65 a_354_3730.t6 0 0.43157f
C66 a_354_3730.n5 0 0.37522f
C67 a_354_3730.t8 0 1.6062f
C68 a_354_3730.n6 0 0.88564f
C69 a_354_3730.t9 0 1.60554f
C70 a_354_3730.n7 0 1.0116f
C71 a_354_3730.t10 0 1.60554f
C72 a_354_3730.n8 0 1.12528f
C73 a_354_3730.t11 0 1.60554f
C74 a_354_3730.n9 0 1.54058f
C75 a_354_3730.t12 0 0.9316f
C76 a_354_3730.n10 0 1.15901f
C77 a_354_3730.t13 0 0.9316f
C78 a_354_3730.n11 0 0.913f
C79 a_354_3730.t14 0 1.60554f
C80 a_354_3730.n12 0 2.0499f
C81 a_354_3730.t15 0 1.63537f
C82 a_354_3730.t7 0 1.6151f
C83 a_354_3730.n13 0 1.07423f
C84 a_8774_3730.t0 0 1.18929f
C85 a_8774_3730.t1 0 1.17497f
C86 a_8774_3730.n0 0 0.87899f
C87 a_8774_3730.t2 0 1.21447f
C88 a_7150_3730.t2 0 0.66133f
C89 a_7150_3730.t3 0 1.01501f
C90 a_7150_3730.n0 0 1.26024f
C91 a_7150_3730.t4 0 1.03887f
C92 a_7150_3730.t0 0 1.77253f
C93 a_7150_3730.n1 0 1.1904f
C94 a_7150_3730.t1 0 1.76402f
C95 a_7150_3730.n2 0 0.41308f
C96 a_254_3846.t0 0 0.06442f
C97 a_254_3846.t1 0 0.06442f
C98 a_554_3846.t0 0 1.20032f
C99 a_554_3846.t1 0 1.17069f
C100 a_554_3846.n0 0 0.38959f
C101 a_554_3846.t2 0 1.17069f
C102 a_554_3846.n1 0 0.43549f
C103 a_554_3846.t3 0 1.21548f
C104 a_1366_3846.t0 0 0.06415f
C105 a_1366_3846.t1 0 0.06415f
C106 a_2478_3846.t1 0 0.0617f
C107 a_2478_3846.t0 0 0.28896f
C108 a_2478_3846.n0 0 0.15043f
C109 a_2478_3846.t3 0 12.8003f
C110 a_2478_3846.t2 0 0.06221f
C111 a_2478_3846.n1 0 0.14602f
C112 a_3290_3846.t1 0 0.56067f
C113 a_3290_3846.t0 0 2.63576f
C114 a_3290_3846.t2 0 0.69755f
C115 a_3290_3846.n0 0 1.36249f
C116 a_4102_3846.t1 0 0.62158f
C117 a_4102_3846.t3 0 1.09332f
C118 a_4102_3846.n0 0 0.61984f
C119 a_4102_3846.t4 0 1.09332f
C120 a_4102_3846.n1 0 1.08525f
C121 a_4102_3846.t2 0 1.04898f
C122 a_4102_3846.t0 0 0.96803f
C123 a_4102_3846.n2 0 0.56643f
C124 a_3010_446.t0 0 1.10667f
C125 a_3010_446.t2 0 1.29878f
C126 a_3010_446.n0 0 1.57822f
C127 a_3010_446.t1 0 1.48527f
C128 a_2278_446.t0 0 0.59538f
C129 a_2278_446.n0 0 0.35087f
C130 a_2278_446.t3 0 8.02125f
C131 a_2278_446.t2 0 0.59269f
C132 a_2278_446.n1 0 0.67436f
C133 a_2278_446.t1 0 0.50213f
C134 a_4914_3846.t1 0 0.75811f
C135 a_4914_3846.t2 0 1.65039f
C136 a_4914_3846.t0 0 1.3881f
C137 a_4914_3846.n0 0 2.85926f
C138 a_4914_3846.t3 0 11.8604f
C139 a_4914_3846.n1 0 1.44657f
C140 a_3760_446.t1 0 0.75821f
C141 a_3760_446.t3 0 1.04492f
C142 a_3760_446.n0 0 1.00891f
C143 a_3760_446.t4 0 1.04492f
C144 a_3760_446.n1 0 1.66949f
C145 a_3760_446.t2 0 0.855f
C146 a_3760_446.t0 0 1.38254f
C147 a_3760_446.n2 0 0.99514f
C148 a_4492_446.t1 0 0.86301f
C149 a_4492_446.t2 0 1.17597f
C150 a_4492_446.t0 0 1.89034f
C151 a_4492_446.n0 0 2.53299f
C152 a_4492_446.t3 0 1.21166f
C153 a_4492_446.n1 0 2.06389f
C154 a_8974_3846.t0 0 0.07965f
C155 a_8974_3846.t1 0 0.07965f
C156 a_10898_3846.t0 0 0.06925f
C157 a_10898_3846.t1 0 0.06925f
C158 a_6488_330.t2 0 0.65339f
C159 a_6488_330.t1 0 1.15603f
C160 a_6488_330.n0 0 0.81087f
C161 a_6488_330.t3 0 0.75666f
C162 a_6488_330.n1 0 1.38367f
C163 a_6488_330.t4 0 0.78387f
C164 a_6488_330.t0 0 2.32897f
C165 a_6488_330.n2 0 0.92077f
C166 a_12010_3846.t0 0 0.0679f
C167 a_12010_3846.t1 0 0.0679f
C168 a_314_330.t2 0 0.26827f
C169 a_314_330.t1 0 0.49708f
C170 a_314_330.n0 0 0.60202f
C171 a_314_330.t4 0 1.09809f
C172 a_314_330.n1 0 0.9569f
C173 a_314_330.t5 0 1.09809f
C174 a_314_330.n2 0 1.35488f
C175 a_314_330.t6 0 0.71322f
C176 a_314_330.n3 0 1.13672f
C177 a_314_330.t7 0 0.71322f
C178 a_314_330.n4 0 0.85832f
C179 a_314_330.t8 0 1.09809f
C180 a_314_330.n5 0 1.54731f
C181 a_314_330.t9 0 1.12943f
C182 a_314_330.t0 0 2.10334f
C183 a_314_330.n6 0 0.89002f
C184 a_314_330.t3 0 1.10355f
C185 a_314_330.n7 0 0.33986f
C186 a_13122_3846.t0 0 0.077f
C187 a_13122_3846.t1 0 0.077f
C188 a_14_330.t0 0 0.48907f
C189 a_14_330.t2 0 0.92273f
C190 a_14_330.n0 0 0.99101f
C191 a_14_330.t3 0 0.92273f
C192 a_14_330.n1 0 1.86022f
C193 a_14_330.t4 0 0.92273f
C194 a_14_330.n2 0 1.90075f
C195 a_14_330.t5 0 0.94836f
C196 a_14_330.t1 0 1.83439f
C197 a_14_330.n3 0 0.52951f
C198 a_15046_3846.t0 0 0.07909f
C199 a_15046_3846.t1 0 0.07909f
C200 a_8896_446.t0 0 0.65221f
C201 a_8896_446.t2 0 1.09307f
C202 a_8896_446.n0 0 1.08668f
C203 a_8896_446.t1 0 0.67614f
C204 a_214_446.t0 0 0.03849f
C205 a_214_446.t1 0 0.03849f
C206 a_514_446.t0 0 0.77875f
C207 a_514_446.t3 0 0.74288f
C208 a_514_446.n0 0 0.55544f
C209 a_514_446.t1 0 0.74288f
C210 a_514_446.n1 0 0.64636f
C211 a_514_446.t2 0 0.80143f
C212 a_1246_446.t0 0 0.03701f
C213 a_1246_446.t1 0 0.03701f
C214 a_8152_446.t0 0 0.04038f
C215 a_8152_446.t1 0 0.04038f
C216 a_9916_446.t0 0 0.04139f
C217 a_9916_446.t1 0 0.04139f
C218 a_12412_446.t0 0 0.03937f
C219 a_12412_446.t1 0 0.03937f
C220 INP.t1 0 1.40378f
C221 INP.t0 0 0.94589f
C222 INN.t1 0 1.43529f
C223 INN.t0 0 1.01738f
C224 VDD.t6 0 0.5004f
C225 VDD.n0 0 0.18581f
C226 VDD.n1 0 0.24824f
C227 VDD.n2 0 0.25058f
C228 VDD.n3 0 0.24946f
C229 VDD.n4 0 0.25058f
C230 VDD.t3 0 0.5004f
C231 VDD.n5 0 0.19419f
C232 VDD.n6 0 0.25058f
C233 VDD.t7 0 0.5004f
C234 VDD.n7 0 0.26678f
C235 VDD.n8 0 0.25058f
C236 VDD.t10 0 0.19222f
C237 VDD.n9 0 0.33505f
C238 VDD.n10 0 1.3583f
C239 VDD.t4 0 0.5004f
C240 VDD.t5 0 0.41319f
C241 VDD.n11 0 0.70635f
C242 VDD.n12 0 0.55695f
C243 VDD.n13 0 0.15131f
C244 VDD.n14 0 0.23348f
C245 VDD.n15 0 0.25058f
C246 VDD.n16 0 0.25058f
C247 VDD.n17 0 0.14423f
C248 VDD.n18 0 0.24767f
C249 VDD.n19 0 0.20709f
C250 VDD.n20 0 0.25058f
C251 VDD.n21 0 0.25058f
C252 VDD.n22 0 0.17411f
C253 VDD.n23 0 0.25058f
C254 VDD.t0 0 0.5004f
C255 VDD.n24 0 0.26678f
C256 VDD.n25 0 0.1807f
C257 VDD.n26 0 0.25058f
C258 VDD.n27 0 0.25058f
C259 VDD.n28 0 0.25058f
C260 VDD.n29 0 0.25048f
C261 VDD.n30 0 0.15431f
C262 VDD.n31 0 0.26678f
C263 VDD.n32 0 0.22689f
C264 VDD.n33 0 0.25058f
C265 VDD.n34 0 0.25058f
C266 VDD.n35 0 0.25058f
C267 VDD.n36 0 0.2453f
C268 VDD.n37 0 0.25058f
C269 VDD.n38 0 0.13152f
C270 VDD.n39 0 0.25058f
C271 VDD.n40 0 0.25058f
C272 VDD.n41 0 0.14232f
C273 VDD.n42 0 0.25058f
C274 VDD.t2 0 0.3334f
C275 VDD.n43 0 0.28168f
C276 VDD.t1 0 0.3334f
C277 VDD.n44 0 0.24901f
C278 VDD.n45 0 0.25058f
C279 VDD.n46 0 0.24939f
C280 VDD.n47 0 0.25058f
C281 VDD.n48 0 0.25058f
C282 VDD.t9 0 0.53659f
C283 VDD.n49 0 0.71982f
C284 VDD.t8 0 0.5004f
C285 VDD.n50 0 0.41246f
C286 VDD.n51 0 0.13392f
C287 VDD.n52 0 0.91031f
C288 VDD.n53 0 0.25058f
C289 VDD.n54 0 0.25058f
C290 VDD.n55 0 0.25058f
C291 VDD.n56 0 0.25058f
C292 VDD.n57 0 0.24536f
C293 VDD.n58 0 0.25058f
C294 VDD.n59 0 0.25058f
C295 VDD.n60 0 0.25058f
C296 VDD.n61 0 0.25058f
C297 VDD.n62 0 0.25058f
C298 VDD.n63 0 0.24575f
C299 VDD.n64 0 0.25058f
C300 VDD.n65 0 0.25058f
C301 VDD.n66 0 0.25058f
C302 VDD.n67 0 0.23528f
C303 VDD.n68 0 0.28384f
C304 VDD.n69 0 0.14591f
C305 VDD.n70 0 0.23465f
C306 VDD.n71 0 0.25058f
C307 VDD.n72 0 0.25058f
C308 VDD.n73 0 0.25058f
C309 VDD.n74 0 0.25058f
C310 VDD.n75 0 0.25058f
C311 VDD.n76 0 0.24651f
C312 VDD.n77 0 0.25058f
C313 VDD.n78 0 0.25058f
C314 VDD.n79 0 0.25058f
C315 VDD.n80 0 0.21159f
C316 OUT.t1 0 0.05968f
C317 OUT.t2 0 0.06f
C318 OUT.t3 0 18.0118f
C319 OUT.n0 0 0.43632f
C320 OUT.t0 0 2.7283f
C321 OUT.n1 0 0.33416f
C322 VSS.n0 0 0.04267f
C323 VSS.n1 0 0.03475f
C324 VSS.n2 0 0.06304f
C325 VSS.t3 0 0.09576f
C326 VSS.n3 0 0.06085f
C327 VSS.n4 0 0.06304f
C328 VSS.t6 0 0.01351f
C329 VSS.n5 0 0.05059f
C330 VSS.n6 0 0.06304f
C331 VSS.t2 0 0.01351f
C332 VSS.n7 0 0.10211f
C333 VSS.t8 0 0.02316f
C334 VSS.n8 0 0.76021f
C335 VSS.n9 0 0.54649f
C336 VSS.n10 0 0.03791f
C337 VSS.n11 0 0.06304f
C338 VSS.t10 0 0.09576f
C339 VSS.n12 0 0.08131f
C340 VSS.n13 0 0.04531f
C341 VSS.n14 0 0.06304f
C342 VSS.n15 0 0.06304f
C343 VSS.n16 0 0.06304f
C344 VSS.n17 0 0.04018f
C345 VSS.n18 0 0.05425f
C346 VSS.n19 0 0.05572f
C347 VSS.t5 0 0.01351f
C348 VSS.n20 0 0.05425f
C349 VSS.n21 0 0.03505f
C350 VSS.n22 0 0.06304f
C351 VSS.n23 0 0.06304f
C352 VSS.n24 0 0.06304f
C353 VSS.n25 0 0.05255f
C354 VSS.n26 0 0.08131f
C355 VSS.n27 0 0.04335f
C356 VSS.n28 0 0.06304f
C357 VSS.n29 0 0.06304f
C358 VSS.n30 0 0.06304f
C359 VSS.n31 0 0.06304f
C360 VSS.t4 0 0.09576f
C361 VSS.n32 0 0.08131f
C362 VSS.n33 0 0.06304f
C363 VSS.n34 0 0.06304f
C364 VSS.t0 0 0.04008f
C365 VSS.t9 0 0.04008f
C366 VSS.n35 0 0.06867f
C367 VSS.n36 0 0.06304f
C368 VSS.n37 0 0.06304f
C369 VSS.n38 0 0.06304f
C370 VSS.n39 0 0.06304f
C371 VSS.n40 0 0.22891f
C372 VSS.t1 0 0.09576f
C373 VSS.t7 0 0.10659f
C374 VSS.n41 0 0.18116f
C375 VSS.n42 0 0.12299f
C376 VSS.n43 0 0.04274f
C377 VSS.n44 0 0.06304f
C378 VSS.n45 0 0.06304f
C379 VSS.n46 0 0.06304f
C380 VSS.n47 0 0.06304f
C381 VSS.n48 0 0.06304f
C382 VSS.n49 0 0.06304f
C383 VSS.n50 0 0.06304f
C384 VSS.n51 0 0.06304f
C385 VSS.n52 0 0.06304f
C386 VSS.n53 0 0.06304f
C387 VSS.n54 0 0.06304f
C388 VSS.n55 0 0.06304f
C389 VSS.n56 0 0.05149f
C390 VSS.n57 0 0.06304f
C391 VSS.n58 0 0.06304f
C392 VSS.n59 0 0.0444f
C393 VSS.n60 0 0.04636f
C394 VSS.n61 0 0.06867f
C395 VSS.n62 0 0.04953f
C396 VSS.n63 0 0.06304f
C397 VSS.n64 0 0.06304f
C398 VSS.n65 0 0.06304f
C399 VSS.n66 0 0.06304f
C400 VSS.n67 0 0.06304f
C401 VSS.n68 0 0.06115f
C402 VSS.n69 0 0.06304f
C403 VSS.n70 0 0.06304f
C404 VSS.n71 0 0.06304f
C405 VSS.n72 0 0.05323f
.ends
