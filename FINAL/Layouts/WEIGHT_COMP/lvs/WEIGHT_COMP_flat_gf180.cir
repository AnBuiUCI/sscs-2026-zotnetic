* Extracted by KLayout with GF180MCU LVS runset on : 18/08/2026 18:02

.SUBCKT WEIGHT_COMP VC OUT WE OUT_N VD VA VB VDD VSS
M$1 \$63 WE VSS VSS nfet_06v0 L=1U W=2U AS=0.88P AD=0.5P PS=4.88U PD=2.5U
M$2 \$64 WE \$63 VSS nfet_06v0 L=1U W=2U AS=0.5P AD=0.88P PS=2.5U PD=4.88U
M$3 \$25 \$9 VSS VSS nfet_06v0 L=1U W=0.7U AS=0.308P AD=0.175P PS=2.28U PD=1.2U
M$4 \$30 \$9 \$25 VSS nfet_06v0 L=1U W=0.7U AS=0.175P AD=0.175P PS=1.2U PD=1.2U
M$5 \$28 \$9 \$30 VSS nfet_06v0 L=1U W=0.7U AS=0.175P AD=0.175P PS=1.2U PD=1.2U
M$6 \$9 \$9 \$28 VSS nfet_06v0 L=1U W=0.7U AS=0.175P AD=0.308P PS=1.2U PD=2.28U
M$7 OUT_N OUT VSS VSS nfet_05v0 L=0.6U W=1.32U AS=0.5808P AD=0.5808P PS=3.52U
+ PD=3.52U
M$8 OUT \$3 VSS VSS nfet_05v0 L=0.6U W=1.32U AS=0.5808P AD=0.5808P PS=3.52U
+ PD=3.52U
M$9 \$3 WE VSS VSS nfet_05v0 L=0.6U W=1.32U AS=0.5808P AD=0.5808P PS=3.52U
+ PD=3.52U
M$10 \$5 \$9 VSS VSS nfet_06v0 L=1U W=1.24U AS=0.5456P AD=0.5456P PS=3.36U
+ PD=3.36U
M$11 \$4 \$9 VSS VSS nfet_06v0 L=1U W=1.24U AS=0.5456P AD=0.5456P PS=3.36U
+ PD=3.36U
M$12 WE VC \$4 VSS nfet_06v0 L=1U W=2.48U AS=1.0912P AD=0.6448P PS=5.84U PD=3U
M$13 \$4 VC WE VSS nfet_06v0 L=1U W=2.48U AS=0.6448P AD=1.0912P PS=3U PD=5.84U
M$14 WE WE VDD VDD pfet_06v0 L=1U W=2U AS=0.88P AD=0.52P PS=4.88U PD=2.52U
M$15 VDD WE WE VDD pfet_06v0 L=1U W=2U AS=0.52P AD=0.52P PS=2.52U PD=2.52U
M$16 WE WE VDD VDD pfet_06v0 L=1U W=2U AS=0.52P AD=0.52P PS=2.52U PD=2.52U
M$17 VDD WE WE VDD pfet_06v0 L=1U W=2U AS=0.52P AD=0.52P PS=2.52U PD=2.52U
M$18 WE WE VDD VDD pfet_06v0 L=1U W=2U AS=0.52P AD=0.52P PS=2.52U PD=2.52U
M$19 VDD WE WE VDD pfet_06v0 L=1U W=2U AS=0.52P AD=0.88P PS=2.52U PD=4.88U
M$20 \$9 \$9 VDD VDD pfet_06v0 L=1U W=2U AS=0.88P AD=0.88P PS=4.88U PD=4.88U
M$21 OUT_N OUT VDD VDD pfet_05v0 L=0.5U W=1.83U AS=0.8052P AD=0.8052P PS=4.54U
+ PD=4.54U
M$22 OUT \$3 VDD VDD pfet_05v0 L=0.5U W=1.83U AS=0.8052P AD=0.8052P PS=4.54U
+ PD=4.54U
M$23 \$3 WE VDD VDD pfet_05v0 L=0.5U W=1.83U AS=0.8052P AD=0.8052P PS=4.54U
+ PD=4.54U
M$24 \$54 \$9 VSS VSS nfet_06v0 L=1U W=1.24U AS=0.5456P AD=0.5456P PS=3.36U
+ PD=3.36U
M$25 WE VA \$54 VSS nfet_06v0 L=1U W=2.48U AS=1.0912P AD=0.6448P PS=5.84U PD=3U
M$26 \$54 VA WE VSS nfet_06v0 L=1U W=2.48U AS=0.6448P AD=1.0912P PS=3U PD=5.84U
M$27 WE WE \$64 VSS nfet_06v0 L=1U W=2U AS=0.88P AD=0.52P PS=4.88U PD=2.52U
M$28 \$64 WE WE VSS nfet_06v0 L=1U W=2U AS=0.52P AD=0.88P PS=2.52U PD=4.88U
M$29 \$74 \$9 VSS VSS nfet_06v0 L=1U W=1.24U AS=0.5456P AD=0.5456P PS=3.36U
+ PD=3.36U
M$30 WE VB \$74 VSS nfet_06v0 L=1U W=2.48U AS=1.0912P AD=0.6448P PS=5.84U PD=3U
M$31 \$74 VB WE VSS nfet_06v0 L=1U W=2.48U AS=0.6448P AD=1.0912P PS=3U PD=5.84U
M$32 WE VD \$5 VSS nfet_06v0 L=1U W=2.48U AS=1.0912P AD=0.6448P PS=5.84U PD=3U
M$33 \$5 VD WE VSS nfet_06v0 L=1U W=2.48U AS=0.6448P AD=1.0912P PS=3U PD=5.84U
.ENDS WEIGHT_COMP
