* fuente: /foss/designs/a_zonetic2026/XSCHEM/WEIGTH/simulation/WEIGHT_COMP.sch/WEIGHT_COMP.spice
* leida via enlace: /foss/designs/a_zonetic2026/spice_blocks/WEIGHT_COMP.spice
* fecha de la fuente: 2026-08-04 03:13   sha1: 29e1d42ebc
* generado por flatten_spice.py — NO editar a mano
* netlist plana generada por flatten_spice.py (top: WEIGHT_COMP)
* 23 MOSFETs; nets fusionadas por V=0: x1_net11->VSS, x1_net12->VSS, x1_net10->VSS, x1_net13->VSS
* nombres: los del esquematico; solo llevan la ruta de instancias (Mx1_M4) los 8 que chocaban
* m -> fingers: Mx1_M2: m=6 nf=1 -> nf=6; M3: m=2 nf=1 -> nf=2; M5: m=2 nf=1 -> nf=2; Mx1_M1: m=2 nf=1 -> nf=2; M9: m=2 nf=1 -> nf=2; M11: m=2 nf=1 -> nf=2
* para generar el layout: nf = numero de dedos
.subckt WEIGHT_COMP VDD VSS VA VB VC VD WE OUT OUT_N
Mx1_M2 WE WE VDD VDD pfet_06v0 L=1u W=2u nf=6
M3 WE VD x1_net1 VSS nfet_06v0 L=1u W=2.48u nf=2
M5 WE VB x1_net2 VSS nfet_06v0 L=1u W=2.48u nf=2
M6 x1_net2 x1_IN VSS VSS nfet_06v0 L=1u W=1.24u nf=1
Mx1_M1 WE WE x1_net3 VSS nfet_06v0 L=1u W=2u nf=2
M7 x1_net3 WE x1_net4 VSS nfet_06v0 L=1u W=2u nf=1
M8 x1_net4 WE VSS VSS nfet_06v0 L=1u W=2u nf=1
M9 WE VA x1_net5 VSS nfet_06v0 L=1u W=2.48u nf=2
M10 x1_net5 x1_IN VSS VSS nfet_06v0 L=1u W=1.24u nf=1
M11 WE VC x1_net6 VSS nfet_06v0 L=1u W=2.48u nf=2
M12 x1_net6 x1_IN VSS VSS nfet_06v0 L=1u W=1.24u nf=1
M4 x1_net1 x1_IN VSS VSS nfet_06v0 L=1u W=1.24u nf=1
M13 x1_IN x1_IN VDD VDD pfet_06v0 L=1u W=2u nf=1
M14 x1_net8 x1_IN x1_net9 VSS nfet_06v0 L=1u W=0.7u nf=1
M15 x1_net7 x1_IN x1_net8 VSS nfet_06v0 L=1u W=0.7u nf=1
M16 x1_IN x1_IN x1_net7 VSS nfet_06v0 L=1u W=0.7u nf=1
M17 x1_net9 x1_IN VSS VSS nfet_06v0 L=1u W=0.7u nf=1
Mx2_x1_M1 x2_net1 WE VDD VDD pfet_05v0 L=0.5u W=1.83u nf=1
Mx2_x1_M2 x2_net1 WE VSS VSS nfet_05v0 L=0.6u W=1.32u nf=1
Mx2_x2_M1 OUT x2_net1 VDD VDD pfet_05v0 L=0.5u W=1.83u nf=1
Mx2_x2_M2 OUT x2_net1 VSS VSS nfet_05v0 L=0.6u W=1.32u nf=1
Mx2_x3_M1 OUT_N OUT VDD VDD pfet_05v0 L=0.5u W=1.83u nf=1
Mx2_x3_M2 OUT_N OUT VSS VSS nfet_05v0 L=0.6u W=1.32u nf=1
.ends
