* Nodos de bulk atados: 11 de pozo n -> VDD, 23 de sustrato -> VSS.
*   magic no extrae los taps de este layout y los dejaba flotando;
*   la conexion si existe (el LVS de KLayout da 'match uniquely').
*   Quien detecta un tap que falte de verdad es el LVS, no esto.
* NGSPICE file created from WEIGHT_COMP.ext - technology: gf180mcuD

.subckt WEIGHT_COMP VSS VDD WE OUT OUT_N VA VB VC VD
X0 a_3260_3312.t0 WE.t27 VDD.t6 VDD pfet_05v0 ad=0.8052p pd=4.54u as=0.8052p ps=4.54u w=1.83u l=0.5u
X1 OUT.t1 a_3260_3312.t2 VSS.t7 VSS nfet_05v0 ad=0.5808p pd=3.52u as=0.5808p ps=3.52u w=1.32u l=0.6u
X2 a_2882_1208.t2 WE.t25 a_4282_1208.t0 VSS nfet_06v0 ad=0.88p pd=4.88u as=0.5p ps=2.5u w=2u l=1u
X3 WE.t21 VA.t1 a_5026_1208.t1 VSS nfet_06v0 ad=0.6448p pd=3u as=1.0912p ps=5.84u w=2.48u l=1u
X4 a_1038_1208.t2 VB.t0 WE.t22 VSS nfet_06v0 ad=1.0912p pd=5.84u as=0.6448p ps=3u w=2.48u l=1u
X5 a_2882_1208.t1 WE.t0 WE.t1 VSS nfet_06v0 ad=0.88p pd=4.88u as=0.52p ps=2.52u w=2u l=1u
X6 a_1376_n116.t1 a_1376_n116.t0 VDD.t3 VDD pfet_06v0 ad=0.88p pd=4.88u as=0.88p ps=4.88u w=2u l=1u
X7 a_3040_0.t1 a_1376_n116.t6 VSS.t6 VSS nfet_06v0 ad=0.175p pd=1.2u as=0.308p ps=2.28u w=0.7u l=1u
X8 a_3260_3312.t1 WE.t24 VSS.t8 VSS nfet_05v0 ad=0.5808p pd=3.52u as=0.5808p ps=3.52u w=1.32u l=0.6u
X9 a_3640_0.t0 a_1376_n116.t4 a_3340_0.t0 VSS nfet_06v0 ad=0.175p pd=1.2u as=0.175p ps=1.2u w=0.7u l=1u
X10 OUT_N.t0 OUT.t2 VSS.t2 VSS nfet_05v0 ad=0.5808p pd=3.52u as=0.5808p ps=3.52u w=1.32u l=0.6u
X11 OUT_N.t1 OUT.t3 VDD.t2 VDD pfet_05v0 ad=0.8052p pd=4.54u as=0.8052p ps=4.54u w=1.83u l=0.5u
X12 a_5026_1208.t2 VA.t0 WE.t20 VSS nfet_06v0 ad=1.0912p pd=5.84u as=0.6448p ps=3u w=2.48u l=1u
X13 a_n74_1208.t1 VD.t0 WE.t17 VSS nfet_06v0 ad=1.0912p pd=5.84u as=0.6448p ps=3u w=2.48u l=1u
X14 VDD.t8 WE.t4 WE.t5 VDD pfet_06v0 ad=0.52p pd=2.52u as=0.52p ps=2.52u w=2u l=1u
X15 WE.t11 WE.t10 VDD.t0 VDD pfet_06v0 ad=0.52p pd=2.52u as=0.52p ps=2.52u w=2u l=1u
X16 a_1038_1208.t0 a_1376_n116.t10 VSS.t4 VSS nfet_06v0 ad=0.5456p pd=3.36u as=0.5456p ps=3.36u w=1.24u l=1u
X17 OUT.t0 a_3260_3312.t3 VDD.t1 VDD pfet_05v0 ad=0.8052p pd=4.54u as=0.8052p ps=4.54u w=1.83u l=0.5u
X18 WE.t3 WE.t2 VDD.t5 VDD pfet_06v0 ad=0.52p pd=2.52u as=0.88p ps=4.88u w=2u l=1u
X19 WE.t23 VB.t1 a_1038_1208.t1 VSS nfet_06v0 ad=0.6448p pd=3u as=1.0912p ps=5.84u w=2.48u l=1u
X20 VDD.t9 WE.t12 WE.t13 VDD pfet_06v0 ad=0.88p pd=4.88u as=0.52p ps=2.52u w=2u l=1u
X21 WE.t15 WE.t14 a_2882_1208.t0 VSS nfet_06v0 ad=0.52p pd=2.52u as=0.88p ps=4.88u w=2u l=1u
X22 WE.t7 WE.t6 VDD.t7 VDD pfet_06v0 ad=0.52p pd=2.52u as=0.52p ps=2.52u w=2u l=1u
X23 a_n74_0.t2 a_1376_n116.t8 VSS.t1 VSS nfet_06v0 ad=0.5456p pd=3.36u as=0.5456p ps=3.36u w=1.24u l=1u
X24 a_n74_1208.t2 a_1376_n116.t7 VSS.t0 VSS nfet_06v0 ad=0.5456p pd=3.36u as=0.5456p ps=3.36u w=1.24u l=1u
X25 a_3340_0.t1 a_1376_n116.t5 a_3040_0.t0 VSS nfet_06v0 ad=0.175p pd=1.2u as=0.175p ps=1.2u w=0.7u l=1u
X26 WE.t16 VD.t1 a_n74_1208.t0 VSS nfet_06v0 ad=0.6448p pd=3u as=1.0912p ps=5.84u w=2.48u l=1u
X27 a_n74_0.t1 VC.t0 WE.t19 VSS nfet_06v0 ad=1.0912p pd=5.84u as=0.6448p ps=3u w=2.48u l=1u
X28 a_4282_1208.t1 WE.t26 VSS.t5 VSS nfet_06v0 ad=0.5p pd=2.5u as=0.88p ps=4.88u w=2u l=1u
X29 a_1376_n116.t3 a_1376_n116.t2 a_3640_0.t1 VSS nfet_06v0 ad=0.308p pd=2.28u as=0.175p ps=1.2u w=0.7u l=1u
X30 VDD.t4 WE.t8 WE.t9 VDD pfet_06v0 ad=0.52p pd=2.52u as=0.52p ps=2.52u w=2u l=1u
X31 a_5026_1208.t0 a_1376_n116.t9 VSS.t3 VSS nfet_06v0 ad=0.5456p pd=3.36u as=0.5456p ps=3.36u w=1.24u l=1u
X32 WE.t18 VC.t1 a_n74_0.t0 VSS nfet_06v0 ad=0.6448p pd=3u as=1.0912p ps=5.84u w=2.48u l=1u
R0 VC VC.t0 17.3073
R1 VC VC.t1 15.9725
R2 VSS.n6 VSS.t6 9.93823
R3 VSS.n4 VSS.t1 5.9862
R4 VSS.n4 VSS.t0 5.6202
R5 VSS.n2 VSS.t8 5.51806
R6 VSS.n1 VSS.t7 5.51806
R7 VSS.n0 VSS.t2 5.51806
R8 VSS.n0 VSS.t3 5.36143
R9 VSS.n5 VSS.t4 5.13643
R10 VSS.n3 VSS.t5 3.1466
R11 VSS VSS.n6 0.351
R12 VSS.n1 VSS.n0 0.3265
R13 VSS.n2 VSS.n1 0.3265
R14 VSS.n6 VSS.n5 0.3015
R15 VSS VSS.n3 0.271
R16 VSS.n3 VSS.n2 0.1955
R17 VSS.n5 VSS.n4 0.0655
R18 VA VA.t1 17.1173
R19 VA VA.t0 16.1625
R20 VB VB.t1 17.1173
R21 VB VB.t0 16.1625
R22 VD VD.t1 17.1173
R23 VD VD.t0 16.1625
R24 OUT_N OUT_N.t0 5.32182
R25 OUT_N OUT_N.t1 3.71725
R26 OUT.n1 OUT.t3 32.5399
R27 OUT.n1 OUT.n0 27.1929
R28 OUT.n0 OUT.t2 26.4905
R29 OUT OUT.t1 5.83834
R30 OUT OUT.n1 5.42139
R31 OUT.n0 OUT 5.30889
R32 OUT OUT.t0 3.97551
R33 VDD.n2 VDD.t9 7.70006
R34 VDD.n5 VDD.t5 6.898
R35 VDD.n6 VDD.n5 6.86101
R36 VDD.n4 VDD.n3 6.0255
R37 VDD.n2 VDD.n1 6.0255
R38 VDD.n0 VDD.t2 3.88248
R39 VDD.n7 VDD.t6 3.52648
R40 VDD.n0 VDD.t1 3.52648
R41 VDD.n6 VDD.t3 2.9617
R42 VDD.n3 VDD.t7 0.9105
R43 VDD.n3 VDD.t8 0.9105
R44 VDD.n1 VDD.t0 0.9105
R45 VDD.n1 VDD.t4 0.9105
R46 VDD.n4 VDD.n2 0.805206
R47 VDD.n5 VDD.n4 0.802559
R48 VDD.n7 VDD.n6 0.4065
R49 VDD VDD.n7 0.191
R50 VDD VDD.n0 0.166
R51 WE.n14 WE.t24 30.4248
R52 WE.n11 WE.t27 29.1153
R53 WE.n15 WE.n14 21.4537
R54 WE.n7 WE.t26 19.7326
R55 WE.n6 WE.t25 19.7326
R56 WE.n6 WE.n5 19.0431
R57 WE.n22 WE.n16 17.1628
R58 WE.n9 WE.n8 17.0986
R59 WE.n24 WE.n23 16.9828
R60 WE.n10 WE.t14 15.3272
R61 WE.n17 WE.t12 14.9805
R62 WE.n21 WE.t10 14.8655
R63 WE.n10 WE.t0 14.2942
R64 WE.n19 WE.t2 14.2205
R65 WE.n18 WE.t4 14.2205
R66 WE.n17 WE.t8 14.2205
R67 WE.n20 WE.t6 14.2205
R68 WE WE.n13 13.335
R69 WE WE.n4 7.47982
R70 WE.n2 WE.n0 6.83021
R71 WE.n14 WE 6.68621
R72 WE.n22 WE.n21 6.34159
R73 WE.n2 WE.n1 6.0255
R74 WE.n4 WE.n3 6.0255
R75 WE WE.n25 4.5005
R76 WE.n12 WE.n11 4.5005
R77 WE.n15 WE.n12 1.87282
R78 WE.n24 WE.n22 1.54336
R79 WE.n19 WE.n18 1.16479
R80 WE.n11 WE.n10 1.03872
R81 WE.n0 WE.t5 0.9105
R82 WE.n0 WE.t3 0.9105
R83 WE.n1 WE.t9 0.9105
R84 WE.n1 WE.t7 0.9105
R85 WE.n3 WE.t13 0.9105
R86 WE.n3 WE.t11 0.9105
R87 WE.n9 WE.n7 0.839429
R88 WE.n8 WE.t1 0.8195
R89 WE.n8 WE.t15 0.8195
R90 WE.n4 WE.n2 0.805206
R91 WE.n18 WE.n17 0.7605
R92 WE.n20 WE.n19 0.7605
R93 WE.n23 WE.t22 0.660984
R94 WE.n23 WE.t23 0.660984
R95 WE.n16 WE.t17 0.660984
R96 WE.n16 WE.t16 0.660984
R97 WE.n5 WE.t20 0.660984
R98 WE.n5 WE.t21 0.660984
R99 WE.n13 WE.t19 0.660984
R100 WE.n13 WE.t18 0.660984
R101 WE.n12 WE.n9 0.59675
R102 WE.n7 WE.n6 0.4505
R103 WE.n25 WE.n15 0.186929
R104 WE.n25 WE.n24 0.1805
R105 WE.n21 WE.n20 0.1155
R106 a_3640_0.t0 a_3640_0.t1 4.5005
R107 a_3340_0.t0 a_3340_0.t1 4.5005
R108 a_3040_0.t0 a_3040_0.t1 4.5005
R109 a_n74_0.t1 a_n74_0.n0 7.7829
R110 a_n74_0.n0 a_n74_0.t2 24.2505
R111 a_n74_0.n0 a_n74_0.t0 6.98348
R112 a_4282_1208.t0 a_4282_1208.t1 1.5755
R113 a_2882_1208.t1 a_2882_1208.n0 7.88141
R114 a_2882_1208.n0 a_2882_1208.t2 22.6493
R115 a_2882_1208.n0 a_2882_1208.t0 7.082
R116 a_5026_1208.t0 a_5026_1208.n0 23.3769
R117 a_5026_1208.n0 a_5026_1208.t2 7.7829
R118 a_5026_1208.n0 a_5026_1208.t1 6.98348
R119 a_1038_1208.t0 a_1038_1208.n0 24.41
R120 a_1038_1208.n0 a_1038_1208.t2 7.7829
R121 a_1038_1208.n0 a_1038_1208.t1 6.98348
R122 a_n74_1208.t1 a_n74_1208.n0 7.7829
R123 a_n74_1208.n0 a_n74_1208.t2 52.9511
R124 a_n74_1208.n0 a_n74_1208.t0 6.98348
R125 a_3260_3312.t1 a_3260_3312.n0 11.405
R126 a_3260_3312.n0 a_3260_3312.n1 28.7679
R127 a_3260_3312.n1 a_3260_3312.t0 9.65466
R128 a_3260_3312.n1 a_3260_3312.t3 32.7982
R129 a_3260_3312.n0 a_3260_3312.t2 26.7487
R130 a_1376_n116.t3 a_1376_n116.n8 14.2588
R131 a_1376_n116.n8 a_1376_n116.n7 24.9705
R132 a_1376_n116.n7 a_1376_n116.t9 18.0714
R133 a_1376_n116.n7 a_1376_n116.n5 5.59818
R134 a_1376_n116.n5 a_1376_n116.n6 0.239964
R135 a_1376_n116.n6 a_1376_n116.t10 17.9525
R136 a_1376_n116.n6 a_1376_n116.t0 20.0613
R137 a_1376_n116.n5 a_1376_n116.t1 8.49369
R138 a_1376_n116.n8 a_1376_n116.n0 0.239964
R139 a_1376_n116.n0 a_1376_n116.n1 0.4505
R140 a_1376_n116.n1 a_1376_n116.n2 0.4505
R141 a_1376_n116.n2 a_1376_n116.n3 0.4505
R142 a_1376_n116.n3 a_1376_n116.n4 1.14479
R143 a_1376_n116.n4 a_1376_n116.t8 17.915
R144 a_1376_n116.n4 a_1376_n116.t7 16.7707
R145 a_1376_n116.n3 a_1376_n116.t6 14.7997
R146 a_1376_n116.n2 a_1376_n116.t5 14.7997
R147 a_1376_n116.n1 a_1376_n116.t4 14.7997
R148 a_1376_n116.n0 a_1376_n116.t2 14.7997
R149 VDD VDD 355.517
R150 VDD VDD 266.2
R151 VDD VDD 266.2
R152 VDD VDD 266.2
R153 VDD VDD 266.2
R154 VDD VDD 266.2
R155 VDD VDD 711.034
R156 VDD VDD 667.25
R157 VDD VDD 623.468
R158 VDD VDD 623.468
R159 VSS VSS 340.332
R160 VSS VSS 256.091
R161 VSS VSS 680.664
R162 VSS VSS 210.601
R163 VSS VSS 45.4904
R164 VSS VSS 571.152
R165 VSS VSS 109.513
R166 VSS VSS 507.128
R167 VSS VSS 109.513
R168 VSS VSS 143.209
R169 VSS VSS 112.882
R170 VSS VSS 139.839
R171 VSS VSS 252.722
R172 VSS VSS 288.103
R173 VSS VSS 252.722
R174 VSS VSS 42.1208
R175 VSS VSS 549.249
R176 VSS VSS 25.2727
R177 VSS VSS 256.091
R178 VSS VSS 267.885
R179 VSS VSS 412.779
C0 WE VC 0.48335f
C1 VD VSS 0.09207f
C2 VSS VB 0.09303f
C3 OUT_N VSS 0.16636f
C4 WE VSS 1.13054f
C5 VC VSS 0.15338f
C6 VA WE 0.4885f
C7 OUT VDD 0.32084f
C8 VA VSS 0.09218f
C9 OUT OUT_N 2.6981f
C10 WE VD 0.50235f
C11 WE VB 0.51909f
C12 OUT_N VDD 0.15503f
C13 WE VDD 3.1046f
C14 OUT VSS 0.32403f
C15 VC 0 1.15095f
C16 VSS 0 4.8255f
C17 VA 0 1.18165f
C18 VB 0 1.16826f
C19 VD 0 1.15071f
C20 OUT_N 0 5.05624f
C21 OUT 0 2.54157f
C22 VDD 0 2.84091f
C23 WE 0 7.65608f
C24 VDD 0 0.22473f
C25 VDD 0 0.393f
C26 VDD 0 0.33654f
C27 VDD 0 0.33654f
C28 VDD 0 0.33654f
C29 VDD 0 0.33654f
C30 VDD 0 0.61773f
C31 VDD 0 0.87124f
C32 VDD 0 0.81589f
C33 VDD 0 0.78822f
C34 VDD 0 0.78822f
C35 a_1376_n116.t3 0 0.11692f
C36 a_1376_n116.t2 0 0.30451f
C37 a_1376_n116.n0 0 0.22371f
C38 a_1376_n116.t4 0 0.30451f
C39 a_1376_n116.n1 0 0.24107f
C40 a_1376_n116.t5 0 0.30451f
C41 a_1376_n116.n2 0 0.24107f
C42 a_1376_n116.t6 0 0.30451f
C43 a_1376_n116.n3 0 0.29831f
C44 a_1376_n116.t7 0 0.38063f
C45 a_1376_n116.n4 0 0.65758f
C46 a_1376_n116.t8 0 0.39945f
C47 a_1376_n116.t1 0 0.37422f
C48 a_1376_n116.n5 0 0.61762f
C49 a_1376_n116.t0 0 0.50672f
C50 a_1376_n116.n6 0 0.58604f
C51 a_1376_n116.t10 0 0.42408f
C52 a_1376_n116.t9 0 0.4261f
C53 a_1376_n116.n7 0 1.50854f
C54 a_1376_n116.n8 0 1.17764f
C55 a_3260_3312.t1 0 0.44078f
C56 a_3260_3312.t2 0 0.40288f
C57 a_3260_3312.n0 0 2.7219f
C58 a_3260_3312.t3 0 0.3808f
C59 a_3260_3312.n1 0 2.97569f
C60 a_3260_3312.t0 0 0.57052f
C61 a_n74_1208.t1 0 0.40653f
C62 a_n74_1208.t0 0 0.38347f
C63 a_n74_1208.n0 0 2.74888f
C64 a_n74_1208.t2 0 2.18741f
C65 a_1038_1208.t0 0 0.89515f
C66 a_1038_1208.t1 0 0.48224f
C67 a_1038_1208.n0 0 1.44654f
C68 a_1038_1208.t2 0 0.51124f
C69 a_5026_1208.t0 0 0.69128f
C70 a_5026_1208.t1 0 0.41382f
C71 a_5026_1208.n0 0 1.1627f
C72 a_5026_1208.t2 0 0.43871f
C73 a_2882_1208.t1 0 0.45568f
C74 a_2882_1208.t0 0 0.42535f
C75 a_2882_1208.n0 0 1.54835f
C76 a_2882_1208.t2 0 1.21754f
C77 a_4282_1208.t0 0 0.02285f
C78 a_4282_1208.t1 0 0.02285f
C79 a_n74_0.t1 0 0.31882f
C80 a_n74_0.t0 0 0.30073f
C81 a_n74_0.n0 0 0.97089f
C82 a_n74_0.t2 0 0.64107f
C83 WE.t5 0 0.06239f
C84 WE.t3 0 0.06239f
C85 WE.n0 0 0.25403f
C86 WE.t9 0 0.06239f
C87 WE.t7 0 0.06239f
C88 WE.n1 0 0.23381f
C89 WE.n2 0 0.43147f
C90 WE.t13 0 0.06239f
C91 WE.t11 0 0.06239f
C92 WE.n3 0 0.23381f
C93 WE.n4 0 0.44319f
C94 WE.t20 0 0.07736f
C95 WE.t21 0 0.07736f
C96 WE.n5 0 0.62573f
C97 WE.t25 0 0.62711f
C98 WE.n6 0 1.11543f
C99 WE.t26 0 0.62711f
C100 WE.n7 0 0.44359f
C101 WE.t1 0 0.06239f
C102 WE.t15 0 0.06239f
C103 WE.n8 0 0.49902f
C104 WE.n9 0 0.52357f
C105 WE.t0 0 0.41562f
C106 WE.t14 0 0.44111f
C107 WE.n10 0 0.81855f
C108 WE.t27 0 0.26077f
C109 WE.n11 0 0.48342f
C110 WE.n12 0 0.27385f
C111 WE.t24 0 0.38483f
C112 WE.t19 0 0.07736f
C113 WE.t18 0 0.07736f
C114 WE.n13 0 0.44667f
C115 WE.n14 0 2.12875f
C116 WE.n15 0 0.92824f
C117 WE.t17 0 0.07736f
C118 WE.t16 0 0.07736f
C119 WE.n16 0 0.56405f
C120 WE.t10 0 0.37505f
C121 WE.t12 0 0.4311f
C122 WE.t8 0 0.41455f
C123 WE.n17 0 0.72411f
C124 WE.t4 0 0.41455f
C125 WE.n18 0 0.47727f
C126 WE.t2 0 0.36176f
C127 WE.n19 0 0.47052f
C128 WE.t6 0 0.36176f
C129 WE.n20 0 0.30295f
C130 WE.n21 0 0.66161f
C131 WE.n22 0 0.64912f
C132 WE.t22 0 0.07736f
C133 WE.t23 0 0.07736f
C134 WE.n23 0 0.55971f
C135 WE.n24 0 0.56552f
C136 WE.n25 0 0.05414f
C137 VDD.t1 0 0.0861f
C138 VDD.t2 0 0.25054f
C139 VDD.n0 0 1.9941f
C140 VDD.t6 0 0.0861f
C141 VDD.t3 0 0.09116f
C142 VDD.t9 0 0.17685f
C143 VDD.t0 0 0.03344f
C144 VDD.t4 0 0.03344f
C145 VDD.n1 0 0.12532f
C146 VDD.n2 0 0.25342f
C147 VDD.t7 0 0.03344f
C148 VDD.t8 0 0.03344f
C149 VDD.n3 0 0.12532f
C150 VDD.n4 0 0.14991f
C151 VDD.t5 0 0.16481f
C152 VDD.n5 0 0.30893f
C153 VDD.n6 0 1.70494f
C154 VDD.n7 0 0.41061f
C155 OUT.t0 0 0.34001f
C156 OUT.t1 0 0.25003f
C157 OUT.t2 0 0.44616f
C158 OUT.n0 0 2.51131f
C159 OUT.t3 0 0.42356f
C160 OUT.n1 0 2.90727f
C161 OUT_N.t1 0 0.1976f
C162 OUT_N.t0 0 0.13607f
C163 VD.t0 0 0.3082f
C164 VD.t1 0 0.32236f
C165 VB.t0 0 0.31214f
C166 VB.t1 0 0.32648f
C167 VA.t0 0 0.30953f
C168 VA.t1 0 0.32374f
C169 VSS.t5 0 0.08983f
C170 VSS.t8 0 0.05336f
C171 VSS.t7 0 0.05336f
C172 VSS.t2 0 0.05336f
C173 VSS.t3 0 0.07724f
C174 VSS.n0 0 0.89978f
C175 VSS.n1 0 0.35266f
C176 VSS.n2 0 0.29438f
C177 VSS.n3 0 0.30861f
C178 VSS.t6 0 0.02981f
C179 VSS.t4 0 0.0513f
C180 VSS.t0 0 0.0503f
C181 VSS.t1 0 0.10516f
C182 VSS.n4 0 1.09787f
C183 VSS.n5 0 0.24165f
C184 VSS.n6 0 0.3622f
C185 VC.t0 0 0.33345f
C186 VC.t1 0 0.31241f
.ends
