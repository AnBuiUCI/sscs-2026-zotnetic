* Nodos de bulk atados: 11 de pozo n -> VDD, 23 de sustrato -> VSS.
*   magic no extrae los taps de este layout y los dejaba flotando;
*   la conexion si existe (el LVS de KLayout da 'match uniquely').
*   Quien detecta un tap que falte de verdad es el LVS, no esto.
* NGSPICE file created from WEIGHT_COMP.ext - technology: gf180mcuD

.subckt WEIGHT_COMP VSS VDD VD WE VA VB OUT OUT_N VC
X0 a_3260_3312.t1 WE.t27 VDD.t7 VDD pfet_05v0 ad=0.8052p pd=4.54u as=0.8052p ps=4.54u w=1.83u l=0.5u
X1 OUT.t1 a_3260_3312.t2 VSS.t3 VSS nfet_05v0 ad=0.5808p pd=3.52u as=0.5808p ps=3.52u w=1.32u l=0.6u
X2 a_2882_1208.t0 WE.t25 a_4282_1208.t0 VSS nfet_06v0 ad=0.88p pd=4.88u as=0.5p ps=2.5u w=2u l=1u
X3 WE.t5 VA.t1 a_5026_1208.t0 VSS nfet_06v0 ad=0.6448p pd=3u as=1.0912p ps=5.84u w=2.48u l=1u
X4 a_1038_1208.t1 VB.t0 WE.t7 VSS nfet_06v0 ad=1.0912p pd=5.84u as=0.6448p ps=3u w=2.48u l=1u
X5 a_2882_1208.t2 WE.t22 WE.t23 VSS nfet_06v0 ad=0.88p pd=4.88u as=0.52p ps=2.52u w=2u l=1u
X6 a_1376_n116.t3 a_1376_n116.t2 VDD.t6 VDD pfet_06v0 ad=0.88p pd=4.88u as=0.88p ps=4.88u w=2u l=1u
X7 a_3040_0.t1 a_1376_n116.t6 VSS.t6 VSS nfet_06v0 ad=0.175p pd=1.2u as=0.308p ps=2.28u w=0.7u l=1u
X8 a_3260_3312.t0 WE.t24 VSS.t5 VSS nfet_05v0 ad=0.5808p pd=3.52u as=0.5808p ps=3.52u w=1.32u l=0.6u
X9 a_3640_0.t1 a_1376_n116.t4 a_3340_0.t0 VSS nfet_06v0 ad=0.175p pd=1.2u as=0.175p ps=1.2u w=0.7u l=1u
X10 OUT_N.t0 OUT.t2 VSS.t0 VSS nfet_05v0 ad=0.5808p pd=3.52u as=0.5808p ps=3.52u w=1.32u l=0.6u
X11 OUT_N.t1 OUT.t3 VDD.t4 VDD pfet_05v0 ad=0.8052p pd=4.54u as=0.8052p ps=4.54u w=1.83u l=0.5u
X12 a_5026_1208.t1 VA.t0 WE.t4 VSS nfet_06v0 ad=1.0912p pd=5.84u as=0.6448p ps=3u w=2.48u l=1u
X13 a_n74_1208.t1 VD.t0 WE.t1 VSS nfet_06v0 ad=1.0912p pd=5.84u as=0.6448p ps=3u w=2.48u l=1u
X14 VDD.t3 WE.t12 WE.t13 VDD pfet_06v0 ad=0.52p pd=2.52u as=0.52p ps=2.52u w=2u l=1u
X15 WE.t19 WE.t18 VDD.t9 VDD pfet_06v0 ad=0.52p pd=2.52u as=0.52p ps=2.52u w=2u l=1u
X16 a_1038_1208.t2 a_1376_n116.t10 VSS.t8 VSS nfet_06v0 ad=0.5456p pd=3.36u as=0.5456p ps=3.36u w=1.24u l=1u
X17 OUT.t0 a_3260_3312.t3 VDD.t1 VDD pfet_05v0 ad=0.8052p pd=4.54u as=0.8052p ps=4.54u w=1.83u l=0.5u
X18 WE.t11 WE.t10 VDD.t2 VDD pfet_06v0 ad=0.52p pd=2.52u as=0.88p ps=4.88u w=2u l=1u
X19 WE.t6 VB.t1 a_1038_1208.t0 VSS nfet_06v0 ad=0.6448p pd=3u as=1.0912p ps=5.84u w=2.48u l=1u
X20 VDD.t8 WE.t20 WE.t21 VDD pfet_06v0 ad=0.88p pd=4.88u as=0.52p ps=2.52u w=2u l=1u
X21 WE.t9 WE.t8 a_2882_1208.t1 VSS nfet_06v0 ad=0.52p pd=2.52u as=0.88p ps=4.88u w=2u l=1u
X22 WE.t15 WE.t14 VDD.t0 VDD pfet_06v0 ad=0.52p pd=2.52u as=0.52p ps=2.52u w=2u l=1u
X23 a_n74_0.t2 a_1376_n116.t8 VSS.t2 VSS nfet_06v0 ad=0.5456p pd=3.36u as=0.5456p ps=3.36u w=1.24u l=1u
X24 a_n74_1208.t2 a_1376_n116.t7 VSS.t1 VSS nfet_06v0 ad=0.5456p pd=3.36u as=0.5456p ps=3.36u w=1.24u l=1u
X25 a_3340_0.t1 a_1376_n116.t5 a_3040_0.t0 VSS nfet_06v0 ad=0.175p pd=1.2u as=0.175p ps=1.2u w=0.7u l=1u
X26 WE.t0 VD.t1 a_n74_1208.t0 VSS nfet_06v0 ad=0.6448p pd=3u as=1.0912p ps=5.84u w=2.48u l=1u
X27 a_n74_0.t1 VC.t0 WE.t3 VSS nfet_06v0 ad=1.0912p pd=5.84u as=0.6448p ps=3u w=2.48u l=1u
X28 a_4282_1208.t1 WE.t26 VSS.t4 VSS nfet_06v0 ad=0.5p pd=2.5u as=0.88p ps=4.88u w=2u l=1u
X29 a_1376_n116.t1 a_1376_n116.t0 a_3640_0.t0 VSS nfet_06v0 ad=0.308p pd=2.28u as=0.175p ps=1.2u w=0.7u l=1u
X30 VDD.t5 WE.t16 WE.t17 VDD pfet_06v0 ad=0.52p pd=2.52u as=0.52p ps=2.52u w=2u l=1u
X31 a_5026_1208.t2 a_1376_n116.t9 VSS.t7 VSS nfet_06v0 ad=0.5456p pd=3.36u as=0.5456p ps=3.36u w=1.24u l=1u
X32 WE.t2 VC.t1 a_n74_0.t0 VSS nfet_06v0 ad=0.6448p pd=3u as=1.0912p ps=5.84u w=2.48u l=1u
R0 VC.n0 VC.t0 17.3073
R1 VC.n0 VC.t1 15.9725
R2 VC VC.n0 1.083
R3 VSS.n13 VSS.t6 9.93823
R4 VSS.n17 VSS.n12 9.0005
R5 VSS.n19 VSS.n18 9.0005
R6 VSS.n20 VSS.n1 9.0005
R7 VSS.n22 VSS.n21 9.0005
R8 VSS.n11 VSS.n0 9.0005
R9 VSS.n10 VSS.n9 9.0005
R10 VSS.n5 VSS.n2 9.0005
R11 VSS.n14 VSS.t2 5.69436
R12 VSS.n15 VSS.t1 5.6202
R13 VSS.n7 VSS.t5 5.51806
R14 VSS.n8 VSS.t3 5.51806
R15 VSS.n4 VSS.t0 5.51806
R16 VSS.n3 VSS.t7 5.20912
R17 VSS.n16 VSS.t8 5.13643
R18 VSS.n3 VSS.n2 4.72864
R19 VSS.n6 VSS.t4 3.1466
R20 VSS.n14 VSS.n12 2.03917
R21 VSS.n11 VSS.n10 0.6005
R22 VSS.n8 VSS.n7 0.3265
R23 VSS.n15 VSS.n14 0.287892
R24 VSS.n10 VSS.n2 0.2005
R25 VSS.n21 VSS.n11 0.2005
R26 VSS.n21 VSS.n20 0.2005
R27 VSS.n20 VSS.n19 0.2005
R28 VSS.n19 VSS.n12 0.2005
R29 VSS.n9 VSS.n5 0.2005
R30 VSS.n22 VSS.n1 0.2005
R31 VSS.n18 VSS.n17 0.2005
R32 VSS VSS.n0 0.1995
R33 VSS.n7 VSS.n6 0.1955
R34 VSS.n4 VSS.n3 0.15269
R35 VSS.n13 VSS.n1 0.15
R36 VSS.n5 VSS.n4 0.119
R37 VSS.n6 VSS.n0 0.072
R38 VSS.n16 VSS.n15 0.0655
R39 VSS.n18 VSS.n13 0.051
R40 VSS.n17 VSS.n16 0.051
R41 VSS.n9 VSS.n8 0.008
R42 VSS VSS.n22 0.0015
R43 VA.n0 VA.t1 17.1173
R44 VA.n0 VA.t0 16.1625
R45 VA VA.n0 1.0668
R46 VB.n0 VB.t1 17.1173
R47 VB.n0 VB.t0 16.1625
R48 VB VB.n0 1.32507
R49 VD.n0 VD.t1 17.1173
R50 VD.n0 VD.t0 16.1625
R51 VD VD.n0 0.808543
R52 OUT_N OUT_N.t0 5.32182
R53 OUT_N OUT_N.t1 3.71725
R54 OUT.n1 OUT.t3 32.5399
R55 OUT.n1 OUT.n0 27.0301
R56 OUT.n0 OUT.t2 26.4905
R57 OUT OUT.t1 5.83834
R58 OUT OUT.n1 5.42139
R59 OUT.n0 OUT 5.30889
R60 OUT OUT.t0 3.97551
R61 VDD.n11 VDD.n3 9.0005
R62 VDD.n13 VDD.n12 9.0005
R63 VDD.n15 VDD.n14 9.0005
R64 VDD.n5 VDD.t8 7.70006
R65 VDD.n8 VDD.t2 6.898
R66 VDD.n9 VDD.n8 6.26061
R67 VDD.n7 VDD.n6 6.0255
R68 VDD.n5 VDD.n4 6.0255
R69 VDD.n2 VDD.t4 3.60541
R70 VDD.n1 VDD.t7 3.52648
R71 VDD.n0 VDD.t1 3.52648
R72 VDD.n10 VDD.t6 2.9617
R73 VDD.n14 VDD.n2 1.81072
R74 VDD.n9 VDD.n3 1.62272
R75 VDD.n6 VDD.t0 0.9105
R76 VDD.n6 VDD.t3 0.9105
R77 VDD.n4 VDD.t9 0.9105
R78 VDD.n4 VDD.t5 0.9105
R79 VDD.n7 VDD.n5 0.805206
R80 VDD.n8 VDD.n7 0.802559
R81 VDD.n10 VDD.n9 0.504638
R82 VDD.n2 VDD.n0 0.270477
R83 VDD.n14 VDD.n13 0.2005
R84 VDD.n13 VDD.n3 0.2005
R85 VDD.n12 VDD.n11 0.2005
R86 VDD.n11 VDD.n10 0.196
R87 VDD.n15 VDD.n1 0.19
R88 VDD VDD.n0 0.166
R89 VDD.n12 VDD.n1 0.011
R90 VDD VDD.n15 0.0015
R91 WE.n6 WE.t24 30.4248
R92 WE.n19 WE.t27 29.1153
R93 WE.n7 WE.n6 21.4537
R94 WE.n17 WE.t26 19.7326
R95 WE.n16 WE.t25 19.7326
R96 WE.n16 WE.n15 19.0431
R97 WE.n14 WE.n8 17.1628
R98 WE.n22 WE.n21 17.0986
R99 WE.n26 WE.n25 16.9828
R100 WE.n18 WE.t8 15.3272
R101 WE.n9 WE.t20 14.9805
R102 WE.n13 WE.t18 14.8655
R103 WE.n18 WE.t22 14.2942
R104 WE.n11 WE.t10 14.2205
R105 WE.n10 WE.t12 14.2205
R106 WE.n9 WE.t16 14.2205
R107 WE.n12 WE.t14 14.2205
R108 WE WE.n5 13.335
R109 WE.n24 WE.n23 11.5205
R110 WE WE.n4 7.47982
R111 WE.n2 WE.n0 6.83021
R112 WE.n6 WE 6.64764
R113 WE.n14 WE.n13 6.34159
R114 WE.n2 WE.n1 6.0255
R115 WE.n4 WE.n3 6.0255
R116 WE WE.n27 4.5005
R117 WE.n20 WE.n19 4.5005
R118 WE.n20 WE.n7 1.87282
R119 WE.n24 WE.n14 1.26371
R120 WE.n11 WE.n10 1.16479
R121 WE.n19 WE.n18 1.03872
R122 WE.n0 WE.t13 0.9105
R123 WE.n0 WE.t11 0.9105
R124 WE.n1 WE.t17 0.9105
R125 WE.n1 WE.t15 0.9105
R126 WE.n3 WE.t21 0.9105
R127 WE.n3 WE.t19 0.9105
R128 WE.n21 WE.t23 0.8195
R129 WE.n21 WE.t9 0.8195
R130 WE.n4 WE.n2 0.805206
R131 WE.n10 WE.n9 0.7605
R132 WE.n12 WE.n11 0.7605
R133 WE.n8 WE.t1 0.660984
R134 WE.n8 WE.t0 0.660984
R135 WE.n25 WE.t7 0.660984
R136 WE.n25 WE.t6 0.660984
R137 WE.n15 WE.t4 0.660984
R138 WE.n15 WE.t5 0.660984
R139 WE.n5 WE.t3 0.660984
R140 WE.n5 WE.t2 0.660984
R141 WE.n22 WE.n20 0.59675
R142 WE.n23 WE.n17 0.476214
R143 WE.n17 WE.n16 0.4505
R144 WE.n23 WE.n22 0.325143
R145 WE.n26 WE.n24 0.241571
R146 WE.n27 WE.n7 0.186929
R147 WE.n27 WE.n26 0.1805
R148 WE.n13 WE.n12 0.1155
R149 a_3640_0.t0 a_3640_0.t1 4.5005
R150 a_3340_0.t0 a_3340_0.t1 4.5005
R151 a_3040_0.t0 a_3040_0.t1 4.5005
R152 a_n74_0.t1 a_n74_0.n0 7.7829
R153 a_n74_0.n0 a_n74_0.t2 24.2505
R154 a_n74_0.n0 a_n74_0.t0 6.98348
R155 a_4282_1208.t0 a_4282_1208.t1 1.5755
R156 a_2882_1208.t1 a_2882_1208.n0 7.082
R157 a_2882_1208.n0 a_2882_1208.t0 22.6493
R158 a_2882_1208.n0 a_2882_1208.t2 7.88141
R159 a_5026_1208.t1 a_5026_1208.n0 7.7829
R160 a_5026_1208.n0 a_5026_1208.t2 23.3769
R161 a_5026_1208.n0 a_5026_1208.t0 6.98348
R162 a_1038_1208.t1 a_1038_1208.n0 7.7829
R163 a_1038_1208.n0 a_1038_1208.t2 24.41
R164 a_1038_1208.n0 a_1038_1208.t0 6.98348
R165 a_n74_1208.t1 a_n74_1208.n0 7.7829
R166 a_n74_1208.n0 a_n74_1208.t2 52.9511
R167 a_n74_1208.n0 a_n74_1208.t0 6.98348
R168 a_3260_3312.t0 a_3260_3312.n0 11.405
R169 a_3260_3312.n0 a_3260_3312.n1 28.7679
R170 a_3260_3312.n1 a_3260_3312.t1 9.65466
R171 a_3260_3312.n1 a_3260_3312.t3 32.7982
R172 a_3260_3312.n0 a_3260_3312.t2 26.7487
R173 a_1376_n116.t1 a_1376_n116.n8 14.2588
R174 a_1376_n116.n8 a_1376_n116.n7 24.9705
R175 a_1376_n116.n7 a_1376_n116.t9 18.0714
R176 a_1376_n116.n7 a_1376_n116.n5 5.59818
R177 a_1376_n116.n5 a_1376_n116.n6 0.239964
R178 a_1376_n116.n6 a_1376_n116.t10 17.9525
R179 a_1376_n116.n6 a_1376_n116.t2 20.0613
R180 a_1376_n116.n5 a_1376_n116.t3 8.49369
R181 a_1376_n116.n8 a_1376_n116.n0 0.239964
R182 a_1376_n116.n0 a_1376_n116.n1 0.4505
R183 a_1376_n116.n1 a_1376_n116.n2 0.4505
R184 a_1376_n116.n2 a_1376_n116.n3 0.4505
R185 a_1376_n116.n3 a_1376_n116.n4 1.14479
R186 a_1376_n116.n4 a_1376_n116.t8 17.915
R187 a_1376_n116.n4 a_1376_n116.t7 16.7707
R188 a_1376_n116.n3 a_1376_n116.t6 14.7997
R189 a_1376_n116.n2 a_1376_n116.t5 14.7997
R190 a_1376_n116.n1 a_1376_n116.t4 14.7997
R191 a_1376_n116.n0 a_1376_n116.t0 14.7997
R192 VDD VDD 355.517
R193 VDD VDD 266.2
R194 VDD VDD 266.2
R195 VDD VDD 266.2
R196 VDD VDD 266.2
R197 VDD VDD 266.2
R198 VDD VDD 711.034
R199 VDD VDD 667.25
R200 VDD VDD 623.468
R201 VDD VDD 623.468
R202 VSS VSS 340.332
R203 VSS VSS 256.091
R204 VSS VSS 680.664
R205 VSS VSS 210.601
R206 VSS VSS 45.4904
R207 VSS VSS 571.152
R208 VSS VSS 109.513
R209 VSS VSS 507.128
R210 VSS VSS 109.513
R211 VSS VSS 143.209
R212 VSS VSS 112.882
R213 VSS VSS 139.839
R214 VSS VSS 252.722
R215 VSS VSS 288.103
R216 VSS VSS 252.722
R217 VSS VSS 42.1208
R218 VSS VSS 549.249
R219 VSS VSS 25.2727
R220 VSS VSS 256.091
R221 VSS VSS 267.885
R222 VSS VSS 412.779
C0 VDD WE 3.30995f
C1 VA OUT 0.15556f
C2 VA WE 1.01123f
C3 VSS OUT 0.41766f
C4 VSS VB 0.11741f
C5 OUT OUT_N 2.80363f
C6 VSS WE 1.57746f
C7 VDD OUT_N 0.19577f
C8 VC WE 0.57303f
C9 VA VSS 0.1601f
C10 VD VDD 0.02903f
C11 VD WE 0.60551f
C12 VSS OUT_N 0.27747f
C13 VC VSS 0.18688f
C14 VD VSS 0.12009f
C15 VDD OUT 0.41427f
C16 VB VDD 0.09095f
C17 VB WE 0.92906f
C18 VC 0 0.90405f
C19 VSS 0 6.2865f
C20 VA 0 1.69639f
C21 VB 0 1.46132f
C22 VD 0 0.78671f
C23 OUT_N 0 5.43602f
C24 OUT 0 2.69297f
C25 VDD 0 4.68585f
C26 WE 0 7.87573f
C27 VDD 0 0.23962f
C28 VDD 0 0.41905f
C29 VDD 0 0.35885f
C30 VDD 0 0.35885f
C31 VDD 0 0.35885f
C32 VDD 0 0.35885f
C33 VDD 0 0.65867f
C34 VDD 0 0.92899f
C35 VDD 0 0.86997f
C36 VDD 0 0.84045f
C37 VDD 0 0.84045f
C38 a_1376_n116.t1 0 0.12777f
C39 a_1376_n116.t0 0 0.33277f
C40 a_1376_n116.n0 0 0.24446f
C41 a_1376_n116.t4 0 0.33277f
C42 a_1376_n116.n1 0 0.26343f
C43 a_1376_n116.t5 0 0.33277f
C44 a_1376_n116.n2 0 0.26343f
C45 a_1376_n116.t6 0 0.33277f
C46 a_1376_n116.n3 0 0.32599f
C47 a_1376_n116.t7 0 0.41594f
C48 a_1376_n116.n4 0 0.71859f
C49 a_1376_n116.t8 0 0.43651f
C50 a_1376_n116.t3 0 0.40894f
C51 a_1376_n116.n5 0 0.67492f
C52 a_1376_n116.t2 0 0.55373f
C53 a_1376_n116.n6 0 0.64042f
C54 a_1376_n116.t10 0 0.46343f
C55 a_1376_n116.t9 0 0.46564f
C56 a_1376_n116.n7 0 1.64851f
C57 a_1376_n116.n8 0 1.28691f
C58 a_3260_3312.t0 0 0.45607f
C59 a_3260_3312.t2 0 0.41685f
C60 a_3260_3312.n0 0 2.81631f
C61 a_3260_3312.t3 0 0.39401f
C62 a_3260_3312.n1 0 3.07889f
C63 a_3260_3312.t1 0 0.59031f
C64 a_n74_1208.t1 0 0.45086f
C65 a_n74_1208.t0 0 0.42529f
C66 a_n74_1208.n0 0 3.04867f
C67 a_n74_1208.t2 0 2.42597f
C68 a_1038_1208.t1 0 0.59754f
C69 a_1038_1208.t0 0 0.56365f
C70 a_1038_1208.n0 0 1.69074f
C71 a_1038_1208.t2 0 1.04626f
C72 a_5026_1208.t1 0 0.46888f
C73 a_5026_1208.t0 0 0.44228f
C74 a_5026_1208.n0 0 1.24265f
C75 a_5026_1208.t2 0 0.73881f
C76 a_2882_1208.t1 0 0.44485f
C77 a_2882_1208.t2 0 0.47657f
C78 a_2882_1208.t0 0 1.27334f
C79 a_2882_1208.n0 0 1.61932f
C80 a_4282_1208.t0 0 0.02326f
C81 a_4282_1208.t1 0 0.02326f
C82 a_n74_0.t1 0 0.3809f
C83 a_n74_0.t0 0 0.35929f
C84 a_n74_0.n0 0 1.15994f
C85 a_n74_0.t2 0 0.7659f
C86 WE.t13 0 0.06375f
C87 WE.t11 0 0.06375f
C88 WE.n0 0 0.25956f
C89 WE.t17 0 0.06375f
C90 WE.t15 0 0.06375f
C91 WE.n1 0 0.2389f
C92 WE.n2 0 0.44087f
C93 WE.t21 0 0.06375f
C94 WE.t19 0 0.06375f
C95 WE.n3 0 0.2389f
C96 WE.n4 0 0.45284f
C97 WE.t24 0 0.39321f
C98 WE.t3 0 0.07905f
C99 WE.t2 0 0.07905f
C100 WE.n5 0 0.4564f
C101 WE.n6 0 2.15454f
C102 WE.n7 0 0.94846f
C103 WE.t1 0 0.07905f
C104 WE.t0 0 0.07905f
C105 WE.n8 0 0.57633f
C106 WE.t18 0 0.38322f
C107 WE.t20 0 0.44049f
C108 WE.t16 0 0.42358f
C109 WE.n9 0 0.73988f
C110 WE.t12 0 0.42358f
C111 WE.n10 0 0.48767f
C112 WE.t10 0 0.36964f
C113 WE.n11 0 0.48077f
C114 WE.t14 0 0.36964f
C115 WE.n12 0 0.30955f
C116 WE.n13 0 0.67602f
C117 WE.n14 0 0.63342f
C118 WE.t4 0 0.07905f
C119 WE.t5 0 0.07905f
C120 WE.n15 0 0.63936f
C121 WE.t25 0 0.64077f
C122 WE.n16 0 1.13972f
C123 WE.t26 0 0.64077f
C124 WE.n17 0 0.41455f
C125 WE.t22 0 0.42467f
C126 WE.t8 0 0.45072f
C127 WE.n18 0 0.83638f
C128 WE.t27 0 0.26645f
C129 WE.n19 0 0.49395f
C130 WE.n20 0 0.27981f
C131 WE.t23 0 0.06375f
C132 WE.t9 0 0.06375f
C133 WE.n21 0 0.50989f
C134 WE.n22 0 0.48018f
C135 WE.n23 0 0.78138f
C136 WE.n24 0 0.91664f
C137 WE.t7 0 0.07905f
C138 WE.t6 0 0.07905f
C139 WE.n25 0 0.5719f
C140 WE.n26 0 0.43899f
C141 WE.n27 0 0.05532f
C142 VDD.t1 0 0.05517f
C143 VDD.n0 0 0.23227f
C144 VDD.t7 0 0.05517f
C145 VDD.n1 0 0.11605f
C146 VDD.t4 0 0.08344f
C147 VDD.n2 0 1.47229f
C148 VDD.n3 0 0.88538f
C149 VDD.t6 0 0.05841f
C150 VDD.t8 0 0.11331f
C151 VDD.t9 0 0.02143f
C152 VDD.t5 0 0.02143f
C153 VDD.n4 0 0.0803f
C154 VDD.n5 0 0.16237f
C155 VDD.t0 0 0.02143f
C156 VDD.t3 0 0.02143f
C157 VDD.n6 0 0.0803f
C158 VDD.n7 0 0.09605f
C159 VDD.t2 0 0.1056f
C160 VDD.n8 0 0.15301f
C161 VDD.n9 0 1.01214f
C162 VDD.n10 0 0.43256f
C163 VDD.n11 0 0.15326f
C164 VDD.n12 0 0.08466f
C165 VDD.n13 0 0.15493f
C166 VDD.n14 0 1.19899f
C167 VDD.n15 0 0.07724f
C168 OUT.t0 0 0.32825f
C169 OUT.t1 0 0.24139f
C170 OUT.t2 0 0.43073f
C171 OUT.n0 0 2.40089f
C172 OUT.t3 0 0.40891f
C173 OUT.n1 0 3.6638f
C174 OUT_N.t1 0 0.23256f
C175 OUT_N.t0 0 0.16015f
C176 VD.t0 0 0.45569f
C177 VD.t1 0 0.47662f
C178 VD.n0 0 0.80188f
C179 VB.t0 0 0.47488f
C180 VB.t1 0 0.49669f
C181 VB.n0 0 0.86984f
C182 VA.t0 0 0.5889f
C183 VA.t1 0 0.61595f
C184 VA.n0 0 1.05748f
C185 VSS.n0 0 0.09685f
C186 VSS.n1 0 0.12339f
C187 VSS.n2 0 0.62034f
C188 VSS.t0 0 0.0403f
C189 VSS.t7 0 0.04504f
C190 VSS.n3 0 0.50989f
C191 VSS.n4 0 0.15237f
C192 VSS.n5 0 0.11298f
C193 VSS.t3 0 0.0403f
C194 VSS.t5 0 0.0403f
C195 VSS.t4 0 0.06784f
C196 VSS.n6 0 0.16622f
C197 VSS.n7 0 0.22233f
C198 VSS.n8 0 0.15934f
C199 VSS.n9 0 0.07569f
C200 VSS.n10 0 0.27474f
C201 VSS.n11 0 0.27474f
C202 VSS.n12 0 0.81846f
C203 VSS.t6 0 0.02251f
C204 VSS.n13 0 0.12186f
C205 VSS.t8 0 0.03875f
C206 VSS.t1 0 0.03799f
C207 VSS.t2 0 0.04741f
C208 VSS.n14 0 0.86069f
C209 VSS.n15 0 0.18693f
C210 VSS.n16 0 0.09835f
C211 VSS.n17 0 0.09013f
C212 VSS.n18 0 0.09013f
C213 VSS.n19 0 0.14036f
C214 VSS.n20 0 0.14036f
C215 VSS.n21 0 0.14036f
C216 VSS.n22 0 0.0735f
C217 VC.t0 0 0.47035f
C218 VC.t1 0 0.44066f
C219 VC.n0 0 0.79072f
.ends
