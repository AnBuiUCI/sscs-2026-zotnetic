* Nodos de bulk atados: 1 de pozo n -> VDD, 1 de sustrato -> VSS.
*   magic no extrae los taps de este layout y los dejaba flotando;
*   la conexion si existe (el LVS de KLayout da 'match uniquely').
*   Quien detecta un tap que falte de verdad es el LVS, no esto.
* NGSPICE file created from WEIGHT_COMP.ext - technology: gf180mcuD

.subckt WEIGHT_COMP VSS VDD VD WE VA VB OUT OUT_N VC
X0 a_3260_3312# WE VDD VDD pfet_05v0 ad=0.8052p pd=4.54u as=0.8052p ps=4.54u w=1.83u l=0.5u
X1 OUT a_3260_3312# VSS VSS nfet_05v0 ad=0.5808p pd=3.52u as=0.5808p ps=3.52u w=1.32u l=0.6u
X2 a_2882_1208# WE a_4282_1208# VSS nfet_06v0 ad=0.88p pd=4.88u as=0.5p ps=2.5u w=2u l=1u
X3 WE VA a_5026_1208# VSS nfet_06v0 ad=0.6448p pd=3u as=1.0912p ps=5.84u w=2.48u l=1u
X4 a_1038_1208# VB WE VSS nfet_06v0 ad=1.0912p pd=5.84u as=0.6448p ps=3u w=2.48u l=1u
X5 a_2882_1208# WE WE VSS nfet_06v0 ad=0.88p pd=4.88u as=0.52p ps=2.52u w=2u l=1u
X6 a_1376_n116# a_1376_n116# VDD VDD pfet_06v0 ad=0.88p pd=4.88u as=0.88p ps=4.88u w=2u l=1u
X7 a_3040_0# a_1376_n116# VSS VSS nfet_06v0 ad=0.175p pd=1.2u as=0.308p ps=2.28u w=0.7u l=1u
X8 a_3260_3312# WE VSS VSS nfet_05v0 ad=0.5808p pd=3.52u as=0.5808p ps=3.52u w=1.32u l=0.6u
X9 a_3640_0# a_1376_n116# a_3340_0# VSS nfet_06v0 ad=0.175p pd=1.2u as=0.175p ps=1.2u w=0.7u l=1u
X10 OUT_N OUT VSS VSS nfet_05v0 ad=0.5808p pd=3.52u as=0.5808p ps=3.52u w=1.32u l=0.6u
X11 OUT_N OUT VDD VDD pfet_05v0 ad=0.8052p pd=4.54u as=0.8052p ps=4.54u w=1.83u l=0.5u
X12 a_5026_1208# VA WE VSS nfet_06v0 ad=1.0912p pd=5.84u as=0.6448p ps=3u w=2.48u l=1u
X13 a_n74_1208# VD WE VSS nfet_06v0 ad=1.0912p pd=5.84u as=0.6448p ps=3u w=2.48u l=1u
X14 VDD WE WE VDD pfet_06v0 ad=0.52p pd=2.52u as=0.52p ps=2.52u w=2u l=1u
X15 WE WE VDD VDD pfet_06v0 ad=0.52p pd=2.52u as=0.52p ps=2.52u w=2u l=1u
X16 a_1038_1208# a_1376_n116# VSS VSS nfet_06v0 ad=0.5456p pd=3.36u as=0.5456p ps=3.36u w=1.24u l=1u
X17 OUT a_3260_3312# VDD VDD pfet_05v0 ad=0.8052p pd=4.54u as=0.8052p ps=4.54u w=1.83u l=0.5u
X18 WE WE VDD VDD pfet_06v0 ad=0.52p pd=2.52u as=0.88p ps=4.88u w=2u l=1u
X19 WE VB a_1038_1208# VSS nfet_06v0 ad=0.6448p pd=3u as=1.0912p ps=5.84u w=2.48u l=1u
X20 VDD WE WE VDD pfet_06v0 ad=0.88p pd=4.88u as=0.52p ps=2.52u w=2u l=1u
X21 WE WE a_2882_1208# VSS nfet_06v0 ad=0.52p pd=2.52u as=0.88p ps=4.88u w=2u l=1u
X22 WE WE VDD VDD pfet_06v0 ad=0.52p pd=2.52u as=0.52p ps=2.52u w=2u l=1u
X23 a_n74_0# a_1376_n116# VSS VSS nfet_06v0 ad=0.5456p pd=3.36u as=0.5456p ps=3.36u w=1.24u l=1u
X24 a_n74_1208# a_1376_n116# VSS VSS nfet_06v0 ad=0.5456p pd=3.36u as=0.5456p ps=3.36u w=1.24u l=1u
X25 a_3340_0# a_1376_n116# a_3040_0# VSS nfet_06v0 ad=0.175p pd=1.2u as=0.175p ps=1.2u w=0.7u l=1u
X26 WE VD a_n74_1208# VSS nfet_06v0 ad=0.6448p pd=3u as=1.0912p ps=5.84u w=2.48u l=1u
X27 a_n74_0# VC WE VSS nfet_06v0 ad=1.0912p pd=5.84u as=0.6448p ps=3u w=2.48u l=1u
X28 a_4282_1208# WE VSS VSS nfet_06v0 ad=0.5p pd=2.5u as=0.88p ps=4.88u w=2u l=1u
X29 a_1376_n116# a_1376_n116# a_3640_0# VSS nfet_06v0 ad=0.308p pd=2.28u as=0.175p ps=1.2u w=0.7u l=1u
X30 VDD WE WE VDD pfet_06v0 ad=0.52p pd=2.52u as=0.52p ps=2.52u w=2u l=1u
X31 a_5026_1208# a_1376_n116# VSS VSS nfet_06v0 ad=0.5456p pd=3.36u as=0.5456p ps=3.36u w=1.24u l=1u
X32 WE VC a_n74_0# VSS nfet_06v0 ad=0.6448p pd=3u as=1.0912p ps=5.84u w=2.48u l=1u
C0 VDD a_3260_3312# 0.42267f
C1 a_1038_1208# a_2882_1208# 0.22004f
C2 VDD VDD 2.22806f
C3 a_n74_1208# WE 3.98985f
C4 VDD VD 0.01317f
C5 OUT_N VSS 0.27571f
C6 VSS a_5026_1208# 0.2055f
C7 a_n74_1208# a_1038_1208# 0.09186f
C8 VA a_5026_1208# 0.74263f
C9 VB VSS 0.14219f
C10 OUT OUT_N 2.79717f
C11 OUT a_5026_1208# 0.01429f
C12 a_1038_1208# WE 1.80409f
C13 OUT_N a_1376_n116# 0.32975f
C14 a_1376_n116# a_5026_1208# 0.44242f
C15 VDD WE 2.42576f
C16 a_n74_0# VSS 0.1616f
C17 VB a_1376_n116# 0.01468f
C18 OUT_N a_3260_3312# 0.07341f
C19 VA VSS 0.1601f
C20 VDD a_1038_1208# 0.01531f
C21 a_3260_3312# a_5026_1208# 0.14971f
C22 OUT_N VDD 0.19084f
C23 a_n74_0# a_1376_n116# 0.32976f
C24 a_5026_1208# a_2882_1208# 0.16307f
C25 OUT VSS 0.41768f
C26 a_1376_n116# VSS 1.32782f
C27 VB VDD 0.09192f
C28 OUT VA 0.15556f
C29 a_1376_n116# VA 0.73865f
C30 a_n74_0# VC 0.93833f
C31 OUT a_1376_n116# 0.47596f
C32 a_n74_1208# a_5026_1208# 0.01766f
C33 a_3260_3312# VSS 0.46229f
C34 VSS VC 0.18688f
C35 VSS a_2882_1208# 0.18261f
C36 a_3260_3312# VA 0.06262f
C37 VB a_n74_1208# 0.05583f
C38 WE a_5026_1208# 1.15137f
C39 VA a_2882_1208# 0.04625f
C40 VD VSS 0.12009f
C41 OUT a_3260_3312# 3.64738f
C42 OUT VDD 0.41435f
C43 a_1376_n116# a_3260_3312# 1.67813f
C44 a_4282_1208# VSS 0.01684f
C45 a_n74_1208# a_n74_0# 0.03062f
C46 VB WE 0.78266f
C47 a_1376_n116# VDD 0.37433f
C48 a_1376_n116# a_2882_1208# 0.74171f
C49 a_n74_1208# VSS 0.58483f
C50 VDD OUT_N 0.10167f
C51 a_n74_1208# VA 0.01074f
C52 a_n74_0# WE 1.19758f
C53 VB a_1038_1208# 1.03148f
C54 a_3260_3312# VDD 0.34945f
C55 VSS WE 1.54759f
C56 VB VDD 0.04238f
C57 a_n74_1208# a_1376_n116# 0.52628f
C58 VA WE 1.01123f
C59 VD VDD 0.02903f
C60 a_1038_1208# VSS 0.19331f
C61 a_1376_n116# WE 2.2247f
C62 a_4282_1208# a_2882_1208# 0.01057f
C63 a_n74_1208# a_3260_3312# 0.04672f
C64 a_n74_1208# a_2882_1208# 0.08238f
C65 OUT VDD 0.43197f
C66 a_n74_1208# VD 0.84961f
C67 a_1376_n116# a_1038_1208# 0.51245f
C68 a_3260_3312# WE 0.85731f
C69 WE VC 0.56577f
C70 VDD a_1376_n116# 0.54245f
C71 WE VDD 3.30993f
C72 a_n74_1208# a_4282_1208# 0.01864f
C73 WE a_2882_1208# 2.35289f
C74 VD WE 0.60265f
C75 VC VSS 0.89576f
C76 VSS VSS 6.24024f
C77 VA VSS 1.02452f
C78 VB VSS 1.04273f
C79 VD VSS 0.89017f
C80 OUT_N VSS 2.01279f
C81 OUT VSS 1.78473f
C82 VDD VSS 4.63093f
C83 WE VSS 6.75329f
C84 a_n74_0# VSS 1.24479f
C85 a_2882_1208# VSS 0.72411f
C86 a_5026_1208# VSS 0.7769f
C87 a_1038_1208# VSS 0.70008f
C88 a_n74_1208# VSS 2.41677f
C89 a_3260_3312# VSS 2.13225f
C90 a_1376_n116# VSS 6.19226f
C91 VDD VSS 18.0893f
.ends
