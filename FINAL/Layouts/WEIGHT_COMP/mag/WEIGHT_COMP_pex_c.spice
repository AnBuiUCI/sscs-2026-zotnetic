* Nodos de bulk atados: 1 de pozo n -> VDD, 1 de sustrato -> VSS.
*   magic no extrae los taps de este layout y los dejaba flotando;
*   la conexion si existe (el LVS de KLayout da 'match uniquely').
*   Quien detecta un tap que falte de verdad es el LVS, no esto.
* NGSPICE file created from WEIGHT_COMP.ext - technology: gf180mcuD

.subckt WEIGHT_COMP VSS VDD VD WE VA VB OUT OUT_N VC
X0 a_3260_3312# WE VDD VDD pfet_05v0 ad=0.8052p pd=4.54u as=0.8052p ps=4.54u w=1.83u l=0.5u
X1 OUT a_3260_3312# VSS VSS nfet_05v0 ad=0.5808p pd=3.52u as=0.5808p ps=3.52u w=1.32u l=0.6u
X2 a_2882_1208# WE a_4282_1208# VSS nfet_06v0 ad=0.88p pd=4.88u as=0.5p ps=2.5u w=2u l=1u
X3 WE VA a_5026_1208# VSS nfet_06v0 ad=0.6448p pd=3u as=1.0912p ps=5.84u w=2.48u l=1u
X4 a_1038_1208# VB WE VSS nfet_06v0 ad=1.0912p pd=5.84u as=0.6448p ps=3u w=2.48u l=1u
X5 a_2882_1208# WE WE VSS nfet_06v0 ad=0.88p pd=4.88u as=0.52p ps=2.52u w=2u l=1u
X6 a_1376_n116# a_1376_n116# VDD VDD pfet_06v0 ad=0.88p pd=4.88u as=0.88p ps=4.88u w=2u l=1u
X7 a_3040_0# a_1376_n116# VSS VSS nfet_06v0 ad=0.175p pd=1.2u as=0.308p ps=2.28u w=0.7u l=1u
X8 a_3260_3312# WE VSS VSS nfet_05v0 ad=0.5808p pd=3.52u as=0.5808p ps=3.52u w=1.32u l=0.6u
X9 a_3640_0# a_1376_n116# a_3340_0# VSS nfet_06v0 ad=0.175p pd=1.2u as=0.175p ps=1.2u w=0.7u l=1u
X10 OUT_N OUT VSS VSS nfet_05v0 ad=0.5808p pd=3.52u as=0.5808p ps=3.52u w=1.32u l=0.6u
X11 OUT_N OUT VDD VDD pfet_05v0 ad=0.8052p pd=4.54u as=0.8052p ps=4.54u w=1.83u l=0.5u
X12 a_5026_1208# VA WE VSS nfet_06v0 ad=1.0912p pd=5.84u as=0.6448p ps=3u w=2.48u l=1u
X13 a_n74_1208# VD WE VSS nfet_06v0 ad=1.0912p pd=5.84u as=0.6448p ps=3u w=2.48u l=1u
X14 VDD WE WE VDD pfet_06v0 ad=0.52p pd=2.52u as=0.52p ps=2.52u w=2u l=1u
X15 WE WE VDD VDD pfet_06v0 ad=0.52p pd=2.52u as=0.52p ps=2.52u w=2u l=1u
X16 a_1038_1208# a_1376_n116# VSS VSS nfet_06v0 ad=0.5456p pd=3.36u as=0.5456p ps=3.36u w=1.24u l=1u
X17 OUT a_3260_3312# VDD VDD pfet_05v0 ad=0.8052p pd=4.54u as=0.8052p ps=4.54u w=1.83u l=0.5u
X18 WE WE VDD VDD pfet_06v0 ad=0.52p pd=2.52u as=0.88p ps=4.88u w=2u l=1u
X19 WE VB a_1038_1208# VSS nfet_06v0 ad=0.6448p pd=3u as=1.0912p ps=5.84u w=2.48u l=1u
X20 VDD WE WE VDD pfet_06v0 ad=0.88p pd=4.88u as=0.52p ps=2.52u w=2u l=1u
X21 WE WE a_2882_1208# VSS nfet_06v0 ad=0.52p pd=2.52u as=0.88p ps=4.88u w=2u l=1u
X22 WE WE VDD VDD pfet_06v0 ad=0.52p pd=2.52u as=0.52p ps=2.52u w=2u l=1u
X23 a_n74_0# a_1376_n116# VSS VSS nfet_06v0 ad=0.5456p pd=3.36u as=0.5456p ps=3.36u w=1.24u l=1u
X24 a_n74_1208# a_1376_n116# VSS VSS nfet_06v0 ad=0.5456p pd=3.36u as=0.5456p ps=3.36u w=1.24u l=1u
X25 a_3340_0# a_1376_n116# a_3040_0# VSS nfet_06v0 ad=0.175p pd=1.2u as=0.175p ps=1.2u w=0.7u l=1u
X26 WE VD a_n74_1208# VSS nfet_06v0 ad=0.6448p pd=3u as=1.0912p ps=5.84u w=2.48u l=1u
X27 a_n74_0# VC WE VSS nfet_06v0 ad=1.0912p pd=5.84u as=0.6448p ps=3u w=2.48u l=1u
X28 a_4282_1208# WE VSS VSS nfet_06v0 ad=0.5p pd=2.5u as=0.88p ps=4.88u w=2u l=1u
X29 a_1376_n116# a_1376_n116# a_3640_0# VSS nfet_06v0 ad=0.308p pd=2.28u as=0.175p ps=1.2u w=0.7u l=1u
X30 VDD WE WE VDD pfet_06v0 ad=0.52p pd=2.52u as=0.52p ps=2.52u w=2u l=1u
X31 a_5026_1208# a_1376_n116# VSS VSS nfet_06v0 ad=0.5456p pd=3.36u as=0.5456p ps=3.36u w=1.24u l=1u
X32 WE VC a_n74_0# VSS nfet_06v0 ad=0.6448p pd=3u as=1.0912p ps=5.84u w=2.48u l=1u
C0 VDD VD 0.02903f
C1 VB a_1376_n116# 0.01468f
C2 VB VSS 0.11741f
C3 a_n74_1208# VA 0.01074f
C4 VDD a_3260_3312# 0.34939f
C5 a_1038_1208# a_1376_n116# 0.51245f
C6 a_n74_1208# a_n74_0# 0.03062f
C7 a_1038_1208# VSS 0.19291f
C8 VDD a_1376_n116# 0.37423f
C9 VDD OUT 0.41427f
C10 VB WE 0.92906f
C11 a_1038_1208# WE 1.83534f
C12 VDD WE 3.30995f
C13 a_5026_1208# a_3260_3312# 0.14971f
C14 a_2882_1208# a_1038_1208# 0.22004f
C15 a_5026_1208# a_1376_n116# 0.44242f
C16 VSS a_5026_1208# 0.2055f
C17 a_5026_1208# OUT 0.01429f
C18 VSS VD 0.12009f
C19 a_1376_n116# a_3260_3312# 1.67813f
C20 VSS a_3260_3312# 0.46098f
C21 a_5026_1208# WE 1.15137f
C22 OUT a_3260_3312# 3.64738f
C23 WE VD 0.60551f
C24 VSS a_1376_n116# 1.32534f
C25 OUT a_1376_n116# 0.47596f
C26 VDD OUT_N 0.19577f
C27 a_2882_1208# a_5026_1208# 0.16307f
C28 VSS OUT 0.41766f
C29 WE a_3260_3312# 0.85729f
C30 WE a_1376_n116# 2.22469f
C31 VSS WE 1.57746f
C32 VB a_n74_1208# 0.05042f
C33 a_2882_1208# a_1376_n116# 0.74171f
C34 a_2882_1208# VSS 0.18028f
C35 a_n74_1208# a_1038_1208# 0.09186f
C36 a_2882_1208# WE 2.35115f
C37 OUT_N a_3260_3312# 0.07488f
C38 OUT_N a_1376_n116# 0.33198f
C39 VSS OUT_N 0.27747f
C40 OUT OUT_N 2.80363f
C41 a_n74_1208# a_5026_1208# 0.01766f
C42 VC a_n74_0# 0.9383f
C43 a_n74_1208# VD 0.84961f
C44 a_n74_1208# a_3260_3312# 0.04672f
C45 VSS a_4282_1208# 0.01684f
C46 a_n74_1208# a_1376_n116# 0.52628f
C47 a_n74_1208# VSS 0.58503f
C48 VB VDD 0.04202f
C49 a_n74_1208# WE 4.01461f
C50 a_1038_1208# VDD 0.01531f
C51 a_2882_1208# a_4282_1208# 0.01057f
C52 VDD VDD 2.22806f
C53 a_2882_1208# a_n74_1208# 0.08238f
C54 VDD VD 0.01317f
C55 VDD a_3260_3312# 0.42267f
C56 VDD a_1376_n116# 0.54245f
C57 OUT VDD 0.43197f
C58 VA a_5026_1208# 0.74263f
C59 a_n74_1208# a_4282_1208# 0.01864f
C60 WE VDD 2.42592f
C61 VA a_3260_3312# 0.06262f
C62 VA a_1376_n116# 0.73865f
C63 VA VSS 0.1601f
C64 VA OUT 0.15556f
C65 a_n74_0# a_1376_n116# 0.32976f
C66 VSS a_n74_0# 0.16155f
C67 VA WE 1.01123f
C68 WE a_n74_0# 1.20417f
C69 VC VSS 0.18688f
C70 VDD OUT_N 0.10167f
C71 a_2882_1208# VA 0.04625f
C72 VB a_1038_1208# 1.02799f
C73 VDD VB 0.09095f
C74 VC WE 0.57303f
C75 VC VSS 0.89033f
C76 VSS VSS 6.21931f
C77 VA VSS 1.02452f
C78 VB VSS 1.02621f
C79 VD VSS 0.88956f
C80 OUT_N VSS 2.03503f
C81 OUT VSS 1.78472f
C82 VDD VSS 4.62696f
C83 WE VSS 6.81434f
C84 a_n74_0# VSS 1.24464f
C85 a_2882_1208# VSS 0.72418f
C86 a_5026_1208# VSS 0.7769f
C87 a_1038_1208# VSS 0.70008f
C88 a_n74_1208# VSS 2.41679f
C89 a_3260_3312# VSS 2.13225f
C90 a_1376_n116# VSS 6.1959f
C91 VDD VSS 18.0893f
.ends
