* fuente: /foss/designs/a_zonetic2026/XSCHEM/OPAM/simulation/OPAM_LIN_flat.sch/OPAM_LIN_flat.spice
* leida via enlace: /foss/designs/a_zonetic2026/spice_blocks/OPAM_LIN_flat.spice
* fecha de la fuente: 2026-08-18 00:59   sha1: a8b9a6dfa3
* generado por flatten_spice.py — NO editar a mano
* netlist plana generada por flatten_spice.py (top: OPAM_LIN_flat)
* 53 MOSFETs; nets fusionadas por V=0: ninguna
* nombres: los del esquematico; solo llevan la ruta de instancias (Mx1_M4) los -2 que chocaban
* m -> fingers: ninguno
* para generar el layout: nf = numero de dedos
.subckt OPAM_LIN_flat INN INP VDD VSS OUT
XM11 net5 net1 VDD VDD pfet_06v0 L=1.0u W=10.0u nf=1
XM12 net11 net6 net5 VDD pfet_06v0 L=1.0u W=10.0u nf=1
XM13 net22 net1 VDD VDD pfet_06v0 L=1.0u W=10.0u nf=1
XM14 net11 net6 net22 VDD pfet_06v0 L=1.0u W=10.0u nf=1
XM15 net9 INP net11 VDD pfet_06v0 L=1.0u W=1.1u nf=1
XM16 net8 INN net11 VDD pfet_06v0 L=1.0u W=1.0u nf=1
XM17 net12 net4 net2 VSS nfet_06v0 L=1.0u W=5.0u nf=1
XM18 net2 net3 VSS VSS nfet_06v0 L=1.0u W=5.0u nf=1
XM19 net12 net4 net23 VSS nfet_06v0 L=1.0u W=5.0u nf=1
XM20 net23 net3 VSS VSS nfet_06v0 L=1.0u W=5.0u nf=1
XM21 net10 INP net12 VSS nfet_06v0 L=1.0u W=1u nf=1
XM22 net7 INN net12 VSS nfet_06v0 L=1.0u W=1u nf=1
XM29 net13 net6 net7 VDD pfet_06v0 L=1.0u W=5u nf=1
XM30 G_OUT_P net6 net10 VDD pfet_06v0 L=1.0u W=5u nf=1
XM31 net7 net13 VDD VDD pfet_06v0 L=1.0u W=5u nf=1
XM35 net10 net13 VDD VDD pfet_06v0 L=1.0u W=5u nf=1
XM32 net14 net24 net13 VDD pfet_06v0 L=1.0u W=5.0u nf=1
XM33 net25 net24 G_OUT_P VDD pfet_06v0 L=1.0u W=5.0u nf=1
XM23 net14 net4 net8 VSS nfet_06v0 L=1.0u W=2.5u nf=1
XM24 net25 net4 net9 VSS nfet_06v0 L=1.0u W=2.5u nf=1
XM25 net8 net14 VSS VSS nfet_06v0 L=1.0u W=2.5u nf=1
XM26 net9 net14 VSS VSS nfet_06v0 L=1.0u W=2.5u nf=1
XM27 net13 net15 net14 VSS nfet_06v0 L=1.0u W=2.5u nf=1
XM28 G_OUT_P net15 net25 VSS nfet_06v0 L=1.0u W=2.5u nf=1
XM34 net16 net17 VDD VDD pfet_06v0 L=1.0u W=10.0u nf=1
XM36 net17 net6 net16 VDD pfet_06v0 L=1.0u W=10.0u nf=1
XM37 net24 net24 net17 VDD pfet_06v0 L=1.0u W=10.0u nf=1
XM38 net24 net4 net18 VSS nfet_06v0 L=1.0u W=5.0u nf=1
XM39 net18 net3 VSS VSS nfet_06v0 L=1.0u W=5.0u nf=1
XM45 net19 net1 VDD VDD pfet_06v0 L=1.0u W=10.0u nf=1
XM46 net15 net6 net19 VDD pfet_06v0 L=1.0u W=10.0u nf=1
XM40 net15 net15 net21 VSS nfet_06v0 L=1.0u W=5.0u nf=1
XM41 net21 net4 net20 VSS nfet_06v0 L=1.0u W=5.0u nf=1
XM42 net20 net21 VSS VSS nfet_06v0 L=1.0u W=5.0u nf=1
XM43_m1 OUT G_OUT_P VDD VDD pfet_06v0 L=1.0u W=0.5u nf=1
XM43_m2 OUT G_OUT_P VDD VDD pfet_06v0 L=1.0u W=0.5u nf=1
XM43_m3 OUT G_OUT_P VDD VDD pfet_06v0 L=1.0u W=0.5u nf=1
XM43_m4 OUT G_OUT_P VDD VDD pfet_06v0 L=1.0u W=0.5u nf=1
XM44 OUT net25 VSS VSS nfet_06v0 L=1.0u W=1.0u nf=1
XM4 net28 net1 VDD VDD pfet_06v0 L=1.0u W=10.0u nf=1
XM5 net4 net6 net28 VDD pfet_06v0 L=1.0u W=10.0u nf=1
XM6 net4 net4 VSS VSS nfet_06v0 L=1.0u W=1.0u nf=1
XM7 net27 net1 VDD VDD pfet_06v0 L=1.0u W=10.0u nf=1
XM8 net3 net6 net27 VDD pfet_06v0 L=1.0u W=10.0u nf=1
XM9 net3 net4 net26 VSS nfet_06v0 L=1.0u W=5.0u nf=1
XM10 net26 net3 VSS VSS nfet_06v0 L=1.0u W=5.0u nf=1
XM1 net6 net6 VDD VDD pfet_06v0 L=1.0u W=2u nf=1
XM2 net29 net1 VDD VDD pfet_06v0 L=1.0u W=10.0u nf=1
XM3 net1 net6 net29 VDD pfet_06v0 L=1.0u W=10.0u nf=1
XM47 net30 net6 VSS VSS nfet_06v0 L=1.0u W=1.0u nf=1
XM48 net31 net6 VSS VSS nfet_06v0 L=1.0u W=1.0u nf=1
XM49 net6 net6 net31 VSS nfet_06v0 L=1.0u W=1.0u nf=1
XM50 net1 net6 net30 VSS nfet_06v0 L=1.0u W=1.0u nf=1
XC3 net10 OUT cap_mim_2f0fF c_width=4.0u c_length=25.0u
XC1 OUT net9 cap_mim_2f0fF c_width=4.0u c_length=25.0u
XRFB G_OUT_P OUT VSS ppolyf_u_3k r_width=1e-6 r_length=76.45e-6 m=1 s=5
.ends
