* fuente: /foss/designs/a_zonetic2026/XSCHEM/OPAM/simulation/OPAM_LIN_flat.sch/OPAM_LIN_flat.spice
* leida via enlace: /foss/designs/a_zonetic2026/spice_blocks/OPAM_LIN_flat.spice
* fecha de la fuente: 2026-08-18 00:59   sha1: a8b9a6dfa3
* generado por flatten_spice.py — NO editar a mano
* netlist plana generada por flatten_spice.py (top: OPAM_LIN_flat)
* 53 MOSFETs; nets fusionadas por V=0: ninguna
* nombres: los del esquematico; solo llevan la ruta de instancias (Mx1_M4) los -2 que chocaban
* m -> fingers: ninguno
* para LVS: cada dedo, un transistor en paralelo
.subckt OPAM_LIN_flat INN INP VDD VSS OUT
M11 net5 net1 VDD VDD pfet_06v0 L=1.0u W=10.0u
M12 net11 net6 net5 VDD pfet_06v0 L=1.0u W=10.0u
M13 net22 net1 VDD VDD pfet_06v0 L=1.0u W=10.0u
M14 net11 net6 net22 VDD pfet_06v0 L=1.0u W=10.0u
M15 net9 INP net11 VDD pfet_06v0 L=1.0u W=1.1u
M16 net8 INN net11 VDD pfet_06v0 L=1.0u W=1.0u
M17 net12 net4 net2 VSS nfet_06v0 L=1.0u W=5.0u
M18 net2 net3 VSS VSS nfet_06v0 L=1.0u W=5.0u
M19 net12 net4 net23 VSS nfet_06v0 L=1.0u W=5.0u
M20 net23 net3 VSS VSS nfet_06v0 L=1.0u W=5.0u
M21 net10 INP net12 VSS nfet_06v0 L=1.0u W=1u
M22 net7 INN net12 VSS nfet_06v0 L=1.0u W=1u
M29 net13 net6 net7 VDD pfet_06v0 L=1.0u W=5u
M30 G_OUT_P net6 net10 VDD pfet_06v0 L=1.0u W=5u
M31 net7 net13 VDD VDD pfet_06v0 L=1.0u W=5u
M35 net10 net13 VDD VDD pfet_06v0 L=1.0u W=5u
M32 net14 net24 net13 VDD pfet_06v0 L=1.0u W=5.0u
M33 net25 net24 G_OUT_P VDD pfet_06v0 L=1.0u W=5.0u
M23 net14 net4 net8 VSS nfet_06v0 L=1.0u W=2.5u
M24 net25 net4 net9 VSS nfet_06v0 L=1.0u W=2.5u
M25 net8 net14 VSS VSS nfet_06v0 L=1.0u W=2.5u
M26 net9 net14 VSS VSS nfet_06v0 L=1.0u W=2.5u
M27 net13 net15 net14 VSS nfet_06v0 L=1.0u W=2.5u
M28 G_OUT_P net15 net25 VSS nfet_06v0 L=1.0u W=2.5u
M34 net16 net17 VDD VDD pfet_06v0 L=1.0u W=10.0u
M36 net17 net6 net16 VDD pfet_06v0 L=1.0u W=10.0u
M37 net24 net24 net17 VDD pfet_06v0 L=1.0u W=10.0u
M38 net24 net4 net18 VSS nfet_06v0 L=1.0u W=5.0u
M39 net18 net3 VSS VSS nfet_06v0 L=1.0u W=5.0u
M45 net19 net1 VDD VDD pfet_06v0 L=1.0u W=10.0u
M46 net15 net6 net19 VDD pfet_06v0 L=1.0u W=10.0u
M40 net15 net15 net21 VSS nfet_06v0 L=1.0u W=5.0u
M41 net21 net4 net20 VSS nfet_06v0 L=1.0u W=5.0u
M42 net20 net21 VSS VSS nfet_06v0 L=1.0u W=5.0u
M43_m1 OUT G_OUT_P VDD VDD pfet_06v0 L=1.0u W=0.5u
M43_m2 OUT G_OUT_P VDD VDD pfet_06v0 L=1.0u W=0.5u
M43_m3 OUT G_OUT_P VDD VDD pfet_06v0 L=1.0u W=0.5u
M43_m4 OUT G_OUT_P VDD VDD pfet_06v0 L=1.0u W=0.5u
M44 OUT net25 VSS VSS nfet_06v0 L=1.0u W=1.0u
M4 net28 net1 VDD VDD pfet_06v0 L=1.0u W=10.0u
M5 net4 net6 net28 VDD pfet_06v0 L=1.0u W=10.0u
M6 net4 net4 VSS VSS nfet_06v0 L=1.0u W=1.0u
M7 net27 net1 VDD VDD pfet_06v0 L=1.0u W=10.0u
M8 net3 net6 net27 VDD pfet_06v0 L=1.0u W=10.0u
M9 net3 net4 net26 VSS nfet_06v0 L=1.0u W=5.0u
M10 net26 net3 VSS VSS nfet_06v0 L=1.0u W=5.0u
M1 net6 net6 VDD VDD pfet_06v0 L=1.0u W=2u
M2 net29 net1 VDD VDD pfet_06v0 L=1.0u W=10.0u
M3 net1 net6 net29 VDD pfet_06v0 L=1.0u W=10.0u
M47 net30 net6 VSS VSS nfet_06v0 L=1.0u W=1.0u
M48 net31 net6 VSS VSS nfet_06v0 L=1.0u W=1.0u
M49 net6 net6 net31 VSS nfet_06v0 L=1.0u W=1.0u
M50 net1 net6 net30 VSS nfet_06v0 L=1.0u W=1.0u
* condensadores: elemento 'C' con W/L en METROS, no 'X' con c_width/c_length.
*   El deck de KLayout los lee con un delegate (custom_classes.lvs, SubcircuitModelsReader#element)
*   que SOLO actua si el elemento empieza por 'C', y de ahi saca A=W*L*1e12 y P=2*(W+L)*1e6.
*   Escrito como 'X...' se leeria como llamada a subcircuito y no emparejaria con nada.
C3 net10 OUT cap_mim_2f0fF W=4e-06 L=2.5e-05
C1 OUT net9 cap_mim_2f0fF W=4e-06 L=2.5e-05
* resistencias: elemento 'R' con W/L/S en METROS, no 'X' con r_width/r_length.
*   Mismo motivo que los condensadores: el delegate del deck (custom_classes.lvs,
*   SubcircuitModelsReader#element) solo entra por la primera letra, y para 'R' de tres
*   nodos monta un DeviceClassResistorWithBulk con los terminales A, B, W.
*   El deck hace W=W*PAR*1e6 y L=L*S*1e6, o sea que la 'S' MULTIPLICA el largo.
*   Aun asi la serie se escribe TRAMO A TRAMO, no con un 'S=5': el layout dibuja
*   `s` cuerpos de poly encadenados por metal1 y las dos herramientas los extraen
*   como `s` dispositivos. Juntarlos en uno exige la reduccion en serie, y netgen no
*   la aplica aqui porque lee la resistencia de tres nodos como si tuviera dos y le
*   pone de modelo el nodo de sustrato: la clase le sale 'VSS' y su setup no la
*   reconoce. Escribiendo los tramos, las dos partes cuentan lo mismo y no hace falta.
RFB_1 G_OUT_P RFB$1 VSS ppolyf_u_3k W=1e-06 L=7.645e-05 R=229350
RFB_2 RFB$1 RFB$2 VSS ppolyf_u_3k W=1e-06 L=7.645e-05 R=229350
RFB_3 RFB$2 RFB$3 VSS ppolyf_u_3k W=1e-06 L=7.645e-05 R=229350
RFB_4 RFB$3 RFB$4 VSS ppolyf_u_3k W=1e-06 L=7.645e-05 R=229350
RFB_5 RFB$4 OUT VSS ppolyf_u_3k W=1e-06 L=7.645e-05 R=229350
.ends
