* Nodos de bulk atados: 0 de pozo n -> VDD, 1 de sustrato -> VSS.
*   magic no extrae los taps de este layout y los dejaba flotando;
*   la conexion si existe (el LVS de KLayout da 'match uniquely').
*   Quien detecta un tap que falte de verdad es el LVS, no esto.
* NGSPICE file created from OPAM_LIN_flat.ext - technology: gf180mcuD

.subckt OPAM_LIN_flat VSS VDD INP OUT INN
X0 a_10898_6868# a_54_6752# VDD VDD pfet_06v0 ad=2.5p pd=10.5u as=4.4p ps=20.88u w=10u l=1u
X1 a_928_4922# a_16346_4472# VSS ppolyf_u_3k r_width=1u r_length=76.45u
X2 OUT a_928_4472# VDD VDD pfet_06v0 ad=0.22p pd=1.88u as=0.22p ps=1.88u w=0.5u l=1u
X3 a_54_6752# a_354_6752# a_18294_6868# VDD pfet_06v0 ad=4.4p pd=20.88u as=2.5p ps=10.5u w=10u l=1u
X4 a_928_4472# a_16346_4472# VSS ppolyf_u_3k r_width=1u r_length=76.45u
X5 a_2278_446# a_4102_6868# VDD VDD pfet_06v0 ad=2.2p pd=10.88u as=2.2p ps=10.88u w=5u l=1u
X6 a_214_446# a_14_330# VSS VSS nfet_06v0 ad=1.25p pd=5.5u as=2.2p ps=10.88u w=5u l=1u
X7 a_4492_446# a_314_330# a_2478_6868# VSS nfet_06v0 ad=1.1p pd=5.88u as=1.1p ps=5.88u w=2.5u l=1u
X8 a_2478_6868# a_3760_446# VSS VSS nfet_06v0 ad=1.1p pd=5.88u as=1.1p ps=5.88u w=2.5u l=1u
X9 a_4492_446# a_7150_6752# a_928_4472# VDD pfet_06v0 ad=2.2p pd=10.88u as=2.2p ps=10.88u w=5u l=1u
X10 a_354_6752# a_354_6752# VDD VDD pfet_06v0 ad=0.88p pd=4.88u as=0.88p ps=4.88u w=2u l=1u
X11 a_7150_6752# a_314_330# a_8152_446# VSS nfet_06v0 ad=2.2p pd=10.88u as=1.25p ps=5.5u w=5u l=1u
X12 a_9916_446# a_8896_446# VSS VSS nfet_06v0 ad=1.25p pd=5.5u as=2.2p ps=10.88u w=5u l=1u
X13 a_12412_446# a_14_330# VSS VSS nfet_06v0 ad=1.25p pd=5.5u as=2.2p ps=10.88u w=5u l=1u
X14 a_15258_6868# a_54_6752# VDD VDD pfet_06v0 ad=2.5p pd=10.5u as=4.4p ps=20.88u w=10u l=1u
X15 a_6488_330# a_354_6752# a_10898_6868# VDD pfet_06v0 ad=4.4p pd=20.88u as=2.5p ps=10.5u w=10u l=1u
X16 a_928_5822# a_16346_5372# VSS ppolyf_u_3k r_width=1u r_length=76.45u
X17 a_928_4922# a_16346_5372# VSS ppolyf_u_3k r_width=1u r_length=76.45u
X18 a_8152_446# a_14_330# VSS VSS nfet_06v0 ad=1.25p pd=5.5u as=2.2p ps=10.88u w=5u l=1u
X19 a_14_330# a_314_330# a_12412_446# VSS nfet_06v0 ad=2.2p pd=10.88u as=1.25p ps=5.5u w=5u l=1u
X20 a_4102_6868# a_354_6752# a_3010_446# VDD pfet_06v0 ad=2.2p pd=10.88u as=2.2p ps=10.88u w=5u l=1u
X21 a_16370_6868# a_54_6752# VDD VDD pfet_06v0 ad=2.5p pd=10.5u as=4.4p ps=20.88u w=10u l=1u
X22 a_3290_6868# INN a_554_6868# VDD pfet_06v0 ad=0.44p pd=2.88u as=0.44p ps=2.88u w=1u l=1u
X23 a_8774_6752# a_354_6752# a_8974_6868# VDD pfet_06v0 ad=4.4p pd=20.88u as=2.5p ps=10.5u w=10u l=1u
X24 a_4102_6868# a_6488_330# a_3760_446# VSS nfet_06v0 ad=1.1p pd=5.88u as=1.1p ps=5.88u w=2.5u l=1u
X25 a_2478_6868# OUT cap_mim_2f0_m4m5_noshield c_width=25u c_length=4u
X26 a_554_6868# a_354_6752# a_254_6868# VDD pfet_06v0 ad=4.4p pd=20.88u as=2.5p ps=10.5u w=10u l=1u
X27 a_1246_446# a_14_330# VSS VSS nfet_06v0 ad=1.25p pd=5.5u as=2.2p ps=10.88u w=5u l=1u
X28 OUT a_928_4472# VDD VDD pfet_06v0 ad=0.22p pd=1.88u as=0.22p ps=1.88u w=0.5u l=1u
X29 a_314_330# a_354_6752# a_15258_6868# VDD pfet_06v0 ad=4.4p pd=20.88u as=2.5p ps=10.5u w=10u l=1u
X30 a_3010_446# INN a_514_446# VSS nfet_06v0 ad=0.44p pd=2.88u as=0.44p ps=2.88u w=1u l=1u
X31 OUT a_4492_446# VSS VSS nfet_06v0 ad=0.44p pd=2.88u as=0.44p ps=2.88u w=1u l=1u
X32 a_2478_6868# INP a_554_6868# VDD pfet_06v0 ad=0.484p pd=3.08u as=0.484p ps=3.08u w=1.1u l=1u
X33 a_3010_446# a_4102_6868# VDD VDD pfet_06v0 ad=2.2p pd=10.88u as=2.2p ps=10.88u w=5u l=1u
X34 a_514_446# a_314_330# a_1246_446# VSS nfet_06v0 ad=2.2p pd=10.88u as=1.25p ps=5.5u w=5u l=1u
X35 a_13444_446# a_354_6752# VSS VSS nfet_06v0 ad=0.25p pd=1.5u as=0.44p ps=2.88u w=1u l=1u
X36 a_928_5822# OUT VSS ppolyf_u_3k r_width=1u r_length=76.45u
X37 a_7150_6752# a_7150_6752# a_8774_6752# VDD pfet_06v0 ad=4.4p pd=20.88u as=4.4p ps=20.88u w=10u l=1u
X38 a_14_330# a_354_6752# a_16370_6868# VDD pfet_06v0 ad=4.4p pd=20.88u as=2.5p ps=10.5u w=10u l=1u
X39 a_3290_6868# a_3760_446# VSS VSS nfet_06v0 ad=1.1p pd=5.88u as=1.1p ps=5.88u w=2.5u l=1u
X40 a_1366_6868# a_54_6752# VDD VDD pfet_06v0 ad=2.5p pd=10.5u as=4.4p ps=20.88u w=10u l=1u
X41 OUT a_928_4472# VDD VDD pfet_06v0 ad=0.22p pd=1.88u as=0.22p ps=1.88u w=0.5u l=1u
X42 a_6488_330# a_6488_330# a_8896_446# VSS nfet_06v0 ad=2.2p pd=10.88u as=2.2p ps=10.88u w=5u l=1u
X43 a_54_6752# a_354_6752# a_13444_446# VSS nfet_06v0 ad=0.44p pd=2.88u as=0.25p ps=1.5u w=1u l=1u
X44 a_314_330# a_314_330# VSS VSS nfet_06v0 ad=0.44p pd=2.88u as=0.44p ps=2.88u w=1u l=1u
X45 a_8974_6868# a_8774_6752# VDD VDD pfet_06v0 ad=2.5p pd=10.5u as=4.4p ps=20.88u w=10u l=1u
X46 a_18294_6868# a_54_6752# VDD VDD pfet_06v0 ad=2.5p pd=10.5u as=4.4p ps=20.88u w=10u l=1u
X47 a_2278_446# INP a_514_446# VSS nfet_06v0 ad=0.44p pd=2.88u as=0.44p ps=2.88u w=1u l=1u
X48 a_254_6868# a_54_6752# VDD VDD pfet_06v0 ad=2.5p pd=10.5u as=4.4p ps=20.88u w=10u l=1u
X49 a_928_4472# a_6488_330# a_4492_446# VSS nfet_06v0 ad=1.1p pd=5.88u as=1.1p ps=5.88u w=2.5u l=1u
X50 a_514_446# a_314_330# a_214_446# VSS nfet_06v0 ad=2.2p pd=10.88u as=1.25p ps=5.5u w=5u l=1u
X51 a_3760_446# a_314_330# a_3290_6868# VSS nfet_06v0 ad=1.1p pd=5.88u as=1.1p ps=5.88u w=2.5u l=1u
X52 OUT a_928_4472# VDD VDD pfet_06v0 ad=0.22p pd=1.88u as=0.22p ps=1.88u w=0.5u l=1u
X53 a_14476_446# a_354_6752# VSS VSS nfet_06v0 ad=0.25p pd=1.5u as=0.44p ps=2.88u w=1u l=1u
X54 a_554_6868# a_354_6752# a_1366_6868# VDD pfet_06v0 ad=4.4p pd=20.88u as=2.5p ps=10.5u w=10u l=1u
X55 a_928_4472# a_354_6752# a_2278_446# VDD pfet_06v0 ad=2.2p pd=10.88u as=2.2p ps=10.88u w=5u l=1u
X56 a_3760_446# a_7150_6752# a_4102_6868# VDD pfet_06v0 ad=2.2p pd=10.88u as=2.2p ps=10.88u w=5u l=1u
X57 a_8896_446# a_314_330# a_9916_446# VSS nfet_06v0 ad=2.2p pd=10.88u as=1.25p ps=5.5u w=5u l=1u
X58 a_354_6752# a_354_6752# a_14476_446# VSS nfet_06v0 ad=0.44p pd=2.88u as=0.25p ps=1.5u w=1u l=1u
X59 OUT a_2278_446# cap_mim_2f0_m4m5_noshield c_width=25u c_length=4u
C0 a_4492_446# a_2278_446# 0.0144f
C1 a_928_4472# a_3290_6868# 0.01786f
C2 a_354_6752# INP 0.53492f
C3 a_928_4472# INN 0.06174f
C4 a_2478_6868# a_514_446# 0.10845f
C5 a_354_6752# VDD 5.16739f
C6 a_354_6752# OUT 1.57857f
C7 a_928_4472# INP 0.01661f
C8 a_2478_6868# a_2278_446# 0.21792f
C9 a_3010_446# a_314_330# 0.02347f
C10 a_3010_446# a_3760_446# 0.82561f
C11 VDD a_18294_6868# 0.07296f
C12 a_4102_6868# a_314_330# 0.01983f
C13 a_4102_6868# a_3760_446# 0.6454f
C14 a_928_4472# VDD 2.58097f
C15 a_928_4472# OUT 8.27129f
C16 a_3290_6868# a_314_330# 1.29388f
C17 a_8152_446# a_7150_6752# 0.02626f
C18 a_3760_446# a_3290_6868# 0.90253f
C19 a_54_6752# a_16346_4472# 0.28303f
C20 INN a_314_330# 0.02882f
C21 a_16370_6868# a_14_330# 0.05253f
C22 a_354_6752# a_928_4472# 5.25801f
C23 a_3010_446# a_14_330# 0.02716f
C24 a_54_6752# a_928_4922# 0.11941f
C25 a_4492_446# a_54_6752# 2.4151f
C26 INP a_314_330# 0.02598f
C27 a_4102_6868# a_14_330# 0.02759f
C28 a_54_6752# a_6488_330# 0.14417f
C29 a_4102_6868# a_7150_6752# 1.48835f
C30 VDD a_10898_6868# 0.06858f
C31 VDD a_314_330# 0.67365f
C32 a_3760_446# VDD 0.18668f
C33 OUT a_314_330# 0.23087f
C34 OUT a_3760_446# 0.17675f
C35 a_3010_446# a_514_446# 0.04597f
C36 a_8774_6752# a_8974_6868# 0.05253f
C37 a_54_6752# a_2478_6868# 0.71055f
C38 a_3010_446# a_2278_446# 0.09371f
C39 a_554_6868# a_3290_6868# 0.04597f
C40 a_4492_446# a_6488_330# 1.11616f
C41 a_3290_6868# a_14_330# 0.05712f
C42 a_8774_6752# a_7150_6752# 2.54393f
C43 a_554_6868# INN 1.52649f
C44 a_4102_6868# a_2278_446# 2.73849f
C45 INN a_14_330# 0.02671f
C46 a_554_6868# INP 1.30901f
C47 a_4492_446# a_2478_6868# 0.83063f
C48 INP a_14_330# 0.02677f
C49 a_354_6752# a_314_330# 1.91766f
C50 a_354_6752# a_3760_446# 0.50396f
C51 a_6488_330# a_2478_6868# 0.09817f
C52 VDD a_8974_6868# 0.06907f
C53 INN a_514_446# 0.61292f
C54 a_3290_6868# a_2278_446# 0.06691f
C55 a_554_6868# VDD 1.43519f
C56 a_554_6868# OUT 0.25382f
C57 VDD a_14_330# 0.67874f
C58 OUT a_14_330# 0.0973f
C59 INN a_2278_446# 0.09494f
C60 a_928_4472# a_314_330# 0.03002f
C61 a_928_4472# a_3760_446# 1.64002f
C62 VDD a_7150_6752# 1.81739f
C63 a_9916_446# a_8896_446# 0.02626f
C64 OUT a_7150_6752# 0.05113f
C65 VDD a_928_5822# 0.02455f
C66 INP a_514_446# 0.63585f
C67 INP a_2278_446# 1.28511f
C68 a_1366_6868# VDD 0.06858f
C69 OUT a_514_446# 0.02066f
C70 VDD a_2278_446# 0.5705f
C71 a_354_6752# a_554_6868# 3.10723f
C72 OUT a_2278_446# 1.41002f
C73 a_354_6752# a_14_330# 2.26398f
C74 VDD a_254_6868# 0.07506f
C75 a_354_6752# a_7150_6752# 0.46211f
C76 a_3010_446# a_54_6752# 0.02204f
C77 OUT a_16346_5372# 0.03247f
C78 a_928_4472# a_554_6868# 0.06602f
C79 a_4102_6868# a_54_6752# 0.02832f
C80 a_928_4472# a_14_330# 0.06384f
C81 a_928_4472# a_7150_6752# 1.82581f
C82 a_3760_446# a_314_330# 0.58399f
C83 a_354_6752# a_2278_446# 2.51126f
C84 a_4492_446# a_4102_6868# 0.26125f
C85 a_354_6752# a_16346_5372# 0.43868f
C86 a_12412_446# a_14_330# 0.0329f
C87 a_54_6752# a_3290_6868# 0.02609f
C88 VDD a_15258_6868# 0.06858f
C89 a_4102_6868# a_6488_330# 0.5605f
C90 INN a_54_6752# 0.0242f
C91 a_928_4472# a_2278_446# 0.38118f
C92 a_3010_446# a_2478_6868# 0.02638f
C93 a_4492_446# a_8774_6752# 0.28641f
C94 a_54_6752# INP 0.17055f
C95 a_4102_6868# a_2478_6868# 0.01136f
C96 a_4492_446# a_3290_6868# 0.02668f
C97 a_8896_446# a_314_330# 0.60356f
C98 a_54_6752# VDD 4.9922f
C99 a_14_330# a_314_330# 7.0269f
C100 a_3760_446# a_14_330# 0.12051f
C101 OUT a_54_6752# 0.93942f
C102 a_7150_6752# a_314_330# 0.39205f
C103 a_3760_446# a_7150_6752# 1.52616f
C104 a_2478_6868# a_3290_6868# 0.80926f
C105 INN a_2478_6868# 0.22376f
C106 a_4492_446# VDD 0.28741f
C107 a_4492_446# OUT 0.74901f
C108 a_1246_446# a_514_446# 0.02626f
C109 a_514_446# a_314_330# 1.66622f
C110 a_6488_330# VDD 0.67262f
C111 OUT a_6488_330# 0.22246f
C112 a_2278_446# a_314_330# 0.07621f
C113 a_3760_446# a_2278_446# 0.42678f
C114 a_2478_6868# INP 1.58261f
C115 a_354_6752# a_54_6752# 8.64773f
C116 a_8896_446# a_14_330# 0.10617f
C117 a_7150_6752# a_8896_446# 0.22142f
C118 a_354_6752# a_16346_4472# 0.43886f
C119 a_54_6752# a_18294_6868# 0.05253f
C120 VDD a_2478_6868# 0.0955f
C121 OUT a_2478_6868# 2.55578f
C122 a_928_4472# a_54_6752# 0.12099f
C123 a_7150_6752# a_14_330# 0.06359f
C124 a_554_6868# a_928_5822# 0.04286f
C125 a_4492_446# a_354_6752# 0.02544f
C126 a_554_6868# a_1366_6868# 0.05253f
C127 a_354_6752# a_6488_330# 2.0717f
C128 a_3010_446# a_4102_6868# 2.51212f
C129 a_514_446# a_14_330# 0.20977f
C130 a_928_4472# a_928_4922# 0.02812f
C131 a_4492_446# a_928_4472# 0.41415f
C132 a_554_6868# a_2278_446# 0.08428f
C133 a_15258_6868# a_314_330# 0.05253f
C134 a_2278_446# a_14_330# 0.06854f
C135 a_928_4472# a_6488_330# 0.84771f
C136 a_554_6868# a_254_6868# 0.05253f
C137 a_354_6752# a_2478_6868# 0.47742f
C138 a_3010_446# a_3290_6868# 0.81011f
C139 a_3010_446# INN 1.30959f
C140 a_928_4472# a_2478_6868# 0.10677f
C141 a_514_446# a_2278_446# 0.30994f
C142 a_54_6752# a_314_330# 0.87032f
C143 a_54_6752# a_3760_446# 0.10126f
C144 VDD a_16370_6868# 0.06858f
C145 OUT a_16370_6868# 0.01351f
C146 a_3010_446# VDD 0.71262f
C147 a_3010_446# OUT 0.19311f
C148 a_6488_330# a_10898_6868# 0.05253f
C149 a_4492_446# a_314_330# 0.61964f
C150 a_4492_446# a_3760_446# 0.20148f
C151 INN a_3290_6868# 1.35934f
C152 a_4102_6868# VDD 1.63929f
C153 OUT a_4102_6868# 0.10935f
C154 a_6488_330# a_314_330# 1.87168f
C155 a_3760_446# a_6488_330# 0.54983f
C156 INN INP 0.03427f
C157 a_554_6868# a_54_6752# 0.28287f
C158 a_214_446# a_514_446# 0.02626f
C159 a_54_6752# a_14_330# 0.27956f
C160 a_2478_6868# a_314_330# 0.94005f
C161 VDD a_8774_6752# 1.55797f
C162 a_3760_446# a_2478_6868# 1.13427f
C163 OUT a_8774_6752# 0.03221f
C164 a_54_6752# a_7150_6752# 1.44539f
C165 a_3010_446# a_354_6752# 1.61306f
C166 VDD a_3290_6868# 0.09251f
C167 OUT a_3290_6868# 0.0458f
C168 a_54_6752# a_928_5822# 0.11941f
C169 INN VDD 0.40821f
C170 a_4492_446# a_8896_446# 0.67896f
C171 INN OUT 0.40619f
C172 a_354_6752# a_4102_6868# 1.45924f
C173 a_6488_330# a_8896_446# 1.29827f
C174 a_554_6868# a_928_4922# 0.04313f
C175 a_3010_446# a_928_4472# 0.09451f
C176 a_4492_446# a_14_330# 0.08674f
C177 a_54_6752# a_514_446# 0.23842f
C178 VDD INP 0.40855f
C179 OUT INP 0.09358f
C180 a_4492_446# a_7150_6752# 1.79893f
C181 a_6488_330# a_14_330# 0.13522f
C182 a_928_4472# a_4102_6868# 0.37928f
C183 a_54_6752# a_2278_446# 1.97928f
C184 a_928_4922# a_928_5822# 0.01879f
C185 a_6488_330# a_7150_6752# 0.03331f
C186 a_354_6752# a_8774_6752# 2.89662f
C187 a_2478_6868# a_8896_446# 0.06525f
C188 a_54_6752# a_16346_5372# 0.28331f
C189 a_354_6752# a_3290_6868# 0.03502f
C190 OUT VDD 0.60411f
C191 a_354_6752# INN 0.08915f
C192 a_554_6868# a_2478_6868# 0.41908f
C193 a_2478_6868# a_14_330# 0.18518f
C194 a_16346_4472# a_16346_5372# 0.01879f
C195 a_928_4472# a_8774_6752# 0.08552f
C196 a_2478_6868# a_7150_6752# 0.03606f
C197 OUT VSS 11.5107f
C198 INN VSS 1.62685f
C199 INP VSS 1.55518f
C200 VDD VSS 0.16424p
C201 a_14476_446# VSS 0.01078f
C202 a_13444_446# VSS 0.01272f
C203 a_12412_446# VSS 0.0407f
C204 a_9916_446# VSS 0.04305f
C205 a_8152_446# VSS 0.0407f
C206 a_1246_446# VSS 0.0407f
C207 a_514_446# VSS 1.74352f
C208 a_214_446# VSS 0.04408f
C209 a_8896_446# VSS 1.71072f
C210 a_16346_4472# VSS 0.42113f
C211 a_928_4922# VSS 0.57275f
C212 a_16346_5372# VSS 0.40473f
C213 a_928_5822# VSS 0.56459f
C214 a_14_330# VSS 7.41398f
C215 a_314_330# VSS 7.48287f
C216 a_6488_330# VSS 3.50204f
C217 a_4492_446# VSS 3.05177f
C218 a_3760_446# VSS 4.34218f
C219 a_928_4472# VSS 7.9536f
C220 a_2278_446# VSS 4.12216f
C221 a_3290_6868# VSS 1.79522f
C222 a_2478_6868# VSS 6.09546f
C223 a_3010_446# VSS 2.06355f
C224 a_4102_6868# VSS 3.70231f
C225 a_554_6868# VSS 3.57583f
C226 a_7150_6752# VSS 3.16477f
C227 a_8774_6752# VSS 2.48493f
C228 a_354_6752# VSS 13.7488f
C229 a_54_6752# VSS 10.5299f
.ends
