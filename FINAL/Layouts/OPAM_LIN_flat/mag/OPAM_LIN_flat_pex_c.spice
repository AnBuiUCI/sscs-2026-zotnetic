* Nodos de bulk atados: 0 de pozo n -> VDD, 1 de sustrato -> VSS.
*   magic no extrae los taps de este layout y los dejaba flotando;
*   la conexion si existe (el LVS de KLayout da 'match uniquely').
*   Quien detecta un tap que falte de verdad es el LVS, no esto.
* NGSPICE file created from OPAM_LIN_flat.ext - technology: gf180mcuD

.subckt OPAM_LIN_flat VSS VDD INP OUT INN
X0 a_4492_446# a_7150_7452# a_928_5172# VDD pfet_06v0 ad=1.76p pd=8.88u as=1.76p ps=8.88u w=4u l=1u
X1 a_354_7452# a_354_7452# VDD VDD pfet_06v0 ad=0.88p pd=4.88u as=0.88p ps=4.88u w=2u l=1u
X2 a_15258_7568# a_54_7452# VDD VDD pfet_06v0 ad=2.5p pd=10.5u as=4.4p ps=20.88u w=10u l=1u
X3 a_214_446# a_14_330# VSS VSS nfet_06v0 ad=1.25p pd=5.5u as=2.2p ps=10.88u w=5u l=1u
X4 a_4492_446# a_314_330# a_2478_7568# VSS nfet_06v0 ad=1.1p pd=5.88u as=1.1p ps=5.88u w=2.5u l=1u
X5 a_2478_7568# a_3760_446# VSS VSS nfet_06v0 ad=1.1p pd=5.88u as=1.1p ps=5.88u w=2.5u l=1u
X6 a_6488_330# a_354_7452# a_10898_7568# VDD pfet_06v0 ad=4.4p pd=20.88u as=2.5p ps=10.5u w=10u l=1u
X7 a_7150_7452# a_314_330# a_8152_446# VSS nfet_06v0 ad=2.2p pd=10.88u as=1.25p ps=5.5u w=5u l=1u
X8 a_9916_446# a_8896_446# VSS VSS nfet_06v0 ad=1.25p pd=5.5u as=2.2p ps=10.88u w=5u l=1u
X9 a_12412_446# a_14_330# VSS VSS nfet_06v0 ad=1.25p pd=5.5u as=2.2p ps=10.88u w=5u l=1u
X10 a_928_6522# a_16346_6072# VSS ppolyf_u_1k r_width=1u r_length=76.45u
X11 a_928_5622# a_16346_6072# VSS ppolyf_u_1k r_width=1u r_length=76.45u
X12 a_3290_7568# INN a_554_7568# VDD pfet_06v0 ad=0.22p pd=1.88u as=0.22p ps=1.88u w=0.5u l=1u
X13 a_4102_7568# a_354_7452# a_3010_446# VDD pfet_06v0 ad=4.4p pd=20.88u as=4.4p ps=20.88u w=10u l=1u
X14 a_16370_7568# a_54_7452# VDD VDD pfet_06v0 ad=2.5p pd=10.5u as=4.4p ps=20.88u w=10u l=1u
X15 a_8774_7452# a_354_7452# a_8974_7568# VDD pfet_06v0 ad=4.4p pd=20.88u as=2.5p ps=10.5u w=10u l=1u
X16 a_8152_446# a_14_330# VSS VSS nfet_06v0 ad=1.25p pd=5.5u as=2.2p ps=10.88u w=5u l=1u
X17 a_14_330# a_314_330# a_12412_446# VSS nfet_06v0 ad=2.2p pd=10.88u as=1.25p ps=5.5u w=5u l=1u
X18 a_554_7568# a_354_7452# a_254_7568# VDD pfet_06v0 ad=4.4p pd=20.88u as=2.5p ps=10.5u w=10u l=1u
X19 OUT a_928_5172# VDD VDD pfet_06v0 ad=0.44p pd=2.88u as=0.44p ps=2.88u w=1u l=1u
X20 a_4102_7568# a_6488_330# a_3760_446# VSS nfet_06v0 ad=0.88p pd=4.88u as=0.88p ps=4.88u w=2u l=1u
X21 a_2478_7568# INP a_554_7568# VDD pfet_06v0 ad=0.242p pd=1.98u as=0.242p ps=1.98u w=0.55u l=1u
X22 a_3010_446# a_4102_7568# VDD VDD pfet_06v0 ad=2.2p pd=10.88u as=2.2p ps=10.88u w=5u l=1u
X23 a_314_330# a_354_7452# a_15258_7568# VDD pfet_06v0 ad=4.4p pd=20.88u as=2.5p ps=10.5u w=10u l=1u
X24 a_928_6522# OUT VSS ppolyf_u_1k r_width=1u r_length=76.45u
X25 a_1246_446# a_14_330# VSS VSS nfet_06v0 ad=1.25p pd=5.5u as=2.2p ps=10.88u w=5u l=1u
X26 a_14_330# a_354_7452# a_16370_7568# VDD pfet_06v0 ad=4.4p pd=20.88u as=2.5p ps=10.5u w=10u l=1u
X27 a_3010_446# INN a_514_446# VSS nfet_06v0 ad=3.74p pd=17.88u as=3.74p ps=17.88u w=8.5u l=1u
X28 OUT a_4492_446# VSS VSS nfet_06v0 ad=0.44p pd=2.88u as=0.44p ps=2.88u w=1u l=1u
X29 a_7150_7452# a_7150_7452# a_8774_7452# VDD pfet_06v0 ad=4.4p pd=20.88u as=4.4p ps=20.88u w=10u l=1u
X30 OUT a_928_5172# VDD VDD pfet_06v0 ad=0.44p pd=2.88u as=0.44p ps=2.88u w=1u l=1u
X31 a_514_446# a_314_330# a_1246_446# VSS nfet_06v0 ad=2.2p pd=10.88u as=1.25p ps=5.5u w=5u l=1u
X32 a_13444_446# a_354_7452# VSS VSS nfet_06v0 ad=0.25p pd=1.5u as=0.44p ps=2.88u w=1u l=1u
X33 a_1366_7568# a_54_7452# VDD VDD pfet_06v0 ad=2.5p pd=10.5u as=4.4p ps=20.88u w=10u l=1u
X34 a_3290_7568# a_3760_446# VSS VSS nfet_06v0 ad=1.1p pd=5.88u as=1.1p ps=5.88u w=2.5u l=1u
X35 a_8974_7568# a_8774_7452# VDD VDD pfet_06v0 ad=2.5p pd=10.5u as=4.4p ps=20.88u w=10u l=1u
X36 a_6488_330# a_6488_330# a_8896_446# VSS nfet_06v0 ad=2.2p pd=10.88u as=2.2p ps=10.88u w=5u l=1u
X37 a_54_7452# a_354_7452# a_13444_446# VSS nfet_06v0 ad=0.44p pd=2.88u as=0.25p ps=1.5u w=1u l=1u
X38 a_18294_7568# a_54_7452# VDD VDD pfet_06v0 ad=2.5p pd=10.5u as=4.4p ps=20.88u w=10u l=1u
X39 a_314_330# a_314_330# VSS VSS nfet_06v0 ad=0.44p pd=2.88u as=0.44p ps=2.88u w=1u l=1u
X40 a_2478_7568# OUT cap_mim_2f0_m4m5_noshield c_width=25u c_length=8u
X41 OUT a_2278_446# cap_mim_2f0_m4m5_noshield c_width=25u c_length=8u
X42 a_254_7568# a_54_7452# VDD VDD pfet_06v0 ad=2.5p pd=10.5u as=4.4p ps=20.88u w=10u l=1u
X43 OUT a_928_5172# VDD VDD pfet_06v0 ad=0.44p pd=2.88u as=0.44p ps=2.88u w=1u l=1u
X44 a_2278_446# INP a_514_446# VSS nfet_06v0 ad=3.3p pd=15.88u as=3.3p ps=15.88u w=7.5u l=1u
X45 a_554_7568# a_354_7452# a_1366_7568# VDD pfet_06v0 ad=4.4p pd=20.88u as=2.5p ps=10.5u w=10u l=1u
X46 a_928_5172# a_354_7452# a_2278_446# VDD pfet_06v0 ad=4.4p pd=20.88u as=4.4p ps=20.88u w=10u l=1u
X47 a_3760_446# a_7150_7452# a_4102_7568# VDD pfet_06v0 ad=1.76p pd=8.88u as=1.76p ps=8.88u w=4u l=1u
X48 a_928_5172# a_6488_330# a_4492_446# VSS nfet_06v0 ad=0.88p pd=4.88u as=0.88p ps=4.88u w=2u l=1u
X49 a_514_446# a_314_330# a_214_446# VSS nfet_06v0 ad=2.2p pd=10.88u as=1.25p ps=5.5u w=5u l=1u
X50 a_3760_446# a_314_330# a_3290_7568# VSS nfet_06v0 ad=1.1p pd=5.88u as=1.1p ps=5.88u w=2.5u l=1u
X51 a_10898_7568# a_54_7452# VDD VDD pfet_06v0 ad=2.5p pd=10.5u as=4.4p ps=20.88u w=10u l=1u
X52 a_14476_446# a_354_7452# VSS VSS nfet_06v0 ad=0.25p pd=1.5u as=0.44p ps=2.88u w=1u l=1u
X53 OUT a_928_5172# VDD VDD pfet_06v0 ad=0.44p pd=2.88u as=0.44p ps=2.88u w=1u l=1u
X54 a_54_7452# a_354_7452# a_18294_7568# VDD pfet_06v0 ad=4.4p pd=20.88u as=2.5p ps=10.5u w=10u l=1u
X55 a_928_5622# a_16346_5172# VSS ppolyf_u_1k r_width=1u r_length=76.45u
X56 a_928_5172# a_16346_5172# VSS ppolyf_u_1k r_width=1u r_length=76.45u
X57 a_2278_446# a_4102_7568# VDD VDD pfet_06v0 ad=2.2p pd=10.88u as=2.2p ps=10.88u w=5u l=1u
X58 a_8896_446# a_314_330# a_9916_446# VSS nfet_06v0 ad=2.2p pd=10.88u as=1.25p ps=5.5u w=5u l=1u
X59 a_354_7452# a_354_7452# a_14476_446# VSS nfet_06v0 ad=0.44p pd=2.88u as=0.25p ps=1.5u w=1u l=1u
C0 a_514_446# a_214_446# 0.02626f
C1 a_8774_7452# OUT 0.03221f
C2 a_54_7452# a_314_330# 0.8687f
C3 a_3760_446# a_7150_7452# 1.50353f
C4 a_3760_446# a_2278_446# 0.46175f
C5 a_3760_446# OUT 0.20003f
C6 a_3010_446# a_4102_7568# 2.7066f
C7 a_14_330# a_6488_330# 0.10996f
C8 VDD a_6488_330# 0.67259f
C9 a_3010_446# a_514_446# 0.33769f
C10 a_14_330# a_16370_7568# 0.05253f
C11 a_4492_446# a_14_330# 0.08332f
C12 a_354_7452# a_314_330# 1.91465f
C13 VDD a_16370_7568# 0.06858f
C14 VDD a_4492_446# 0.24486f
C15 a_4102_7568# a_928_5172# 0.37954f
C16 a_3290_7568# a_4492_446# 0.02665f
C17 a_2478_7568# a_6488_330# 0.08594f
C18 a_54_7452# a_354_7452# 8.95463f
C19 a_2478_7568# a_4492_446# 0.82867f
C20 a_7150_7452# a_6488_330# 0.03127f
C21 a_15258_7568# a_314_330# 0.05253f
C22 a_16346_5172# a_16346_6072# 0.01879f
C23 a_7150_7452# a_8152_446# 0.02626f
C24 a_4492_446# a_7150_7452# 1.77626f
C25 OUT a_6488_330# 0.22325f
C26 a_4492_446# a_2278_446# 0.03559f
C27 VDD a_10898_7568# 0.06858f
C28 OUT a_16370_7568# 0.01351f
C29 OUT a_4492_446# 1.0902f
C30 a_1366_7568# VDD 0.06858f
C31 VDD a_18294_7568# 0.07296f
C32 a_4102_7568# a_314_330# 0.0198f
C33 VDD a_254_7568# 0.07506f
C34 a_54_7452# a_4102_7568# 0.02831f
C35 a_514_446# a_314_330# 2.16784f
C36 a_54_7452# a_514_446# 0.23841f
C37 a_9916_446# a_8896_446# 0.02626f
C38 a_1246_446# a_514_446# 0.02626f
C39 a_3010_446# a_14_330# 0.02975f
C40 VDD a_3010_446# 0.90406f
C41 OUT a_16346_6072# 0.03604f
C42 a_3290_7568# a_3010_446# 0.87898f
C43 a_8896_446# a_14_330# 0.08936f
C44 a_928_5172# a_14_330# 0.11846f
C45 a_3010_446# a_2478_7568# 0.02609f
C46 VDD a_928_5172# 2.82474f
C47 a_354_7452# a_4102_7568# 1.57028f
C48 a_3290_7568# a_928_5172# 0.01786f
C49 a_2478_7568# a_8896_446# 0.05738f
C50 VDD a_554_7568# 1.41763f
C51 a_3290_7568# a_554_7568# 0.02653f
C52 a_2478_7568# a_928_5172# 0.12838f
C53 a_2478_7568# a_554_7568# 0.3881f
C54 a_3010_446# a_2278_446# 0.09297f
C55 a_7150_7452# a_8896_446# 0.30509f
C56 a_8774_7452# a_4492_446# 0.28641f
C57 OUT a_3010_446# 0.11034f
C58 a_7150_7452# a_928_5172# 1.80317f
C59 a_3760_446# a_6488_330# 0.82334f
C60 a_2278_446# a_928_5172# 0.44823f
C61 a_314_330# a_14_330# 7.71987f
C62 OUT a_928_5172# 8.22645f
C63 a_2278_446# a_554_7568# 0.0177f
C64 a_3010_446# INN 1.19255f
C65 a_3760_446# a_4492_446# 0.25714f
C66 VDD a_314_330# 0.67365f
C67 a_54_7452# a_14_330# 0.2759f
C68 a_3290_7568# a_314_330# 1.54433f
C69 OUT a_554_7568# 0.04089f
C70 VDD a_54_7452# 4.9922f
C71 a_3290_7568# a_54_7452# 0.02607f
C72 a_2478_7568# a_314_330# 1.21156f
C73 INN a_928_5172# 0.06174f
C74 a_54_7452# a_16346_5172# 0.28303f
C75 a_54_7452# a_2478_7568# 0.87014f
C76 INN a_554_7568# 1.51488f
C77 INP a_928_5172# 0.01661f
C78 a_354_7452# a_14_330# 2.31088f
C79 VDD a_354_7452# 5.26427f
C80 INP a_554_7568# 1.29656f
C81 a_7150_7452# a_314_330# 0.64075f
C82 a_3290_7568# a_354_7452# 0.03502f
C83 a_314_330# a_2278_446# 0.11732f
C84 a_54_7452# a_7150_7452# 1.44536f
C85 a_54_7452# a_2278_446# 1.97498f
C86 a_354_7452# a_16346_5172# 0.43886f
C87 OUT a_314_330# 0.73105f
C88 a_2478_7568# a_354_7452# 0.64976f
C89 OUT a_54_7452# 1.02818f
C90 a_4492_446# a_6488_330# 1.39092f
C91 a_8974_7568# VDD 0.06907f
C92 INN a_314_330# 0.02968f
C93 VDD a_15258_7568# 0.06858f
C94 a_8774_7452# a_928_5172# 0.08552f
C95 a_54_7452# INN 0.02447f
C96 a_3760_446# a_3010_446# 0.82561f
C97 a_354_7452# a_7150_7452# 0.4621f
C98 a_354_7452# a_2278_446# 2.63744f
C99 INP a_314_330# 0.02636f
C100 OUT a_354_7452# 1.15037f
C101 a_3760_446# a_928_5172# 1.62087f
C102 a_54_7452# INP 0.17074f
C103 a_554_7568# a_928_6522# 0.04286f
C104 a_4102_7568# a_14_330# 0.02706f
C105 a_928_5622# a_928_6522# 0.01879f
C106 VDD a_4102_7568# 1.74767f
C107 a_514_446# a_14_330# 0.26554f
C108 a_354_7452# INN 0.08929f
C109 a_2478_7568# a_4102_7568# 0.01073f
C110 a_10898_7568# a_6488_330# 0.05253f
C111 a_2478_7568# a_514_446# 0.10847f
C112 a_354_7452# INP 0.53504f
C113 a_4102_7568# a_7150_7452# 1.45873f
C114 a_4102_7568# a_2278_446# 2.78035f
C115 a_54_7452# a_928_6522# 0.11941f
C116 a_3760_446# a_314_330# 0.83435f
C117 a_8896_446# a_6488_330# 1.60421f
C118 a_514_446# a_2278_446# 0.6734f
C119 OUT a_4102_7568# 0.04211f
C120 a_3760_446# a_54_7452# 0.10099f
C121 a_928_5172# a_6488_330# 1.12309f
C122 a_4492_446# a_8896_446# 0.73462f
C123 OUT a_514_446# 0.42151f
C124 a_4492_446# a_928_5172# 0.35579f
C125 a_8774_7452# a_354_7452# 2.89662f
C126 a_514_446# INN 0.49601f
C127 VDD a_14_330# 0.67874f
C128 a_3760_446# a_354_7452# 0.50396f
C129 a_3290_7568# a_14_330# 0.05609f
C130 INP a_514_446# 0.5683f
C131 a_3290_7568# VDD 0.08112f
C132 a_8974_7568# a_8774_7452# 0.05253f
C133 a_2478_7568# a_14_330# 0.20995f
C134 VDD a_2478_7568# 0.08262f
C135 a_3290_7568# a_2478_7568# 0.80921f
C136 a_314_330# a_6488_330# 1.86927f
C137 a_2478_7568# a_16346_5172# 0.03048f
C138 a_54_7452# a_6488_330# 0.14362f
C139 a_4492_446# a_314_330# 0.86958f
C140 a_1366_7568# a_554_7568# 0.05253f
C141 a_54_7452# a_4492_446# 2.41509f
C142 a_7150_7452# a_14_330# 0.06095f
C143 VDD a_7150_7452# 1.8156f
C144 a_2278_446# a_14_330# 0.1247f
C145 a_254_7568# a_554_7568# 0.05253f
C146 VDD a_2278_446# 0.7065f
C147 a_3290_7568# a_2278_446# 0.06806f
C148 OUT a_14_330# 0.80446f
C149 a_3010_446# a_928_5172# 0.09451f
C150 VDD OUT 0.77642f
C151 a_2478_7568# a_7150_7452# 0.03459f
C152 a_3290_7568# OUT 0.17267f
C153 a_3760_446# a_4102_7568# 0.58714f
C154 a_2478_7568# a_2278_446# 0.22064f
C155 a_354_7452# a_6488_330# 2.06984f
C156 a_54_7452# a_16346_6072# 0.28331f
C157 OUT a_16346_5172# 0.01133f
C158 OUT a_2478_7568# 3.15956f
C159 INN a_14_330# 0.04186f
C160 VDD INN 0.40788f
C161 a_354_7452# a_4492_446# 0.02544f
C162 a_3290_7568# INN 1.3479f
C163 a_928_5172# a_554_7568# 0.06602f
C164 a_928_5172# a_928_5622# 0.02812f
C165 a_2478_7568# INN 0.22392f
C166 INP a_14_330# 0.03562f
C167 a_554_7568# a_928_5622# 0.04313f
C168 a_7150_7452# a_2278_446# 0.01259f
C169 VDD INP 0.40808f
C170 a_54_7452# a_18294_7568# 0.05253f
C171 OUT a_7150_7452# 0.05113f
C172 a_354_7452# a_16346_6072# 0.43868f
C173 OUT a_2278_446# 1.98171f
C174 a_2478_7568# INP 1.57016f
C175 a_12412_446# a_14_330# 0.02789f
C176 a_3010_446# a_314_330# 0.02367f
C177 a_3010_446# a_54_7452# 0.02206f
C178 INN a_2278_446# 0.07929f
C179 a_314_330# a_8896_446# 0.96946f
C180 a_4102_7568# a_6488_330# 0.83597f
C181 OUT INN 0.12736f
C182 a_314_330# a_928_5172# 0.02899f
C183 a_8774_7452# VDD 1.55797f
C184 a_4492_446# a_4102_7568# 0.34531f
C185 a_54_7452# a_928_5172# 0.12098f
C186 INP a_2278_446# 1.21173f
C187 a_54_7452# a_554_7568# 0.28287f
C188 a_54_7452# a_928_5622# 0.11941f
C189 OUT INP 0.1188f
C190 VDD a_928_6522# 0.02455f
C191 a_3760_446# a_14_330# 0.11034f
C192 a_3010_446# a_354_7452# 1.72626f
C193 a_3760_446# VDD 0.16324f
C194 a_3290_7568# a_3760_446# 1.20918f
C195 INP INN 0.03276f
C196 a_3760_446# a_2478_7568# 1.54904f
C197 a_354_7452# a_928_5172# 5.37119f
C198 a_8774_7452# a_7150_7452# 2.54393f
C199 a_354_7452# a_554_7568# 3.10723f
C200 OUT VSS 13.035f
C201 INN VSS 1.55134f
C202 INP VSS 1.49142f
C203 VDD VSS 0.16412p
C204 a_14476_446# VSS 0.01078f
C205 a_13444_446# VSS 0.01272f
C206 a_12412_446# VSS 0.0407f
C207 a_9916_446# VSS 0.04305f
C208 a_8152_446# VSS 0.0407f
C209 a_8896_446# VSS 2.14414f
C210 a_1246_446# VSS 0.0407f
C211 a_214_446# VSS 0.04408f
C212 a_514_446# VSS 2.05174f
C213 a_16346_5172# VSS 0.42113f
C214 a_928_5622# VSS 0.57275f
C215 a_16346_6072# VSS 0.40473f
C216 a_928_6522# VSS 0.56459f
C217 a_14_330# VSS 8.45558f
C218 a_314_330# VSS 8.50291f
C219 a_6488_330# VSS 3.93066f
C220 a_4492_446# VSS 3.46784f
C221 a_3760_446# VSS 4.88123f
C222 a_928_5172# VSS 8.10275f
C223 a_2278_446# VSS 4.33482f
C224 a_4102_7568# VSS 3.83692f
C225 a_3290_7568# VSS 2.06408f
C226 a_2478_7568# VSS 7.09981f
C227 a_3010_446# VSS 2.10851f
C228 a_554_7568# VSS 3.579f
C229 a_7150_7452# VSS 3.29423f
C230 a_8774_7452# VSS 2.48493f
C231 a_354_7452# VSS 14.5333f
C232 a_54_7452# VSS 10.6735f
.ends
