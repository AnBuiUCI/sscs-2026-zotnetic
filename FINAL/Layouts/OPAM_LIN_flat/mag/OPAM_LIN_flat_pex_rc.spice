* Nodos de bulk atados: 28 de pozo n -> VDD, 26 de sustrato -> VSS.
*   magic no extrae los taps de este layout y los dejaba flotando;
*   la conexion si existe (el LVS de KLayout da 'match uniquely').
*   Quien detecta un tap que falte de verdad es el LVS, no esto.
* NGSPICE file created from OPAM_LIN_flat.ext - technology: gf180mcuD

.subckt OPAM_LIN_flat VSS VDD INP OUT INN
X0 a_10898_6868.t1 a_54_6752.t5 VDD.t35 VDD pfet_06v0 ad=2.5p pd=10.5u as=4.4p ps=20.88u w=10u l=1u
X1 a_928_4922.t1 a_16346_4472.t1 VSS.t9 ppolyf_u_3k r_width=1u r_length=76.45u
X2 OUT.t6 a_928_4472.t5 VDD.t33 VDD pfet_06v0 ad=0.22p pd=1.88u as=0.22p ps=1.88u w=0.5u l=1u
X3 a_54_6752.t1 a_354_6752.t7 a_18294_6868.t1 VDD pfet_06v0 ad=4.4p pd=20.88u as=2.5p ps=10.5u w=10u l=1u
X4 a_928_4472.t2 a_16346_4472.t0 VSS.t9 ppolyf_u_3k r_width=1u r_length=76.45u
X5 a_2278_446.t1 a_4102_6868.t3 VDD.t12 VDD pfet_06v0 ad=2.2p pd=10.88u as=2.2p ps=10.88u w=5u l=1u
X6 a_214_446.t0 a_14_330.t5 VSS.t8 VSS nfet_06v0 ad=1.25p pd=5.5u as=2.2p ps=10.88u w=5u l=1u
X7 a_4492_446.t2 a_314_330.t6 a_2478_6868.t1 VSS nfet_06v0 ad=1.1p pd=5.88u as=1.1p ps=5.88u w=2.5u l=1u
X8 a_2478_6868.t0 a_3760_446.t3 VSS.t20 VSS nfet_06v0 ad=1.1p pd=5.88u as=1.1p ps=5.88u w=2.5u l=1u
X9 a_4492_446.t1 a_7150_6752.t3 a_928_4472.t3 VDD pfet_06v0 ad=2.2p pd=10.88u as=2.2p ps=10.88u w=5u l=1u
X10 a_354_6752.t3 a_354_6752.t2 VDD.t25 VDD pfet_06v0 ad=0.88p pd=4.88u as=0.88p ps=4.88u w=2u l=1u
X11 a_7150_6752.t0 a_314_330.t5 a_8152_446.t0 VSS nfet_06v0 ad=2.2p pd=10.88u as=1.25p ps=5.5u w=5u l=1u
X12 a_9916_446.t1 a_8896_446.t2 VSS.t30 VSS nfet_06v0 ad=1.25p pd=5.5u as=2.2p ps=10.88u w=5u l=1u
X13 a_12412_446.t0 a_14_330.t2 VSS.t11 VSS nfet_06v0 ad=1.25p pd=5.5u as=2.2p ps=10.88u w=5u l=1u
X14 a_15258_6868.t1 a_54_6752.t4 VDD.t31 VDD pfet_06v0 ad=2.5p pd=10.5u as=4.4p ps=20.88u w=10u l=1u
X15 a_6488_330.t2 a_354_6752.t10 a_10898_6868.t0 VDD pfet_06v0 ad=4.4p pd=20.88u as=2.5p ps=10.5u w=10u l=1u
X16 a_928_5822.t1 a_16346_5372.t1 VSS.t9 ppolyf_u_3k r_width=1u r_length=76.45u
X17 a_928_4922.t0 a_16346_5372.t0 VSS.t9 ppolyf_u_3k r_width=1u r_length=76.45u
X18 a_8152_446.t1 a_14_330.t3 VSS.t32 VSS nfet_06v0 ad=1.25p pd=5.5u as=2.2p ps=10.88u w=5u l=1u
X19 a_14_330.t1 a_314_330.t3 a_12412_446.t1 VSS nfet_06v0 ad=2.2p pd=10.88u as=1.25p ps=5.5u w=5u l=1u
X20 a_4102_6868.t2 a_354_6752.t13 a_3010_446.t2 VDD pfet_06v0 ad=2.2p pd=10.88u as=2.2p ps=10.88u w=5u l=1u
X21 a_16370_6868.t1 a_54_6752.t3 VDD.t18 VDD pfet_06v0 ad=2.5p pd=10.5u as=4.4p ps=20.88u w=10u l=1u
X22 a_3290_6868.t1 INN.t1 a_554_6868.t1 VDD pfet_06v0 ad=0.44p pd=2.88u as=0.44p ps=2.88u w=1u l=1u
X23 a_8774_6752.t1 a_354_6752.t11 a_8974_6868.t1 VDD pfet_06v0 ad=4.4p pd=20.88u as=2.5p ps=10.5u w=10u l=1u
X24 a_4102_6868.t0 a_6488_330.t4 a_3760_446.t0 VSS nfet_06v0 ad=1.1p pd=5.88u as=1.1p ps=5.88u w=2.5u l=1u
X25 a_2478_6868.t3 OUT.t3 cap_mim_2f0_m4m5_noshield c_width=25u c_length=4u
X26 a_554_6868.t2 a_354_6752.t15 a_254_6868.t1 VDD pfet_06v0 ad=4.4p pd=20.88u as=2.5p ps=10.5u w=10u l=1u
X27 a_1246_446.t0 a_14_330.t4 VSS.t34 VSS nfet_06v0 ad=1.25p pd=5.5u as=2.2p ps=10.88u w=5u l=1u
X28 OUT.t4 a_928_4472.t6 VDD.t27 VDD pfet_06v0 ad=0.22p pd=1.88u as=0.22p ps=1.88u w=0.5u l=1u
X29 a_314_330.t0 a_354_6752.t9 a_15258_6868.t0 VDD pfet_06v0 ad=4.4p pd=20.88u as=2.5p ps=10.5u w=10u l=1u
X30 a_3010_446.t0 INN.t0 a_514_446.t0 VSS nfet_06v0 ad=0.44p pd=2.88u as=0.44p ps=2.88u w=1u l=1u
X31 OUT.t0 a_4492_446.t3 VSS.t1 VSS nfet_06v0 ad=0.44p pd=2.88u as=0.44p ps=2.88u w=1u l=1u
X32 a_2478_6868.t2 INP.t1 a_554_6868.t3 VDD pfet_06v0 ad=0.484p pd=3.08u as=0.484p ps=3.08u w=1.1u l=1u
X33 a_3010_446.t1 a_4102_6868.t4 VDD.t21 VDD pfet_06v0 ad=2.2p pd=10.88u as=2.2p ps=10.88u w=5u l=1u
X34 a_514_446.t2 a_314_330.t8 a_1246_446.t1 VSS nfet_06v0 ad=2.2p pd=10.88u as=1.25p ps=5.5u w=5u l=1u
X35 a_13444_446.t0 a_354_6752.t6 VSS.t3 VSS nfet_06v0 ad=0.25p pd=1.5u as=0.44p ps=2.88u w=1u l=1u
X36 a_928_5822.t0 OUT.t2 VSS.t9 ppolyf_u_3k r_width=1u r_length=76.45u
X37 a_7150_6752.t2 a_7150_6752.t1 a_8774_6752.t0 VDD pfet_06v0 ad=4.4p pd=20.88u as=4.4p ps=20.88u w=10u l=1u
X38 a_14_330.t0 a_354_6752.t8 a_16370_6868.t0 VDD pfet_06v0 ad=4.4p pd=20.88u as=2.5p ps=10.5u w=10u l=1u
X39 a_3290_6868.t0 a_3760_446.t4 VSS.t16 VSS nfet_06v0 ad=1.1p pd=5.88u as=1.1p ps=5.88u w=2.5u l=1u
X40 a_1366_6868.t0 a_54_6752.t6 VDD.t2 VDD pfet_06v0 ad=2.5p pd=10.5u as=4.4p ps=20.88u w=10u l=1u
X41 OUT.t1 a_928_4472.t4 VDD.t8 VDD pfet_06v0 ad=0.22p pd=1.88u as=0.22p ps=1.88u w=0.5u l=1u
X42 a_6488_330.t1 a_6488_330.t0 a_8896_446.t0 VSS nfet_06v0 ad=2.2p pd=10.88u as=2.2p ps=10.88u w=5u l=1u
X43 a_54_6752.t0 a_354_6752.t5 a_13444_446.t1 VSS nfet_06v0 ad=0.44p pd=2.88u as=0.25p ps=1.5u w=1u l=1u
X44 a_314_330.t2 a_314_330.t1 VSS.t27 VSS nfet_06v0 ad=0.44p pd=2.88u as=0.44p ps=2.88u w=1u l=1u
X45 a_8974_6868.t0 a_8774_6752.t2 VDD.t23 VDD pfet_06v0 ad=2.5p pd=10.5u as=4.4p ps=20.88u w=10u l=1u
X46 a_18294_6868.t0 a_54_6752.t2 VDD.t14 VDD pfet_06v0 ad=2.5p pd=10.5u as=4.4p ps=20.88u w=10u l=1u
X47 a_2278_446.t3 INP.t0 a_514_446.t1 VSS nfet_06v0 ad=0.44p pd=2.88u as=0.44p ps=2.88u w=1u l=1u
X48 a_254_6868.t0 a_54_6752.t7 VDD.t6 VDD pfet_06v0 ad=2.5p pd=10.5u as=4.4p ps=20.88u w=10u l=1u
X49 a_928_4472.t0 a_6488_330.t3 a_4492_446.t0 VSS nfet_06v0 ad=1.1p pd=5.88u as=1.1p ps=5.88u w=2.5u l=1u
X50 a_514_446.t3 a_314_330.t9 a_214_446.t1 VSS nfet_06v0 ad=2.2p pd=10.88u as=1.25p ps=5.5u w=5u l=1u
X51 a_3760_446.t2 a_314_330.t7 a_3290_6868.t2 VSS nfet_06v0 ad=1.1p pd=5.88u as=1.1p ps=5.88u w=2.5u l=1u
X52 OUT.t5 a_928_4472.t7 VDD.t29 VDD pfet_06v0 ad=0.22p pd=1.88u as=0.22p ps=1.88u w=0.5u l=1u
X53 a_14476_446.t1 a_354_6752.t4 VSS.t24 VSS nfet_06v0 ad=0.25p pd=1.5u as=0.44p ps=2.88u w=1u l=1u
X54 a_554_6868.t0 a_354_6752.t14 a_1366_6868.t1 VDD pfet_06v0 ad=4.4p pd=20.88u as=2.5p ps=10.5u w=10u l=1u
X55 a_928_4472.t1 a_354_6752.t12 a_2278_446.t0 VDD pfet_06v0 ad=2.2p pd=10.88u as=2.2p ps=10.88u w=5u l=1u
X56 a_3760_446.t1 a_7150_6752.t4 a_4102_6868.t1 VDD pfet_06v0 ad=2.2p pd=10.88u as=2.2p ps=10.88u w=5u l=1u
X57 a_8896_446.t1 a_314_330.t4 a_9916_446.t0 VSS nfet_06v0 ad=2.2p pd=10.88u as=1.25p ps=5.5u w=5u l=1u
X58 a_354_6752.t1 a_354_6752.t0 a_14476_446.t0 VSS nfet_06v0 ad=0.44p pd=2.88u as=0.25p ps=1.5u w=1u l=1u
X59 OUT.t7 a_2278_446.t2 cap_mim_2f0_m4m5_noshield c_width=25u c_length=4u
R0 OUT.n2 OUT.t2 24.3632
R1 OUT.n3 OUT.t1 21.0191
R2 OUT.n5 OUT.t4 20.6077
R3 OUT.n4 OUT.t6 20.6077
R4 OUT OUT.t5 16.1077
R5 OUT.n1 OUT.t7 15.7572
R6 OUT.n1 OUT.t0 14.5181
R7 OUT.n7 OUT.n6 5.423
R8 OUT.n8 OUT.n7 5.1755
R9 OUT.n2 OUT.t3 4.67993
R10 OUT.n3 OUT.n2 4.5005
R11 OUT.n7 OUT.n0 4.5005
R12 OUT OUT.n9 4.5005
R13 OUT.n8 OUT.n1 1.34407
R14 OUT.n6 OUT.n5 0.842643
R15 OUT.n9 OUT.n0 0.829786
R16 OUT.n4 OUT.n3 0.823357
R17 OUT.n5 OUT.n0 0.4055
R18 OUT.n6 OUT.n4 0.392643
R19 OUT.n9 OUT.n8 0.0715526
R20 INN INN.t0 25.1959
R21 INN INN.t1 17.0491
R22 INP INP.t0 23.7679
R23 INP INP.t1 18.7054
R24 VDD VDD 296.135
R25 VDD VDD 296.135
R26 VDD VDD 296.135
R27 VDD VDD 296.135
R28 VDD VDD 296.135
R29 VDD VDD 296.135
R30 VDD VDD 296.135
R31 VDD VDD 296.135
R32 VDD VDD 296.135
R33 VDD VDD 296.135
R34 VDD.n20 VDD 148.797
R35 VDD.n39 VDD 148.797
R36 VDD.n41 VDD 148.797
R37 VDD VDD.n40 148.797
R38 VDD.n114 VDD 148.797
R39 VDD VDD.n113 148.797
R40 VDD.n103 VDD 148.797
R41 VDD VDD.n102 148.797
R42 VDD.n93 VDD 148.797
R43 VDD VDD.n92 148.797
R44 VDD.n20 VDD 147.339
R45 VDD VDD.n39 147.339
R46 VDD.n41 VDD 147.339
R47 VDD.n40 VDD 147.339
R48 VDD.n114 VDD 147.339
R49 VDD.n113 VDD 147.339
R50 VDD.n103 VDD 147.339
R51 VDD.n102 VDD 147.339
R52 VDD.n93 VDD 147.339
R53 VDD.n92 VDD 147.339
R54 VDD VDD 109.409
R55 VDD VDD 109.409
R56 VDD VDD 109.409
R57 VDD VDD 109.409
R58 VDD VDD 109.409
R59 VDD VDD 109.409
R60 VDD VDD 109.409
R61 VDD.n49 VDD.t29 13.136
R62 VDD.n8 VDD.t27 13.136
R63 VDD.n10 VDD.t33 13.136
R64 VDD.n31 VDD.t8 13.136
R65 VDD.n21 VDD.n20 12.6005
R66 VDD.n39 VDD.n38 12.6005
R67 VDD.n42 VDD.n41 12.6005
R68 VDD.n40 VDD.n6 12.6005
R69 VDD.n115 VDD.n114 12.6005
R70 VDD.n113 VDD.n112 12.6005
R71 VDD.n104 VDD.n103 12.6005
R72 VDD.n102 VDD.n101 12.6005
R73 VDD.n94 VDD.n93 12.6005
R74 VDD.n92 VDD.n91 12.6005
R75 VDD.n89 VDD.n88 9.0005
R76 VDD.n87 VDD.n81 9.0005
R77 VDD.n86 VDD.n85 9.0005
R78 VDD.n84 VDD.n82 9.0005
R79 VDD.n83 VDD.n79 9.0005
R80 VDD.n95 VDD.n78 9.0005
R81 VDD.n97 VDD.n96 9.0005
R82 VDD.n98 VDD.n70 9.0005
R83 VDD.n100 VDD.n99 9.0005
R84 VDD.n77 VDD.n69 9.0005
R85 VDD.n76 VDD.n75 9.0005
R86 VDD.n73 VDD.n72 9.0005
R87 VDD.n71 VDD.n68 9.0005
R88 VDD.n106 VDD.n67 9.0005
R89 VDD.n108 VDD.n107 9.0005
R90 VDD.n109 VDD.n3 9.0005
R91 VDD.n111 VDD.n110 9.0005
R92 VDD.n66 VDD.n2 9.0005
R93 VDD.n65 VDD.n64 9.0005
R94 VDD.n62 VDD.n4 9.0005
R95 VDD.n61 VDD.n60 9.0005
R96 VDD.n59 VDD.n1 9.0005
R97 VDD.n58 VDD.n0 9.0005
R98 VDD.n57 VDD.n56 9.0005
R99 VDD.n54 VDD.n5 9.0005
R100 VDD.n53 VDD.n52 9.0005
R101 VDD.n51 VDD.n50 9.0005
R102 VDD.n48 VDD.n7 9.0005
R103 VDD.n47 VDD.n46 9.0005
R104 VDD.n45 VDD.n44 9.0005
R105 VDD.n43 VDD.n9 9.0005
R106 VDD.n32 VDD.n30 9.0005
R107 VDD.n34 VDD.n33 9.0005
R108 VDD.n35 VDD.n12 9.0005
R109 VDD.n37 VDD.n36 9.0005
R110 VDD.n29 VDD.n28 9.0005
R111 VDD.n27 VDD.n13 9.0005
R112 VDD.n26 VDD.n25 9.0005
R113 VDD.n24 VDD.n23 9.0005
R114 VDD.n22 VDD.n15 9.0005
R115 VDD.n19 VDD.n18 9.0005
R116 VDD.n16 VDD.t25 6.09214
R117 VDD.n74 VDD.t21 3.93838
R118 VDD.n105 VDD.t12 3.93838
R119 VDD.n90 VDD.n89 3.23511
R120 VDD.n90 VDD.t6 2.28071
R121 VDD.n18 VDD.n17 2.25773
R122 VDD.n17 VDD.t14 2.17725
R123 VDD.n80 VDD.t2 2.1044
R124 VDD.n63 VDD.t23 2.1044
R125 VDD.n55 VDD.t35 2.1044
R126 VDD.n11 VDD.t31 2.1044
R127 VDD.n14 VDD.t18 2.1044
R128 VDD.n17 VDD.n16 0.330481
R129 VDD.n91 VDD.n90 0.25569
R130 VDD.n18 VDD.n15 0.2005
R131 VDD.n24 VDD.n15 0.2005
R132 VDD.n25 VDD.n24 0.2005
R133 VDD.n25 VDD.n13 0.2005
R134 VDD.n29 VDD.n13 0.2005
R135 VDD.n36 VDD.n29 0.2005
R136 VDD.n36 VDD.n35 0.2005
R137 VDD.n35 VDD.n34 0.2005
R138 VDD.n34 VDD.n30 0.2005
R139 VDD.n30 VDD.n9 0.2005
R140 VDD.n45 VDD.n9 0.2005
R141 VDD.n46 VDD.n45 0.2005
R142 VDD.n46 VDD.n7 0.2005
R143 VDD.n51 VDD.n7 0.2005
R144 VDD.n52 VDD.n51 0.2005
R145 VDD.n52 VDD.n5 0.2005
R146 VDD.n57 VDD.n5 0.2005
R147 VDD.n58 VDD.n57 0.2005
R148 VDD.n59 VDD.n58 0.2005
R149 VDD.n60 VDD.n59 0.2005
R150 VDD.n60 VDD.n4 0.2005
R151 VDD.n65 VDD.n4 0.2005
R152 VDD.n66 VDD.n65 0.2005
R153 VDD.n110 VDD.n66 0.2005
R154 VDD.n110 VDD.n109 0.2005
R155 VDD.n109 VDD.n108 0.2005
R156 VDD.n108 VDD.n67 0.2005
R157 VDD.n71 VDD.n67 0.2005
R158 VDD.n72 VDD.n71 0.2005
R159 VDD.n76 VDD.n72 0.2005
R160 VDD.n77 VDD.n76 0.2005
R161 VDD.n99 VDD.n77 0.2005
R162 VDD.n99 VDD.n98 0.2005
R163 VDD.n98 VDD.n97 0.2005
R164 VDD.n97 VDD.n78 0.2005
R165 VDD.n83 VDD.n78 0.2005
R166 VDD.n84 VDD.n83 0.2005
R167 VDD.n85 VDD.n84 0.2005
R168 VDD.n85 VDD.n81 0.2005
R169 VDD.n89 VDD.n81 0.2005
R170 VDD.n23 VDD.n22 0.2005
R171 VDD.n27 VDD.n26 0.2005
R172 VDD.n28 VDD.n27 0.2005
R173 VDD.n37 VDD.n12 0.2005
R174 VDD.n33 VDD.n32 0.2005
R175 VDD.n44 VDD.n43 0.2005
R176 VDD.n48 VDD.n47 0.2005
R177 VDD.n54 VDD.n53 0.2005
R178 VDD.n56 VDD.n0 0.2005
R179 VDD.n61 VDD.n1 0.2005
R180 VDD.n62 VDD.n61 0.2005
R181 VDD.n64 VDD.n2 0.2005
R182 VDD.n111 VDD.n3 0.2005
R183 VDD.n107 VDD.n3 0.2005
R184 VDD.n107 VDD.n106 0.2005
R185 VDD.n73 VDD.n68 0.2005
R186 VDD.n75 VDD.n69 0.2005
R187 VDD.n100 VDD.n70 0.2005
R188 VDD.n96 VDD.n70 0.2005
R189 VDD.n96 VDD.n95 0.2005
R190 VDD.n82 VDD.n79 0.2005
R191 VDD.n86 VDD.n82 0.2005
R192 VDD.n87 VDD.n86 0.2005
R193 VDD.n88 VDD.n87 0.2005
R194 VDD.n64 VDD.n63 0.199
R195 VDD.n53 VDD.n6 0.1975
R196 VDD.n75 VDD.n74 0.175
R197 VDD.n95 VDD.n94 0.1635
R198 VDD.n56 VDD.n55 0.161
R199 VDD VDD.n0 0.1565
R200 VDD.n101 VDD.n69 0.1515
R201 VDD.n33 VDD.n31 0.135
R202 VDD.n22 VDD.n21 0.1335
R203 VDD.n112 VDD.n2 0.1275
R204 VDD.n47 VDD.n8 0.123
R205 VDD.n38 VDD.n11 0.12
R206 VDD.n42 VDD.n10 0.12
R207 VDD.n105 VDD.n104 0.12
R208 VDD.n91 VDD.n80 0.12
R209 VDD.n50 VDD.n49 0.117
R210 VDD.n23 VDD.n14 0.104
R211 VDD.n26 VDD.n14 0.097
R212 VDD.n49 VDD.n48 0.084
R213 VDD.n44 VDD.n8 0.078
R214 VDD.n112 VDD.n111 0.0735
R215 VDD.n32 VDD.n10 0.072
R216 VDD.n21 VDD.n19 0.0675
R217 VDD.n31 VDD.n12 0.066
R218 VDD.n104 VDD.n68 0.0615
R219 VDD.n28 VDD.n11 0.06
R220 VDD.n19 VDD.n16 0.053
R221 VDD.n101 VDD.n100 0.0495
R222 VDD.n55 VDD.n54 0.04
R223 VDD.n94 VDD.n79 0.0375
R224 VDD.n115 VDD.n1 0.0355
R225 VDD.n74 VDD.n73 0.026
R226 VDD.n38 VDD.n37 0.0215
R227 VDD.n106 VDD.n105 0.02
R228 VDD.n43 VDD.n42 0.0095
R229 VDD VDD.n115 0.0095
R230 VDD.n88 VDD.n80 0.006
R231 VDD.n50 VDD.n6 0.0035
R232 VDD.n63 VDD.n62 0.002
R233 VSS VSS 370.892
R234 VSS VSS 361.99
R235 VSS VSS 361.99
R236 VSS VSS 361.99
R237 VSS VSS 361.99
R238 VSS VSS 361.99
R239 VSS VSS 361.99
R240 VSS VSS 361.99
R241 VSS.n16 VSS 273.421
R242 VSS.n24 VSS 181.984
R243 VSS.n25 VSS 181.984
R244 VSS.n40 VSS 181.984
R245 VSS.n41 VSS 181.984
R246 VSS.n83 VSS 181.984
R247 VSS VSS.n82 181.984
R248 VSS.n74 VSS 181.984
R249 VSS VSS.n73 181.984
R250 VSS.n63 VSS 181.984
R251 VSS VSS.n24 180.006
R252 VSS.n25 VSS 180.006
R253 VSS VSS.n40 180.006
R254 VSS.n83 VSS 180.006
R255 VSS.n82 VSS 180.006
R256 VSS.n74 VSS 180.006
R257 VSS.n73 VSS 180.006
R258 VSS.n63 VSS 180.006
R259 VSS VSS.t9 172.589
R260 VSS VSS 148.357
R261 VSS VSS 148.357
R262 VSS VSS 148.357
R263 VSS VSS 148.357
R264 VSS VSS 148.357
R265 VSS VSS 148.357
R266 VSS VSS 148.357
R267 VSS.n24 VSS.n23 10.4005
R268 VSS.n26 VSS.n25 10.4005
R269 VSS.n40 VSS.n39 10.4005
R270 VSS.n41 VSS.n4 10.4005
R271 VSS.n84 VSS.n83 10.4005
R272 VSS.n82 VSS.n81 10.4005
R273 VSS.n75 VSS.n74 10.4005
R274 VSS.n73 VSS.n72 10.4005
R275 VSS.n64 VSS.n63 10.4005
R276 VSS.n90 VSS.n3 9.0005
R277 VSS.n89 VSS.n88 9.0005
R278 VSS.n87 VSS.n86 9.0005
R279 VSS.n85 VSS.n6 9.0005
R280 VSS.n44 VSS.n7 9.0005
R281 VSS.n46 VSS.n45 9.0005
R282 VSS.n49 VSS.n48 9.0005
R283 VSS.n50 VSS.n42 9.0005
R284 VSS.n80 VSS.n79 9.0005
R285 VSS.n78 VSS.n77 9.0005
R286 VSS.n76 VSS.n51 9.0005
R287 VSS.n55 VSS.n52 9.0005
R288 VSS.n57 VSS.n56 9.0005
R289 VSS.n59 VSS.n58 9.0005
R290 VSS.n60 VSS.n53 9.0005
R291 VSS.n71 VSS.n70 9.0005
R292 VSS.n69 VSS.n54 9.0005
R293 VSS.n68 VSS.n67 9.0005
R294 VSS.n66 VSS.n61 9.0005
R295 VSS.n22 VSS.n21 9.0005
R296 VSS.n20 VSS.n15 9.0005
R297 VSS.n19 VSS.n18 9.0005
R298 VSS.n13 VSS.n12 9.0005
R299 VSS.n29 VSS.n28 9.0005
R300 VSS.n30 VSS.n11 9.0005
R301 VSS.n32 VSS.n31 9.0005
R302 VSS.n34 VSS.n10 9.0005
R303 VSS.n36 VSS.n35 9.0005
R304 VSS.n38 VSS.n37 9.0005
R305 VSS.n9 VSS.n2 9.0005
R306 VSS.n95 VSS.n94 9.0005
R307 VSS.n93 VSS.n1 9.0005
R308 VSS.n92 VSS.n91 9.0005
R309 VSS.t9 VSS.n41 7.41833
R310 VSS.n14 VSS.t24 5.42612
R311 VSS.n17 VSS.t3 5.42612
R312 VSS.n33 VSS.t27 5.42612
R313 VSS.n8 VSS.t1 5.42612
R314 VSS.n62 VSS.n61 3.22882
R315 VSS.n47 VSS.t20 2.72532
R316 VSS.n43 VSS.t16 2.72532
R317 VSS.n62 VSS.t8 2.24507
R318 VSS.n27 VSS.t11 2.05582
R319 VSS.n0 VSS.t30 2.05582
R320 VSS.n5 VSS.t32 2.05582
R321 VSS.n65 VSS.t34 2.05582
R322 VSS.n21 VSS.n16 1.60346
R323 VSS.n16 VSS.n14 0.375096
R324 VSS.n64 VSS.n62 0.221979
R325 VSS.n21 VSS.n20 0.2005
R326 VSS.n20 VSS.n19 0.2005
R327 VSS.n19 VSS.n12 0.2005
R328 VSS.n29 VSS.n12 0.2005
R329 VSS.n30 VSS.n29 0.2005
R330 VSS.n31 VSS.n30 0.2005
R331 VSS.n31 VSS.n10 0.2005
R332 VSS.n36 VSS.n10 0.2005
R333 VSS.n37 VSS.n36 0.2005
R334 VSS.n37 VSS.n2 0.2005
R335 VSS.n94 VSS.n2 0.2005
R336 VSS.n94 VSS.n93 0.2005
R337 VSS.n93 VSS.n92 0.2005
R338 VSS.n92 VSS.n3 0.2005
R339 VSS.n88 VSS.n3 0.2005
R340 VSS.n88 VSS.n87 0.2005
R341 VSS.n87 VSS.n6 0.2005
R342 VSS.n44 VSS.n6 0.2005
R343 VSS.n45 VSS.n44 0.2005
R344 VSS.n49 VSS.n45 0.2005
R345 VSS.n50 VSS.n49 0.2005
R346 VSS.n79 VSS.n50 0.2005
R347 VSS.n79 VSS.n78 0.2005
R348 VSS.n78 VSS.n51 0.2005
R349 VSS.n55 VSS.n51 0.2005
R350 VSS.n56 VSS.n55 0.2005
R351 VSS.n59 VSS.n56 0.2005
R352 VSS.n60 VSS.n59 0.2005
R353 VSS.n70 VSS.n60 0.2005
R354 VSS.n70 VSS.n69 0.2005
R355 VSS.n69 VSS.n68 0.2005
R356 VSS.n68 VSS.n61 0.2005
R357 VSS.n22 VSS.n15 0.2005
R358 VSS.n18 VSS.n13 0.2005
R359 VSS.n28 VSS.n13 0.2005
R360 VSS.n32 VSS.n11 0.2005
R361 VSS.n35 VSS.n34 0.2005
R362 VSS.n38 VSS.n9 0.2005
R363 VSS.n95 VSS.n1 0.2005
R364 VSS.n91 VSS.n90 0.2005
R365 VSS.n90 VSS.n89 0.2005
R366 VSS.n86 VSS.n85 0.2005
R367 VSS.n46 VSS.n7 0.2005
R368 VSS.n48 VSS.n46 0.2005
R369 VSS.n77 VSS.n76 0.2005
R370 VSS.n57 VSS.n52 0.2005
R371 VSS.n58 VSS.n57 0.2005
R372 VSS.n58 VSS.n53 0.2005
R373 VSS.n71 VSS.n54 0.2005
R374 VSS.n67 VSS.n54 0.2005
R375 VSS.n67 VSS.n66 0.2005
R376 VSS.n4 VSS.n1 0.1965
R377 VSS.n81 VSS.n80 0.1905
R378 VSS.n86 VSS.n5 0.188
R379 VSS.n17 VSS.n15 0.167
R380 VSS.n34 VSS.n33 0.152
R381 VSS.n76 VSS.n75 0.1425
R382 VSS.n9 VSS.n0 0.131
R383 VSS.n77 VSS.n43 0.124
R384 VSS.n84 VSS.n7 0.1225
R385 VSS.n72 VSS.n71 0.1175
R386 VSS.n48 VSS.n47 0.111
R387 VSS.n23 VSS.n14 0.1
R388 VSS.n27 VSS.n26 0.1
R389 VSS.n39 VSS.n8 0.1
R390 VSS.n65 VSS.n64 0.1
R391 VSS.n47 VSS.n42 0.09
R392 VSS.n39 VSS.n38 0.0865
R393 VSS.n72 VSS.n53 0.0835
R394 VSS.n28 VSS.n27 0.083
R395 VSS.n85 VSS.n84 0.0785
R396 VSS.n80 VSS.n43 0.077
R397 VSS.n66 VSS.n65 0.066
R398 VSS.n75 VSS.n52 0.0585
R399 VSS.n23 VSS.n22 0.0505
R400 VSS.n33 VSS.n32 0.049
R401 VSS VSS.n95 0.0445
R402 VSS.n18 VSS.n17 0.034
R403 VSS VSS.n0 0.026
R404 VSS.n26 VSS.n11 0.0185
R405 VSS.n35 VSS.n8 0.015
R406 VSS.n89 VSS.n5 0.013
R407 VSS.n81 VSS.n42 0.0105
R408 VSS.n91 VSS.n4 0.0045
R409 a_14476_446.t0 a_14476_446.t1 3.1505
R410 a_13444_446.t0 a_13444_446.t1 3.1505
R411 a_12412_446.t0 a_12412_446.t1 0.6305
R412 a_9916_446.t0 a_9916_446.t1 0.6305
R413 a_8152_446.t0 a_8152_446.t1 0.6305
R414 a_1246_446.t0 a_1246_446.t1 0.6305
R415 a_514_446.t0 a_514_446.n0 13.4066
R416 a_514_446.n0 a_514_446.n1 0.601571
R417 a_514_446.n1 a_514_446.t3 8.95471
R418 a_514_446.n1 a_514_446.t2 7.32828
R419 a_514_446.n0 a_514_446.t1 12.2624
R420 a_214_446.t0 a_214_446.t1 0.6305
R421 a_8896_446.t0 a_8896_446.n0 9.00244
R422 a_8896_446.n0 a_8896_446.t1 8.30815
R423 a_8896_446.n0 a_8896_446.t2 31.0113
R424 a_16346_4472.t0 a_16346_4472.t1 15.2227
R425 a_928_4922.t0 a_928_4922.t1 15.2227
R426 a_16346_5372.t0 a_16346_5372.t1 15.2227
R427 a_928_5822.t0 a_928_5822.t1 15.2227
R428 a_18294_6868.t0 a_18294_6868.t1 0.3505
R429 a_14_330.t1 a_14_330.n3 6.81176
R430 a_14_330.n3 a_14_330.t0 22.2016
R431 a_14_330.n3 a_14_330.n0 0.722107
R432 a_14_330.n0 a_14_330.n1 6.81479
R433 a_14_330.n1 a_14_330.n2 11.0673
R434 a_14_330.n2 a_14_330.t5 31.8629
R435 a_14_330.n2 a_14_330.t4 30.2365
R436 a_14_330.n1 a_14_330.t3 30.2365
R437 a_14_330.n0 a_14_330.t2 30.2365
R438 a_16370_6868.t0 a_16370_6868.t1 0.3505
R439 a_314_330.t2 a_314_330.n7 12.0041
R440 a_314_330.n7 a_314_330.n6 1.35532
R441 a_314_330.n6 a_314_330.t0 20.4278
R442 a_314_330.n6 a_314_330.t3 30.4947
R443 a_314_330.n7 a_314_330.n0 0.239964
R444 a_314_330.n0 a_314_330.n1 2.32121
R445 a_314_330.n1 a_314_330.n2 2.80336
R446 a_314_330.n2 a_314_330.n3 6.33264
R447 a_314_330.n3 a_314_330.n4 1.14479
R448 a_314_330.n4 a_314_330.n5 3.52657
R449 a_314_330.n5 a_314_330.t9 32.1212
R450 a_314_330.n5 a_314_330.t8 30.4947
R451 a_314_330.n4 a_314_330.t7 22.348
R452 a_314_330.n3 a_314_330.t6 22.348
R453 a_314_330.n2 a_314_330.t5 30.4947
R454 a_314_330.n1 a_314_330.t4 30.4947
R455 a_314_330.n0 a_314_330.t1 17.46
R456 a_15258_6868.t0 a_15258_6868.t1 0.3505
R457 a_6488_330.t1 a_6488_330.n2 7.32828
R458 a_6488_330.n2 a_6488_330.t2 18.5607
R459 a_6488_330.n2 a_6488_330.n0 0.239964
R460 a_6488_330.n0 a_6488_330.n1 2.80336
R461 a_6488_330.n1 a_6488_330.t4 23.7506
R462 a_6488_330.n1 a_6488_330.t3 22.6063
R463 a_6488_330.n0 a_6488_330.t0 30.753
R464 a_10898_6868.t0 a_10898_6868.t1 0.3505
R465 a_8974_6868.t0 a_8974_6868.t1 0.3505
R466 a_4492_446.t0 a_4492_446.n1 9.4922
R467 a_4492_446.n1 a_4492_446.n0 1.70407
R468 a_4492_446.n0 a_4492_446.t3 22.4085
R469 a_4492_446.n0 a_4492_446.t1 14.7172
R470 a_4492_446.n1 a_4492_446.t2 13.6226
R471 a_3760_446.t0 a_3760_446.n2 11.0418
R472 a_3760_446.n2 a_3760_446.t1 14.7427
R473 a_3760_446.n2 a_3760_446.n0 0.873179
R474 a_3760_446.n0 a_3760_446.n1 1.14479
R475 a_3760_446.n1 a_3760_446.t2 13.0909
R476 a_3760_446.n1 a_3760_446.t4 24.6724
R477 a_3760_446.n0 a_3760_446.t3 24.6724
R478 a_928_4472.t2 a_928_4472.n5 29.4483
R479 a_928_4472.n5 a_928_4472.n0 3.60693
R480 a_928_4472.n0 a_928_4472.n1 0.617643
R481 a_928_4472.n1 a_928_4472.n2 6.42425
R482 a_928_4472.n2 a_928_4472.n3 1.27336
R483 a_928_4472.n3 a_928_4472.n4 1.27336
R484 a_928_4472.n4 a_928_4472.t4 21.7717
R485 a_928_4472.n4 a_928_4472.t5 20.4989
R486 a_928_4472.n3 a_928_4472.t6 20.4989
R487 a_928_4472.n2 a_928_4472.t7 20.4989
R488 a_928_4472.n1 a_928_4472.t3 13.4259
R489 a_928_4472.n0 a_928_4472.t0 10.7835
R490 a_928_4472.n5 a_928_4472.t1 13.7763
R491 a_2278_446.t3 a_2278_446.n0 13.485
R492 a_2278_446.n0 a_2278_446.n1 3.43336
R493 a_2278_446.n1 a_2278_446.t1 17.3218
R494 a_2278_446.n1 a_2278_446.t0 14.2007
R495 a_2278_446.n0 a_2278_446.t2 9.0005
R496 a_3290_6868.t1 a_3290_6868.n0 18.4896
R497 a_3290_6868.n0 a_3290_6868.t0 11.8396
R498 a_3290_6868.n0 a_3290_6868.t2 8.97568
R499 a_2478_6868.t2 a_2478_6868.n0 20.5587
R500 a_2478_6868.n0 a_2478_6868.n1 2.63943
R501 a_2478_6868.n1 a_2478_6868.t0 9.42037
R502 a_2478_6868.n1 a_2478_6868.t3 16.8488
R503 a_2478_6868.n0 a_2478_6868.t1 9.23394
R504 a_3010_446.t0 a_3010_446.n0 15.7664
R505 a_3010_446.n0 a_3010_446.t1 16.0305
R506 a_3010_446.n0 a_3010_446.t2 12.9094
R507 a_4102_6868.t0 a_4102_6868.n2 11.5583
R508 a_4102_6868.n2 a_4102_6868.t1 13.1397
R509 a_4102_6868.n2 a_4102_6868.n0 0.481036
R510 a_4102_6868.n0 a_4102_6868.n1 1.27336
R511 a_4102_6868.n1 a_4102_6868.t2 14.9574
R512 a_4102_6868.n1 a_4102_6868.t4 36.1491
R513 a_4102_6868.n0 a_4102_6868.t3 36.1491
R514 a_1366_6868.t0 a_1366_6868.t1 0.3505
R515 a_554_6868.t1 a_554_6868.n0 16.7416
R516 a_554_6868.n0 a_554_6868.n1 0.730143
R517 a_554_6868.n1 a_554_6868.t2 14.2702
R518 a_554_6868.n1 a_554_6868.t0 12.5152
R519 a_554_6868.n0 a_554_6868.t3 15.3147
R520 a_254_6868.t0 a_254_6868.t1 0.3505
R521 a_7150_6752.t0 a_7150_6752.n2 8.36133
R522 a_7150_6752.n2 a_7150_6752.n1 2.32282
R523 a_7150_6752.n1 a_7150_6752.t2 14.5625
R524 a_7150_6752.n1 a_7150_6752.t1 55.9487
R525 a_7150_6752.n2 a_7150_6752.n0 0.706036
R526 a_7150_6752.n0 a_7150_6752.t4 38.9715
R527 a_7150_6752.n0 a_7150_6752.t3 37.6987
R528 a_8774_6752.t0 a_8774_6752.n0 14.7944
R529 a_8774_6752.n0 a_8774_6752.t2 56.412
R530 a_8774_6752.n0 a_8774_6752.t1 14.0648
R531 a_354_6752.t1 a_354_6752.n13 13.8119
R532 a_354_6752.n13 a_354_6752.n9 0.953536
R533 a_354_6752.n9 a_354_6752.n10 1.7555
R534 a_354_6752.n10 a_354_6752.n11 1.27336
R535 a_354_6752.n11 a_354_6752.n12 0.239964
R536 a_354_6752.n12 a_354_6752.t7 56.9155
R537 a_354_6752.n12 a_354_6752.t3 14.6646
R538 a_354_6752.n11 a_354_6752.t2 26.2321
R539 a_354_6752.n10 a_354_6752.t8 55.4321
R540 a_354_6752.n9 a_354_6752.t9 55.4321
R541 a_354_6752.n13 a_354_6752.n0 0.239964
R542 a_354_6752.n0 a_354_6752.n1 0.4505
R543 a_354_6752.n1 a_354_6752.n2 1.14479
R544 a_354_6752.n2 a_354_6752.n3 0.4505
R545 a_354_6752.n3 a_354_6752.n4 3.54264
R546 a_354_6752.n4 a_354_6752.n5 3.09586
R547 a_354_6752.n5 a_354_6752.n6 6.9755
R548 a_354_6752.n6 a_354_6752.n7 1.27336
R549 a_354_6752.n7 a_354_6752.n8 3.88336
R550 a_354_6752.n8 a_354_6752.t15 57.1871
R551 a_354_6752.n8 a_354_6752.t14 55.4321
R552 a_354_6752.n7 a_354_6752.t13 37.1821
R553 a_354_6752.n6 a_354_6752.t12 37.1821
R554 a_354_6752.n5 a_354_6752.t11 55.4321
R555 a_354_6752.n4 a_354_6752.t10 55.4321
R556 a_354_6752.n3 a_354_6752.t6 19.2678
R557 a_354_6752.n2 a_354_6752.t5 19.2678
R558 a_354_6752.n1 a_354_6752.t4 19.2678
R559 a_354_6752.n0 a_354_6752.t0 19.2678
R560 a_54_6752.t0 a_54_6752.n5 13.0371
R561 a_54_6752.n5 a_54_6752.n2 2.12996
R562 a_54_6752.n2 a_54_6752.n3 1.7555
R563 a_54_6752.n3 a_54_6752.n4 3.0605
R564 a_54_6752.n4 a_54_6752.t1 15.3029
R565 a_54_6752.n4 a_54_6752.t2 56.2069
R566 a_54_6752.n3 a_54_6752.t3 56.2069
R567 a_54_6752.n2 a_54_6752.t4 56.2069
R568 a_54_6752.n5 a_54_6752.n0 4.81389
R569 a_54_6752.n0 a_54_6752.n1 15.2876
R570 a_54_6752.n1 a_54_6752.t7 57.9619
R571 a_54_6752.n1 a_54_6752.t6 56.2069
R572 a_54_6752.n0 a_54_6752.t5 56.2069
C0 INN VDD 0.40821f
C1 VDD INP 0.40855f
C2 INN OUT 0.40619f
C3 OUT INP 0.09358f
C4 INN INP 0.03427f
C5 OUT VDD 0.60411f
C6 OUT VSS 11.70626f
C7 INN VSS 4.97682f
C8 INP VSS 4.6474f
C9 VDD VSS 0.16425p
C10 a_54_6752.t0 VSS 0.25817f
C11 a_54_6752.t5 VSS 1.68281f
C12 a_54_6752.n0 VSS 2.68017f
C13 a_54_6752.t6 VSS 1.68281f
C14 a_54_6752.n1 VSS 3.69672f
C15 a_54_6752.t7 VSS 1.72183f
C16 a_54_6752.t4 VSS 1.68281f
C17 a_54_6752.n2 VSS 1.44414f
C18 a_54_6752.t3 VSS 1.68281f
C19 a_54_6752.n3 VSS 1.51507f
C20 a_54_6752.t2 VSS 1.68281f
C21 a_54_6752.n4 VSS 1.88739f
C22 a_54_6752.t1 VSS 1.93822f
C23 a_54_6752.n5 VSS 0.75154f
C24 a_354_6752.t1 VSS 0.36588f
C25 a_354_6752.t0 VSS 0.56188f
C26 a_354_6752.n0 VSS 0.53062f
C27 a_354_6752.t4 VSS 0.56188f
C28 a_354_6752.n1 VSS 0.61549f
C29 a_354_6752.t5 VSS 0.56188f
C30 a_354_6752.n2 VSS 0.61549f
C31 a_354_6752.t6 VSS 0.56188f
C32 a_354_6752.n3 VSS 0.84041f
C33 a_354_6752.t10 VSS 2.04431f
C34 a_354_6752.n4 VSS 1.96387f
C35 a_354_6752.t11 VSS 2.04431f
C36 a_354_6752.n5 VSS 2.28587f
C37 a_354_6752.t12 VSS 1.28703f
C38 a_354_6752.n6 VSS 1.79542f
C39 a_354_6752.t13 VSS 1.28703f
C40 a_354_6752.n7 VSS 1.50537f
C41 a_354_6752.t14 VSS 2.04431f
C42 a_354_6752.n8 VSS 3.33797f
C43 a_354_6752.t15 VSS 2.09078f
C44 a_354_6752.t9 VSS 2.04431f
C45 a_354_6752.n9 VSS 1.59529f
C46 a_354_6752.t8 VSS 2.04431f
C47 a_354_6752.n10 VSS 1.62529f
C48 a_354_6752.t2 VSS 0.86627f
C49 a_354_6752.n11 VSS 0.93832f
C50 a_354_6752.t3 VSS 0.881f
C51 a_354_6752.n12 VSS 2.09262f
C52 a_354_6752.t7 VSS 2.08311f
C53 a_354_6752.n13 VSS 0.43535f
C54 a_8774_6752.t0 VSS 1.88655f
C55 a_8774_6752.t1 VSS 1.86455f
C56 a_8774_6752.n0 VSS 2.06079f
C57 a_8774_6752.t2 VSS 1.66442f
C58 a_7150_6752.t0 VSS 0.73198f
C59 a_7150_6752.t3 VSS 1.41392f
C60 a_7150_6752.n0 VSS 2.59827f
C61 a_7150_6752.t4 VSS 1.45602f
C62 a_7150_6752.t1 VSS 2.22751f
C63 a_7150_6752.n1 VSS 2.31603f
C64 a_7150_6752.t2 VSS 2.53632f
C65 a_7150_6752.n2 VSS 0.45833f
C66 a_254_6868.t0 VSS 0.06379f
C67 a_254_6868.t1 VSS 0.06379f
C68 a_554_6868.t1 VSS 0.65653f
C69 a_554_6868.t3 VSS 0.62896f
C70 a_554_6868.n0 VSS 1.31228f
C71 a_554_6868.t0 VSS 2.40992f
C72 a_554_6868.n1 VSS 1.2307f
C73 a_554_6868.t2 VSS 2.48627f
C74 a_1366_6868.t0 VSS 0.06055f
C75 a_1366_6868.t1 VSS 0.06055f
C76 a_4102_6868.t0 VSS 0.75096f
C77 a_4102_6868.t3 VSS 1.53542f
C78 a_4102_6868.n0 VSS 1.35497f
C79 a_4102_6868.t4 VSS 1.53542f
C80 a_4102_6868.n1 VSS 2.20877f
C81 a_4102_6868.t2 VSS 1.8037f
C82 a_4102_6868.t1 VSS 1.707f
C83 a_4102_6868.n2 VSS 0.99168f
C84 a_3010_446.t0 VSS 0.72224f
C85 a_3010_446.t2 VSS 2.21921f
C86 a_3010_446.n0 VSS 2.934f
C87 a_3010_446.t1 VSS 2.43931f
C88 a_2478_6868.t2 VSS 0.1728f
C89 a_2478_6868.t1 VSS 0.08842f
C90 a_2478_6868.n0 VSS 0.28675f
C91 a_2478_6868.n1 VSS 0.26036f
C92 a_2478_6868.t3 VSS 9.76545f
C93 a_2478_6868.t0 VSS 0.08916f
C94 a_3290_6868.t1 VSS 1.34647f
C95 a_3290_6868.t2 VSS 0.75717f
C96 a_3290_6868.n0 VSS 2.55295f
C97 a_3290_6868.t0 VSS 0.94201f
C98 a_2278_446.t3 VSS 0.21007f
C99 a_2278_446.n0 VSS 0.42646f
C100 a_2278_446.t2 VSS 8.71331f
C101 a_2278_446.t0 VSS 0.91848f
C102 a_2278_446.n1 VSS 1.07229f
C103 a_2278_446.t1 VSS 1.00537f
C104 a_928_4472.t2 VSS 1.16871f
C105 a_928_4472.t1 VSS 2.17726f
C106 a_928_4472.t0 VSS 0.83916f
C107 a_928_4472.n0 VSS 0.96745f
C108 a_928_4472.t3 VSS 2.15897f
C109 a_928_4472.n1 VSS 1.65812f
C110 a_928_4472.t7 VSS 1.01073f
C111 a_928_4472.n2 VSS 2.06713f
C112 a_928_4472.t6 VSS 1.01073f
C113 a_928_4472.n3 VSS 1.33419f
C114 a_928_4472.t5 VSS 1.01073f
C115 a_928_4472.n4 VSS 2.43191f
C116 a_928_4472.t4 VSS 1.07889f
C117 a_928_4472.n5 VSS 3.37819f
C118 a_3760_446.t0 VSS 0.75258f
C119 a_3760_446.t3 VSS 1.01861f
C120 a_3760_446.n0 VSS 0.99676f
C121 a_3760_446.t4 VSS 1.01861f
C122 a_3760_446.n1 VSS 1.64864f
C123 a_3760_446.t2 VSS 0.8466f
C124 a_3760_446.t1 VSS 1.92954f
C125 a_3760_446.n2 VSS 1.31447f
C126 a_4492_446.t0 VSS 0.74085f
C127 a_4492_446.t2 VSS 1.01948f
C128 a_4492_446.t1 VSS 2.44865f
C129 a_4492_446.n0 VSS 2.74141f
C130 a_4492_446.t3 VSS 1.0594f
C131 a_4492_446.n1 VSS 1.80375f
C132 a_8974_6868.t0 VSS 0.0608f
C133 a_8974_6868.t1 VSS 0.0608f
C134 a_10898_6868.t0 VSS 0.06055f
C135 a_10898_6868.t1 VSS 0.06055f
C136 a_6488_330.t1 VSS 0.6576f
C137 a_6488_330.t0 VSS 1.16348f
C138 a_6488_330.n0 VSS 0.81609f
C139 a_6488_330.t3 VSS 0.76153f
C140 a_6488_330.n1 VSS 1.39259f
C141 a_6488_330.t4 VSS 0.78892f
C142 a_6488_330.t2 VSS 2.84758f
C143 a_6488_330.n2 VSS 1.25527f
C144 a_15258_6868.t0 VSS 0.06324f
C145 a_15258_6868.t1 VSS 0.06324f
C146 a_314_330.t2 VSS 0.2639f
C147 a_314_330.t1 VSS 0.48898f
C148 a_314_330.n0 VSS 0.59221f
C149 a_314_330.t4 VSS 1.0802f
C150 a_314_330.n1 VSS 0.94131f
C151 a_314_330.t5 VSS 1.0802f
C152 a_314_330.n2 VSS 1.3328f
C153 a_314_330.t6 VSS 0.7016f
C154 a_314_330.n3 VSS 1.11819f
C155 a_314_330.t7 VSS 0.7016f
C156 a_314_330.n4 VSS 0.84433f
C157 a_314_330.t8 VSS 1.0802f
C158 a_314_330.n5 VSS 1.52209f
C159 a_314_330.t9 VSS 1.11102f
C160 a_314_330.t3 VSS 1.0802f
C161 a_314_330.n6 VSS 1.85752f
C162 a_314_330.t0 VSS 2.7804f
C163 a_314_330.n7 VSS 0.37087f
C164 a_16370_6868.t0 VSS 0.06731f
C165 a_16370_6868.t1 VSS 0.06731f
C166 a_14_330.t1 VSS 0.44345f
C167 a_14_330.t2 VSS 0.83666f
C168 a_14_330.n0 VSS 0.89856f
C169 a_14_330.t3 VSS 0.83666f
C170 a_14_330.n1 VSS 1.68669f
C171 a_14_330.t4 VSS 0.83666f
C172 a_14_330.n2 VSS 1.72344f
C173 a_14_330.t5 VSS 0.85989f
C174 a_14_330.t0 VSS 2.26253f
C175 a_14_330.n3 VSS 1.28408f
C176 a_18294_6868.t0 VSS 0.06274f
C177 a_18294_6868.t1 VSS 0.06274f
C178 a_928_5822.t0 VSS 0.10389f
C179 a_928_5822.t1 VSS 0.10389f
C180 a_16346_5372.t0 VSS 0.38834f
C181 a_16346_5372.t1 VSS 0.38834f
C182 a_928_4922.t0 VSS 0.10648f
C183 a_928_4922.t1 VSS 0.10648f
C184 a_16346_4472.t0 VSS 0.38012f
C185 a_16346_4472.t1 VSS 0.38012f
C186 a_8896_446.t0 VSS 0.58126f
C187 a_8896_446.t2 VSS 0.93968f
C188 a_8896_446.n0 VSS 0.93419f
C189 a_8896_446.t1 VSS 0.56069f
C190 a_214_446.t0 VSS 0.0178f
C191 a_214_446.t1 VSS 0.0178f
C192 a_514_446.t0 VSS 0.38788f
C193 a_514_446.t1 VSS 0.35025f
C194 a_514_446.n0 VSS 0.90633f
C195 a_514_446.t2 VSS 0.76825f
C196 a_514_446.n1 VSS 0.66843f
C197 a_514_446.t3 VSS 0.8288f
C198 a_1246_446.t0 VSS 0.01811f
C199 a_1246_446.t1 VSS 0.01811f
C200 a_8152_446.t0 VSS 0.01862f
C201 a_8152_446.t1 VSS 0.01862f
C202 a_9916_446.t0 VSS 0.01842f
C203 a_9916_446.t1 VSS 0.01842f
C204 a_12412_446.t0 VSS 0.01817f
C205 a_12412_446.t1 VSS 0.01817f
C206 VDD.n0 VSS 0.02724f
C207 VDD.n1 VSS 0.01842f
C208 VDD VSS 0.67713f
C209 VDD VSS 0.67491f
C210 VDD.n2 VSS 0.02512f
C211 VDD.n3 VSS 0.03044f
C212 VDD.n4 VSS 0.03044f
C213 VDD.t23 VSS 0.06079f
C214 VDD.n5 VSS 0.03044f
C215 VDD.t35 VSS 0.06079f
C216 VDD.n6 VSS 0.01193f
C217 VDD.n7 VSS 0.03044f
C218 VDD.n8 VSS 0.04918f
C219 VDD.n9 VSS 0.03044f
C220 VDD.n10 VSS 0.04853f
C221 VDD VSS 0.39296f
C222 VDD.t31 VSS 0.06079f
C223 VDD.n11 VSS 0.03088f
C224 VDD.n12 VSS 0.02064f
C225 VDD.n13 VSS 0.03044f
C226 VDD.t18 VSS 0.06079f
C227 VDD.n14 VSS 0.03241f
C228 VDD.n15 VSS 0.03044f
C229 VDD.t25 VSS 0.02335f
C230 VDD.n16 VSS 0.05737f
C231 VDD.t14 VSS 0.06572f
C232 VDD.n17 VSS 0.1748f
C233 VDD.n18 VSS 0.16475f
C234 VDD.n19 VSS 0.01f
C235 VDD VSS 0.61719f
C236 VDD VSS 0.61719f
C237 VDD VSS 0.67713f
C238 VDD VSS 0.61719f
C239 VDD VSS 0.61719f
C240 VDD VSS 0.39074f
C241 VDD.n20 VSS 0.44881f
C242 VDD.n21 VSS 0.01193f
C243 VDD.n22 VSS 0.02556f
C244 VDD.n23 VSS 0.02341f
C245 VDD.n24 VSS 0.03044f
C246 VDD.n25 VSS 0.03044f
C247 VDD.n26 VSS 0.0229f
C248 VDD.n27 VSS 0.03044f
C249 VDD.n28 VSS 0.02021f
C250 VDD.n29 VSS 0.03044f
C251 VDD.n30 VSS 0.03044f
C252 VDD.n31 VSS 0.04918f
C253 VDD.n32 VSS 0.02108f
C254 VDD.n33 VSS 0.02567f
C255 VDD.n34 VSS 0.03044f
C256 VDD.n35 VSS 0.03044f
C257 VDD.n36 VSS 0.03044f
C258 VDD.n37 VSS 0.0174f
C259 VDD.n39 VSS 0.44881f
C260 VDD VSS 0.67491f
C261 VDD VSS 0.67713f
C262 VDD VSS 0.61719f
C263 VDD VSS 0.39074f
C264 VDD.n40 VSS 0.44881f
C265 VDD VSS 0.67713f
C266 VDD VSS 0.67491f
C267 VDD.n41 VSS 0.44881f
C268 VDD.n43 VSS 0.01653f
C269 VDD.n44 VSS 0.02152f
C270 VDD.n45 VSS 0.03044f
C271 VDD.n46 VSS 0.03044f
C272 VDD.n47 VSS 0.0248f
C273 VDD.n48 VSS 0.02195f
C274 VDD.n49 VSS 0.04918f
C275 VDD.n50 VSS 0.01f
C276 VDD.n51 VSS 0.03044f
C277 VDD.n52 VSS 0.03044f
C278 VDD.n53 VSS 0.03022f
C279 VDD.n54 VSS 0.01875f
C280 VDD.n55 VSS 0.03241f
C281 VDD.n56 VSS 0.02757f
C282 VDD.n57 VSS 0.03044f
C283 VDD.n58 VSS 0.03044f
C284 VDD.n59 VSS 0.03044f
C285 VDD.n60 VSS 0.03044f
C286 VDD.n61 VSS 0.03044f
C287 VDD.n62 VSS 0.01598f
C288 VDD.n63 VSS 0.03241f
C289 VDD.n64 VSS 0.03033f
C290 VDD.n65 VSS 0.03044f
C291 VDD.n66 VSS 0.03044f
C292 VDD.n67 VSS 0.03044f
C293 VDD.t12 VSS 0.04051f
C294 VDD.n68 VSS 0.02031f
C295 VDD VSS 0.67713f
C296 VDD VSS 0.67491f
C297 VDD.n69 VSS 0.02687f
C298 VDD.n70 VSS 0.03044f
C299 VDD.n71 VSS 0.03044f
C300 VDD.n72 VSS 0.03044f
C301 VDD.t21 VSS 0.04051f
C302 VDD.n73 VSS 0.01773f
C303 VDD.n74 VSS 0.03448f
C304 VDD.n75 VSS 0.02859f
C305 VDD.n76 VSS 0.03044f
C306 VDD.n77 VSS 0.03044f
C307 VDD.n78 VSS 0.03044f
C308 VDD.n79 VSS 0.01857f
C309 VDD VSS 0.67713f
C310 VDD VSS 0.61719f
C311 VDD VSS 0.39074f
C312 VDD.t2 VSS 0.06079f
C313 VDD.n80 VSS 0.02695f
C314 VDD.t6 VSS 0.06519f
C315 VDD.n81 VSS 0.03044f
C316 VDD.n82 VSS 0.03044f
C317 VDD.n83 VSS 0.03044f
C318 VDD.n84 VSS 0.03044f
C319 VDD.n85 VSS 0.03044f
C320 VDD.n86 VSS 0.03044f
C321 VDD.n87 VSS 0.03044f
C322 VDD.n88 VSS 0.01627f
C323 VDD.n89 VSS 0.1106f
C324 VDD.n90 VSS 0.07661f
C325 VDD.n91 VSS 0.03215f
C326 VDD.n92 VSS 0.44881f
C327 VDD VSS 0.39296f
C328 VDD VSS 0.61719f
C329 VDD VSS 0.67491f
C330 VDD.n93 VSS 0.44881f
C331 VDD.n94 VSS 0.01193f
C332 VDD.n95 VSS 0.02775f
C333 VDD.n96 VSS 0.03044f
C334 VDD.n97 VSS 0.03044f
C335 VDD.n98 VSS 0.03044f
C336 VDD.n99 VSS 0.03044f
C337 VDD.n100 VSS 0.01944f
C338 VDD.n101 VSS 0.01193f
C339 VDD.n102 VSS 0.44881f
C340 VDD VSS 0.67713f
C341 VDD VSS 0.67491f
C342 VDD.n103 VSS 0.44881f
C343 VDD.n104 VSS 0.01051f
C344 VDD.n105 VSS 0.03004f
C345 VDD.n106 VSS 0.01729f
C346 VDD.n107 VSS 0.03044f
C347 VDD.n108 VSS 0.03044f
C348 VDD.n109 VSS 0.03044f
C349 VDD.n110 VSS 0.03044f
C350 VDD.n111 VSS 0.02119f
C351 VDD.n112 VSS 0.01193f
C352 VDD.n113 VSS 0.44881f
C353 VDD VSS 0.67713f
C354 VDD VSS 0.61719f
C355 VDD VSS 0.39074f
C356 VDD.n114 VSS 0.44881f
C357 INP.t1 VSS 1.46227f
C358 INP.t0 VSS 1.57283f
C359 INN.t1 VSS 1.13434f
C360 INN.t0 VSS 1.72972f
C361 OUT.t5 VSS 0.06769f
C362 OUT.n0 VSS 0.03441f
C363 OUT.t0 VSS 0.10412f
C364 OUT.t7 VSS 12.0542f
C365 OUT.n1 VSS 0.26871f
C366 OUT.t1 VSS 0.1137f
C367 OUT.t2 VSS 0.12567f
C368 OUT.t3 VSS 3.66247f
C369 OUT.n2 VSS 0.42328f
C370 OUT.n3 VSS 0.19981f
C371 OUT.t6 VSS 0.1104f
C372 OUT.n4 VSS 0.186f
C373 OUT.t4 VSS 0.1104f
C374 OUT.n5 VSS 0.18678f
C375 OUT.n6 VSS 0.04293f
C376 OUT.n7 VSS 0.15344f
C377 OUT.n8 VSS 0.04323f
C378 OUT.n9 VSS 0.02525f
.ends
