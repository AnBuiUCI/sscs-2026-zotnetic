* Extracted by KLayout with GF180MCU LVS runset on : 29/08/2026 05:57

.SUBCKT OPAM_LIN_flat OUT INP INN VDD VSS
M$1 \$705 \$39 VDD VDD pfet_06v0 L=1U W=10U AS=4.4P AD=2.5P PS=20.88U PD=10.5U
M$2 \$383 \$27 \$705 VDD pfet_06v0 L=1U W=10U AS=2.5P AD=4.4P PS=10.5U PD=20.88U
M$3 \$733 \$362 VDD VDD pfet_06v0 L=1U W=10U AS=4.4P AD=2.5P PS=20.88U PD=10.5U
M$4 \$362 \$27 \$733 VDD pfet_06v0 L=1U W=10U AS=2.5P AD=4.4P PS=10.5U PD=20.88U
M$5 \$696 \$39 VDD VDD pfet_06v0 L=1U W=10U AS=4.4P AD=2.5P PS=20.88U PD=10.5U
M$6 \$39 \$27 \$696 VDD pfet_06v0 L=1U W=10U AS=2.5P AD=4.4P PS=10.5U PD=20.88U
M$7 \$693 \$39 VDD VDD pfet_06v0 L=1U W=10U AS=4.4P AD=2.5P PS=20.88U PD=10.5U
M$8 \$383 \$27 \$693 VDD pfet_06v0 L=1U W=10U AS=2.5P AD=4.4P PS=10.5U PD=20.88U
M$9 \$710 \$39 VDD VDD pfet_06v0 L=1U W=10U AS=4.4P AD=2.5P PS=20.88U PD=10.5U
M$10 \$182 \$27 \$710 VDD pfet_06v0 L=1U W=10U AS=2.5P AD=4.4P PS=10.5U
+ PD=20.88U
M$11 \$724 \$39 VDD VDD pfet_06v0 L=1U W=10U AS=4.4P AD=2.5P PS=20.88U PD=10.5U
M$12 \$292 \$27 \$724 VDD pfet_06v0 L=1U W=10U AS=2.5P AD=4.4P PS=10.5U
+ PD=20.88U
M$13 \$709 \$39 VDD VDD pfet_06v0 L=1U W=10U AS=4.4P AD=2.5P PS=20.88U PD=10.5U
M$14 \$43 \$27 \$709 VDD pfet_06v0 L=1U W=10U AS=2.5P AD=4.4P PS=10.5U PD=20.88U
M$15 \$30 \$27 VSS VSS nfet_06v0 L=1U W=1U AS=0.44P AD=0.25P PS=2.88U PD=1.5U
M$16 \$27 \$27 \$30 VSS nfet_06v0 L=1U W=1U AS=0.25P AD=0.44P PS=1.5U PD=2.88U
M$17 \$18 \$43 VSS VSS nfet_06v0 L=1U W=5U AS=2.2P AD=1.25P PS=10.88U PD=5.5U
M$18 \$11 \$182 \$18 VSS nfet_06v0 L=1U W=5U AS=1.25P AD=2.2P PS=5.5U PD=10.88U
M$19 \$47 \$43 VSS VSS nfet_06v0 L=1U W=5U AS=2.2P AD=1.25P PS=10.88U PD=5.5U
M$20 \$43 \$182 \$47 VSS nfet_06v0 L=1U W=5U AS=1.25P AD=2.2P PS=5.5U PD=10.88U
M$21 \$38 \$27 VSS VSS nfet_06v0 L=1U W=1U AS=0.44P AD=0.25P PS=2.88U PD=1.5U
M$22 \$39 \$27 \$38 VSS nfet_06v0 L=1U W=1U AS=0.25P AD=0.44P PS=1.5U PD=2.88U
M$23 \$56 \$52 VSS VSS nfet_06v0 L=1U W=5U AS=2.2P AD=1.25P PS=10.88U PD=5.5U
M$24 \$52 \$182 \$56 VSS nfet_06v0 L=1U W=5U AS=1.25P AD=2.2P PS=5.5U PD=10.88U
M$25 \$54 \$43 VSS VSS nfet_06v0 L=1U W=5U AS=2.2P AD=1.25P PS=10.88U PD=5.5U
M$26 \$55 \$182 \$54 VSS nfet_06v0 L=1U W=5U AS=1.25P AD=2.2P PS=5.5U PD=10.88U
M$27 \$8 \$43 VSS VSS nfet_06v0 L=1U W=5U AS=2.2P AD=1.25P PS=10.88U PD=5.5U
M$28 \$11 \$182 \$8 VSS nfet_06v0 L=1U W=5U AS=1.25P AD=2.2P PS=5.5U PD=10.88U
C$29 OUT \$261 4e-13 cap_mim_2f0fF A=200P P=66U
C$30 \$3 OUT 4e-13 cap_mim_2f0fF A=200P P=66U
M$31 \$182 \$182 VSS VSS nfet_06v0 L=1U W=1U AS=0.44P AD=0.44P PS=2.88U PD=2.88U
M$32 OUT \$277 VSS VSS nfet_06v0 L=1U W=1U AS=0.44P AD=0.44P PS=2.88U PD=2.88U
M$33 \$375 \$292 \$370 VSS nfet_06v0 L=1U W=2U AS=0.88P AD=0.88P PS=4.88U
+ PD=4.88U
M$34 \$292 \$292 \$52 VSS nfet_06v0 L=1U W=5U AS=2.2P AD=2.2P PS=10.88U
+ PD=10.88U
M$35 \$363 \$292 \$277 VSS nfet_06v0 L=1U W=2U AS=0.88P AD=0.88P PS=4.88U
+ PD=4.88U
M$36 \$261 \$370 VSS VSS nfet_06v0 L=1U W=2.5U AS=1.1P AD=1.1P PS=5.88U PD=5.88U
M$37 \$318 \$370 VSS VSS nfet_06v0 L=1U W=2.5U AS=1.1P AD=1.1P PS=5.88U PD=5.88U
M$38 \$370 \$182 \$318 VSS nfet_06v0 L=1U W=2.5U AS=1.1P AD=1.1P PS=5.88U
+ PD=5.88U
M$39 \$368 INN \$11 VSS nfet_06v0 L=1U W=8.5U AS=3.74P AD=3.74P PS=17.88U
+ PD=17.88U
M$40 \$3 INP \$11 VSS nfet_06v0 L=1U W=7.5U AS=3.3P AD=3.3P PS=15.88U PD=15.88U
M$41 \$277 \$182 \$261 VSS nfet_06v0 L=1U W=2.5U AS=1.1P AD=1.1P PS=5.88U
+ PD=5.88U
M$42 \$277 \$55 \$363 VDD pfet_06v0 L=1U W=4U AS=1.76P AD=1.76P PS=8.88U
+ PD=8.88U
M$43 \$370 \$55 \$375 VDD pfet_06v0 L=1U W=4U AS=1.76P AD=1.76P PS=8.88U
+ PD=8.88U
M$44 \$3 \$375 VDD VDD pfet_06v0 L=1U W=5U AS=2.2P AD=2.2P PS=10.88U PD=10.88U
M$45 \$368 \$375 VDD VDD pfet_06v0 L=1U W=5U AS=2.2P AD=2.2P PS=10.88U PD=10.88U
M$46 \$363 \$27 \$3 VDD pfet_06v0 L=1U W=10U AS=4.4P AD=4.4P PS=20.88U PD=20.88U
M$47 \$375 \$27 \$368 VDD pfet_06v0 L=1U W=10U AS=4.4P AD=4.4P PS=20.88U
+ PD=20.88U
M$48 \$318 INN \$383 VDD pfet_06v0 L=1U W=0.5U AS=0.22P AD=0.22P PS=1.88U
+ PD=1.88U
M$49 \$261 INP \$383 VDD pfet_06v0 L=1U W=0.55U AS=0.242P AD=0.242P PS=1.98U
+ PD=1.98U
M$50 \$55 \$55 \$362 VDD pfet_06v0 L=1U W=10U AS=4.4P AD=4.4P PS=20.88U
+ PD=20.88U
M$51 \$27 \$27 VDD VDD pfet_06v0 L=1U W=2U AS=0.88P AD=0.88P PS=4.88U PD=4.88U
M$52 OUT \$363 VDD VDD pfet_06v0 L=1U W=1U AS=0.44P AD=0.44P PS=2.88U PD=2.88U
M$53 OUT \$363 VDD VDD pfet_06v0 L=1U W=1U AS=0.44P AD=0.44P PS=2.88U PD=2.88U
M$54 OUT \$363 VDD VDD pfet_06v0 L=1U W=1U AS=0.44P AD=0.44P PS=2.88U PD=2.88U
M$55 OUT \$363 VDD VDD pfet_06v0 L=1U W=1U AS=0.44P AD=0.44P PS=2.88U PD=2.88U
R$56 \$363 \$I344 VSS 76450 ppolyf_u_1k L=76.45U W=1U
R$57 \$I345 \$I344 VSS 76450 ppolyf_u_1k L=76.45U W=1U
R$58 \$I345 \$I346 VSS 76450 ppolyf_u_1k L=76.45U W=1U
R$59 \$I347 \$I346 VSS 76450 ppolyf_u_1k L=76.45U W=1U
R$60 \$I347 OUT VSS 76450 ppolyf_u_1k L=76.45U W=1U
.ENDS OPAM_LIN_flat
