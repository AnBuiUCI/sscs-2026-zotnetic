* netlist plana generada por flatten_spice.py (top: GRADIENT_NAV2)
* 1539 MOSFETs; nets fusionadas por V=0: x5_net11->VSS, x5_net12->VSS, x5_net10->VSS, x5_net13->VSS, x6_net11->VSS, x6_net12->VSS, x6_net10->VSS, x6_net13->VSS, x7_net11->VSS, x7_net12->VSS, x7_net10->VSS, x7_net13->VSS
* nombres: los del esquematico; solo llevan la ruta de instancias (Mx1_M4) los 1383 que chocaban
* m -> fingers: Mx5_XM2: m=6 nf=1 -> nf=6; Mx5_XM3: m=2 nf=1 -> nf=2; Mx5_XM5: m=2 nf=1 -> nf=2; Mx5_XM1: m=2 nf=1 -> nf=2; Mx5_XM9: m=2 nf=1 -> nf=2; Mx5_XM11: m=2 nf=1 -> nf=2; Mx5_XMF1: m=2 nf=1 -> nf=2; Mx6_XM2: m=6 nf=1 -> nf=6; Mx6_XM3: m=2 nf=1 -> nf=2; Mx6_XM5: m=2 nf=1 -> nf=2; Mx6_XM1: m=2 nf=1 -> nf=2; Mx6_XM9: m=2 nf=1 -> nf=2; Mx6_XM11: m=2 nf=1 -> nf=2; Mx6_XMF1: m=2 nf=1 -> nf=2; Mx7_XM2: m=6 nf=1 -> nf=6; Mx7_XM3: m=2 nf=1 -> nf=2; Mx7_XM5: m=2 nf=1 -> nf=2; Mx7_XM1: m=2 nf=1 -> nf=2; Mx7_XM9: m=2 nf=1 -> nf=2; Mx7_XM11: m=2 nf=1 -> nf=2; Mx7_XMF1: m=2 nf=1 -> nf=2; Mx1_x4_x2_XM15: m=2 nf=1 -> nf=2; Mx1_x4_x2_XM16: m=2 nf=1 -> nf=2; Mx1_x4_x2_XM21: m=2 nf=1 -> nf=2; Mx1_x4_x2_XM22: m=2 nf=1 -> nf=2; Mx1_x4_x2_XM29: m=2 nf=1 -> nf=2; Mx1_x4_x2_XM30: m=2 nf=1 -> nf=2; Mx1_x4_x2_XM31: m=4 nf=1 -> nf=4; Mx1_x4_x2_XM35: m=4 nf=1 -> nf=4; Mx1_x4_x2_XM23: m=2 nf=1 -> nf=2; Mx1_x4_x2_XM24: m=2 nf=1 -> nf=2; Mx1_x4_x2_XM25: m=4 nf=1 -> nf=4; Mx1_x4_x2_XM26: m=4 nf=1 -> nf=4; Mx1_x4_x2_XM43: m=3 nf=1 -> nf=3; Mx1_x4_x2_XM44: m=3 nf=1 -> nf=3; Mx1_x5_x2_XM15: m=2 nf=1 -> nf=2; Mx1_x5_x2_XM16: m=2 nf=1 -> nf=2; Mx1_x5_x2_XM21: m=2 nf=1 -> nf=2; Mx1_x5_x2_XM22: m=2 nf=1 -> nf=2; Mx1_x5_x2_XM29: m=2 nf=1 -> nf=2; Mx1_x5_x2_XM30: m=2 nf=1 -> nf=2; Mx1_x5_x2_XM31: m=4 nf=1 -> nf=4; Mx1_x5_x2_XM35: m=4 nf=1 -> nf=4; Mx1_x5_x2_XM23: m=2 nf=1 -> nf=2; Mx1_x5_x2_XM24: m=2 nf=1 -> nf=2; Mx1_x5_x2_XM25: m=4 nf=1 -> nf=4; Mx1_x5_x2_XM26: m=4 nf=1 -> nf=4; Mx1_x5_x2_XM43: m=3 nf=1 -> nf=3; Mx1_x5_x2_XM44: m=3 nf=1 -> nf=3; Mx1_x6_x2_XM15: m=2 nf=1 -> nf=2; Mx1_x6_x2_XM16: m=2 nf=1 -> nf=2; Mx1_x6_x2_XM21: m=2 nf=1 -> nf=2; Mx1_x6_x2_XM22: m=2 nf=1 -> nf=2; Mx1_x6_x2_XM29: m=2 nf=1 -> nf=2; Mx1_x6_x2_XM30: m=2 nf=1 -> nf=2; Mx1_x6_x2_XM31: m=4 nf=1 -> nf=4; Mx1_x6_x2_XM35: m=4 nf=1 -> nf=4; Mx1_x6_x2_XM23: m=2 nf=1 -> nf=2; Mx1_x6_x2_XM24: m=2 nf=1 -> nf=2; Mx1_x6_x2_XM25: m=4 nf=1 -> nf=4; Mx1_x6_x2_XM26: m=4 nf=1 -> nf=4; Mx1_x6_x2_XM43: m=3 nf=1 -> nf=3; Mx1_x6_x2_XM44: m=3 nf=1 -> nf=3; Mx2_x4_x2_XM15: m=2 nf=1 -> nf=2; Mx2_x4_x2_XM16: m=2 nf=1 -> nf=2; Mx2_x4_x2_XM21: m=2 nf=1 -> nf=2; Mx2_x4_x2_XM22: m=2 nf=1 -> nf=2; Mx2_x4_x2_XM29: m=2 nf=1 -> nf=2; Mx2_x4_x2_XM30: m=2 nf=1 -> nf=2; Mx2_x4_x2_XM31: m=4 nf=1 -> nf=4; Mx2_x4_x2_XM35: m=4 nf=1 -> nf=4; Mx2_x4_x2_XM23: m=2 nf=1 -> nf=2; Mx2_x4_x2_XM24: m=2 nf=1 -> nf=2; Mx2_x4_x2_XM25: m=4 nf=1 -> nf=4; Mx2_x4_x2_XM26: m=4 nf=1 -> nf=4; Mx2_x4_x2_XM43: m=3 nf=1 -> nf=3; Mx2_x4_x2_XM44: m=3 nf=1 -> nf=3; Mx2_x5_x2_XM15: m=2 nf=1 -> nf=2; Mx2_x5_x2_XM16: m=2 nf=1 -> nf=2; Mx2_x5_x2_XM21: m=2 nf=1 -> nf=2; Mx2_x5_x2_XM22: m=2 nf=1 -> nf=2; Mx2_x5_x2_XM29: m=2 nf=1 -> nf=2; Mx2_x5_x2_XM30: m=2 nf=1 -> nf=2; Mx2_x5_x2_XM31: m=4 nf=1 -> nf=4; Mx2_x5_x2_XM35: m=4 nf=1 -> nf=4; Mx2_x5_x2_XM23: m=2 nf=1 -> nf=2; Mx2_x5_x2_XM24: m=2 nf=1 -> nf=2; Mx2_x5_x2_XM25: m=4 nf=1 -> nf=4; Mx2_x5_x2_XM26: m=4 nf=1 -> nf=4; Mx2_x5_x2_XM43: m=3 nf=1 -> nf=3; Mx2_x5_x2_XM44: m=3 nf=1 -> nf=3; Mx2_x6_x2_XM15: m=2 nf=1 -> nf=2; Mx2_x6_x2_XM16: m=2 nf=1 -> nf=2; Mx2_x6_x2_XM21: m=2 nf=1 -> nf=2; Mx2_x6_x2_XM22: m=2 nf=1 -> nf=2; Mx2_x6_x2_XM29: m=2 nf=1 -> nf=2; Mx2_x6_x2_XM30: m=2 nf=1 -> nf=2; Mx2_x6_x2_XM31: m=4 nf=1 -> nf=4; Mx2_x6_x2_XM35: m=4 nf=1 -> nf=4; Mx2_x6_x2_XM23: m=2 nf=1 -> nf=2; Mx2_x6_x2_XM24: m=2 nf=1 -> nf=2; Mx2_x6_x2_XM25: m=4 nf=1 -> nf=4; Mx2_x6_x2_XM26: m=4 nf=1 -> nf=4; Mx2_x6_x2_XM43: m=3 nf=1 -> nf=3; Mx2_x6_x2_XM44: m=3 nf=1 -> nf=3; Mx3_x4_x2_XM15: m=2 nf=1 -> nf=2; Mx3_x4_x2_XM16: m=2 nf=1 -> nf=2; Mx3_x4_x2_XM21: m=2 nf=1 -> nf=2; Mx3_x4_x2_XM22: m=2 nf=1 -> nf=2; Mx3_x4_x2_XM29: m=2 nf=1 -> nf=2; Mx3_x4_x2_XM30: m=2 nf=1 -> nf=2; Mx3_x4_x2_XM31: m=4 nf=1 -> nf=4; Mx3_x4_x2_XM35: m=4 nf=1 -> nf=4; Mx3_x4_x2_XM23: m=2 nf=1 -> nf=2; Mx3_x4_x2_XM24: m=2 nf=1 -> nf=2; Mx3_x4_x2_XM25: m=4 nf=1 -> nf=4; Mx3_x4_x2_XM26: m=4 nf=1 -> nf=4; Mx3_x4_x2_XM43: m=3 nf=1 -> nf=3; Mx3_x4_x2_XM44: m=3 nf=1 -> nf=3; Mx3_x5_x2_XM15: m=2 nf=1 -> nf=2; Mx3_x5_x2_XM16: m=2 nf=1 -> nf=2; Mx3_x5_x2_XM21: m=2 nf=1 -> nf=2; Mx3_x5_x2_XM22: m=2 nf=1 -> nf=2; Mx3_x5_x2_XM29: m=2 nf=1 -> nf=2; Mx3_x5_x2_XM30: m=2 nf=1 -> nf=2; Mx3_x5_x2_XM31: m=4 nf=1 -> nf=4; Mx3_x5_x2_XM35: m=4 nf=1 -> nf=4; Mx3_x5_x2_XM23: m=2 nf=1 -> nf=2; Mx3_x5_x2_XM24: m=2 nf=1 -> nf=2; Mx3_x5_x2_XM25: m=4 nf=1 -> nf=4; Mx3_x5_x2_XM26: m=4 nf=1 -> nf=4; Mx3_x5_x2_XM43: m=3 nf=1 -> nf=3; Mx3_x5_x2_XM44: m=3 nf=1 -> nf=3; Mx3_x6_x2_XM15: m=2 nf=1 -> nf=2; Mx3_x6_x2_XM16: m=2 nf=1 -> nf=2; Mx3_x6_x2_XM21: m=2 nf=1 -> nf=2; Mx3_x6_x2_XM22: m=2 nf=1 -> nf=2; Mx3_x6_x2_XM29: m=2 nf=1 -> nf=2; Mx3_x6_x2_XM30: m=2 nf=1 -> nf=2; Mx3_x6_x2_XM31: m=4 nf=1 -> nf=4; Mx3_x6_x2_XM35: m=4 nf=1 -> nf=4; Mx3_x6_x2_XM23: m=2 nf=1 -> nf=2; Mx3_x6_x2_XM24: m=2 nf=1 -> nf=2; Mx3_x6_x2_XM25: m=4 nf=1 -> nf=4; Mx3_x6_x2_XM26: m=4 nf=1 -> nf=4; Mx3_x6_x2_XM43: m=3 nf=1 -> nf=3; Mx3_x6_x2_XM44: m=3 nf=1 -> nf=3; Mx4_x4_x2_XM15: m=2 nf=1 -> nf=2; Mx4_x4_x2_XM16: m=2 nf=1 -> nf=2; Mx4_x4_x2_XM21: m=2 nf=1 -> nf=2; Mx4_x4_x2_XM22: m=2 nf=1 -> nf=2; Mx4_x4_x2_XM29: m=2 nf=1 -> nf=2; Mx4_x4_x2_XM30: m=2 nf=1 -> nf=2; Mx4_x4_x2_XM31: m=4 nf=1 -> nf=4; Mx4_x4_x2_XM35: m=4 nf=1 -> nf=4; Mx4_x4_x2_XM23: m=2 nf=1 -> nf=2; Mx4_x4_x2_XM24: m=2 nf=1 -> nf=2; Mx4_x4_x2_XM25: m=4 nf=1 -> nf=4; Mx4_x4_x2_XM26: m=4 nf=1 -> nf=4; Mx4_x4_x2_XM43: m=3 nf=1 -> nf=3; Mx4_x4_x2_XM44: m=3 nf=1 -> nf=3; Mx4_x5_x2_XM15: m=2 nf=1 -> nf=2; Mx4_x5_x2_XM16: m=2 nf=1 -> nf=2; Mx4_x5_x2_XM21: m=2 nf=1 -> nf=2; Mx4_x5_x2_XM22: m=2 nf=1 -> nf=2; Mx4_x5_x2_XM29: m=2 nf=1 -> nf=2; Mx4_x5_x2_XM30: m=2 nf=1 -> nf=2; Mx4_x5_x2_XM31: m=4 nf=1 -> nf=4; Mx4_x5_x2_XM35: m=4 nf=1 -> nf=4; Mx4_x5_x2_XM23: m=2 nf=1 -> nf=2; Mx4_x5_x2_XM24: m=2 nf=1 -> nf=2; Mx4_x5_x2_XM25: m=4 nf=1 -> nf=4; Mx4_x5_x2_XM26: m=4 nf=1 -> nf=4; Mx4_x5_x2_XM43: m=3 nf=1 -> nf=3; Mx4_x5_x2_XM44: m=3 nf=1 -> nf=3; Mx4_x6_x2_XM15: m=2 nf=1 -> nf=2; Mx4_x6_x2_XM16: m=2 nf=1 -> nf=2; Mx4_x6_x2_XM21: m=2 nf=1 -> nf=2; Mx4_x6_x2_XM22: m=2 nf=1 -> nf=2; Mx4_x6_x2_XM29: m=2 nf=1 -> nf=2; Mx4_x6_x2_XM30: m=2 nf=1 -> nf=2; Mx4_x6_x2_XM31: m=4 nf=1 -> nf=4; Mx4_x6_x2_XM35: m=4 nf=1 -> nf=4; Mx4_x6_x2_XM23: m=2 nf=1 -> nf=2; Mx4_x6_x2_XM24: m=2 nf=1 -> nf=2; Mx4_x6_x2_XM25: m=4 nf=1 -> nf=4; Mx4_x6_x2_XM26: m=4 nf=1 -> nf=4; Mx4_x6_x2_XM43: m=3 nf=1 -> nf=3; Mx4_x6_x2_XM44: m=3 nf=1 -> nf=3
* para LVS: cada dedo, un transistor en paralelo
.subckt GRADIENT_NAV2 VDD VSS XP X XN YP Y YN ZP Z ZN S2P S2N S4P S4N S3P S3N S1P S1N
Mx5_XM2_f1 X X VDD VDD pfet_06v0 L=1u W=2u
Mx5_XM2_f2 X X VDD VDD pfet_06v0 L=1u W=2u
Mx5_XM2_f3 X X VDD VDD pfet_06v0 L=1u W=2u
Mx5_XM2_f4 X X VDD VDD pfet_06v0 L=1u W=2u
Mx5_XM2_f5 X X VDD VDD pfet_06v0 L=1u W=2u
Mx5_XM2_f6 X X VDD VDD pfet_06v0 L=1u W=2u
Mx5_XM3_f1 X X4 x5_net1 VSS nfet_06v0 L=1u W=2.48u
Mx5_XM3_f2 X X4 x5_net1 VSS nfet_06v0 L=1u W=2.48u
Mx5_XM5_f1 X X2 x5_net2 VSS nfet_06v0 L=1u W=2.48u
Mx5_XM5_f2 X X2 x5_net2 VSS nfet_06v0 L=1u W=2.48u
Mx5_XM6 x5_net2 x5_IN VSS VSS nfet_06v0 L=1u W=1.24u
Mx5_XM1_f1 X X x5_net3 VSS nfet_06v0 L=1u W=2u
Mx5_XM1_f2 X X x5_net3 VSS nfet_06v0 L=1u W=2u
Mx5_XM7 x5_net3 X x5_net4 VSS nfet_06v0 L=1u W=2u
Mx5_XM8 x5_net4 X VSS VSS nfet_06v0 L=1u W=2u
Mx5_XM9_f1 X X1 x5_net5 VSS nfet_06v0 L=1u W=2.48u
Mx5_XM9_f2 X X1 x5_net5 VSS nfet_06v0 L=1u W=2.48u
Mx5_XM10 x5_net5 x5_IN VSS VSS nfet_06v0 L=1u W=1.24u
Mx5_XM11_f1 X X3 x5_net6 VSS nfet_06v0 L=1u W=2.48u
Mx5_XM11_f2 X X3 x5_net6 VSS nfet_06v0 L=1u W=2.48u
Mx5_XM12 x5_net6 x5_IN VSS VSS nfet_06v0 L=1u W=1.24u
Mx5_XM4 x5_net1 x5_IN VSS VSS nfet_06v0 L=1u W=1.24u
Mx5_XM13 x5_IN x5_IN VDD VDD pfet_06v0 L=1u W=2u
Mx5_XM14 x5_net8 x5_IN x5_net9 VSS nfet_06v0 L=1u W=0.7u
Mx5_XM15 x5_net7 x5_IN x5_net8 VSS nfet_06v0 L=1u W=0.7u
Mx5_XM16 x5_IN x5_IN x5_net7 VSS nfet_06v0 L=1u W=0.7u
Mx5_XM17 x5_net9 x5_IN VSS VSS nfet_06v0 L=1u W=0.7u
Mx5_XMF1_f1 X VDD x5_netF VSS nfet_06v0 L=1u W=2.48u
Mx5_XMF1_f2 X VDD x5_netF VSS nfet_06v0 L=1u W=2.48u
Mx5_XMF2 x5_netF x5_IN VSS VSS nfet_06v0 L=1u W=1.24u
Mx6_XM2_f1 Y Y VDD VDD pfet_06v0 L=1u W=2u
Mx6_XM2_f2 Y Y VDD VDD pfet_06v0 L=1u W=2u
Mx6_XM2_f3 Y Y VDD VDD pfet_06v0 L=1u W=2u
Mx6_XM2_f4 Y Y VDD VDD pfet_06v0 L=1u W=2u
Mx6_XM2_f5 Y Y VDD VDD pfet_06v0 L=1u W=2u
Mx6_XM2_f6 Y Y VDD VDD pfet_06v0 L=1u W=2u
Mx6_XM3_f1 Y Y4 x6_net1 VSS nfet_06v0 L=1u W=2.48u
Mx6_XM3_f2 Y Y4 x6_net1 VSS nfet_06v0 L=1u W=2.48u
Mx6_XM5_f1 Y Y2 x6_net2 VSS nfet_06v0 L=1u W=2.48u
Mx6_XM5_f2 Y Y2 x6_net2 VSS nfet_06v0 L=1u W=2.48u
Mx6_XM6 x6_net2 x6_IN VSS VSS nfet_06v0 L=1u W=1.24u
Mx6_XM1_f1 Y Y x6_net3 VSS nfet_06v0 L=1u W=2u
Mx6_XM1_f2 Y Y x6_net3 VSS nfet_06v0 L=1u W=2u
Mx6_XM7 x6_net3 Y x6_net4 VSS nfet_06v0 L=1u W=2u
Mx6_XM8 x6_net4 Y VSS VSS nfet_06v0 L=1u W=2u
Mx6_XM9_f1 Y Y1 x6_net5 VSS nfet_06v0 L=1u W=2.48u
Mx6_XM9_f2 Y Y1 x6_net5 VSS nfet_06v0 L=1u W=2.48u
Mx6_XM10 x6_net5 x6_IN VSS VSS nfet_06v0 L=1u W=1.24u
Mx6_XM11_f1 Y Y3 x6_net6 VSS nfet_06v0 L=1u W=2.48u
Mx6_XM11_f2 Y Y3 x6_net6 VSS nfet_06v0 L=1u W=2.48u
Mx6_XM12 x6_net6 x6_IN VSS VSS nfet_06v0 L=1u W=1.24u
Mx6_XM4 x6_net1 x6_IN VSS VSS nfet_06v0 L=1u W=1.24u
Mx6_XM13 x6_IN x6_IN VDD VDD pfet_06v0 L=1u W=2u
Mx6_XM14 x6_net8 x6_IN x6_net9 VSS nfet_06v0 L=1u W=0.7u
Mx6_XM15 x6_net7 x6_IN x6_net8 VSS nfet_06v0 L=1u W=0.7u
Mx6_XM16 x6_IN x6_IN x6_net7 VSS nfet_06v0 L=1u W=0.7u
Mx6_XM17 x6_net9 x6_IN VSS VSS nfet_06v0 L=1u W=0.7u
Mx6_XMF1_f1 Y VDD x6_netF VSS nfet_06v0 L=1u W=2.48u
Mx6_XMF1_f2 Y VDD x6_netF VSS nfet_06v0 L=1u W=2.48u
Mx6_XMF2 x6_netF x6_IN VSS VSS nfet_06v0 L=1u W=1.24u
Mx7_XM2_f1 Z Z VDD VDD pfet_06v0 L=1u W=2u
Mx7_XM2_f2 Z Z VDD VDD pfet_06v0 L=1u W=2u
Mx7_XM2_f3 Z Z VDD VDD pfet_06v0 L=1u W=2u
Mx7_XM2_f4 Z Z VDD VDD pfet_06v0 L=1u W=2u
Mx7_XM2_f5 Z Z VDD VDD pfet_06v0 L=1u W=2u
Mx7_XM2_f6 Z Z VDD VDD pfet_06v0 L=1u W=2u
Mx7_XM3_f1 Z Z4 x7_net1 VSS nfet_06v0 L=1u W=2.48u
Mx7_XM3_f2 Z Z4 x7_net1 VSS nfet_06v0 L=1u W=2.48u
Mx7_XM5_f1 Z Z2 x7_net2 VSS nfet_06v0 L=1u W=2.48u
Mx7_XM5_f2 Z Z2 x7_net2 VSS nfet_06v0 L=1u W=2.48u
Mx7_XM6 x7_net2 x7_IN VSS VSS nfet_06v0 L=1u W=1.24u
Mx7_XM1_f1 Z Z x7_net3 VSS nfet_06v0 L=1u W=2u
Mx7_XM1_f2 Z Z x7_net3 VSS nfet_06v0 L=1u W=2u
Mx7_XM7 x7_net3 Z x7_net4 VSS nfet_06v0 L=1u W=2u
Mx7_XM8 x7_net4 Z VSS VSS nfet_06v0 L=1u W=2u
Mx7_XM9_f1 Z Z1 x7_net5 VSS nfet_06v0 L=1u W=2.48u
Mx7_XM9_f2 Z Z1 x7_net5 VSS nfet_06v0 L=1u W=2.48u
Mx7_XM10 x7_net5 x7_IN VSS VSS nfet_06v0 L=1u W=1.24u
Mx7_XM11_f1 Z Z3 x7_net6 VSS nfet_06v0 L=1u W=2.48u
Mx7_XM11_f2 Z Z3 x7_net6 VSS nfet_06v0 L=1u W=2.48u
Mx7_XM12 x7_net6 x7_IN VSS VSS nfet_06v0 L=1u W=1.24u
Mx7_XM4 x7_net1 x7_IN VSS VSS nfet_06v0 L=1u W=1.24u
Mx7_XM13 x7_IN x7_IN VDD VDD pfet_06v0 L=1u W=2u
Mx7_XM14 x7_net8 x7_IN x7_net9 VSS nfet_06v0 L=1u W=0.7u
Mx7_XM15 x7_net7 x7_IN x7_net8 VSS nfet_06v0 L=1u W=0.7u
Mx7_XM16 x7_IN x7_IN x7_net7 VSS nfet_06v0 L=1u W=0.7u
Mx7_XM17 x7_net9 x7_IN VSS VSS nfet_06v0 L=1u W=0.7u
Mx7_XMF1_f1 Z VDD x7_netF VSS nfet_06v0 L=1u W=2.48u
Mx7_XMF1_f2 Z VDD x7_netF VSS nfet_06v0 L=1u W=2.48u
Mx7_XMF2 x7_netF x7_IN VSS VSS nfet_06v0 L=1u W=1.24u
Mx8_x1_XM3 x8_net1 X VDD VDD pfet_05v0 L=0.5u W=1.83u
Mx8_x1_XM4 x8_net1 X VSS VSS nfet_05v0 L=0.6u W=1.32u
Mx8_x2_XM3 XN x8_net1 VDD VDD pfet_05v0 L=0.5u W=1.83u
Mx8_x2_XM4 XN x8_net1 VSS VSS nfet_05v0 L=0.6u W=1.32u
Mx8_x3_XM3 XP XN VDD VDD pfet_05v0 L=0.5u W=1.83u
Mx8_x3_XM4 XP XN VSS VSS nfet_05v0 L=0.6u W=1.32u
Mx9_x1_XM3 x9_net1 Y VDD VDD pfet_05v0 L=0.5u W=1.83u
Mx9_x1_XM4 x9_net1 Y VSS VSS nfet_05v0 L=0.6u W=1.32u
Mx9_x2_XM3 YN x9_net1 VDD VDD pfet_05v0 L=0.5u W=1.83u
Mx9_x2_XM4 YN x9_net1 VSS VSS nfet_05v0 L=0.6u W=1.32u
Mx9_x3_XM3 YP YN VDD VDD pfet_05v0 L=0.5u W=1.83u
Mx9_x3_XM4 YP YN VSS VSS nfet_05v0 L=0.6u W=1.32u
Mx10_x1_XM3 x10_net1 Z VDD VDD pfet_05v0 L=0.5u W=1.83u
Mx10_x1_XM4 x10_net1 Z VSS VSS nfet_05v0 L=0.6u W=1.32u
Mx10_x2_XM3 ZN x10_net1 VDD VDD pfet_05v0 L=0.5u W=1.83u
Mx10_x2_XM4 ZN x10_net1 VSS VSS nfet_05v0 L=0.6u W=1.32u
Mx10_x3_XM3 ZP ZN VDD VDD pfet_05v0 L=0.5u W=1.83u
Mx10_x3_XM4 ZP ZN VSS VSS nfet_05v0 L=0.6u W=1.32u
Mx1_x4_x1_XM4 x1_x4_x1_net3 x1_x4_net4 VDD VDD pfet_06v0 L=1.0u W=10.0u
Mx1_x4_x1_XM5 x1_x4_net2 x1_x4_net3 x1_x4_x1_net3 VDD pfet_06v0 L=1.0u W=10.0u
Mx1_x4_x1_XM6 x1_x4_net2 x1_x4_net2 VSS VSS nfet_06v0 L=1.0u W=1.0u
Mx1_x4_x1_XM7 x1_x4_x1_net2 x1_x4_net4 VDD VDD pfet_06v0 L=1.0u W=10.0u
Mx1_x4_x1_XM8 x1_x4_net1 x1_x4_net3 x1_x4_x1_net2 VDD pfet_06v0 L=1.0u W=10.0u
Mx1_x4_x1_XM9 x1_x4_net1 x1_x4_net2 x1_x4_x1_net1 VSS nfet_06v0 L=1.0u W=5.0u
Mx1_x4_x1_XM10 x1_x4_x1_net1 x1_x4_net1 VSS VSS nfet_06v0 L=1.0u W=5.0u
Mx1_x4_x1_XM1 x1_x4_net3 x1_x4_net3 VDD VDD pfet_06v0 L=1.0u W=2u
Mx1_x4_x1_XM2 x1_x4_x1_net4 x1_x4_net4 VDD VDD pfet_06v0 L=1.0u W=10.0u
Mx1_x4_x1_XM3 x1_x4_net4 x1_x4_net3 x1_x4_x1_net4 VDD pfet_06v0 L=1.0u W=10.0u
Mx1_x4_x1_XM47 x1_x4_x1_net5 x1_x4_net3 VSS VSS nfet_06v0 L=1.0u W=1.0u
Mx1_x4_x1_XM48 x1_x4_x1_net6 x1_x4_net3 VSS VSS nfet_06v0 L=1.0u W=1.0u
Mx1_x4_x1_XM49 x1_x4_net3 x1_x4_net3 x1_x4_x1_net6 VSS nfet_06v0 L=1.0u W=1.0u
Mx1_x4_x1_XM50 x1_x4_net4 x1_x4_net3 x1_x4_x1_net5 VSS nfet_06v0 L=1.0u W=1.0u
Mx1_x4_x2_XM11 x1_x4_x2_net2 x1_x4_net4 VDD VDD pfet_06v0 L=1.0u W=10.0u
Mx1_x4_x2_XM12 x1_x4_x2_net7 x1_x4_net3 x1_x4_x2_net2 VDD pfet_06v0 L=1.0u W=10.0u
Mx1_x4_x2_XM13 x1_x4_x2_net19 x1_x4_net4 VDD VDD pfet_06v0 L=1.0u W=10.0u
Mx1_x4_x2_XM14 x1_x4_x2_net7 x1_x4_net3 x1_x4_x2_net19 VDD pfet_06v0 L=1.0u W=10.0u
Mx1_x4_x2_XM15_f1 x1_x4_x2_net5 x1_SY x1_x4_x2_net7 VDD pfet_06v0 L=1.0u W=10.0u
Mx1_x4_x2_XM15_f2 x1_x4_x2_net5 x1_SY x1_x4_x2_net7 VDD pfet_06v0 L=1.0u W=10.0u
Mx1_x4_x2_XM16_f1 x1_x4_x2_net4 x1_SX x1_x4_x2_net7 VDD pfet_06v0 L=1.0u W=10.0u
Mx1_x4_x2_XM16_f2 x1_x4_x2_net4 x1_SX x1_x4_x2_net7 VDD pfet_06v0 L=1.0u W=10.0u
Mx1_x4_x2_XM17 x1_x4_x2_net8 x1_x4_net2 x1_x4_x2_net1 VSS nfet_06v0 L=1.0u W=5.0u
Mx1_x4_x2_XM18 x1_x4_x2_net1 x1_x4_net1 VSS VSS nfet_06v0 L=1.0u W=5.0u
Mx1_x4_x2_XM19 x1_x4_x2_net8 x1_x4_net2 x1_x4_x2_net20 VSS nfet_06v0 L=1.0u W=5.0u
Mx1_x4_x2_XM20 x1_x4_x2_net20 x1_x4_net1 VSS VSS nfet_06v0 L=1.0u W=5.0u
Mx1_x4_x2_XM21_f1 x1_x4_x2_net6 x1_SY x1_x4_x2_net8 VSS nfet_06v0 L=1.0u W=5u
Mx1_x4_x2_XM21_f2 x1_x4_x2_net6 x1_SY x1_x4_x2_net8 VSS nfet_06v0 L=1.0u W=5u
Mx1_x4_x2_XM22_f1 x1_x4_x2_net3 x1_SX x1_x4_x2_net8 VSS nfet_06v0 L=1.0u W=5u
Mx1_x4_x2_XM22_f2 x1_x4_x2_net3 x1_SX x1_x4_x2_net8 VSS nfet_06v0 L=1.0u W=5u
Mx1_x4_x2_XM29_f1 x1_x4_x2_net9 x1_x4_net3 x1_x4_x2_net3 VDD pfet_06v0 L=1.0u W=5u
Mx1_x4_x2_XM29_f2 x1_x4_x2_net9 x1_x4_net3 x1_x4_x2_net3 VDD pfet_06v0 L=1.0u W=5u
Mx1_x4_x2_XM30_f1 x1_x4_x2_net12 x1_x4_net3 x1_x4_x2_net6 VDD pfet_06v0 L=1.0u W=5.0u
Mx1_x4_x2_XM30_f2 x1_x4_x2_net12 x1_x4_net3 x1_x4_x2_net6 VDD pfet_06v0 L=1.0u W=5.0u
Mx1_x4_x2_XM31_f1 x1_x4_x2_net3 x1_x4_x2_net9 VDD VDD pfet_06v0 L=1.0u W=5u
Mx1_x4_x2_XM31_f2 x1_x4_x2_net3 x1_x4_x2_net9 VDD VDD pfet_06v0 L=1.0u W=5u
Mx1_x4_x2_XM31_f3 x1_x4_x2_net3 x1_x4_x2_net9 VDD VDD pfet_06v0 L=1.0u W=5u
Mx1_x4_x2_XM31_f4 x1_x4_x2_net3 x1_x4_x2_net9 VDD VDD pfet_06v0 L=1.0u W=5u
Mx1_x4_x2_XM35_f1 x1_x4_x2_net6 x1_x4_x2_net9 VDD VDD pfet_06v0 L=1.0u W=5.0u
Mx1_x4_x2_XM35_f2 x1_x4_x2_net6 x1_x4_x2_net9 VDD VDD pfet_06v0 L=1.0u W=5.0u
Mx1_x4_x2_XM35_f3 x1_x4_x2_net6 x1_x4_x2_net9 VDD VDD pfet_06v0 L=1.0u W=5.0u
Mx1_x4_x2_XM35_f4 x1_x4_x2_net6 x1_x4_x2_net9 VDD VDD pfet_06v0 L=1.0u W=5.0u
Mx1_x4_x2_XM32 x1_x4_x2_net10 x1_x4_x2_net21 x1_x4_x2_net9 VDD pfet_06v0 L=1.0u W=5u
Mx1_x4_x2_XM33 x1_x4_x2_net22 x1_x4_x2_net21 x1_x4_x2_net12 VDD pfet_06v0 L=1.0u W=5.0u
Mx1_x4_x2_XM23_f1 x1_x4_x2_net10 x1_x4_net2 x1_x4_x2_net4 VSS nfet_06v0 L=1.0u W=2.5u
Mx1_x4_x2_XM23_f2 x1_x4_x2_net10 x1_x4_net2 x1_x4_x2_net4 VSS nfet_06v0 L=1.0u W=2.5u
Mx1_x4_x2_XM24_f1 x1_x4_x2_net22 x1_x4_net2 x1_x4_x2_net5 VSS nfet_06v0 L=1.0u W=2.5u
Mx1_x4_x2_XM24_f2 x1_x4_x2_net22 x1_x4_net2 x1_x4_x2_net5 VSS nfet_06v0 L=1.0u W=2.5u
Mx1_x4_x2_XM25_f1 x1_x4_x2_net4 x1_x4_x2_net10 VSS VSS nfet_06v0 L=1.0u W=2.5u
Mx1_x4_x2_XM25_f2 x1_x4_x2_net4 x1_x4_x2_net10 VSS VSS nfet_06v0 L=1.0u W=2.5u
Mx1_x4_x2_XM25_f3 x1_x4_x2_net4 x1_x4_x2_net10 VSS VSS nfet_06v0 L=1.0u W=2.5u
Mx1_x4_x2_XM25_f4 x1_x4_x2_net4 x1_x4_x2_net10 VSS VSS nfet_06v0 L=1.0u W=2.5u
Mx1_x4_x2_XM26_f1 x1_x4_x2_net5 x1_x4_x2_net10 VSS VSS nfet_06v0 L=1.0u W=2.5u
Mx1_x4_x2_XM26_f2 x1_x4_x2_net5 x1_x4_x2_net10 VSS VSS nfet_06v0 L=1.0u W=2.5u
Mx1_x4_x2_XM26_f3 x1_x4_x2_net5 x1_x4_x2_net10 VSS VSS nfet_06v0 L=1.0u W=2.5u
Mx1_x4_x2_XM26_f4 x1_x4_x2_net5 x1_x4_x2_net10 VSS VSS nfet_06v0 L=1.0u W=2.5u
Mx1_x4_x2_XM27 x1_x4_x2_net9 x1_x4_x2_net11 x1_x4_x2_net10 VSS nfet_06v0 L=1.0u W=2.5u
Mx1_x4_x2_XM28 x1_x4_x2_net12 x1_x4_x2_net11 x1_x4_x2_net22 VSS nfet_06v0 L=1.0u W=2.5u
Mx1_x4_x2_XM34 x1_x4_x2_net13 x1_x4_x2_net14 VDD VDD pfet_06v0 L=1.0u W=10.0u
Mx1_x4_x2_XM36 x1_x4_x2_net14 x1_x4_net3 x1_x4_x2_net13 VDD pfet_06v0 L=1.0u W=10.0u
Mx1_x4_x2_XM37 x1_x4_x2_net21 x1_x4_x2_net21 x1_x4_x2_net14 VDD pfet_06v0 L=1.0u W=10.0u
Mx1_x4_x2_XM38 x1_x4_x2_net21 x1_x4_net2 x1_x4_x2_net15 VSS nfet_06v0 L=1.0u W=5.0u
Mx1_x4_x2_XM39 x1_x4_x2_net15 x1_x4_net1 VSS VSS nfet_06v0 L=1.0u W=5.0u
Mx1_x4_x2_XM45 x1_x4_x2_net16 x1_x4_net4 VDD VDD pfet_06v0 L=1.0u W=10.0u
Mx1_x4_x2_XM46 x1_x4_x2_net11 x1_x4_net3 x1_x4_x2_net16 VDD pfet_06v0 L=1.0u W=10.0u
Mx1_x4_x2_XM40 x1_x4_x2_net11 x1_x4_x2_net11 x1_x4_x2_net18 VSS nfet_06v0 L=1.0u W=5.0u
Mx1_x4_x2_XM41 x1_x4_x2_net18 x1_x4_net2 x1_x4_x2_net17 VSS nfet_06v0 L=1.0u W=5.0u
Mx1_x4_x2_XM42 x1_x4_x2_net17 x1_x4_x2_net18 VSS VSS nfet_06v0 L=1.0u W=5.0u
Mx1_x4_x2_XM43_f1 x1_net1 x1_x4_x2_net12 VDD VDD pfet_06v0 L=1.0u W=10u
Mx1_x4_x2_XM43_f2 x1_net1 x1_x4_x2_net12 VDD VDD pfet_06v0 L=1.0u W=10u
Mx1_x4_x2_XM43_f3 x1_net1 x1_x4_x2_net12 VDD VDD pfet_06v0 L=1.0u W=10u
Mx1_x4_x2_XM44_f1 x1_net1 x1_x4_x2_net22 VSS VSS nfet_06v0 L=1.0u W=5u
Mx1_x4_x2_XM44_f2 x1_net1 x1_x4_x2_net22 VSS VSS nfet_06v0 L=1.0u W=5u
Mx1_x4_x2_XM44_f3 x1_net1 x1_x4_x2_net22 VSS VSS nfet_06v0 L=1.0u W=5u
Mx1_x5_x1_XM4 x1_x5_x1_net3 x1_x5_net4 VDD VDD pfet_06v0 L=1.0u W=10.0u
Mx1_x5_x1_XM5 x1_x5_net2 x1_x5_net3 x1_x5_x1_net3 VDD pfet_06v0 L=1.0u W=10.0u
Mx1_x5_x1_XM6 x1_x5_net2 x1_x5_net2 VSS VSS nfet_06v0 L=1.0u W=1.0u
Mx1_x5_x1_XM7 x1_x5_x1_net2 x1_x5_net4 VDD VDD pfet_06v0 L=1.0u W=10.0u
Mx1_x5_x1_XM8 x1_x5_net1 x1_x5_net3 x1_x5_x1_net2 VDD pfet_06v0 L=1.0u W=10.0u
Mx1_x5_x1_XM9 x1_x5_net1 x1_x5_net2 x1_x5_x1_net1 VSS nfet_06v0 L=1.0u W=5.0u
Mx1_x5_x1_XM10 x1_x5_x1_net1 x1_x5_net1 VSS VSS nfet_06v0 L=1.0u W=5.0u
Mx1_x5_x1_XM1 x1_x5_net3 x1_x5_net3 VDD VDD pfet_06v0 L=1.0u W=2u
Mx1_x5_x1_XM2 x1_x5_x1_net4 x1_x5_net4 VDD VDD pfet_06v0 L=1.0u W=10.0u
Mx1_x5_x1_XM3 x1_x5_net4 x1_x5_net3 x1_x5_x1_net4 VDD pfet_06v0 L=1.0u W=10.0u
Mx1_x5_x1_XM47 x1_x5_x1_net5 x1_x5_net3 VSS VSS nfet_06v0 L=1.0u W=1.0u
Mx1_x5_x1_XM48 x1_x5_x1_net6 x1_x5_net3 VSS VSS nfet_06v0 L=1.0u W=1.0u
Mx1_x5_x1_XM49 x1_x5_net3 x1_x5_net3 x1_x5_x1_net6 VSS nfet_06v0 L=1.0u W=1.0u
Mx1_x5_x1_XM50 x1_x5_net4 x1_x5_net3 x1_x5_x1_net5 VSS nfet_06v0 L=1.0u W=1.0u
Mx1_x5_x2_XM11 x1_x5_x2_net2 x1_x5_net4 VDD VDD pfet_06v0 L=1.0u W=10.0u
Mx1_x5_x2_XM12 x1_x5_x2_net7 x1_x5_net3 x1_x5_x2_net2 VDD pfet_06v0 L=1.0u W=10.0u
Mx1_x5_x2_XM13 x1_x5_x2_net19 x1_x5_net4 VDD VDD pfet_06v0 L=1.0u W=10.0u
Mx1_x5_x2_XM14 x1_x5_x2_net7 x1_x5_net3 x1_x5_x2_net19 VDD pfet_06v0 L=1.0u W=10.0u
Mx1_x5_x2_XM15_f1 x1_x5_x2_net5 x1_SZ x1_x5_x2_net7 VDD pfet_06v0 L=1.0u W=10.0u
Mx1_x5_x2_XM15_f2 x1_x5_x2_net5 x1_SZ x1_x5_x2_net7 VDD pfet_06v0 L=1.0u W=10.0u
Mx1_x5_x2_XM16_f1 x1_x5_x2_net4 x1_SX x1_x5_x2_net7 VDD pfet_06v0 L=1.0u W=10.0u
Mx1_x5_x2_XM16_f2 x1_x5_x2_net4 x1_SX x1_x5_x2_net7 VDD pfet_06v0 L=1.0u W=10.0u
Mx1_x5_x2_XM17 x1_x5_x2_net8 x1_x5_net2 x1_x5_x2_net1 VSS nfet_06v0 L=1.0u W=5.0u
Mx1_x5_x2_XM18 x1_x5_x2_net1 x1_x5_net1 VSS VSS nfet_06v0 L=1.0u W=5.0u
Mx1_x5_x2_XM19 x1_x5_x2_net8 x1_x5_net2 x1_x5_x2_net20 VSS nfet_06v0 L=1.0u W=5.0u
Mx1_x5_x2_XM20 x1_x5_x2_net20 x1_x5_net1 VSS VSS nfet_06v0 L=1.0u W=5.0u
Mx1_x5_x2_XM21_f1 x1_x5_x2_net6 x1_SZ x1_x5_x2_net8 VSS nfet_06v0 L=1.0u W=5u
Mx1_x5_x2_XM21_f2 x1_x5_x2_net6 x1_SZ x1_x5_x2_net8 VSS nfet_06v0 L=1.0u W=5u
Mx1_x5_x2_XM22_f1 x1_x5_x2_net3 x1_SX x1_x5_x2_net8 VSS nfet_06v0 L=1.0u W=5u
Mx1_x5_x2_XM22_f2 x1_x5_x2_net3 x1_SX x1_x5_x2_net8 VSS nfet_06v0 L=1.0u W=5u
Mx1_x5_x2_XM29_f1 x1_x5_x2_net9 x1_x5_net3 x1_x5_x2_net3 VDD pfet_06v0 L=1.0u W=5u
Mx1_x5_x2_XM29_f2 x1_x5_x2_net9 x1_x5_net3 x1_x5_x2_net3 VDD pfet_06v0 L=1.0u W=5u
Mx1_x5_x2_XM30_f1 x1_x5_x2_net12 x1_x5_net3 x1_x5_x2_net6 VDD pfet_06v0 L=1.0u W=5.0u
Mx1_x5_x2_XM30_f2 x1_x5_x2_net12 x1_x5_net3 x1_x5_x2_net6 VDD pfet_06v0 L=1.0u W=5.0u
Mx1_x5_x2_XM31_f1 x1_x5_x2_net3 x1_x5_x2_net9 VDD VDD pfet_06v0 L=1.0u W=5u
Mx1_x5_x2_XM31_f2 x1_x5_x2_net3 x1_x5_x2_net9 VDD VDD pfet_06v0 L=1.0u W=5u
Mx1_x5_x2_XM31_f3 x1_x5_x2_net3 x1_x5_x2_net9 VDD VDD pfet_06v0 L=1.0u W=5u
Mx1_x5_x2_XM31_f4 x1_x5_x2_net3 x1_x5_x2_net9 VDD VDD pfet_06v0 L=1.0u W=5u
Mx1_x5_x2_XM35_f1 x1_x5_x2_net6 x1_x5_x2_net9 VDD VDD pfet_06v0 L=1.0u W=5.0u
Mx1_x5_x2_XM35_f2 x1_x5_x2_net6 x1_x5_x2_net9 VDD VDD pfet_06v0 L=1.0u W=5.0u
Mx1_x5_x2_XM35_f3 x1_x5_x2_net6 x1_x5_x2_net9 VDD VDD pfet_06v0 L=1.0u W=5.0u
Mx1_x5_x2_XM35_f4 x1_x5_x2_net6 x1_x5_x2_net9 VDD VDD pfet_06v0 L=1.0u W=5.0u
Mx1_x5_x2_XM32 x1_x5_x2_net10 x1_x5_x2_net21 x1_x5_x2_net9 VDD pfet_06v0 L=1.0u W=5u
Mx1_x5_x2_XM33 x1_x5_x2_net22 x1_x5_x2_net21 x1_x5_x2_net12 VDD pfet_06v0 L=1.0u W=5.0u
Mx1_x5_x2_XM23_f1 x1_x5_x2_net10 x1_x5_net2 x1_x5_x2_net4 VSS nfet_06v0 L=1.0u W=2.5u
Mx1_x5_x2_XM23_f2 x1_x5_x2_net10 x1_x5_net2 x1_x5_x2_net4 VSS nfet_06v0 L=1.0u W=2.5u
Mx1_x5_x2_XM24_f1 x1_x5_x2_net22 x1_x5_net2 x1_x5_x2_net5 VSS nfet_06v0 L=1.0u W=2.5u
Mx1_x5_x2_XM24_f2 x1_x5_x2_net22 x1_x5_net2 x1_x5_x2_net5 VSS nfet_06v0 L=1.0u W=2.5u
Mx1_x5_x2_XM25_f1 x1_x5_x2_net4 x1_x5_x2_net10 VSS VSS nfet_06v0 L=1.0u W=2.5u
Mx1_x5_x2_XM25_f2 x1_x5_x2_net4 x1_x5_x2_net10 VSS VSS nfet_06v0 L=1.0u W=2.5u
Mx1_x5_x2_XM25_f3 x1_x5_x2_net4 x1_x5_x2_net10 VSS VSS nfet_06v0 L=1.0u W=2.5u
Mx1_x5_x2_XM25_f4 x1_x5_x2_net4 x1_x5_x2_net10 VSS VSS nfet_06v0 L=1.0u W=2.5u
Mx1_x5_x2_XM26_f1 x1_x5_x2_net5 x1_x5_x2_net10 VSS VSS nfet_06v0 L=1.0u W=2.5u
Mx1_x5_x2_XM26_f2 x1_x5_x2_net5 x1_x5_x2_net10 VSS VSS nfet_06v0 L=1.0u W=2.5u
Mx1_x5_x2_XM26_f3 x1_x5_x2_net5 x1_x5_x2_net10 VSS VSS nfet_06v0 L=1.0u W=2.5u
Mx1_x5_x2_XM26_f4 x1_x5_x2_net5 x1_x5_x2_net10 VSS VSS nfet_06v0 L=1.0u W=2.5u
Mx1_x5_x2_XM27 x1_x5_x2_net9 x1_x5_x2_net11 x1_x5_x2_net10 VSS nfet_06v0 L=1.0u W=2.5u
Mx1_x5_x2_XM28 x1_x5_x2_net12 x1_x5_x2_net11 x1_x5_x2_net22 VSS nfet_06v0 L=1.0u W=2.5u
Mx1_x5_x2_XM34 x1_x5_x2_net13 x1_x5_x2_net14 VDD VDD pfet_06v0 L=1.0u W=10.0u
Mx1_x5_x2_XM36 x1_x5_x2_net14 x1_x5_net3 x1_x5_x2_net13 VDD pfet_06v0 L=1.0u W=10.0u
Mx1_x5_x2_XM37 x1_x5_x2_net21 x1_x5_x2_net21 x1_x5_x2_net14 VDD pfet_06v0 L=1.0u W=10.0u
Mx1_x5_x2_XM38 x1_x5_x2_net21 x1_x5_net2 x1_x5_x2_net15 VSS nfet_06v0 L=1.0u W=5.0u
Mx1_x5_x2_XM39 x1_x5_x2_net15 x1_x5_net1 VSS VSS nfet_06v0 L=1.0u W=5.0u
Mx1_x5_x2_XM45 x1_x5_x2_net16 x1_x5_net4 VDD VDD pfet_06v0 L=1.0u W=10.0u
Mx1_x5_x2_XM46 x1_x5_x2_net11 x1_x5_net3 x1_x5_x2_net16 VDD pfet_06v0 L=1.0u W=10.0u
Mx1_x5_x2_XM40 x1_x5_x2_net11 x1_x5_x2_net11 x1_x5_x2_net18 VSS nfet_06v0 L=1.0u W=5.0u
Mx1_x5_x2_XM41 x1_x5_x2_net18 x1_x5_net2 x1_x5_x2_net17 VSS nfet_06v0 L=1.0u W=5.0u
Mx1_x5_x2_XM42 x1_x5_x2_net17 x1_x5_x2_net18 VSS VSS nfet_06v0 L=1.0u W=5.0u
Mx1_x5_x2_XM43_f1 x1_net2 x1_x5_x2_net12 VDD VDD pfet_06v0 L=1.0u W=10u
Mx1_x5_x2_XM43_f2 x1_net2 x1_x5_x2_net12 VDD VDD pfet_06v0 L=1.0u W=10u
Mx1_x5_x2_XM43_f3 x1_net2 x1_x5_x2_net12 VDD VDD pfet_06v0 L=1.0u W=10u
Mx1_x5_x2_XM44_f1 x1_net2 x1_x5_x2_net22 VSS VSS nfet_06v0 L=1.0u W=5u
Mx1_x5_x2_XM44_f2 x1_net2 x1_x5_x2_net22 VSS VSS nfet_06v0 L=1.0u W=5u
Mx1_x5_x2_XM44_f3 x1_net2 x1_x5_x2_net22 VSS VSS nfet_06v0 L=1.0u W=5u
Mx1_x6_x1_XM4 x1_x6_x1_net3 x1_x6_net4 VDD VDD pfet_06v0 L=1.0u W=10.0u
Mx1_x6_x1_XM5 x1_x6_net2 x1_x6_net3 x1_x6_x1_net3 VDD pfet_06v0 L=1.0u W=10.0u
Mx1_x6_x1_XM6 x1_x6_net2 x1_x6_net2 VSS VSS nfet_06v0 L=1.0u W=1.0u
Mx1_x6_x1_XM7 x1_x6_x1_net2 x1_x6_net4 VDD VDD pfet_06v0 L=1.0u W=10.0u
Mx1_x6_x1_XM8 x1_x6_net1 x1_x6_net3 x1_x6_x1_net2 VDD pfet_06v0 L=1.0u W=10.0u
Mx1_x6_x1_XM9 x1_x6_net1 x1_x6_net2 x1_x6_x1_net1 VSS nfet_06v0 L=1.0u W=5.0u
Mx1_x6_x1_XM10 x1_x6_x1_net1 x1_x6_net1 VSS VSS nfet_06v0 L=1.0u W=5.0u
Mx1_x6_x1_XM1 x1_x6_net3 x1_x6_net3 VDD VDD pfet_06v0 L=1.0u W=2u
Mx1_x6_x1_XM2 x1_x6_x1_net4 x1_x6_net4 VDD VDD pfet_06v0 L=1.0u W=10.0u
Mx1_x6_x1_XM3 x1_x6_net4 x1_x6_net3 x1_x6_x1_net4 VDD pfet_06v0 L=1.0u W=10.0u
Mx1_x6_x1_XM47 x1_x6_x1_net5 x1_x6_net3 VSS VSS nfet_06v0 L=1.0u W=1.0u
Mx1_x6_x1_XM48 x1_x6_x1_net6 x1_x6_net3 VSS VSS nfet_06v0 L=1.0u W=1.0u
Mx1_x6_x1_XM49 x1_x6_net3 x1_x6_net3 x1_x6_x1_net6 VSS nfet_06v0 L=1.0u W=1.0u
Mx1_x6_x1_XM50 x1_x6_net4 x1_x6_net3 x1_x6_x1_net5 VSS nfet_06v0 L=1.0u W=1.0u
Mx1_x6_x2_XM11 x1_x6_x2_net2 x1_x6_net4 VDD VDD pfet_06v0 L=1.0u W=10.0u
Mx1_x6_x2_XM12 x1_x6_x2_net7 x1_x6_net3 x1_x6_x2_net2 VDD pfet_06v0 L=1.0u W=10.0u
Mx1_x6_x2_XM13 x1_x6_x2_net19 x1_x6_net4 VDD VDD pfet_06v0 L=1.0u W=10.0u
Mx1_x6_x2_XM14 x1_x6_x2_net7 x1_x6_net3 x1_x6_x2_net19 VDD pfet_06v0 L=1.0u W=10.0u
Mx1_x6_x2_XM15_f1 x1_x6_x2_net5 x1_SZ x1_x6_x2_net7 VDD pfet_06v0 L=1.0u W=10.0u
Mx1_x6_x2_XM15_f2 x1_x6_x2_net5 x1_SZ x1_x6_x2_net7 VDD pfet_06v0 L=1.0u W=10.0u
Mx1_x6_x2_XM16_f1 x1_x6_x2_net4 x1_SY x1_x6_x2_net7 VDD pfet_06v0 L=1.0u W=10.0u
Mx1_x6_x2_XM16_f2 x1_x6_x2_net4 x1_SY x1_x6_x2_net7 VDD pfet_06v0 L=1.0u W=10.0u
Mx1_x6_x2_XM17 x1_x6_x2_net8 x1_x6_net2 x1_x6_x2_net1 VSS nfet_06v0 L=1.0u W=5.0u
Mx1_x6_x2_XM18 x1_x6_x2_net1 x1_x6_net1 VSS VSS nfet_06v0 L=1.0u W=5.0u
Mx1_x6_x2_XM19 x1_x6_x2_net8 x1_x6_net2 x1_x6_x2_net20 VSS nfet_06v0 L=1.0u W=5.0u
Mx1_x6_x2_XM20 x1_x6_x2_net20 x1_x6_net1 VSS VSS nfet_06v0 L=1.0u W=5.0u
Mx1_x6_x2_XM21_f1 x1_x6_x2_net6 x1_SZ x1_x6_x2_net8 VSS nfet_06v0 L=1.0u W=5u
Mx1_x6_x2_XM21_f2 x1_x6_x2_net6 x1_SZ x1_x6_x2_net8 VSS nfet_06v0 L=1.0u W=5u
Mx1_x6_x2_XM22_f1 x1_x6_x2_net3 x1_SY x1_x6_x2_net8 VSS nfet_06v0 L=1.0u W=5u
Mx1_x6_x2_XM22_f2 x1_x6_x2_net3 x1_SY x1_x6_x2_net8 VSS nfet_06v0 L=1.0u W=5u
Mx1_x6_x2_XM29_f1 x1_x6_x2_net9 x1_x6_net3 x1_x6_x2_net3 VDD pfet_06v0 L=1.0u W=5u
Mx1_x6_x2_XM29_f2 x1_x6_x2_net9 x1_x6_net3 x1_x6_x2_net3 VDD pfet_06v0 L=1.0u W=5u
Mx1_x6_x2_XM30_f1 x1_x6_x2_net12 x1_x6_net3 x1_x6_x2_net6 VDD pfet_06v0 L=1.0u W=5.0u
Mx1_x6_x2_XM30_f2 x1_x6_x2_net12 x1_x6_net3 x1_x6_x2_net6 VDD pfet_06v0 L=1.0u W=5.0u
Mx1_x6_x2_XM31_f1 x1_x6_x2_net3 x1_x6_x2_net9 VDD VDD pfet_06v0 L=1.0u W=5u
Mx1_x6_x2_XM31_f2 x1_x6_x2_net3 x1_x6_x2_net9 VDD VDD pfet_06v0 L=1.0u W=5u
Mx1_x6_x2_XM31_f3 x1_x6_x2_net3 x1_x6_x2_net9 VDD VDD pfet_06v0 L=1.0u W=5u
Mx1_x6_x2_XM31_f4 x1_x6_x2_net3 x1_x6_x2_net9 VDD VDD pfet_06v0 L=1.0u W=5u
Mx1_x6_x2_XM35_f1 x1_x6_x2_net6 x1_x6_x2_net9 VDD VDD pfet_06v0 L=1.0u W=5.0u
Mx1_x6_x2_XM35_f2 x1_x6_x2_net6 x1_x6_x2_net9 VDD VDD pfet_06v0 L=1.0u W=5.0u
Mx1_x6_x2_XM35_f3 x1_x6_x2_net6 x1_x6_x2_net9 VDD VDD pfet_06v0 L=1.0u W=5.0u
Mx1_x6_x2_XM35_f4 x1_x6_x2_net6 x1_x6_x2_net9 VDD VDD pfet_06v0 L=1.0u W=5.0u
Mx1_x6_x2_XM32 x1_x6_x2_net10 x1_x6_x2_net21 x1_x6_x2_net9 VDD pfet_06v0 L=1.0u W=5u
Mx1_x6_x2_XM33 x1_x6_x2_net22 x1_x6_x2_net21 x1_x6_x2_net12 VDD pfet_06v0 L=1.0u W=5.0u
Mx1_x6_x2_XM23_f1 x1_x6_x2_net10 x1_x6_net2 x1_x6_x2_net4 VSS nfet_06v0 L=1.0u W=2.5u
Mx1_x6_x2_XM23_f2 x1_x6_x2_net10 x1_x6_net2 x1_x6_x2_net4 VSS nfet_06v0 L=1.0u W=2.5u
Mx1_x6_x2_XM24_f1 x1_x6_x2_net22 x1_x6_net2 x1_x6_x2_net5 VSS nfet_06v0 L=1.0u W=2.5u
Mx1_x6_x2_XM24_f2 x1_x6_x2_net22 x1_x6_net2 x1_x6_x2_net5 VSS nfet_06v0 L=1.0u W=2.5u
Mx1_x6_x2_XM25_f1 x1_x6_x2_net4 x1_x6_x2_net10 VSS VSS nfet_06v0 L=1.0u W=2.5u
Mx1_x6_x2_XM25_f2 x1_x6_x2_net4 x1_x6_x2_net10 VSS VSS nfet_06v0 L=1.0u W=2.5u
Mx1_x6_x2_XM25_f3 x1_x6_x2_net4 x1_x6_x2_net10 VSS VSS nfet_06v0 L=1.0u W=2.5u
Mx1_x6_x2_XM25_f4 x1_x6_x2_net4 x1_x6_x2_net10 VSS VSS nfet_06v0 L=1.0u W=2.5u
Mx1_x6_x2_XM26_f1 x1_x6_x2_net5 x1_x6_x2_net10 VSS VSS nfet_06v0 L=1.0u W=2.5u
Mx1_x6_x2_XM26_f2 x1_x6_x2_net5 x1_x6_x2_net10 VSS VSS nfet_06v0 L=1.0u W=2.5u
Mx1_x6_x2_XM26_f3 x1_x6_x2_net5 x1_x6_x2_net10 VSS VSS nfet_06v0 L=1.0u W=2.5u
Mx1_x6_x2_XM26_f4 x1_x6_x2_net5 x1_x6_x2_net10 VSS VSS nfet_06v0 L=1.0u W=2.5u
Mx1_x6_x2_XM27 x1_x6_x2_net9 x1_x6_x2_net11 x1_x6_x2_net10 VSS nfet_06v0 L=1.0u W=2.5u
Mx1_x6_x2_XM28 x1_x6_x2_net12 x1_x6_x2_net11 x1_x6_x2_net22 VSS nfet_06v0 L=1.0u W=2.5u
Mx1_x6_x2_XM34 x1_x6_x2_net13 x1_x6_x2_net14 VDD VDD pfet_06v0 L=1.0u W=10.0u
Mx1_x6_x2_XM36 x1_x6_x2_net14 x1_x6_net3 x1_x6_x2_net13 VDD pfet_06v0 L=1.0u W=10.0u
Mx1_x6_x2_XM37 x1_x6_x2_net21 x1_x6_x2_net21 x1_x6_x2_net14 VDD pfet_06v0 L=1.0u W=10.0u
Mx1_x6_x2_XM38 x1_x6_x2_net21 x1_x6_net2 x1_x6_x2_net15 VSS nfet_06v0 L=1.0u W=5.0u
Mx1_x6_x2_XM39 x1_x6_x2_net15 x1_x6_net1 VSS VSS nfet_06v0 L=1.0u W=5.0u
Mx1_x6_x2_XM45 x1_x6_x2_net16 x1_x6_net4 VDD VDD pfet_06v0 L=1.0u W=10.0u
Mx1_x6_x2_XM46 x1_x6_x2_net11 x1_x6_net3 x1_x6_x2_net16 VDD pfet_06v0 L=1.0u W=10.0u
Mx1_x6_x2_XM40 x1_x6_x2_net11 x1_x6_x2_net11 x1_x6_x2_net18 VSS nfet_06v0 L=1.0u W=5.0u
Mx1_x6_x2_XM41 x1_x6_x2_net18 x1_x6_net2 x1_x6_x2_net17 VSS nfet_06v0 L=1.0u W=5.0u
Mx1_x6_x2_XM42 x1_x6_x2_net17 x1_x6_x2_net18 VSS VSS nfet_06v0 L=1.0u W=5.0u
Mx1_x6_x2_XM43_f1 x1_net3 x1_x6_x2_net12 VDD VDD pfet_06v0 L=1.0u W=10u
Mx1_x6_x2_XM43_f2 x1_net3 x1_x6_x2_net12 VDD VDD pfet_06v0 L=1.0u W=10u
Mx1_x6_x2_XM43_f3 x1_net3 x1_x6_x2_net12 VDD VDD pfet_06v0 L=1.0u W=10u
Mx1_x6_x2_XM44_f1 x1_net3 x1_x6_x2_net22 VSS VSS nfet_06v0 L=1.0u W=5u
Mx1_x6_x2_XM44_f2 x1_net3 x1_x6_x2_net22 VSS VSS nfet_06v0 L=1.0u W=5u
Mx1_x6_x2_XM44_f3 x1_net3 x1_x6_x2_net22 VSS VSS nfet_06v0 L=1.0u W=5u
Mx1_x7_x2_x2_XM4 x1_x7_x2_net1 x1_net1 VDD VDD pfet_06v0 L=1.0u W=3.0u
Mx1_x7_x2_x2_XM5 VSS x1_net1 x1_x7_x2_net1 VSS nfet_06v0 L=1u W=1u
Mx1_x7_x2_x3_XM4 Y1 x1_x7_x2_x3_net1 VDD VDD pfet_06v0 L=1.0u W=3.0u
Mx1_x7_x2_x3_XM5 VSS x1_x7_x2_x3_net1 Y1 VSS nfet_06v0 L=1u W=1u
Mx1_x7_x2_x3_XM2 VDD x1_net3 x1_x7_x2_x3_net1 VDD pfet_06v0 L=1.0u W=3.0u
Mx1_x7_x2_x3_XM1 VDD x1_x7_x2_net1 x1_x7_x2_x3_net1 VDD pfet_06v0 L=1.0u W=3.0u
Mx1_x7_x2_x3_XM3 VSS x1_net3 x1_x7_x2_x3_net2 VSS nfet_06v0 L=1u W=1u
Mx1_x7_x2_x3_XM6 x1_x7_x2_x3_net2 x1_x7_x2_net1 x1_x7_x2_x3_net1 VSS nfet_06v0 L=1u W=1u
Mx1_x7_x1_XM4 x1_x7_x1_net1 x1_net3 Z1 VDD pfet_06v0 L=1.0u W=3.0u
Mx1_x7_x1_XM5 VDD x1_net2 x1_x7_x1_net1 VDD pfet_06v0 L=1.0u W=3.0u
Mx1_x7_x1_XM7 VSS x1_net3 Z1 VSS nfet_06v0 L=1u W=1u
Mx1_x7_x1_XM1 VSS x1_net2 Z1 VSS nfet_06v0 L=1u W=1u
Mx1_x7_x3_x2_XM4 X1 x1_x7_x3_x2_net1 VDD VDD pfet_06v0 L=1.0u W=3.0u
Mx1_x7_x3_x2_XM5 VSS x1_x7_x3_x2_net1 X1 VSS nfet_06v0 L=1u W=1u
Mx1_x7_x3_x2_XM2 VDD x1_net1 x1_x7_x3_x2_net1 VDD pfet_06v0 L=1.0u W=3.0u
Mx1_x7_x3_x2_XM1 VDD x1_net2 x1_x7_x3_x2_net1 VDD pfet_06v0 L=1.0u W=3.0u
Mx1_x7_x3_x2_XM3 VSS x1_net1 x1_x7_x3_x2_net2 VSS nfet_06v0 L=1u W=1u
Mx1_x7_x3_x2_XM6 x1_x7_x3_x2_net2 x1_net2 x1_x7_x3_x2_net1 VSS nfet_06v0 L=1u W=1u
Mx1_x8_x1_XM4 x1_x8_x1_net3 x1_x8_net3 VDD VDD pfet_06v0 L=1.0u W=10.0u
Mx1_x8_x1_XM5 x1_x8_net2 x1_x8_net4 x1_x8_x1_net3 VDD pfet_06v0 L=1.0u W=10.0u
Mx1_x8_x1_XM6 x1_x8_net2 x1_x8_net2 VSS VSS nfet_06v0 L=1.0u W=1.0u
Mx1_x8_x1_XM7 x1_x8_x1_net2 x1_x8_net3 VDD VDD pfet_06v0 L=1.0u W=10.0u
Mx1_x8_x1_XM8 x1_x8_net1 x1_x8_net4 x1_x8_x1_net2 VDD pfet_06v0 L=1.0u W=10.0u
Mx1_x8_x1_XM9 x1_x8_net1 x1_x8_net2 x1_x8_x1_net1 VSS nfet_06v0 L=1.0u W=5.0u
Mx1_x8_x1_XM10 x1_x8_x1_net1 x1_x8_net1 VSS VSS nfet_06v0 L=1.0u W=5.0u
Mx1_x8_x1_XM1 x1_x8_net4 x1_x8_net4 VDD VDD pfet_06v0 L=1.0u W=2u
Mx1_x8_x1_XM2 x1_x8_x1_net4 x1_x8_net3 VDD VDD pfet_06v0 L=1.0u W=10.0u
Mx1_x8_x1_XM3 x1_x8_net3 x1_x8_net4 x1_x8_x1_net4 VDD pfet_06v0 L=1.0u W=10.0u
Mx1_x8_x1_XM47 x1_x8_x1_net5 x1_x8_net4 VSS VSS nfet_06v0 L=1.0u W=1.0u
Mx1_x8_x1_XM48 x1_x8_x1_net6 x1_x8_net4 VSS VSS nfet_06v0 L=1.0u W=1.0u
Mx1_x8_x1_XM49 x1_x8_net4 x1_x8_net4 x1_x8_x1_net6 VSS nfet_06v0 L=1.0u W=1.0u
Mx1_x8_x1_XM50 x1_x8_net3 x1_x8_net4 x1_x8_x1_net5 VSS nfet_06v0 L=1.0u W=1.0u
Mx1_x8_x2_XM11 x1_x8_x2_net2 x1_x8_net3 VDD VDD pfet_06v0 L=1.0u W=10.0u
Mx1_x8_x2_XM12 x1_x8_x2_net7 x1_x8_net4 x1_x8_x2_net2 VDD pfet_06v0 L=1.0u W=10.0u
Mx1_x8_x2_XM13 x1_x8_x2_net18 x1_x8_net3 VDD VDD pfet_06v0 L=1.0u W=10.0u
Mx1_x8_x2_XM14 x1_x8_x2_net7 x1_x8_net4 x1_x8_x2_net18 VDD pfet_06v0 L=1.0u W=10.0u
Mx1_x8_x2_XM15 x1_x8_x2_net5 S1P x1_x8_x2_net7 VDD pfet_06v0 L=1.0u W=0.55u
Mx1_x8_x2_XM16 x1_x8_x2_net4 S1N x1_x8_x2_net7 VDD pfet_06v0 L=1.0u W=0.5u
Mx1_x8_x2_XM17 x1_x8_x2_net8 x1_x8_net2 x1_x8_x2_net1 VSS nfet_06v0 L=1.0u W=5.0u
Mx1_x8_x2_XM18 x1_x8_x2_net1 x1_x8_net1 VSS VSS nfet_06v0 L=1.0u W=5.0u
Mx1_x8_x2_XM19 x1_x8_x2_net8 x1_x8_net2 x1_x8_x2_net19 VSS nfet_06v0 L=1.0u W=5.0u
Mx1_x8_x2_XM20 x1_x8_x2_net19 x1_x8_net1 VSS VSS nfet_06v0 L=1.0u W=5.0u
Mx1_x8_x2_XM21 x1_x8_x2_net6 S1P x1_x8_x2_net8 VSS nfet_06v0 L=1.0u W=7.5u
Mx1_x8_x2_XM22 x1_x8_x2_net3 S1N x1_x8_x2_net8 VSS nfet_06v0 L=1.0u W=8.5u
Mx1_x8_x2_XM29 x1_x8_x2_net9 x1_x8_net4 x1_x8_x2_net3 VDD pfet_06v0 L=1.0u W=10u
Mx1_x8_x2_XM30 x1_x8_x2_G_OUT_P x1_x8_net4 x1_x8_x2_net6 VDD pfet_06v0 L=1.0u W=10u
Mx1_x8_x2_XM31 x1_x8_x2_net3 x1_x8_x2_net9 VDD VDD pfet_06v0 L=1.0u W=5u
Mx1_x8_x2_XM35 x1_x8_x2_net6 x1_x8_x2_net9 VDD VDD pfet_06v0 L=1.0u W=5u
Mx1_x8_x2_XM32 x1_x8_x2_net10 x1_x8_x2_net20 x1_x8_x2_net9 VDD pfet_06v0 L=1.0u W=4.0u
Mx1_x8_x2_XM33 x1_x8_x2_net21 x1_x8_x2_net20 x1_x8_x2_G_OUT_P VDD pfet_06v0 L=1.0u W=4.0u
Mx1_x8_x2_XM23 x1_x8_x2_net10 x1_x8_net2 x1_x8_x2_net4 VSS nfet_06v0 L=1.0u W=2.5u
Mx1_x8_x2_XM24 x1_x8_x2_net21 x1_x8_net2 x1_x8_x2_net5 VSS nfet_06v0 L=1.0u W=2.5u
Mx1_x8_x2_XM25 x1_x8_x2_net4 x1_x8_x2_net10 VSS VSS nfet_06v0 L=1.0u W=2.5u
Mx1_x8_x2_XM26 x1_x8_x2_net5 x1_x8_x2_net10 VSS VSS nfet_06v0 L=1.0u W=2.5u
Mx1_x8_x2_XM27 x1_x8_x2_net9 x1_x8_x2_net11 x1_x8_x2_net10 VSS nfet_06v0 L=1.0u W=2.0u
Mx1_x8_x2_XM28 x1_x8_x2_G_OUT_P x1_x8_x2_net11 x1_x8_x2_net21 VSS nfet_06v0 L=1.0u W=2.0u
Mx1_x8_x2_XM34 x1_x8_x2_net12 x1_x8_x2_net13 VDD VDD pfet_06v0 L=1.0u W=10.0u
Mx1_x8_x2_XM36 x1_x8_x2_net13 x1_x8_net4 x1_x8_x2_net12 VDD pfet_06v0 L=1.0u W=10.0u
Mx1_x8_x2_XM37 x1_x8_x2_net20 x1_x8_x2_net20 x1_x8_x2_net13 VDD pfet_06v0 L=1.0u W=10.0u
Mx1_x8_x2_XM38 x1_x8_x2_net20 x1_x8_net2 x1_x8_x2_net14 VSS nfet_06v0 L=1.0u W=5.0u
Mx1_x8_x2_XM39 x1_x8_x2_net14 x1_x8_net1 VSS VSS nfet_06v0 L=1.0u W=5.0u
Mx1_x8_x2_XM45 x1_x8_x2_net15 x1_x8_net3 VDD VDD pfet_06v0 L=1.0u W=10.0u
Mx1_x8_x2_XM46 x1_x8_x2_net11 x1_x8_net4 x1_x8_x2_net15 VDD pfet_06v0 L=1.0u W=10.0u
Mx1_x8_x2_XM40 x1_x8_x2_net11 x1_x8_x2_net11 x1_x8_x2_net17 VSS nfet_06v0 L=1.0u W=5.0u
Mx1_x8_x2_XM41 x1_x8_x2_net17 x1_x8_net2 x1_x8_x2_net16 VSS nfet_06v0 L=1.0u W=5.0u
Mx1_x8_x2_XM42 x1_x8_x2_net16 x1_x8_x2_net17 VSS VSS nfet_06v0 L=1.0u W=5.0u
Mx1_x8_x2_XM43_m1 x1_SX x1_x8_x2_G_OUT_P VDD VDD pfet_06v0 L=1.0u W=1.0u
Mx1_x8_x2_XM43_m2 x1_SX x1_x8_x2_G_OUT_P VDD VDD pfet_06v0 L=1.0u W=1.0u
Mx1_x8_x2_XM43_m3 x1_SX x1_x8_x2_G_OUT_P VDD VDD pfet_06v0 L=1.0u W=1.0u
Mx1_x8_x2_XM43_m4 x1_SX x1_x8_x2_G_OUT_P VDD VDD pfet_06v0 L=1.0u W=1.0u
Mx1_x8_x2_XM44 x1_SX x1_x8_x2_net21 VSS VSS nfet_06v0 L=1.0u W=1.0u
Mx1_x1_x1_XM4 x1_x1_x1_net3 x1_x1_net3 VDD VDD pfet_06v0 L=1.0u W=10.0u
Mx1_x1_x1_XM5 x1_x1_net2 x1_x1_net4 x1_x1_x1_net3 VDD pfet_06v0 L=1.0u W=10.0u
Mx1_x1_x1_XM6 x1_x1_net2 x1_x1_net2 VSS VSS nfet_06v0 L=1.0u W=1.0u
Mx1_x1_x1_XM7 x1_x1_x1_net2 x1_x1_net3 VDD VDD pfet_06v0 L=1.0u W=10.0u
Mx1_x1_x1_XM8 x1_x1_net1 x1_x1_net4 x1_x1_x1_net2 VDD pfet_06v0 L=1.0u W=10.0u
Mx1_x1_x1_XM9 x1_x1_net1 x1_x1_net2 x1_x1_x1_net1 VSS nfet_06v0 L=1.0u W=5.0u
Mx1_x1_x1_XM10 x1_x1_x1_net1 x1_x1_net1 VSS VSS nfet_06v0 L=1.0u W=5.0u
Mx1_x1_x1_XM1 x1_x1_net4 x1_x1_net4 VDD VDD pfet_06v0 L=1.0u W=2u
Mx1_x1_x1_XM2 x1_x1_x1_net4 x1_x1_net3 VDD VDD pfet_06v0 L=1.0u W=10.0u
Mx1_x1_x1_XM3 x1_x1_net3 x1_x1_net4 x1_x1_x1_net4 VDD pfet_06v0 L=1.0u W=10.0u
Mx1_x1_x1_XM47 x1_x1_x1_net5 x1_x1_net4 VSS VSS nfet_06v0 L=1.0u W=1.0u
Mx1_x1_x1_XM48 x1_x1_x1_net6 x1_x1_net4 VSS VSS nfet_06v0 L=1.0u W=1.0u
Mx1_x1_x1_XM49 x1_x1_net4 x1_x1_net4 x1_x1_x1_net6 VSS nfet_06v0 L=1.0u W=1.0u
Mx1_x1_x1_XM50 x1_x1_net3 x1_x1_net4 x1_x1_x1_net5 VSS nfet_06v0 L=1.0u W=1.0u
Mx1_x1_x2_XM11 x1_x1_x2_net2 x1_x1_net3 VDD VDD pfet_06v0 L=1.0u W=10.0u
Mx1_x1_x2_XM12 x1_x1_x2_net7 x1_x1_net4 x1_x1_x2_net2 VDD pfet_06v0 L=1.0u W=10.0u
Mx1_x1_x2_XM13 x1_x1_x2_net18 x1_x1_net3 VDD VDD pfet_06v0 L=1.0u W=10.0u
Mx1_x1_x2_XM14 x1_x1_x2_net7 x1_x1_net4 x1_x1_x2_net18 VDD pfet_06v0 L=1.0u W=10.0u
Mx1_x1_x2_XM15 x1_x1_x2_net5 S2P x1_x1_x2_net7 VDD pfet_06v0 L=1.0u W=0.55u
Mx1_x1_x2_XM16 x1_x1_x2_net4 S2N x1_x1_x2_net7 VDD pfet_06v0 L=1.0u W=0.5u
Mx1_x1_x2_XM17 x1_x1_x2_net8 x1_x1_net2 x1_x1_x2_net1 VSS nfet_06v0 L=1.0u W=5.0u
Mx1_x1_x2_XM18 x1_x1_x2_net1 x1_x1_net1 VSS VSS nfet_06v0 L=1.0u W=5.0u
Mx1_x1_x2_XM19 x1_x1_x2_net8 x1_x1_net2 x1_x1_x2_net19 VSS nfet_06v0 L=1.0u W=5.0u
Mx1_x1_x2_XM20 x1_x1_x2_net19 x1_x1_net1 VSS VSS nfet_06v0 L=1.0u W=5.0u
Mx1_x1_x2_XM21 x1_x1_x2_net6 S2P x1_x1_x2_net8 VSS nfet_06v0 L=1.0u W=7.5u
Mx1_x1_x2_XM22 x1_x1_x2_net3 S2N x1_x1_x2_net8 VSS nfet_06v0 L=1.0u W=8.5u
Mx1_x1_x2_XM29 x1_x1_x2_net9 x1_x1_net4 x1_x1_x2_net3 VDD pfet_06v0 L=1.0u W=10u
Mx1_x1_x2_XM30 x1_x1_x2_G_OUT_P x1_x1_net4 x1_x1_x2_net6 VDD pfet_06v0 L=1.0u W=10u
Mx1_x1_x2_XM31 x1_x1_x2_net3 x1_x1_x2_net9 VDD VDD pfet_06v0 L=1.0u W=5u
Mx1_x1_x2_XM35 x1_x1_x2_net6 x1_x1_x2_net9 VDD VDD pfet_06v0 L=1.0u W=5u
Mx1_x1_x2_XM32 x1_x1_x2_net10 x1_x1_x2_net20 x1_x1_x2_net9 VDD pfet_06v0 L=1.0u W=4.0u
Mx1_x1_x2_XM33 x1_x1_x2_net21 x1_x1_x2_net20 x1_x1_x2_G_OUT_P VDD pfet_06v0 L=1.0u W=4.0u
Mx1_x1_x2_XM23 x1_x1_x2_net10 x1_x1_net2 x1_x1_x2_net4 VSS nfet_06v0 L=1.0u W=2.5u
Mx1_x1_x2_XM24 x1_x1_x2_net21 x1_x1_net2 x1_x1_x2_net5 VSS nfet_06v0 L=1.0u W=2.5u
Mx1_x1_x2_XM25 x1_x1_x2_net4 x1_x1_x2_net10 VSS VSS nfet_06v0 L=1.0u W=2.5u
Mx1_x1_x2_XM26 x1_x1_x2_net5 x1_x1_x2_net10 VSS VSS nfet_06v0 L=1.0u W=2.5u
Mx1_x1_x2_XM27 x1_x1_x2_net9 x1_x1_x2_net11 x1_x1_x2_net10 VSS nfet_06v0 L=1.0u W=2.0u
Mx1_x1_x2_XM28 x1_x1_x2_G_OUT_P x1_x1_x2_net11 x1_x1_x2_net21 VSS nfet_06v0 L=1.0u W=2.0u
Mx1_x1_x2_XM34 x1_x1_x2_net12 x1_x1_x2_net13 VDD VDD pfet_06v0 L=1.0u W=10.0u
Mx1_x1_x2_XM36 x1_x1_x2_net13 x1_x1_net4 x1_x1_x2_net12 VDD pfet_06v0 L=1.0u W=10.0u
Mx1_x1_x2_XM37 x1_x1_x2_net20 x1_x1_x2_net20 x1_x1_x2_net13 VDD pfet_06v0 L=1.0u W=10.0u
Mx1_x1_x2_XM38 x1_x1_x2_net20 x1_x1_net2 x1_x1_x2_net14 VSS nfet_06v0 L=1.0u W=5.0u
Mx1_x1_x2_XM39 x1_x1_x2_net14 x1_x1_net1 VSS VSS nfet_06v0 L=1.0u W=5.0u
Mx1_x1_x2_XM45 x1_x1_x2_net15 x1_x1_net3 VDD VDD pfet_06v0 L=1.0u W=10.0u
Mx1_x1_x2_XM46 x1_x1_x2_net11 x1_x1_net4 x1_x1_x2_net15 VDD pfet_06v0 L=1.0u W=10.0u
Mx1_x1_x2_XM40 x1_x1_x2_net11 x1_x1_x2_net11 x1_x1_x2_net17 VSS nfet_06v0 L=1.0u W=5.0u
Mx1_x1_x2_XM41 x1_x1_x2_net17 x1_x1_net2 x1_x1_x2_net16 VSS nfet_06v0 L=1.0u W=5.0u
Mx1_x1_x2_XM42 x1_x1_x2_net16 x1_x1_x2_net17 VSS VSS nfet_06v0 L=1.0u W=5.0u
Mx1_x1_x2_XM43_m1 x1_SY x1_x1_x2_G_OUT_P VDD VDD pfet_06v0 L=1.0u W=1.0u
Mx1_x1_x2_XM43_m2 x1_SY x1_x1_x2_G_OUT_P VDD VDD pfet_06v0 L=1.0u W=1.0u
Mx1_x1_x2_XM43_m3 x1_SY x1_x1_x2_G_OUT_P VDD VDD pfet_06v0 L=1.0u W=1.0u
Mx1_x1_x2_XM43_m4 x1_SY x1_x1_x2_G_OUT_P VDD VDD pfet_06v0 L=1.0u W=1.0u
Mx1_x1_x2_XM44 x1_SY x1_x1_x2_net21 VSS VSS nfet_06v0 L=1.0u W=1.0u
Mx1_x2_x1_XM4 x1_x2_x1_net3 x1_x2_net3 VDD VDD pfet_06v0 L=1.0u W=10.0u
Mx1_x2_x1_XM5 x1_x2_net2 x1_x2_net4 x1_x2_x1_net3 VDD pfet_06v0 L=1.0u W=10.0u
Mx1_x2_x1_XM6 x1_x2_net2 x1_x2_net2 VSS VSS nfet_06v0 L=1.0u W=1.0u
Mx1_x2_x1_XM7 x1_x2_x1_net2 x1_x2_net3 VDD VDD pfet_06v0 L=1.0u W=10.0u
Mx1_x2_x1_XM8 x1_x2_net1 x1_x2_net4 x1_x2_x1_net2 VDD pfet_06v0 L=1.0u W=10.0u
Mx1_x2_x1_XM9 x1_x2_net1 x1_x2_net2 x1_x2_x1_net1 VSS nfet_06v0 L=1.0u W=5.0u
Mx1_x2_x1_XM10 x1_x2_x1_net1 x1_x2_net1 VSS VSS nfet_06v0 L=1.0u W=5.0u
Mx1_x2_x1_XM1 x1_x2_net4 x1_x2_net4 VDD VDD pfet_06v0 L=1.0u W=2u
Mx1_x2_x1_XM2 x1_x2_x1_net4 x1_x2_net3 VDD VDD pfet_06v0 L=1.0u W=10.0u
Mx1_x2_x1_XM3 x1_x2_net3 x1_x2_net4 x1_x2_x1_net4 VDD pfet_06v0 L=1.0u W=10.0u
Mx1_x2_x1_XM47 x1_x2_x1_net5 x1_x2_net4 VSS VSS nfet_06v0 L=1.0u W=1.0u
Mx1_x2_x1_XM48 x1_x2_x1_net6 x1_x2_net4 VSS VSS nfet_06v0 L=1.0u W=1.0u
Mx1_x2_x1_XM49 x1_x2_net4 x1_x2_net4 x1_x2_x1_net6 VSS nfet_06v0 L=1.0u W=1.0u
Mx1_x2_x1_XM50 x1_x2_net3 x1_x2_net4 x1_x2_x1_net5 VSS nfet_06v0 L=1.0u W=1.0u
Mx1_x2_x2_XM11 x1_x2_x2_net2 x1_x2_net3 VDD VDD pfet_06v0 L=1.0u W=10.0u
Mx1_x2_x2_XM12 x1_x2_x2_net7 x1_x2_net4 x1_x2_x2_net2 VDD pfet_06v0 L=1.0u W=10.0u
Mx1_x2_x2_XM13 x1_x2_x2_net18 x1_x2_net3 VDD VDD pfet_06v0 L=1.0u W=10.0u
Mx1_x2_x2_XM14 x1_x2_x2_net7 x1_x2_net4 x1_x2_x2_net18 VDD pfet_06v0 L=1.0u W=10.0u
Mx1_x2_x2_XM15 x1_x2_x2_net5 S3P x1_x2_x2_net7 VDD pfet_06v0 L=1.0u W=0.55u
Mx1_x2_x2_XM16 x1_x2_x2_net4 S3N x1_x2_x2_net7 VDD pfet_06v0 L=1.0u W=0.5u
Mx1_x2_x2_XM17 x1_x2_x2_net8 x1_x2_net2 x1_x2_x2_net1 VSS nfet_06v0 L=1.0u W=5.0u
Mx1_x2_x2_XM18 x1_x2_x2_net1 x1_x2_net1 VSS VSS nfet_06v0 L=1.0u W=5.0u
Mx1_x2_x2_XM19 x1_x2_x2_net8 x1_x2_net2 x1_x2_x2_net19 VSS nfet_06v0 L=1.0u W=5.0u
Mx1_x2_x2_XM20 x1_x2_x2_net19 x1_x2_net1 VSS VSS nfet_06v0 L=1.0u W=5.0u
Mx1_x2_x2_XM21 x1_x2_x2_net6 S3P x1_x2_x2_net8 VSS nfet_06v0 L=1.0u W=7.5u
Mx1_x2_x2_XM22 x1_x2_x2_net3 S3N x1_x2_x2_net8 VSS nfet_06v0 L=1.0u W=8.5u
Mx1_x2_x2_XM29 x1_x2_x2_net9 x1_x2_net4 x1_x2_x2_net3 VDD pfet_06v0 L=1.0u W=10u
Mx1_x2_x2_XM30 x1_x2_x2_G_OUT_P x1_x2_net4 x1_x2_x2_net6 VDD pfet_06v0 L=1.0u W=10u
Mx1_x2_x2_XM31 x1_x2_x2_net3 x1_x2_x2_net9 VDD VDD pfet_06v0 L=1.0u W=5u
Mx1_x2_x2_XM35 x1_x2_x2_net6 x1_x2_x2_net9 VDD VDD pfet_06v0 L=1.0u W=5u
Mx1_x2_x2_XM32 x1_x2_x2_net10 x1_x2_x2_net20 x1_x2_x2_net9 VDD pfet_06v0 L=1.0u W=4.0u
Mx1_x2_x2_XM33 x1_x2_x2_net21 x1_x2_x2_net20 x1_x2_x2_G_OUT_P VDD pfet_06v0 L=1.0u W=4.0u
Mx1_x2_x2_XM23 x1_x2_x2_net10 x1_x2_net2 x1_x2_x2_net4 VSS nfet_06v0 L=1.0u W=2.5u
Mx1_x2_x2_XM24 x1_x2_x2_net21 x1_x2_net2 x1_x2_x2_net5 VSS nfet_06v0 L=1.0u W=2.5u
Mx1_x2_x2_XM25 x1_x2_x2_net4 x1_x2_x2_net10 VSS VSS nfet_06v0 L=1.0u W=2.5u
Mx1_x2_x2_XM26 x1_x2_x2_net5 x1_x2_x2_net10 VSS VSS nfet_06v0 L=1.0u W=2.5u
Mx1_x2_x2_XM27 x1_x2_x2_net9 x1_x2_x2_net11 x1_x2_x2_net10 VSS nfet_06v0 L=1.0u W=2.0u
Mx1_x2_x2_XM28 x1_x2_x2_G_OUT_P x1_x2_x2_net11 x1_x2_x2_net21 VSS nfet_06v0 L=1.0u W=2.0u
Mx1_x2_x2_XM34 x1_x2_x2_net12 x1_x2_x2_net13 VDD VDD pfet_06v0 L=1.0u W=10.0u
Mx1_x2_x2_XM36 x1_x2_x2_net13 x1_x2_net4 x1_x2_x2_net12 VDD pfet_06v0 L=1.0u W=10.0u
Mx1_x2_x2_XM37 x1_x2_x2_net20 x1_x2_x2_net20 x1_x2_x2_net13 VDD pfet_06v0 L=1.0u W=10.0u
Mx1_x2_x2_XM38 x1_x2_x2_net20 x1_x2_net2 x1_x2_x2_net14 VSS nfet_06v0 L=1.0u W=5.0u
Mx1_x2_x2_XM39 x1_x2_x2_net14 x1_x2_net1 VSS VSS nfet_06v0 L=1.0u W=5.0u
Mx1_x2_x2_XM45 x1_x2_x2_net15 x1_x2_net3 VDD VDD pfet_06v0 L=1.0u W=10.0u
Mx1_x2_x2_XM46 x1_x2_x2_net11 x1_x2_net4 x1_x2_x2_net15 VDD pfet_06v0 L=1.0u W=10.0u
Mx1_x2_x2_XM40 x1_x2_x2_net11 x1_x2_x2_net11 x1_x2_x2_net17 VSS nfet_06v0 L=1.0u W=5.0u
Mx1_x2_x2_XM41 x1_x2_x2_net17 x1_x2_net2 x1_x2_x2_net16 VSS nfet_06v0 L=1.0u W=5.0u
Mx1_x2_x2_XM42 x1_x2_x2_net16 x1_x2_x2_net17 VSS VSS nfet_06v0 L=1.0u W=5.0u
Mx1_x2_x2_XM43_m1 x1_SZ x1_x2_x2_G_OUT_P VDD VDD pfet_06v0 L=1.0u W=1.0u
Mx1_x2_x2_XM43_m2 x1_SZ x1_x2_x2_G_OUT_P VDD VDD pfet_06v0 L=1.0u W=1.0u
Mx1_x2_x2_XM43_m3 x1_SZ x1_x2_x2_G_OUT_P VDD VDD pfet_06v0 L=1.0u W=1.0u
Mx1_x2_x2_XM43_m4 x1_SZ x1_x2_x2_G_OUT_P VDD VDD pfet_06v0 L=1.0u W=1.0u
Mx1_x2_x2_XM44 x1_SZ x1_x2_x2_net21 VSS VSS nfet_06v0 L=1.0u W=1.0u
Mx2_x4_x1_XM4 x2_x4_x1_net3 x2_x4_net4 VDD VDD pfet_06v0 L=1.0u W=10.0u
Mx2_x4_x1_XM5 x2_x4_net2 x2_x4_net3 x2_x4_x1_net3 VDD pfet_06v0 L=1.0u W=10.0u
Mx2_x4_x1_XM6 x2_x4_net2 x2_x4_net2 VSS VSS nfet_06v0 L=1.0u W=1.0u
Mx2_x4_x1_XM7 x2_x4_x1_net2 x2_x4_net4 VDD VDD pfet_06v0 L=1.0u W=10.0u
Mx2_x4_x1_XM8 x2_x4_net1 x2_x4_net3 x2_x4_x1_net2 VDD pfet_06v0 L=1.0u W=10.0u
Mx2_x4_x1_XM9 x2_x4_net1 x2_x4_net2 x2_x4_x1_net1 VSS nfet_06v0 L=1.0u W=5.0u
Mx2_x4_x1_XM10 x2_x4_x1_net1 x2_x4_net1 VSS VSS nfet_06v0 L=1.0u W=5.0u
Mx2_x4_x1_XM1 x2_x4_net3 x2_x4_net3 VDD VDD pfet_06v0 L=1.0u W=2u
Mx2_x4_x1_XM2 x2_x4_x1_net4 x2_x4_net4 VDD VDD pfet_06v0 L=1.0u W=10.0u
Mx2_x4_x1_XM3 x2_x4_net4 x2_x4_net3 x2_x4_x1_net4 VDD pfet_06v0 L=1.0u W=10.0u
Mx2_x4_x1_XM47 x2_x4_x1_net5 x2_x4_net3 VSS VSS nfet_06v0 L=1.0u W=1.0u
Mx2_x4_x1_XM48 x2_x4_x1_net6 x2_x4_net3 VSS VSS nfet_06v0 L=1.0u W=1.0u
Mx2_x4_x1_XM49 x2_x4_net3 x2_x4_net3 x2_x4_x1_net6 VSS nfet_06v0 L=1.0u W=1.0u
Mx2_x4_x1_XM50 x2_x4_net4 x2_x4_net3 x2_x4_x1_net5 VSS nfet_06v0 L=1.0u W=1.0u
Mx2_x4_x2_XM11 x2_x4_x2_net2 x2_x4_net4 VDD VDD pfet_06v0 L=1.0u W=10.0u
Mx2_x4_x2_XM12 x2_x4_x2_net7 x2_x4_net3 x2_x4_x2_net2 VDD pfet_06v0 L=1.0u W=10.0u
Mx2_x4_x2_XM13 x2_x4_x2_net19 x2_x4_net4 VDD VDD pfet_06v0 L=1.0u W=10.0u
Mx2_x4_x2_XM14 x2_x4_x2_net7 x2_x4_net3 x2_x4_x2_net19 VDD pfet_06v0 L=1.0u W=10.0u
Mx2_x4_x2_XM15_f1 x2_x4_x2_net5 x2_SY x2_x4_x2_net7 VDD pfet_06v0 L=1.0u W=10.0u
Mx2_x4_x2_XM15_f2 x2_x4_x2_net5 x2_SY x2_x4_x2_net7 VDD pfet_06v0 L=1.0u W=10.0u
Mx2_x4_x2_XM16_f1 x2_x4_x2_net4 x2_SX x2_x4_x2_net7 VDD pfet_06v0 L=1.0u W=10.0u
Mx2_x4_x2_XM16_f2 x2_x4_x2_net4 x2_SX x2_x4_x2_net7 VDD pfet_06v0 L=1.0u W=10.0u
Mx2_x4_x2_XM17 x2_x4_x2_net8 x2_x4_net2 x2_x4_x2_net1 VSS nfet_06v0 L=1.0u W=5.0u
Mx2_x4_x2_XM18 x2_x4_x2_net1 x2_x4_net1 VSS VSS nfet_06v0 L=1.0u W=5.0u
Mx2_x4_x2_XM19 x2_x4_x2_net8 x2_x4_net2 x2_x4_x2_net20 VSS nfet_06v0 L=1.0u W=5.0u
Mx2_x4_x2_XM20 x2_x4_x2_net20 x2_x4_net1 VSS VSS nfet_06v0 L=1.0u W=5.0u
Mx2_x4_x2_XM21_f1 x2_x4_x2_net6 x2_SY x2_x4_x2_net8 VSS nfet_06v0 L=1.0u W=5u
Mx2_x4_x2_XM21_f2 x2_x4_x2_net6 x2_SY x2_x4_x2_net8 VSS nfet_06v0 L=1.0u W=5u
Mx2_x4_x2_XM22_f1 x2_x4_x2_net3 x2_SX x2_x4_x2_net8 VSS nfet_06v0 L=1.0u W=5u
Mx2_x4_x2_XM22_f2 x2_x4_x2_net3 x2_SX x2_x4_x2_net8 VSS nfet_06v0 L=1.0u W=5u
Mx2_x4_x2_XM29_f1 x2_x4_x2_net9 x2_x4_net3 x2_x4_x2_net3 VDD pfet_06v0 L=1.0u W=5u
Mx2_x4_x2_XM29_f2 x2_x4_x2_net9 x2_x4_net3 x2_x4_x2_net3 VDD pfet_06v0 L=1.0u W=5u
Mx2_x4_x2_XM30_f1 x2_x4_x2_net12 x2_x4_net3 x2_x4_x2_net6 VDD pfet_06v0 L=1.0u W=5.0u
Mx2_x4_x2_XM30_f2 x2_x4_x2_net12 x2_x4_net3 x2_x4_x2_net6 VDD pfet_06v0 L=1.0u W=5.0u
Mx2_x4_x2_XM31_f1 x2_x4_x2_net3 x2_x4_x2_net9 VDD VDD pfet_06v0 L=1.0u W=5u
Mx2_x4_x2_XM31_f2 x2_x4_x2_net3 x2_x4_x2_net9 VDD VDD pfet_06v0 L=1.0u W=5u
Mx2_x4_x2_XM31_f3 x2_x4_x2_net3 x2_x4_x2_net9 VDD VDD pfet_06v0 L=1.0u W=5u
Mx2_x4_x2_XM31_f4 x2_x4_x2_net3 x2_x4_x2_net9 VDD VDD pfet_06v0 L=1.0u W=5u
Mx2_x4_x2_XM35_f1 x2_x4_x2_net6 x2_x4_x2_net9 VDD VDD pfet_06v0 L=1.0u W=5.0u
Mx2_x4_x2_XM35_f2 x2_x4_x2_net6 x2_x4_x2_net9 VDD VDD pfet_06v0 L=1.0u W=5.0u
Mx2_x4_x2_XM35_f3 x2_x4_x2_net6 x2_x4_x2_net9 VDD VDD pfet_06v0 L=1.0u W=5.0u
Mx2_x4_x2_XM35_f4 x2_x4_x2_net6 x2_x4_x2_net9 VDD VDD pfet_06v0 L=1.0u W=5.0u
Mx2_x4_x2_XM32 x2_x4_x2_net10 x2_x4_x2_net21 x2_x4_x2_net9 VDD pfet_06v0 L=1.0u W=5u
Mx2_x4_x2_XM33 x2_x4_x2_net22 x2_x4_x2_net21 x2_x4_x2_net12 VDD pfet_06v0 L=1.0u W=5.0u
Mx2_x4_x2_XM23_f1 x2_x4_x2_net10 x2_x4_net2 x2_x4_x2_net4 VSS nfet_06v0 L=1.0u W=2.5u
Mx2_x4_x2_XM23_f2 x2_x4_x2_net10 x2_x4_net2 x2_x4_x2_net4 VSS nfet_06v0 L=1.0u W=2.5u
Mx2_x4_x2_XM24_f1 x2_x4_x2_net22 x2_x4_net2 x2_x4_x2_net5 VSS nfet_06v0 L=1.0u W=2.5u
Mx2_x4_x2_XM24_f2 x2_x4_x2_net22 x2_x4_net2 x2_x4_x2_net5 VSS nfet_06v0 L=1.0u W=2.5u
Mx2_x4_x2_XM25_f1 x2_x4_x2_net4 x2_x4_x2_net10 VSS VSS nfet_06v0 L=1.0u W=2.5u
Mx2_x4_x2_XM25_f2 x2_x4_x2_net4 x2_x4_x2_net10 VSS VSS nfet_06v0 L=1.0u W=2.5u
Mx2_x4_x2_XM25_f3 x2_x4_x2_net4 x2_x4_x2_net10 VSS VSS nfet_06v0 L=1.0u W=2.5u
Mx2_x4_x2_XM25_f4 x2_x4_x2_net4 x2_x4_x2_net10 VSS VSS nfet_06v0 L=1.0u W=2.5u
Mx2_x4_x2_XM26_f1 x2_x4_x2_net5 x2_x4_x2_net10 VSS VSS nfet_06v0 L=1.0u W=2.5u
Mx2_x4_x2_XM26_f2 x2_x4_x2_net5 x2_x4_x2_net10 VSS VSS nfet_06v0 L=1.0u W=2.5u
Mx2_x4_x2_XM26_f3 x2_x4_x2_net5 x2_x4_x2_net10 VSS VSS nfet_06v0 L=1.0u W=2.5u
Mx2_x4_x2_XM26_f4 x2_x4_x2_net5 x2_x4_x2_net10 VSS VSS nfet_06v0 L=1.0u W=2.5u
Mx2_x4_x2_XM27 x2_x4_x2_net9 x2_x4_x2_net11 x2_x4_x2_net10 VSS nfet_06v0 L=1.0u W=2.5u
Mx2_x4_x2_XM28 x2_x4_x2_net12 x2_x4_x2_net11 x2_x4_x2_net22 VSS nfet_06v0 L=1.0u W=2.5u
Mx2_x4_x2_XM34 x2_x4_x2_net13 x2_x4_x2_net14 VDD VDD pfet_06v0 L=1.0u W=10.0u
Mx2_x4_x2_XM36 x2_x4_x2_net14 x2_x4_net3 x2_x4_x2_net13 VDD pfet_06v0 L=1.0u W=10.0u
Mx2_x4_x2_XM37 x2_x4_x2_net21 x2_x4_x2_net21 x2_x4_x2_net14 VDD pfet_06v0 L=1.0u W=10.0u
Mx2_x4_x2_XM38 x2_x4_x2_net21 x2_x4_net2 x2_x4_x2_net15 VSS nfet_06v0 L=1.0u W=5.0u
Mx2_x4_x2_XM39 x2_x4_x2_net15 x2_x4_net1 VSS VSS nfet_06v0 L=1.0u W=5.0u
Mx2_x4_x2_XM45 x2_x4_x2_net16 x2_x4_net4 VDD VDD pfet_06v0 L=1.0u W=10.0u
Mx2_x4_x2_XM46 x2_x4_x2_net11 x2_x4_net3 x2_x4_x2_net16 VDD pfet_06v0 L=1.0u W=10.0u
Mx2_x4_x2_XM40 x2_x4_x2_net11 x2_x4_x2_net11 x2_x4_x2_net18 VSS nfet_06v0 L=1.0u W=5.0u
Mx2_x4_x2_XM41 x2_x4_x2_net18 x2_x4_net2 x2_x4_x2_net17 VSS nfet_06v0 L=1.0u W=5.0u
Mx2_x4_x2_XM42 x2_x4_x2_net17 x2_x4_x2_net18 VSS VSS nfet_06v0 L=1.0u W=5.0u
Mx2_x4_x2_XM43_f1 x2_net1 x2_x4_x2_net12 VDD VDD pfet_06v0 L=1.0u W=10u
Mx2_x4_x2_XM43_f2 x2_net1 x2_x4_x2_net12 VDD VDD pfet_06v0 L=1.0u W=10u
Mx2_x4_x2_XM43_f3 x2_net1 x2_x4_x2_net12 VDD VDD pfet_06v0 L=1.0u W=10u
Mx2_x4_x2_XM44_f1 x2_net1 x2_x4_x2_net22 VSS VSS nfet_06v0 L=1.0u W=5u
Mx2_x4_x2_XM44_f2 x2_net1 x2_x4_x2_net22 VSS VSS nfet_06v0 L=1.0u W=5u
Mx2_x4_x2_XM44_f3 x2_net1 x2_x4_x2_net22 VSS VSS nfet_06v0 L=1.0u W=5u
Mx2_x5_x1_XM4 x2_x5_x1_net3 x2_x5_net4 VDD VDD pfet_06v0 L=1.0u W=10.0u
Mx2_x5_x1_XM5 x2_x5_net2 x2_x5_net3 x2_x5_x1_net3 VDD pfet_06v0 L=1.0u W=10.0u
Mx2_x5_x1_XM6 x2_x5_net2 x2_x5_net2 VSS VSS nfet_06v0 L=1.0u W=1.0u
Mx2_x5_x1_XM7 x2_x5_x1_net2 x2_x5_net4 VDD VDD pfet_06v0 L=1.0u W=10.0u
Mx2_x5_x1_XM8 x2_x5_net1 x2_x5_net3 x2_x5_x1_net2 VDD pfet_06v0 L=1.0u W=10.0u
Mx2_x5_x1_XM9 x2_x5_net1 x2_x5_net2 x2_x5_x1_net1 VSS nfet_06v0 L=1.0u W=5.0u
Mx2_x5_x1_XM10 x2_x5_x1_net1 x2_x5_net1 VSS VSS nfet_06v0 L=1.0u W=5.0u
Mx2_x5_x1_XM1 x2_x5_net3 x2_x5_net3 VDD VDD pfet_06v0 L=1.0u W=2u
Mx2_x5_x1_XM2 x2_x5_x1_net4 x2_x5_net4 VDD VDD pfet_06v0 L=1.0u W=10.0u
Mx2_x5_x1_XM3 x2_x5_net4 x2_x5_net3 x2_x5_x1_net4 VDD pfet_06v0 L=1.0u W=10.0u
Mx2_x5_x1_XM47 x2_x5_x1_net5 x2_x5_net3 VSS VSS nfet_06v0 L=1.0u W=1.0u
Mx2_x5_x1_XM48 x2_x5_x1_net6 x2_x5_net3 VSS VSS nfet_06v0 L=1.0u W=1.0u
Mx2_x5_x1_XM49 x2_x5_net3 x2_x5_net3 x2_x5_x1_net6 VSS nfet_06v0 L=1.0u W=1.0u
Mx2_x5_x1_XM50 x2_x5_net4 x2_x5_net3 x2_x5_x1_net5 VSS nfet_06v0 L=1.0u W=1.0u
Mx2_x5_x2_XM11 x2_x5_x2_net2 x2_x5_net4 VDD VDD pfet_06v0 L=1.0u W=10.0u
Mx2_x5_x2_XM12 x2_x5_x2_net7 x2_x5_net3 x2_x5_x2_net2 VDD pfet_06v0 L=1.0u W=10.0u
Mx2_x5_x2_XM13 x2_x5_x2_net19 x2_x5_net4 VDD VDD pfet_06v0 L=1.0u W=10.0u
Mx2_x5_x2_XM14 x2_x5_x2_net7 x2_x5_net3 x2_x5_x2_net19 VDD pfet_06v0 L=1.0u W=10.0u
Mx2_x5_x2_XM15_f1 x2_x5_x2_net5 x2_SZ x2_x5_x2_net7 VDD pfet_06v0 L=1.0u W=10.0u
Mx2_x5_x2_XM15_f2 x2_x5_x2_net5 x2_SZ x2_x5_x2_net7 VDD pfet_06v0 L=1.0u W=10.0u
Mx2_x5_x2_XM16_f1 x2_x5_x2_net4 x2_SX x2_x5_x2_net7 VDD pfet_06v0 L=1.0u W=10.0u
Mx2_x5_x2_XM16_f2 x2_x5_x2_net4 x2_SX x2_x5_x2_net7 VDD pfet_06v0 L=1.0u W=10.0u
Mx2_x5_x2_XM17 x2_x5_x2_net8 x2_x5_net2 x2_x5_x2_net1 VSS nfet_06v0 L=1.0u W=5.0u
Mx2_x5_x2_XM18 x2_x5_x2_net1 x2_x5_net1 VSS VSS nfet_06v0 L=1.0u W=5.0u
Mx2_x5_x2_XM19 x2_x5_x2_net8 x2_x5_net2 x2_x5_x2_net20 VSS nfet_06v0 L=1.0u W=5.0u
Mx2_x5_x2_XM20 x2_x5_x2_net20 x2_x5_net1 VSS VSS nfet_06v0 L=1.0u W=5.0u
Mx2_x5_x2_XM21_f1 x2_x5_x2_net6 x2_SZ x2_x5_x2_net8 VSS nfet_06v0 L=1.0u W=5u
Mx2_x5_x2_XM21_f2 x2_x5_x2_net6 x2_SZ x2_x5_x2_net8 VSS nfet_06v0 L=1.0u W=5u
Mx2_x5_x2_XM22_f1 x2_x5_x2_net3 x2_SX x2_x5_x2_net8 VSS nfet_06v0 L=1.0u W=5u
Mx2_x5_x2_XM22_f2 x2_x5_x2_net3 x2_SX x2_x5_x2_net8 VSS nfet_06v0 L=1.0u W=5u
Mx2_x5_x2_XM29_f1 x2_x5_x2_net9 x2_x5_net3 x2_x5_x2_net3 VDD pfet_06v0 L=1.0u W=5u
Mx2_x5_x2_XM29_f2 x2_x5_x2_net9 x2_x5_net3 x2_x5_x2_net3 VDD pfet_06v0 L=1.0u W=5u
Mx2_x5_x2_XM30_f1 x2_x5_x2_net12 x2_x5_net3 x2_x5_x2_net6 VDD pfet_06v0 L=1.0u W=5.0u
Mx2_x5_x2_XM30_f2 x2_x5_x2_net12 x2_x5_net3 x2_x5_x2_net6 VDD pfet_06v0 L=1.0u W=5.0u
Mx2_x5_x2_XM31_f1 x2_x5_x2_net3 x2_x5_x2_net9 VDD VDD pfet_06v0 L=1.0u W=5u
Mx2_x5_x2_XM31_f2 x2_x5_x2_net3 x2_x5_x2_net9 VDD VDD pfet_06v0 L=1.0u W=5u
Mx2_x5_x2_XM31_f3 x2_x5_x2_net3 x2_x5_x2_net9 VDD VDD pfet_06v0 L=1.0u W=5u
Mx2_x5_x2_XM31_f4 x2_x5_x2_net3 x2_x5_x2_net9 VDD VDD pfet_06v0 L=1.0u W=5u
Mx2_x5_x2_XM35_f1 x2_x5_x2_net6 x2_x5_x2_net9 VDD VDD pfet_06v0 L=1.0u W=5.0u
Mx2_x5_x2_XM35_f2 x2_x5_x2_net6 x2_x5_x2_net9 VDD VDD pfet_06v0 L=1.0u W=5.0u
Mx2_x5_x2_XM35_f3 x2_x5_x2_net6 x2_x5_x2_net9 VDD VDD pfet_06v0 L=1.0u W=5.0u
Mx2_x5_x2_XM35_f4 x2_x5_x2_net6 x2_x5_x2_net9 VDD VDD pfet_06v0 L=1.0u W=5.0u
Mx2_x5_x2_XM32 x2_x5_x2_net10 x2_x5_x2_net21 x2_x5_x2_net9 VDD pfet_06v0 L=1.0u W=5u
Mx2_x5_x2_XM33 x2_x5_x2_net22 x2_x5_x2_net21 x2_x5_x2_net12 VDD pfet_06v0 L=1.0u W=5.0u
Mx2_x5_x2_XM23_f1 x2_x5_x2_net10 x2_x5_net2 x2_x5_x2_net4 VSS nfet_06v0 L=1.0u W=2.5u
Mx2_x5_x2_XM23_f2 x2_x5_x2_net10 x2_x5_net2 x2_x5_x2_net4 VSS nfet_06v0 L=1.0u W=2.5u
Mx2_x5_x2_XM24_f1 x2_x5_x2_net22 x2_x5_net2 x2_x5_x2_net5 VSS nfet_06v0 L=1.0u W=2.5u
Mx2_x5_x2_XM24_f2 x2_x5_x2_net22 x2_x5_net2 x2_x5_x2_net5 VSS nfet_06v0 L=1.0u W=2.5u
Mx2_x5_x2_XM25_f1 x2_x5_x2_net4 x2_x5_x2_net10 VSS VSS nfet_06v0 L=1.0u W=2.5u
Mx2_x5_x2_XM25_f2 x2_x5_x2_net4 x2_x5_x2_net10 VSS VSS nfet_06v0 L=1.0u W=2.5u
Mx2_x5_x2_XM25_f3 x2_x5_x2_net4 x2_x5_x2_net10 VSS VSS nfet_06v0 L=1.0u W=2.5u
Mx2_x5_x2_XM25_f4 x2_x5_x2_net4 x2_x5_x2_net10 VSS VSS nfet_06v0 L=1.0u W=2.5u
Mx2_x5_x2_XM26_f1 x2_x5_x2_net5 x2_x5_x2_net10 VSS VSS nfet_06v0 L=1.0u W=2.5u
Mx2_x5_x2_XM26_f2 x2_x5_x2_net5 x2_x5_x2_net10 VSS VSS nfet_06v0 L=1.0u W=2.5u
Mx2_x5_x2_XM26_f3 x2_x5_x2_net5 x2_x5_x2_net10 VSS VSS nfet_06v0 L=1.0u W=2.5u
Mx2_x5_x2_XM26_f4 x2_x5_x2_net5 x2_x5_x2_net10 VSS VSS nfet_06v0 L=1.0u W=2.5u
Mx2_x5_x2_XM27 x2_x5_x2_net9 x2_x5_x2_net11 x2_x5_x2_net10 VSS nfet_06v0 L=1.0u W=2.5u
Mx2_x5_x2_XM28 x2_x5_x2_net12 x2_x5_x2_net11 x2_x5_x2_net22 VSS nfet_06v0 L=1.0u W=2.5u
Mx2_x5_x2_XM34 x2_x5_x2_net13 x2_x5_x2_net14 VDD VDD pfet_06v0 L=1.0u W=10.0u
Mx2_x5_x2_XM36 x2_x5_x2_net14 x2_x5_net3 x2_x5_x2_net13 VDD pfet_06v0 L=1.0u W=10.0u
Mx2_x5_x2_XM37 x2_x5_x2_net21 x2_x5_x2_net21 x2_x5_x2_net14 VDD pfet_06v0 L=1.0u W=10.0u
Mx2_x5_x2_XM38 x2_x5_x2_net21 x2_x5_net2 x2_x5_x2_net15 VSS nfet_06v0 L=1.0u W=5.0u
Mx2_x5_x2_XM39 x2_x5_x2_net15 x2_x5_net1 VSS VSS nfet_06v0 L=1.0u W=5.0u
Mx2_x5_x2_XM45 x2_x5_x2_net16 x2_x5_net4 VDD VDD pfet_06v0 L=1.0u W=10.0u
Mx2_x5_x2_XM46 x2_x5_x2_net11 x2_x5_net3 x2_x5_x2_net16 VDD pfet_06v0 L=1.0u W=10.0u
Mx2_x5_x2_XM40 x2_x5_x2_net11 x2_x5_x2_net11 x2_x5_x2_net18 VSS nfet_06v0 L=1.0u W=5.0u
Mx2_x5_x2_XM41 x2_x5_x2_net18 x2_x5_net2 x2_x5_x2_net17 VSS nfet_06v0 L=1.0u W=5.0u
Mx2_x5_x2_XM42 x2_x5_x2_net17 x2_x5_x2_net18 VSS VSS nfet_06v0 L=1.0u W=5.0u
Mx2_x5_x2_XM43_f1 x2_net2 x2_x5_x2_net12 VDD VDD pfet_06v0 L=1.0u W=10u
Mx2_x5_x2_XM43_f2 x2_net2 x2_x5_x2_net12 VDD VDD pfet_06v0 L=1.0u W=10u
Mx2_x5_x2_XM43_f3 x2_net2 x2_x5_x2_net12 VDD VDD pfet_06v0 L=1.0u W=10u
Mx2_x5_x2_XM44_f1 x2_net2 x2_x5_x2_net22 VSS VSS nfet_06v0 L=1.0u W=5u
Mx2_x5_x2_XM44_f2 x2_net2 x2_x5_x2_net22 VSS VSS nfet_06v0 L=1.0u W=5u
Mx2_x5_x2_XM44_f3 x2_net2 x2_x5_x2_net22 VSS VSS nfet_06v0 L=1.0u W=5u
Mx2_x6_x1_XM4 x2_x6_x1_net3 x2_x6_net4 VDD VDD pfet_06v0 L=1.0u W=10.0u
Mx2_x6_x1_XM5 x2_x6_net2 x2_x6_net3 x2_x6_x1_net3 VDD pfet_06v0 L=1.0u W=10.0u
Mx2_x6_x1_XM6 x2_x6_net2 x2_x6_net2 VSS VSS nfet_06v0 L=1.0u W=1.0u
Mx2_x6_x1_XM7 x2_x6_x1_net2 x2_x6_net4 VDD VDD pfet_06v0 L=1.0u W=10.0u
Mx2_x6_x1_XM8 x2_x6_net1 x2_x6_net3 x2_x6_x1_net2 VDD pfet_06v0 L=1.0u W=10.0u
Mx2_x6_x1_XM9 x2_x6_net1 x2_x6_net2 x2_x6_x1_net1 VSS nfet_06v0 L=1.0u W=5.0u
Mx2_x6_x1_XM10 x2_x6_x1_net1 x2_x6_net1 VSS VSS nfet_06v0 L=1.0u W=5.0u
Mx2_x6_x1_XM1 x2_x6_net3 x2_x6_net3 VDD VDD pfet_06v0 L=1.0u W=2u
Mx2_x6_x1_XM2 x2_x6_x1_net4 x2_x6_net4 VDD VDD pfet_06v0 L=1.0u W=10.0u
Mx2_x6_x1_XM3 x2_x6_net4 x2_x6_net3 x2_x6_x1_net4 VDD pfet_06v0 L=1.0u W=10.0u
Mx2_x6_x1_XM47 x2_x6_x1_net5 x2_x6_net3 VSS VSS nfet_06v0 L=1.0u W=1.0u
Mx2_x6_x1_XM48 x2_x6_x1_net6 x2_x6_net3 VSS VSS nfet_06v0 L=1.0u W=1.0u
Mx2_x6_x1_XM49 x2_x6_net3 x2_x6_net3 x2_x6_x1_net6 VSS nfet_06v0 L=1.0u W=1.0u
Mx2_x6_x1_XM50 x2_x6_net4 x2_x6_net3 x2_x6_x1_net5 VSS nfet_06v0 L=1.0u W=1.0u
Mx2_x6_x2_XM11 x2_x6_x2_net2 x2_x6_net4 VDD VDD pfet_06v0 L=1.0u W=10.0u
Mx2_x6_x2_XM12 x2_x6_x2_net7 x2_x6_net3 x2_x6_x2_net2 VDD pfet_06v0 L=1.0u W=10.0u
Mx2_x6_x2_XM13 x2_x6_x2_net19 x2_x6_net4 VDD VDD pfet_06v0 L=1.0u W=10.0u
Mx2_x6_x2_XM14 x2_x6_x2_net7 x2_x6_net3 x2_x6_x2_net19 VDD pfet_06v0 L=1.0u W=10.0u
Mx2_x6_x2_XM15_f1 x2_x6_x2_net5 x2_SZ x2_x6_x2_net7 VDD pfet_06v0 L=1.0u W=10.0u
Mx2_x6_x2_XM15_f2 x2_x6_x2_net5 x2_SZ x2_x6_x2_net7 VDD pfet_06v0 L=1.0u W=10.0u
Mx2_x6_x2_XM16_f1 x2_x6_x2_net4 x2_SY x2_x6_x2_net7 VDD pfet_06v0 L=1.0u W=10.0u
Mx2_x6_x2_XM16_f2 x2_x6_x2_net4 x2_SY x2_x6_x2_net7 VDD pfet_06v0 L=1.0u W=10.0u
Mx2_x6_x2_XM17 x2_x6_x2_net8 x2_x6_net2 x2_x6_x2_net1 VSS nfet_06v0 L=1.0u W=5.0u
Mx2_x6_x2_XM18 x2_x6_x2_net1 x2_x6_net1 VSS VSS nfet_06v0 L=1.0u W=5.0u
Mx2_x6_x2_XM19 x2_x6_x2_net8 x2_x6_net2 x2_x6_x2_net20 VSS nfet_06v0 L=1.0u W=5.0u
Mx2_x6_x2_XM20 x2_x6_x2_net20 x2_x6_net1 VSS VSS nfet_06v0 L=1.0u W=5.0u
Mx2_x6_x2_XM21_f1 x2_x6_x2_net6 x2_SZ x2_x6_x2_net8 VSS nfet_06v0 L=1.0u W=5u
Mx2_x6_x2_XM21_f2 x2_x6_x2_net6 x2_SZ x2_x6_x2_net8 VSS nfet_06v0 L=1.0u W=5u
Mx2_x6_x2_XM22_f1 x2_x6_x2_net3 x2_SY x2_x6_x2_net8 VSS nfet_06v0 L=1.0u W=5u
Mx2_x6_x2_XM22_f2 x2_x6_x2_net3 x2_SY x2_x6_x2_net8 VSS nfet_06v0 L=1.0u W=5u
Mx2_x6_x2_XM29_f1 x2_x6_x2_net9 x2_x6_net3 x2_x6_x2_net3 VDD pfet_06v0 L=1.0u W=5u
Mx2_x6_x2_XM29_f2 x2_x6_x2_net9 x2_x6_net3 x2_x6_x2_net3 VDD pfet_06v0 L=1.0u W=5u
Mx2_x6_x2_XM30_f1 x2_x6_x2_net12 x2_x6_net3 x2_x6_x2_net6 VDD pfet_06v0 L=1.0u W=5.0u
Mx2_x6_x2_XM30_f2 x2_x6_x2_net12 x2_x6_net3 x2_x6_x2_net6 VDD pfet_06v0 L=1.0u W=5.0u
Mx2_x6_x2_XM31_f1 x2_x6_x2_net3 x2_x6_x2_net9 VDD VDD pfet_06v0 L=1.0u W=5u
Mx2_x6_x2_XM31_f2 x2_x6_x2_net3 x2_x6_x2_net9 VDD VDD pfet_06v0 L=1.0u W=5u
Mx2_x6_x2_XM31_f3 x2_x6_x2_net3 x2_x6_x2_net9 VDD VDD pfet_06v0 L=1.0u W=5u
Mx2_x6_x2_XM31_f4 x2_x6_x2_net3 x2_x6_x2_net9 VDD VDD pfet_06v0 L=1.0u W=5u
Mx2_x6_x2_XM35_f1 x2_x6_x2_net6 x2_x6_x2_net9 VDD VDD pfet_06v0 L=1.0u W=5.0u
Mx2_x6_x2_XM35_f2 x2_x6_x2_net6 x2_x6_x2_net9 VDD VDD pfet_06v0 L=1.0u W=5.0u
Mx2_x6_x2_XM35_f3 x2_x6_x2_net6 x2_x6_x2_net9 VDD VDD pfet_06v0 L=1.0u W=5.0u
Mx2_x6_x2_XM35_f4 x2_x6_x2_net6 x2_x6_x2_net9 VDD VDD pfet_06v0 L=1.0u W=5.0u
Mx2_x6_x2_XM32 x2_x6_x2_net10 x2_x6_x2_net21 x2_x6_x2_net9 VDD pfet_06v0 L=1.0u W=5u
Mx2_x6_x2_XM33 x2_x6_x2_net22 x2_x6_x2_net21 x2_x6_x2_net12 VDD pfet_06v0 L=1.0u W=5.0u
Mx2_x6_x2_XM23_f1 x2_x6_x2_net10 x2_x6_net2 x2_x6_x2_net4 VSS nfet_06v0 L=1.0u W=2.5u
Mx2_x6_x2_XM23_f2 x2_x6_x2_net10 x2_x6_net2 x2_x6_x2_net4 VSS nfet_06v0 L=1.0u W=2.5u
Mx2_x6_x2_XM24_f1 x2_x6_x2_net22 x2_x6_net2 x2_x6_x2_net5 VSS nfet_06v0 L=1.0u W=2.5u
Mx2_x6_x2_XM24_f2 x2_x6_x2_net22 x2_x6_net2 x2_x6_x2_net5 VSS nfet_06v0 L=1.0u W=2.5u
Mx2_x6_x2_XM25_f1 x2_x6_x2_net4 x2_x6_x2_net10 VSS VSS nfet_06v0 L=1.0u W=2.5u
Mx2_x6_x2_XM25_f2 x2_x6_x2_net4 x2_x6_x2_net10 VSS VSS nfet_06v0 L=1.0u W=2.5u
Mx2_x6_x2_XM25_f3 x2_x6_x2_net4 x2_x6_x2_net10 VSS VSS nfet_06v0 L=1.0u W=2.5u
Mx2_x6_x2_XM25_f4 x2_x6_x2_net4 x2_x6_x2_net10 VSS VSS nfet_06v0 L=1.0u W=2.5u
Mx2_x6_x2_XM26_f1 x2_x6_x2_net5 x2_x6_x2_net10 VSS VSS nfet_06v0 L=1.0u W=2.5u
Mx2_x6_x2_XM26_f2 x2_x6_x2_net5 x2_x6_x2_net10 VSS VSS nfet_06v0 L=1.0u W=2.5u
Mx2_x6_x2_XM26_f3 x2_x6_x2_net5 x2_x6_x2_net10 VSS VSS nfet_06v0 L=1.0u W=2.5u
Mx2_x6_x2_XM26_f4 x2_x6_x2_net5 x2_x6_x2_net10 VSS VSS nfet_06v0 L=1.0u W=2.5u
Mx2_x6_x2_XM27 x2_x6_x2_net9 x2_x6_x2_net11 x2_x6_x2_net10 VSS nfet_06v0 L=1.0u W=2.5u
Mx2_x6_x2_XM28 x2_x6_x2_net12 x2_x6_x2_net11 x2_x6_x2_net22 VSS nfet_06v0 L=1.0u W=2.5u
Mx2_x6_x2_XM34 x2_x6_x2_net13 x2_x6_x2_net14 VDD VDD pfet_06v0 L=1.0u W=10.0u
Mx2_x6_x2_XM36 x2_x6_x2_net14 x2_x6_net3 x2_x6_x2_net13 VDD pfet_06v0 L=1.0u W=10.0u
Mx2_x6_x2_XM37 x2_x6_x2_net21 x2_x6_x2_net21 x2_x6_x2_net14 VDD pfet_06v0 L=1.0u W=10.0u
Mx2_x6_x2_XM38 x2_x6_x2_net21 x2_x6_net2 x2_x6_x2_net15 VSS nfet_06v0 L=1.0u W=5.0u
Mx2_x6_x2_XM39 x2_x6_x2_net15 x2_x6_net1 VSS VSS nfet_06v0 L=1.0u W=5.0u
Mx2_x6_x2_XM45 x2_x6_x2_net16 x2_x6_net4 VDD VDD pfet_06v0 L=1.0u W=10.0u
Mx2_x6_x2_XM46 x2_x6_x2_net11 x2_x6_net3 x2_x6_x2_net16 VDD pfet_06v0 L=1.0u W=10.0u
Mx2_x6_x2_XM40 x2_x6_x2_net11 x2_x6_x2_net11 x2_x6_x2_net18 VSS nfet_06v0 L=1.0u W=5.0u
Mx2_x6_x2_XM41 x2_x6_x2_net18 x2_x6_net2 x2_x6_x2_net17 VSS nfet_06v0 L=1.0u W=5.0u
Mx2_x6_x2_XM42 x2_x6_x2_net17 x2_x6_x2_net18 VSS VSS nfet_06v0 L=1.0u W=5.0u
Mx2_x6_x2_XM43_f1 x2_net3 x2_x6_x2_net12 VDD VDD pfet_06v0 L=1.0u W=10u
Mx2_x6_x2_XM43_f2 x2_net3 x2_x6_x2_net12 VDD VDD pfet_06v0 L=1.0u W=10u
Mx2_x6_x2_XM43_f3 x2_net3 x2_x6_x2_net12 VDD VDD pfet_06v0 L=1.0u W=10u
Mx2_x6_x2_XM44_f1 x2_net3 x2_x6_x2_net22 VSS VSS nfet_06v0 L=1.0u W=5u
Mx2_x6_x2_XM44_f2 x2_net3 x2_x6_x2_net22 VSS VSS nfet_06v0 L=1.0u W=5u
Mx2_x6_x2_XM44_f3 x2_net3 x2_x6_x2_net22 VSS VSS nfet_06v0 L=1.0u W=5u
Mx2_x7_x2_x2_XM4 x2_x7_x2_net1 x2_net1 VDD VDD pfet_06v0 L=1.0u W=3.0u
Mx2_x7_x2_x2_XM5 VSS x2_net1 x2_x7_x2_net1 VSS nfet_06v0 L=1u W=1u
Mx2_x7_x2_x3_XM4 Y2 x2_x7_x2_x3_net1 VDD VDD pfet_06v0 L=1.0u W=3.0u
Mx2_x7_x2_x3_XM5 VSS x2_x7_x2_x3_net1 Y2 VSS nfet_06v0 L=1u W=1u
Mx2_x7_x2_x3_XM2 VDD x2_net3 x2_x7_x2_x3_net1 VDD pfet_06v0 L=1.0u W=3.0u
Mx2_x7_x2_x3_XM1 VDD x2_x7_x2_net1 x2_x7_x2_x3_net1 VDD pfet_06v0 L=1.0u W=3.0u
Mx2_x7_x2_x3_XM3 VSS x2_net3 x2_x7_x2_x3_net2 VSS nfet_06v0 L=1u W=1u
Mx2_x7_x2_x3_XM6 x2_x7_x2_x3_net2 x2_x7_x2_net1 x2_x7_x2_x3_net1 VSS nfet_06v0 L=1u W=1u
Mx2_x7_x1_XM4 x2_x7_x1_net1 x2_net3 Z2 VDD pfet_06v0 L=1.0u W=3.0u
Mx2_x7_x1_XM5 VDD x2_net2 x2_x7_x1_net1 VDD pfet_06v0 L=1.0u W=3.0u
Mx2_x7_x1_XM7 VSS x2_net3 Z2 VSS nfet_06v0 L=1u W=1u
Mx2_x7_x1_XM1 VSS x2_net2 Z2 VSS nfet_06v0 L=1u W=1u
Mx2_x7_x3_x2_XM4 X2 x2_x7_x3_x2_net1 VDD VDD pfet_06v0 L=1.0u W=3.0u
Mx2_x7_x3_x2_XM5 VSS x2_x7_x3_x2_net1 X2 VSS nfet_06v0 L=1u W=1u
Mx2_x7_x3_x2_XM2 VDD x2_net1 x2_x7_x3_x2_net1 VDD pfet_06v0 L=1.0u W=3.0u
Mx2_x7_x3_x2_XM1 VDD x2_net2 x2_x7_x3_x2_net1 VDD pfet_06v0 L=1.0u W=3.0u
Mx2_x7_x3_x2_XM3 VSS x2_net1 x2_x7_x3_x2_net2 VSS nfet_06v0 L=1u W=1u
Mx2_x7_x3_x2_XM6 x2_x7_x3_x2_net2 x2_net2 x2_x7_x3_x2_net1 VSS nfet_06v0 L=1u W=1u
Mx2_x8_x1_XM4 x2_x8_x1_net3 x2_x8_net3 VDD VDD pfet_06v0 L=1.0u W=10.0u
Mx2_x8_x1_XM5 x2_x8_net2 x2_x8_net4 x2_x8_x1_net3 VDD pfet_06v0 L=1.0u W=10.0u
Mx2_x8_x1_XM6 x2_x8_net2 x2_x8_net2 VSS VSS nfet_06v0 L=1.0u W=1.0u
Mx2_x8_x1_XM7 x2_x8_x1_net2 x2_x8_net3 VDD VDD pfet_06v0 L=1.0u W=10.0u
Mx2_x8_x1_XM8 x2_x8_net1 x2_x8_net4 x2_x8_x1_net2 VDD pfet_06v0 L=1.0u W=10.0u
Mx2_x8_x1_XM9 x2_x8_net1 x2_x8_net2 x2_x8_x1_net1 VSS nfet_06v0 L=1.0u W=5.0u
Mx2_x8_x1_XM10 x2_x8_x1_net1 x2_x8_net1 VSS VSS nfet_06v0 L=1.0u W=5.0u
Mx2_x8_x1_XM1 x2_x8_net4 x2_x8_net4 VDD VDD pfet_06v0 L=1.0u W=2u
Mx2_x8_x1_XM2 x2_x8_x1_net4 x2_x8_net3 VDD VDD pfet_06v0 L=1.0u W=10.0u
Mx2_x8_x1_XM3 x2_x8_net3 x2_x8_net4 x2_x8_x1_net4 VDD pfet_06v0 L=1.0u W=10.0u
Mx2_x8_x1_XM47 x2_x8_x1_net5 x2_x8_net4 VSS VSS nfet_06v0 L=1.0u W=1.0u
Mx2_x8_x1_XM48 x2_x8_x1_net6 x2_x8_net4 VSS VSS nfet_06v0 L=1.0u W=1.0u
Mx2_x8_x1_XM49 x2_x8_net4 x2_x8_net4 x2_x8_x1_net6 VSS nfet_06v0 L=1.0u W=1.0u
Mx2_x8_x1_XM50 x2_x8_net3 x2_x8_net4 x2_x8_x1_net5 VSS nfet_06v0 L=1.0u W=1.0u
Mx2_x8_x2_XM11 x2_x8_x2_net2 x2_x8_net3 VDD VDD pfet_06v0 L=1.0u W=10.0u
Mx2_x8_x2_XM12 x2_x8_x2_net7 x2_x8_net4 x2_x8_x2_net2 VDD pfet_06v0 L=1.0u W=10.0u
Mx2_x8_x2_XM13 x2_x8_x2_net18 x2_x8_net3 VDD VDD pfet_06v0 L=1.0u W=10.0u
Mx2_x8_x2_XM14 x2_x8_x2_net7 x2_x8_net4 x2_x8_x2_net18 VDD pfet_06v0 L=1.0u W=10.0u
Mx2_x8_x2_XM15 x2_x8_x2_net5 S4P x2_x8_x2_net7 VDD pfet_06v0 L=1.0u W=0.55u
Mx2_x8_x2_XM16 x2_x8_x2_net4 S4N x2_x8_x2_net7 VDD pfet_06v0 L=1.0u W=0.5u
Mx2_x8_x2_XM17 x2_x8_x2_net8 x2_x8_net2 x2_x8_x2_net1 VSS nfet_06v0 L=1.0u W=5.0u
Mx2_x8_x2_XM18 x2_x8_x2_net1 x2_x8_net1 VSS VSS nfet_06v0 L=1.0u W=5.0u
Mx2_x8_x2_XM19 x2_x8_x2_net8 x2_x8_net2 x2_x8_x2_net19 VSS nfet_06v0 L=1.0u W=5.0u
Mx2_x8_x2_XM20 x2_x8_x2_net19 x2_x8_net1 VSS VSS nfet_06v0 L=1.0u W=5.0u
Mx2_x8_x2_XM21 x2_x8_x2_net6 S4P x2_x8_x2_net8 VSS nfet_06v0 L=1.0u W=7.5u
Mx2_x8_x2_XM22 x2_x8_x2_net3 S4N x2_x8_x2_net8 VSS nfet_06v0 L=1.0u W=8.5u
Mx2_x8_x2_XM29 x2_x8_x2_net9 x2_x8_net4 x2_x8_x2_net3 VDD pfet_06v0 L=1.0u W=10u
Mx2_x8_x2_XM30 x2_x8_x2_G_OUT_P x2_x8_net4 x2_x8_x2_net6 VDD pfet_06v0 L=1.0u W=10u
Mx2_x8_x2_XM31 x2_x8_x2_net3 x2_x8_x2_net9 VDD VDD pfet_06v0 L=1.0u W=5u
Mx2_x8_x2_XM35 x2_x8_x2_net6 x2_x8_x2_net9 VDD VDD pfet_06v0 L=1.0u W=5u
Mx2_x8_x2_XM32 x2_x8_x2_net10 x2_x8_x2_net20 x2_x8_x2_net9 VDD pfet_06v0 L=1.0u W=4.0u
Mx2_x8_x2_XM33 x2_x8_x2_net21 x2_x8_x2_net20 x2_x8_x2_G_OUT_P VDD pfet_06v0 L=1.0u W=4.0u
Mx2_x8_x2_XM23 x2_x8_x2_net10 x2_x8_net2 x2_x8_x2_net4 VSS nfet_06v0 L=1.0u W=2.5u
Mx2_x8_x2_XM24 x2_x8_x2_net21 x2_x8_net2 x2_x8_x2_net5 VSS nfet_06v0 L=1.0u W=2.5u
Mx2_x8_x2_XM25 x2_x8_x2_net4 x2_x8_x2_net10 VSS VSS nfet_06v0 L=1.0u W=2.5u
Mx2_x8_x2_XM26 x2_x8_x2_net5 x2_x8_x2_net10 VSS VSS nfet_06v0 L=1.0u W=2.5u
Mx2_x8_x2_XM27 x2_x8_x2_net9 x2_x8_x2_net11 x2_x8_x2_net10 VSS nfet_06v0 L=1.0u W=2.0u
Mx2_x8_x2_XM28 x2_x8_x2_G_OUT_P x2_x8_x2_net11 x2_x8_x2_net21 VSS nfet_06v0 L=1.0u W=2.0u
Mx2_x8_x2_XM34 x2_x8_x2_net12 x2_x8_x2_net13 VDD VDD pfet_06v0 L=1.0u W=10.0u
Mx2_x8_x2_XM36 x2_x8_x2_net13 x2_x8_net4 x2_x8_x2_net12 VDD pfet_06v0 L=1.0u W=10.0u
Mx2_x8_x2_XM37 x2_x8_x2_net20 x2_x8_x2_net20 x2_x8_x2_net13 VDD pfet_06v0 L=1.0u W=10.0u
Mx2_x8_x2_XM38 x2_x8_x2_net20 x2_x8_net2 x2_x8_x2_net14 VSS nfet_06v0 L=1.0u W=5.0u
Mx2_x8_x2_XM39 x2_x8_x2_net14 x2_x8_net1 VSS VSS nfet_06v0 L=1.0u W=5.0u
Mx2_x8_x2_XM45 x2_x8_x2_net15 x2_x8_net3 VDD VDD pfet_06v0 L=1.0u W=10.0u
Mx2_x8_x2_XM46 x2_x8_x2_net11 x2_x8_net4 x2_x8_x2_net15 VDD pfet_06v0 L=1.0u W=10.0u
Mx2_x8_x2_XM40 x2_x8_x2_net11 x2_x8_x2_net11 x2_x8_x2_net17 VSS nfet_06v0 L=1.0u W=5.0u
Mx2_x8_x2_XM41 x2_x8_x2_net17 x2_x8_net2 x2_x8_x2_net16 VSS nfet_06v0 L=1.0u W=5.0u
Mx2_x8_x2_XM42 x2_x8_x2_net16 x2_x8_x2_net17 VSS VSS nfet_06v0 L=1.0u W=5.0u
Mx2_x8_x2_XM43_m1 x2_SX x2_x8_x2_G_OUT_P VDD VDD pfet_06v0 L=1.0u W=1.0u
Mx2_x8_x2_XM43_m2 x2_SX x2_x8_x2_G_OUT_P VDD VDD pfet_06v0 L=1.0u W=1.0u
Mx2_x8_x2_XM43_m3 x2_SX x2_x8_x2_G_OUT_P VDD VDD pfet_06v0 L=1.0u W=1.0u
Mx2_x8_x2_XM43_m4 x2_SX x2_x8_x2_G_OUT_P VDD VDD pfet_06v0 L=1.0u W=1.0u
Mx2_x8_x2_XM44 x2_SX x2_x8_x2_net21 VSS VSS nfet_06v0 L=1.0u W=1.0u
Mx2_x1_x1_XM4 x2_x1_x1_net3 x2_x1_net3 VDD VDD pfet_06v0 L=1.0u W=10.0u
Mx2_x1_x1_XM5 x2_x1_net2 x2_x1_net4 x2_x1_x1_net3 VDD pfet_06v0 L=1.0u W=10.0u
Mx2_x1_x1_XM6 x2_x1_net2 x2_x1_net2 VSS VSS nfet_06v0 L=1.0u W=1.0u
Mx2_x1_x1_XM7 x2_x1_x1_net2 x2_x1_net3 VDD VDD pfet_06v0 L=1.0u W=10.0u
Mx2_x1_x1_XM8 x2_x1_net1 x2_x1_net4 x2_x1_x1_net2 VDD pfet_06v0 L=1.0u W=10.0u
Mx2_x1_x1_XM9 x2_x1_net1 x2_x1_net2 x2_x1_x1_net1 VSS nfet_06v0 L=1.0u W=5.0u
Mx2_x1_x1_XM10 x2_x1_x1_net1 x2_x1_net1 VSS VSS nfet_06v0 L=1.0u W=5.0u
Mx2_x1_x1_XM1 x2_x1_net4 x2_x1_net4 VDD VDD pfet_06v0 L=1.0u W=2u
Mx2_x1_x1_XM2 x2_x1_x1_net4 x2_x1_net3 VDD VDD pfet_06v0 L=1.0u W=10.0u
Mx2_x1_x1_XM3 x2_x1_net3 x2_x1_net4 x2_x1_x1_net4 VDD pfet_06v0 L=1.0u W=10.0u
Mx2_x1_x1_XM47 x2_x1_x1_net5 x2_x1_net4 VSS VSS nfet_06v0 L=1.0u W=1.0u
Mx2_x1_x1_XM48 x2_x1_x1_net6 x2_x1_net4 VSS VSS nfet_06v0 L=1.0u W=1.0u
Mx2_x1_x1_XM49 x2_x1_net4 x2_x1_net4 x2_x1_x1_net6 VSS nfet_06v0 L=1.0u W=1.0u
Mx2_x1_x1_XM50 x2_x1_net3 x2_x1_net4 x2_x1_x1_net5 VSS nfet_06v0 L=1.0u W=1.0u
Mx2_x1_x2_XM11 x2_x1_x2_net2 x2_x1_net3 VDD VDD pfet_06v0 L=1.0u W=10.0u
Mx2_x1_x2_XM12 x2_x1_x2_net7 x2_x1_net4 x2_x1_x2_net2 VDD pfet_06v0 L=1.0u W=10.0u
Mx2_x1_x2_XM13 x2_x1_x2_net18 x2_x1_net3 VDD VDD pfet_06v0 L=1.0u W=10.0u
Mx2_x1_x2_XM14 x2_x1_x2_net7 x2_x1_net4 x2_x1_x2_net18 VDD pfet_06v0 L=1.0u W=10.0u
Mx2_x1_x2_XM15 x2_x1_x2_net5 S1P x2_x1_x2_net7 VDD pfet_06v0 L=1.0u W=0.55u
Mx2_x1_x2_XM16 x2_x1_x2_net4 S1N x2_x1_x2_net7 VDD pfet_06v0 L=1.0u W=0.5u
Mx2_x1_x2_XM17 x2_x1_x2_net8 x2_x1_net2 x2_x1_x2_net1 VSS nfet_06v0 L=1.0u W=5.0u
Mx2_x1_x2_XM18 x2_x1_x2_net1 x2_x1_net1 VSS VSS nfet_06v0 L=1.0u W=5.0u
Mx2_x1_x2_XM19 x2_x1_x2_net8 x2_x1_net2 x2_x1_x2_net19 VSS nfet_06v0 L=1.0u W=5.0u
Mx2_x1_x2_XM20 x2_x1_x2_net19 x2_x1_net1 VSS VSS nfet_06v0 L=1.0u W=5.0u
Mx2_x1_x2_XM21 x2_x1_x2_net6 S1P x2_x1_x2_net8 VSS nfet_06v0 L=1.0u W=7.5u
Mx2_x1_x2_XM22 x2_x1_x2_net3 S1N x2_x1_x2_net8 VSS nfet_06v0 L=1.0u W=8.5u
Mx2_x1_x2_XM29 x2_x1_x2_net9 x2_x1_net4 x2_x1_x2_net3 VDD pfet_06v0 L=1.0u W=10u
Mx2_x1_x2_XM30 x2_x1_x2_G_OUT_P x2_x1_net4 x2_x1_x2_net6 VDD pfet_06v0 L=1.0u W=10u
Mx2_x1_x2_XM31 x2_x1_x2_net3 x2_x1_x2_net9 VDD VDD pfet_06v0 L=1.0u W=5u
Mx2_x1_x2_XM35 x2_x1_x2_net6 x2_x1_x2_net9 VDD VDD pfet_06v0 L=1.0u W=5u
Mx2_x1_x2_XM32 x2_x1_x2_net10 x2_x1_x2_net20 x2_x1_x2_net9 VDD pfet_06v0 L=1.0u W=4.0u
Mx2_x1_x2_XM33 x2_x1_x2_net21 x2_x1_x2_net20 x2_x1_x2_G_OUT_P VDD pfet_06v0 L=1.0u W=4.0u
Mx2_x1_x2_XM23 x2_x1_x2_net10 x2_x1_net2 x2_x1_x2_net4 VSS nfet_06v0 L=1.0u W=2.5u
Mx2_x1_x2_XM24 x2_x1_x2_net21 x2_x1_net2 x2_x1_x2_net5 VSS nfet_06v0 L=1.0u W=2.5u
Mx2_x1_x2_XM25 x2_x1_x2_net4 x2_x1_x2_net10 VSS VSS nfet_06v0 L=1.0u W=2.5u
Mx2_x1_x2_XM26 x2_x1_x2_net5 x2_x1_x2_net10 VSS VSS nfet_06v0 L=1.0u W=2.5u
Mx2_x1_x2_XM27 x2_x1_x2_net9 x2_x1_x2_net11 x2_x1_x2_net10 VSS nfet_06v0 L=1.0u W=2.0u
Mx2_x1_x2_XM28 x2_x1_x2_G_OUT_P x2_x1_x2_net11 x2_x1_x2_net21 VSS nfet_06v0 L=1.0u W=2.0u
Mx2_x1_x2_XM34 x2_x1_x2_net12 x2_x1_x2_net13 VDD VDD pfet_06v0 L=1.0u W=10.0u
Mx2_x1_x2_XM36 x2_x1_x2_net13 x2_x1_net4 x2_x1_x2_net12 VDD pfet_06v0 L=1.0u W=10.0u
Mx2_x1_x2_XM37 x2_x1_x2_net20 x2_x1_x2_net20 x2_x1_x2_net13 VDD pfet_06v0 L=1.0u W=10.0u
Mx2_x1_x2_XM38 x2_x1_x2_net20 x2_x1_net2 x2_x1_x2_net14 VSS nfet_06v0 L=1.0u W=5.0u
Mx2_x1_x2_XM39 x2_x1_x2_net14 x2_x1_net1 VSS VSS nfet_06v0 L=1.0u W=5.0u
Mx2_x1_x2_XM45 x2_x1_x2_net15 x2_x1_net3 VDD VDD pfet_06v0 L=1.0u W=10.0u
Mx2_x1_x2_XM46 x2_x1_x2_net11 x2_x1_net4 x2_x1_x2_net15 VDD pfet_06v0 L=1.0u W=10.0u
Mx2_x1_x2_XM40 x2_x1_x2_net11 x2_x1_x2_net11 x2_x1_x2_net17 VSS nfet_06v0 L=1.0u W=5.0u
Mx2_x1_x2_XM41 x2_x1_x2_net17 x2_x1_net2 x2_x1_x2_net16 VSS nfet_06v0 L=1.0u W=5.0u
Mx2_x1_x2_XM42 x2_x1_x2_net16 x2_x1_x2_net17 VSS VSS nfet_06v0 L=1.0u W=5.0u
Mx2_x1_x2_XM43_m1 x2_SY x2_x1_x2_G_OUT_P VDD VDD pfet_06v0 L=1.0u W=1.0u
Mx2_x1_x2_XM43_m2 x2_SY x2_x1_x2_G_OUT_P VDD VDD pfet_06v0 L=1.0u W=1.0u
Mx2_x1_x2_XM43_m3 x2_SY x2_x1_x2_G_OUT_P VDD VDD pfet_06v0 L=1.0u W=1.0u
Mx2_x1_x2_XM43_m4 x2_SY x2_x1_x2_G_OUT_P VDD VDD pfet_06v0 L=1.0u W=1.0u
Mx2_x1_x2_XM44 x2_SY x2_x1_x2_net21 VSS VSS nfet_06v0 L=1.0u W=1.0u
Mx2_x2_x1_XM4 x2_x2_x1_net3 x2_x2_net3 VDD VDD pfet_06v0 L=1.0u W=10.0u
Mx2_x2_x1_XM5 x2_x2_net2 x2_x2_net4 x2_x2_x1_net3 VDD pfet_06v0 L=1.0u W=10.0u
Mx2_x2_x1_XM6 x2_x2_net2 x2_x2_net2 VSS VSS nfet_06v0 L=1.0u W=1.0u
Mx2_x2_x1_XM7 x2_x2_x1_net2 x2_x2_net3 VDD VDD pfet_06v0 L=1.0u W=10.0u
Mx2_x2_x1_XM8 x2_x2_net1 x2_x2_net4 x2_x2_x1_net2 VDD pfet_06v0 L=1.0u W=10.0u
Mx2_x2_x1_XM9 x2_x2_net1 x2_x2_net2 x2_x2_x1_net1 VSS nfet_06v0 L=1.0u W=5.0u
Mx2_x2_x1_XM10 x2_x2_x1_net1 x2_x2_net1 VSS VSS nfet_06v0 L=1.0u W=5.0u
Mx2_x2_x1_XM1 x2_x2_net4 x2_x2_net4 VDD VDD pfet_06v0 L=1.0u W=2u
Mx2_x2_x1_XM2 x2_x2_x1_net4 x2_x2_net3 VDD VDD pfet_06v0 L=1.0u W=10.0u
Mx2_x2_x1_XM3 x2_x2_net3 x2_x2_net4 x2_x2_x1_net4 VDD pfet_06v0 L=1.0u W=10.0u
Mx2_x2_x1_XM47 x2_x2_x1_net5 x2_x2_net4 VSS VSS nfet_06v0 L=1.0u W=1.0u
Mx2_x2_x1_XM48 x2_x2_x1_net6 x2_x2_net4 VSS VSS nfet_06v0 L=1.0u W=1.0u
Mx2_x2_x1_XM49 x2_x2_net4 x2_x2_net4 x2_x2_x1_net6 VSS nfet_06v0 L=1.0u W=1.0u
Mx2_x2_x1_XM50 x2_x2_net3 x2_x2_net4 x2_x2_x1_net5 VSS nfet_06v0 L=1.0u W=1.0u
Mx2_x2_x2_XM11 x2_x2_x2_net2 x2_x2_net3 VDD VDD pfet_06v0 L=1.0u W=10.0u
Mx2_x2_x2_XM12 x2_x2_x2_net7 x2_x2_net4 x2_x2_x2_net2 VDD pfet_06v0 L=1.0u W=10.0u
Mx2_x2_x2_XM13 x2_x2_x2_net18 x2_x2_net3 VDD VDD pfet_06v0 L=1.0u W=10.0u
Mx2_x2_x2_XM14 x2_x2_x2_net7 x2_x2_net4 x2_x2_x2_net18 VDD pfet_06v0 L=1.0u W=10.0u
Mx2_x2_x2_XM15 x2_x2_x2_net5 S2P x2_x2_x2_net7 VDD pfet_06v0 L=1.0u W=0.55u
Mx2_x2_x2_XM16 x2_x2_x2_net4 S2N x2_x2_x2_net7 VDD pfet_06v0 L=1.0u W=0.5u
Mx2_x2_x2_XM17 x2_x2_x2_net8 x2_x2_net2 x2_x2_x2_net1 VSS nfet_06v0 L=1.0u W=5.0u
Mx2_x2_x2_XM18 x2_x2_x2_net1 x2_x2_net1 VSS VSS nfet_06v0 L=1.0u W=5.0u
Mx2_x2_x2_XM19 x2_x2_x2_net8 x2_x2_net2 x2_x2_x2_net19 VSS nfet_06v0 L=1.0u W=5.0u
Mx2_x2_x2_XM20 x2_x2_x2_net19 x2_x2_net1 VSS VSS nfet_06v0 L=1.0u W=5.0u
Mx2_x2_x2_XM21 x2_x2_x2_net6 S2P x2_x2_x2_net8 VSS nfet_06v0 L=1.0u W=7.5u
Mx2_x2_x2_XM22 x2_x2_x2_net3 S2N x2_x2_x2_net8 VSS nfet_06v0 L=1.0u W=8.5u
Mx2_x2_x2_XM29 x2_x2_x2_net9 x2_x2_net4 x2_x2_x2_net3 VDD pfet_06v0 L=1.0u W=10u
Mx2_x2_x2_XM30 x2_x2_x2_G_OUT_P x2_x2_net4 x2_x2_x2_net6 VDD pfet_06v0 L=1.0u W=10u
Mx2_x2_x2_XM31 x2_x2_x2_net3 x2_x2_x2_net9 VDD VDD pfet_06v0 L=1.0u W=5u
Mx2_x2_x2_XM35 x2_x2_x2_net6 x2_x2_x2_net9 VDD VDD pfet_06v0 L=1.0u W=5u
Mx2_x2_x2_XM32 x2_x2_x2_net10 x2_x2_x2_net20 x2_x2_x2_net9 VDD pfet_06v0 L=1.0u W=4.0u
Mx2_x2_x2_XM33 x2_x2_x2_net21 x2_x2_x2_net20 x2_x2_x2_G_OUT_P VDD pfet_06v0 L=1.0u W=4.0u
Mx2_x2_x2_XM23 x2_x2_x2_net10 x2_x2_net2 x2_x2_x2_net4 VSS nfet_06v0 L=1.0u W=2.5u
Mx2_x2_x2_XM24 x2_x2_x2_net21 x2_x2_net2 x2_x2_x2_net5 VSS nfet_06v0 L=1.0u W=2.5u
Mx2_x2_x2_XM25 x2_x2_x2_net4 x2_x2_x2_net10 VSS VSS nfet_06v0 L=1.0u W=2.5u
Mx2_x2_x2_XM26 x2_x2_x2_net5 x2_x2_x2_net10 VSS VSS nfet_06v0 L=1.0u W=2.5u
Mx2_x2_x2_XM27 x2_x2_x2_net9 x2_x2_x2_net11 x2_x2_x2_net10 VSS nfet_06v0 L=1.0u W=2.0u
Mx2_x2_x2_XM28 x2_x2_x2_G_OUT_P x2_x2_x2_net11 x2_x2_x2_net21 VSS nfet_06v0 L=1.0u W=2.0u
Mx2_x2_x2_XM34 x2_x2_x2_net12 x2_x2_x2_net13 VDD VDD pfet_06v0 L=1.0u W=10.0u
Mx2_x2_x2_XM36 x2_x2_x2_net13 x2_x2_net4 x2_x2_x2_net12 VDD pfet_06v0 L=1.0u W=10.0u
Mx2_x2_x2_XM37 x2_x2_x2_net20 x2_x2_x2_net20 x2_x2_x2_net13 VDD pfet_06v0 L=1.0u W=10.0u
Mx2_x2_x2_XM38 x2_x2_x2_net20 x2_x2_net2 x2_x2_x2_net14 VSS nfet_06v0 L=1.0u W=5.0u
Mx2_x2_x2_XM39 x2_x2_x2_net14 x2_x2_net1 VSS VSS nfet_06v0 L=1.0u W=5.0u
Mx2_x2_x2_XM45 x2_x2_x2_net15 x2_x2_net3 VDD VDD pfet_06v0 L=1.0u W=10.0u
Mx2_x2_x2_XM46 x2_x2_x2_net11 x2_x2_net4 x2_x2_x2_net15 VDD pfet_06v0 L=1.0u W=10.0u
Mx2_x2_x2_XM40 x2_x2_x2_net11 x2_x2_x2_net11 x2_x2_x2_net17 VSS nfet_06v0 L=1.0u W=5.0u
Mx2_x2_x2_XM41 x2_x2_x2_net17 x2_x2_net2 x2_x2_x2_net16 VSS nfet_06v0 L=1.0u W=5.0u
Mx2_x2_x2_XM42 x2_x2_x2_net16 x2_x2_x2_net17 VSS VSS nfet_06v0 L=1.0u W=5.0u
Mx2_x2_x2_XM43_m1 x2_SZ x2_x2_x2_G_OUT_P VDD VDD pfet_06v0 L=1.0u W=1.0u
Mx2_x2_x2_XM43_m2 x2_SZ x2_x2_x2_G_OUT_P VDD VDD pfet_06v0 L=1.0u W=1.0u
Mx2_x2_x2_XM43_m3 x2_SZ x2_x2_x2_G_OUT_P VDD VDD pfet_06v0 L=1.0u W=1.0u
Mx2_x2_x2_XM43_m4 x2_SZ x2_x2_x2_G_OUT_P VDD VDD pfet_06v0 L=1.0u W=1.0u
Mx2_x2_x2_XM44 x2_SZ x2_x2_x2_net21 VSS VSS nfet_06v0 L=1.0u W=1.0u
Mx3_x4_x1_XM4 x3_x4_x1_net3 x3_x4_net4 VDD VDD pfet_06v0 L=1.0u W=10.0u
Mx3_x4_x1_XM5 x3_x4_net2 x3_x4_net3 x3_x4_x1_net3 VDD pfet_06v0 L=1.0u W=10.0u
Mx3_x4_x1_XM6 x3_x4_net2 x3_x4_net2 VSS VSS nfet_06v0 L=1.0u W=1.0u
Mx3_x4_x1_XM7 x3_x4_x1_net2 x3_x4_net4 VDD VDD pfet_06v0 L=1.0u W=10.0u
Mx3_x4_x1_XM8 x3_x4_net1 x3_x4_net3 x3_x4_x1_net2 VDD pfet_06v0 L=1.0u W=10.0u
Mx3_x4_x1_XM9 x3_x4_net1 x3_x4_net2 x3_x4_x1_net1 VSS nfet_06v0 L=1.0u W=5.0u
Mx3_x4_x1_XM10 x3_x4_x1_net1 x3_x4_net1 VSS VSS nfet_06v0 L=1.0u W=5.0u
Mx3_x4_x1_XM1 x3_x4_net3 x3_x4_net3 VDD VDD pfet_06v0 L=1.0u W=2u
Mx3_x4_x1_XM2 x3_x4_x1_net4 x3_x4_net4 VDD VDD pfet_06v0 L=1.0u W=10.0u
Mx3_x4_x1_XM3 x3_x4_net4 x3_x4_net3 x3_x4_x1_net4 VDD pfet_06v0 L=1.0u W=10.0u
Mx3_x4_x1_XM47 x3_x4_x1_net5 x3_x4_net3 VSS VSS nfet_06v0 L=1.0u W=1.0u
Mx3_x4_x1_XM48 x3_x4_x1_net6 x3_x4_net3 VSS VSS nfet_06v0 L=1.0u W=1.0u
Mx3_x4_x1_XM49 x3_x4_net3 x3_x4_net3 x3_x4_x1_net6 VSS nfet_06v0 L=1.0u W=1.0u
Mx3_x4_x1_XM50 x3_x4_net4 x3_x4_net3 x3_x4_x1_net5 VSS nfet_06v0 L=1.0u W=1.0u
Mx3_x4_x2_XM11 x3_x4_x2_net2 x3_x4_net4 VDD VDD pfet_06v0 L=1.0u W=10.0u
Mx3_x4_x2_XM12 x3_x4_x2_net7 x3_x4_net3 x3_x4_x2_net2 VDD pfet_06v0 L=1.0u W=10.0u
Mx3_x4_x2_XM13 x3_x4_x2_net19 x3_x4_net4 VDD VDD pfet_06v0 L=1.0u W=10.0u
Mx3_x4_x2_XM14 x3_x4_x2_net7 x3_x4_net3 x3_x4_x2_net19 VDD pfet_06v0 L=1.0u W=10.0u
Mx3_x4_x2_XM15_f1 x3_x4_x2_net5 x3_SY x3_x4_x2_net7 VDD pfet_06v0 L=1.0u W=10.0u
Mx3_x4_x2_XM15_f2 x3_x4_x2_net5 x3_SY x3_x4_x2_net7 VDD pfet_06v0 L=1.0u W=10.0u
Mx3_x4_x2_XM16_f1 x3_x4_x2_net4 x3_SX x3_x4_x2_net7 VDD pfet_06v0 L=1.0u W=10.0u
Mx3_x4_x2_XM16_f2 x3_x4_x2_net4 x3_SX x3_x4_x2_net7 VDD pfet_06v0 L=1.0u W=10.0u
Mx3_x4_x2_XM17 x3_x4_x2_net8 x3_x4_net2 x3_x4_x2_net1 VSS nfet_06v0 L=1.0u W=5.0u
Mx3_x4_x2_XM18 x3_x4_x2_net1 x3_x4_net1 VSS VSS nfet_06v0 L=1.0u W=5.0u
Mx3_x4_x2_XM19 x3_x4_x2_net8 x3_x4_net2 x3_x4_x2_net20 VSS nfet_06v0 L=1.0u W=5.0u
Mx3_x4_x2_XM20 x3_x4_x2_net20 x3_x4_net1 VSS VSS nfet_06v0 L=1.0u W=5.0u
Mx3_x4_x2_XM21_f1 x3_x4_x2_net6 x3_SY x3_x4_x2_net8 VSS nfet_06v0 L=1.0u W=5u
Mx3_x4_x2_XM21_f2 x3_x4_x2_net6 x3_SY x3_x4_x2_net8 VSS nfet_06v0 L=1.0u W=5u
Mx3_x4_x2_XM22_f1 x3_x4_x2_net3 x3_SX x3_x4_x2_net8 VSS nfet_06v0 L=1.0u W=5u
Mx3_x4_x2_XM22_f2 x3_x4_x2_net3 x3_SX x3_x4_x2_net8 VSS nfet_06v0 L=1.0u W=5u
Mx3_x4_x2_XM29_f1 x3_x4_x2_net9 x3_x4_net3 x3_x4_x2_net3 VDD pfet_06v0 L=1.0u W=5u
Mx3_x4_x2_XM29_f2 x3_x4_x2_net9 x3_x4_net3 x3_x4_x2_net3 VDD pfet_06v0 L=1.0u W=5u
Mx3_x4_x2_XM30_f1 x3_x4_x2_net12 x3_x4_net3 x3_x4_x2_net6 VDD pfet_06v0 L=1.0u W=5.0u
Mx3_x4_x2_XM30_f2 x3_x4_x2_net12 x3_x4_net3 x3_x4_x2_net6 VDD pfet_06v0 L=1.0u W=5.0u
Mx3_x4_x2_XM31_f1 x3_x4_x2_net3 x3_x4_x2_net9 VDD VDD pfet_06v0 L=1.0u W=5u
Mx3_x4_x2_XM31_f2 x3_x4_x2_net3 x3_x4_x2_net9 VDD VDD pfet_06v0 L=1.0u W=5u
Mx3_x4_x2_XM31_f3 x3_x4_x2_net3 x3_x4_x2_net9 VDD VDD pfet_06v0 L=1.0u W=5u
Mx3_x4_x2_XM31_f4 x3_x4_x2_net3 x3_x4_x2_net9 VDD VDD pfet_06v0 L=1.0u W=5u
Mx3_x4_x2_XM35_f1 x3_x4_x2_net6 x3_x4_x2_net9 VDD VDD pfet_06v0 L=1.0u W=5.0u
Mx3_x4_x2_XM35_f2 x3_x4_x2_net6 x3_x4_x2_net9 VDD VDD pfet_06v0 L=1.0u W=5.0u
Mx3_x4_x2_XM35_f3 x3_x4_x2_net6 x3_x4_x2_net9 VDD VDD pfet_06v0 L=1.0u W=5.0u
Mx3_x4_x2_XM35_f4 x3_x4_x2_net6 x3_x4_x2_net9 VDD VDD pfet_06v0 L=1.0u W=5.0u
Mx3_x4_x2_XM32 x3_x4_x2_net10 x3_x4_x2_net21 x3_x4_x2_net9 VDD pfet_06v0 L=1.0u W=5u
Mx3_x4_x2_XM33 x3_x4_x2_net22 x3_x4_x2_net21 x3_x4_x2_net12 VDD pfet_06v0 L=1.0u W=5.0u
Mx3_x4_x2_XM23_f1 x3_x4_x2_net10 x3_x4_net2 x3_x4_x2_net4 VSS nfet_06v0 L=1.0u W=2.5u
Mx3_x4_x2_XM23_f2 x3_x4_x2_net10 x3_x4_net2 x3_x4_x2_net4 VSS nfet_06v0 L=1.0u W=2.5u
Mx3_x4_x2_XM24_f1 x3_x4_x2_net22 x3_x4_net2 x3_x4_x2_net5 VSS nfet_06v0 L=1.0u W=2.5u
Mx3_x4_x2_XM24_f2 x3_x4_x2_net22 x3_x4_net2 x3_x4_x2_net5 VSS nfet_06v0 L=1.0u W=2.5u
Mx3_x4_x2_XM25_f1 x3_x4_x2_net4 x3_x4_x2_net10 VSS VSS nfet_06v0 L=1.0u W=2.5u
Mx3_x4_x2_XM25_f2 x3_x4_x2_net4 x3_x4_x2_net10 VSS VSS nfet_06v0 L=1.0u W=2.5u
Mx3_x4_x2_XM25_f3 x3_x4_x2_net4 x3_x4_x2_net10 VSS VSS nfet_06v0 L=1.0u W=2.5u
Mx3_x4_x2_XM25_f4 x3_x4_x2_net4 x3_x4_x2_net10 VSS VSS nfet_06v0 L=1.0u W=2.5u
Mx3_x4_x2_XM26_f1 x3_x4_x2_net5 x3_x4_x2_net10 VSS VSS nfet_06v0 L=1.0u W=2.5u
Mx3_x4_x2_XM26_f2 x3_x4_x2_net5 x3_x4_x2_net10 VSS VSS nfet_06v0 L=1.0u W=2.5u
Mx3_x4_x2_XM26_f3 x3_x4_x2_net5 x3_x4_x2_net10 VSS VSS nfet_06v0 L=1.0u W=2.5u
Mx3_x4_x2_XM26_f4 x3_x4_x2_net5 x3_x4_x2_net10 VSS VSS nfet_06v0 L=1.0u W=2.5u
Mx3_x4_x2_XM27 x3_x4_x2_net9 x3_x4_x2_net11 x3_x4_x2_net10 VSS nfet_06v0 L=1.0u W=2.5u
Mx3_x4_x2_XM28 x3_x4_x2_net12 x3_x4_x2_net11 x3_x4_x2_net22 VSS nfet_06v0 L=1.0u W=2.5u
Mx3_x4_x2_XM34 x3_x4_x2_net13 x3_x4_x2_net14 VDD VDD pfet_06v0 L=1.0u W=10.0u
Mx3_x4_x2_XM36 x3_x4_x2_net14 x3_x4_net3 x3_x4_x2_net13 VDD pfet_06v0 L=1.0u W=10.0u
Mx3_x4_x2_XM37 x3_x4_x2_net21 x3_x4_x2_net21 x3_x4_x2_net14 VDD pfet_06v0 L=1.0u W=10.0u
Mx3_x4_x2_XM38 x3_x4_x2_net21 x3_x4_net2 x3_x4_x2_net15 VSS nfet_06v0 L=1.0u W=5.0u
Mx3_x4_x2_XM39 x3_x4_x2_net15 x3_x4_net1 VSS VSS nfet_06v0 L=1.0u W=5.0u
Mx3_x4_x2_XM45 x3_x4_x2_net16 x3_x4_net4 VDD VDD pfet_06v0 L=1.0u W=10.0u
Mx3_x4_x2_XM46 x3_x4_x2_net11 x3_x4_net3 x3_x4_x2_net16 VDD pfet_06v0 L=1.0u W=10.0u
Mx3_x4_x2_XM40 x3_x4_x2_net11 x3_x4_x2_net11 x3_x4_x2_net18 VSS nfet_06v0 L=1.0u W=5.0u
Mx3_x4_x2_XM41 x3_x4_x2_net18 x3_x4_net2 x3_x4_x2_net17 VSS nfet_06v0 L=1.0u W=5.0u
Mx3_x4_x2_XM42 x3_x4_x2_net17 x3_x4_x2_net18 VSS VSS nfet_06v0 L=1.0u W=5.0u
Mx3_x4_x2_XM43_f1 x3_net1 x3_x4_x2_net12 VDD VDD pfet_06v0 L=1.0u W=10u
Mx3_x4_x2_XM43_f2 x3_net1 x3_x4_x2_net12 VDD VDD pfet_06v0 L=1.0u W=10u
Mx3_x4_x2_XM43_f3 x3_net1 x3_x4_x2_net12 VDD VDD pfet_06v0 L=1.0u W=10u
Mx3_x4_x2_XM44_f1 x3_net1 x3_x4_x2_net22 VSS VSS nfet_06v0 L=1.0u W=5u
Mx3_x4_x2_XM44_f2 x3_net1 x3_x4_x2_net22 VSS VSS nfet_06v0 L=1.0u W=5u
Mx3_x4_x2_XM44_f3 x3_net1 x3_x4_x2_net22 VSS VSS nfet_06v0 L=1.0u W=5u
Mx3_x5_x1_XM4 x3_x5_x1_net3 x3_x5_net4 VDD VDD pfet_06v0 L=1.0u W=10.0u
Mx3_x5_x1_XM5 x3_x5_net2 x3_x5_net3 x3_x5_x1_net3 VDD pfet_06v0 L=1.0u W=10.0u
Mx3_x5_x1_XM6 x3_x5_net2 x3_x5_net2 VSS VSS nfet_06v0 L=1.0u W=1.0u
Mx3_x5_x1_XM7 x3_x5_x1_net2 x3_x5_net4 VDD VDD pfet_06v0 L=1.0u W=10.0u
Mx3_x5_x1_XM8 x3_x5_net1 x3_x5_net3 x3_x5_x1_net2 VDD pfet_06v0 L=1.0u W=10.0u
Mx3_x5_x1_XM9 x3_x5_net1 x3_x5_net2 x3_x5_x1_net1 VSS nfet_06v0 L=1.0u W=5.0u
Mx3_x5_x1_XM10 x3_x5_x1_net1 x3_x5_net1 VSS VSS nfet_06v0 L=1.0u W=5.0u
Mx3_x5_x1_XM1 x3_x5_net3 x3_x5_net3 VDD VDD pfet_06v0 L=1.0u W=2u
Mx3_x5_x1_XM2 x3_x5_x1_net4 x3_x5_net4 VDD VDD pfet_06v0 L=1.0u W=10.0u
Mx3_x5_x1_XM3 x3_x5_net4 x3_x5_net3 x3_x5_x1_net4 VDD pfet_06v0 L=1.0u W=10.0u
Mx3_x5_x1_XM47 x3_x5_x1_net5 x3_x5_net3 VSS VSS nfet_06v0 L=1.0u W=1.0u
Mx3_x5_x1_XM48 x3_x5_x1_net6 x3_x5_net3 VSS VSS nfet_06v0 L=1.0u W=1.0u
Mx3_x5_x1_XM49 x3_x5_net3 x3_x5_net3 x3_x5_x1_net6 VSS nfet_06v0 L=1.0u W=1.0u
Mx3_x5_x1_XM50 x3_x5_net4 x3_x5_net3 x3_x5_x1_net5 VSS nfet_06v0 L=1.0u W=1.0u
Mx3_x5_x2_XM11 x3_x5_x2_net2 x3_x5_net4 VDD VDD pfet_06v0 L=1.0u W=10.0u
Mx3_x5_x2_XM12 x3_x5_x2_net7 x3_x5_net3 x3_x5_x2_net2 VDD pfet_06v0 L=1.0u W=10.0u
Mx3_x5_x2_XM13 x3_x5_x2_net19 x3_x5_net4 VDD VDD pfet_06v0 L=1.0u W=10.0u
Mx3_x5_x2_XM14 x3_x5_x2_net7 x3_x5_net3 x3_x5_x2_net19 VDD pfet_06v0 L=1.0u W=10.0u
Mx3_x5_x2_XM15_f1 x3_x5_x2_net5 x3_SZ x3_x5_x2_net7 VDD pfet_06v0 L=1.0u W=10.0u
Mx3_x5_x2_XM15_f2 x3_x5_x2_net5 x3_SZ x3_x5_x2_net7 VDD pfet_06v0 L=1.0u W=10.0u
Mx3_x5_x2_XM16_f1 x3_x5_x2_net4 x3_SX x3_x5_x2_net7 VDD pfet_06v0 L=1.0u W=10.0u
Mx3_x5_x2_XM16_f2 x3_x5_x2_net4 x3_SX x3_x5_x2_net7 VDD pfet_06v0 L=1.0u W=10.0u
Mx3_x5_x2_XM17 x3_x5_x2_net8 x3_x5_net2 x3_x5_x2_net1 VSS nfet_06v0 L=1.0u W=5.0u
Mx3_x5_x2_XM18 x3_x5_x2_net1 x3_x5_net1 VSS VSS nfet_06v0 L=1.0u W=5.0u
Mx3_x5_x2_XM19 x3_x5_x2_net8 x3_x5_net2 x3_x5_x2_net20 VSS nfet_06v0 L=1.0u W=5.0u
Mx3_x5_x2_XM20 x3_x5_x2_net20 x3_x5_net1 VSS VSS nfet_06v0 L=1.0u W=5.0u
Mx3_x5_x2_XM21_f1 x3_x5_x2_net6 x3_SZ x3_x5_x2_net8 VSS nfet_06v0 L=1.0u W=5u
Mx3_x5_x2_XM21_f2 x3_x5_x2_net6 x3_SZ x3_x5_x2_net8 VSS nfet_06v0 L=1.0u W=5u
Mx3_x5_x2_XM22_f1 x3_x5_x2_net3 x3_SX x3_x5_x2_net8 VSS nfet_06v0 L=1.0u W=5u
Mx3_x5_x2_XM22_f2 x3_x5_x2_net3 x3_SX x3_x5_x2_net8 VSS nfet_06v0 L=1.0u W=5u
Mx3_x5_x2_XM29_f1 x3_x5_x2_net9 x3_x5_net3 x3_x5_x2_net3 VDD pfet_06v0 L=1.0u W=5u
Mx3_x5_x2_XM29_f2 x3_x5_x2_net9 x3_x5_net3 x3_x5_x2_net3 VDD pfet_06v0 L=1.0u W=5u
Mx3_x5_x2_XM30_f1 x3_x5_x2_net12 x3_x5_net3 x3_x5_x2_net6 VDD pfet_06v0 L=1.0u W=5.0u
Mx3_x5_x2_XM30_f2 x3_x5_x2_net12 x3_x5_net3 x3_x5_x2_net6 VDD pfet_06v0 L=1.0u W=5.0u
Mx3_x5_x2_XM31_f1 x3_x5_x2_net3 x3_x5_x2_net9 VDD VDD pfet_06v0 L=1.0u W=5u
Mx3_x5_x2_XM31_f2 x3_x5_x2_net3 x3_x5_x2_net9 VDD VDD pfet_06v0 L=1.0u W=5u
Mx3_x5_x2_XM31_f3 x3_x5_x2_net3 x3_x5_x2_net9 VDD VDD pfet_06v0 L=1.0u W=5u
Mx3_x5_x2_XM31_f4 x3_x5_x2_net3 x3_x5_x2_net9 VDD VDD pfet_06v0 L=1.0u W=5u
Mx3_x5_x2_XM35_f1 x3_x5_x2_net6 x3_x5_x2_net9 VDD VDD pfet_06v0 L=1.0u W=5.0u
Mx3_x5_x2_XM35_f2 x3_x5_x2_net6 x3_x5_x2_net9 VDD VDD pfet_06v0 L=1.0u W=5.0u
Mx3_x5_x2_XM35_f3 x3_x5_x2_net6 x3_x5_x2_net9 VDD VDD pfet_06v0 L=1.0u W=5.0u
Mx3_x5_x2_XM35_f4 x3_x5_x2_net6 x3_x5_x2_net9 VDD VDD pfet_06v0 L=1.0u W=5.0u
Mx3_x5_x2_XM32 x3_x5_x2_net10 x3_x5_x2_net21 x3_x5_x2_net9 VDD pfet_06v0 L=1.0u W=5u
Mx3_x5_x2_XM33 x3_x5_x2_net22 x3_x5_x2_net21 x3_x5_x2_net12 VDD pfet_06v0 L=1.0u W=5.0u
Mx3_x5_x2_XM23_f1 x3_x5_x2_net10 x3_x5_net2 x3_x5_x2_net4 VSS nfet_06v0 L=1.0u W=2.5u
Mx3_x5_x2_XM23_f2 x3_x5_x2_net10 x3_x5_net2 x3_x5_x2_net4 VSS nfet_06v0 L=1.0u W=2.5u
Mx3_x5_x2_XM24_f1 x3_x5_x2_net22 x3_x5_net2 x3_x5_x2_net5 VSS nfet_06v0 L=1.0u W=2.5u
Mx3_x5_x2_XM24_f2 x3_x5_x2_net22 x3_x5_net2 x3_x5_x2_net5 VSS nfet_06v0 L=1.0u W=2.5u
Mx3_x5_x2_XM25_f1 x3_x5_x2_net4 x3_x5_x2_net10 VSS VSS nfet_06v0 L=1.0u W=2.5u
Mx3_x5_x2_XM25_f2 x3_x5_x2_net4 x3_x5_x2_net10 VSS VSS nfet_06v0 L=1.0u W=2.5u
Mx3_x5_x2_XM25_f3 x3_x5_x2_net4 x3_x5_x2_net10 VSS VSS nfet_06v0 L=1.0u W=2.5u
Mx3_x5_x2_XM25_f4 x3_x5_x2_net4 x3_x5_x2_net10 VSS VSS nfet_06v0 L=1.0u W=2.5u
Mx3_x5_x2_XM26_f1 x3_x5_x2_net5 x3_x5_x2_net10 VSS VSS nfet_06v0 L=1.0u W=2.5u
Mx3_x5_x2_XM26_f2 x3_x5_x2_net5 x3_x5_x2_net10 VSS VSS nfet_06v0 L=1.0u W=2.5u
Mx3_x5_x2_XM26_f3 x3_x5_x2_net5 x3_x5_x2_net10 VSS VSS nfet_06v0 L=1.0u W=2.5u
Mx3_x5_x2_XM26_f4 x3_x5_x2_net5 x3_x5_x2_net10 VSS VSS nfet_06v0 L=1.0u W=2.5u
Mx3_x5_x2_XM27 x3_x5_x2_net9 x3_x5_x2_net11 x3_x5_x2_net10 VSS nfet_06v0 L=1.0u W=2.5u
Mx3_x5_x2_XM28 x3_x5_x2_net12 x3_x5_x2_net11 x3_x5_x2_net22 VSS nfet_06v0 L=1.0u W=2.5u
Mx3_x5_x2_XM34 x3_x5_x2_net13 x3_x5_x2_net14 VDD VDD pfet_06v0 L=1.0u W=10.0u
Mx3_x5_x2_XM36 x3_x5_x2_net14 x3_x5_net3 x3_x5_x2_net13 VDD pfet_06v0 L=1.0u W=10.0u
Mx3_x5_x2_XM37 x3_x5_x2_net21 x3_x5_x2_net21 x3_x5_x2_net14 VDD pfet_06v0 L=1.0u W=10.0u
Mx3_x5_x2_XM38 x3_x5_x2_net21 x3_x5_net2 x3_x5_x2_net15 VSS nfet_06v0 L=1.0u W=5.0u
Mx3_x5_x2_XM39 x3_x5_x2_net15 x3_x5_net1 VSS VSS nfet_06v0 L=1.0u W=5.0u
Mx3_x5_x2_XM45 x3_x5_x2_net16 x3_x5_net4 VDD VDD pfet_06v0 L=1.0u W=10.0u
Mx3_x5_x2_XM46 x3_x5_x2_net11 x3_x5_net3 x3_x5_x2_net16 VDD pfet_06v0 L=1.0u W=10.0u
Mx3_x5_x2_XM40 x3_x5_x2_net11 x3_x5_x2_net11 x3_x5_x2_net18 VSS nfet_06v0 L=1.0u W=5.0u
Mx3_x5_x2_XM41 x3_x5_x2_net18 x3_x5_net2 x3_x5_x2_net17 VSS nfet_06v0 L=1.0u W=5.0u
Mx3_x5_x2_XM42 x3_x5_x2_net17 x3_x5_x2_net18 VSS VSS nfet_06v0 L=1.0u W=5.0u
Mx3_x5_x2_XM43_f1 x3_net2 x3_x5_x2_net12 VDD VDD pfet_06v0 L=1.0u W=10u
Mx3_x5_x2_XM43_f2 x3_net2 x3_x5_x2_net12 VDD VDD pfet_06v0 L=1.0u W=10u
Mx3_x5_x2_XM43_f3 x3_net2 x3_x5_x2_net12 VDD VDD pfet_06v0 L=1.0u W=10u
Mx3_x5_x2_XM44_f1 x3_net2 x3_x5_x2_net22 VSS VSS nfet_06v0 L=1.0u W=5u
Mx3_x5_x2_XM44_f2 x3_net2 x3_x5_x2_net22 VSS VSS nfet_06v0 L=1.0u W=5u
Mx3_x5_x2_XM44_f3 x3_net2 x3_x5_x2_net22 VSS VSS nfet_06v0 L=1.0u W=5u
Mx3_x6_x1_XM4 x3_x6_x1_net3 x3_x6_net4 VDD VDD pfet_06v0 L=1.0u W=10.0u
Mx3_x6_x1_XM5 x3_x6_net2 x3_x6_net3 x3_x6_x1_net3 VDD pfet_06v0 L=1.0u W=10.0u
Mx3_x6_x1_XM6 x3_x6_net2 x3_x6_net2 VSS VSS nfet_06v0 L=1.0u W=1.0u
Mx3_x6_x1_XM7 x3_x6_x1_net2 x3_x6_net4 VDD VDD pfet_06v0 L=1.0u W=10.0u
Mx3_x6_x1_XM8 x3_x6_net1 x3_x6_net3 x3_x6_x1_net2 VDD pfet_06v0 L=1.0u W=10.0u
Mx3_x6_x1_XM9 x3_x6_net1 x3_x6_net2 x3_x6_x1_net1 VSS nfet_06v0 L=1.0u W=5.0u
Mx3_x6_x1_XM10 x3_x6_x1_net1 x3_x6_net1 VSS VSS nfet_06v0 L=1.0u W=5.0u
Mx3_x6_x1_XM1 x3_x6_net3 x3_x6_net3 VDD VDD pfet_06v0 L=1.0u W=2u
Mx3_x6_x1_XM2 x3_x6_x1_net4 x3_x6_net4 VDD VDD pfet_06v0 L=1.0u W=10.0u
Mx3_x6_x1_XM3 x3_x6_net4 x3_x6_net3 x3_x6_x1_net4 VDD pfet_06v0 L=1.0u W=10.0u
Mx3_x6_x1_XM47 x3_x6_x1_net5 x3_x6_net3 VSS VSS nfet_06v0 L=1.0u W=1.0u
Mx3_x6_x1_XM48 x3_x6_x1_net6 x3_x6_net3 VSS VSS nfet_06v0 L=1.0u W=1.0u
Mx3_x6_x1_XM49 x3_x6_net3 x3_x6_net3 x3_x6_x1_net6 VSS nfet_06v0 L=1.0u W=1.0u
Mx3_x6_x1_XM50 x3_x6_net4 x3_x6_net3 x3_x6_x1_net5 VSS nfet_06v0 L=1.0u W=1.0u
Mx3_x6_x2_XM11 x3_x6_x2_net2 x3_x6_net4 VDD VDD pfet_06v0 L=1.0u W=10.0u
Mx3_x6_x2_XM12 x3_x6_x2_net7 x3_x6_net3 x3_x6_x2_net2 VDD pfet_06v0 L=1.0u W=10.0u
Mx3_x6_x2_XM13 x3_x6_x2_net19 x3_x6_net4 VDD VDD pfet_06v0 L=1.0u W=10.0u
Mx3_x6_x2_XM14 x3_x6_x2_net7 x3_x6_net3 x3_x6_x2_net19 VDD pfet_06v0 L=1.0u W=10.0u
Mx3_x6_x2_XM15_f1 x3_x6_x2_net5 x3_SZ x3_x6_x2_net7 VDD pfet_06v0 L=1.0u W=10.0u
Mx3_x6_x2_XM15_f2 x3_x6_x2_net5 x3_SZ x3_x6_x2_net7 VDD pfet_06v0 L=1.0u W=10.0u
Mx3_x6_x2_XM16_f1 x3_x6_x2_net4 x3_SY x3_x6_x2_net7 VDD pfet_06v0 L=1.0u W=10.0u
Mx3_x6_x2_XM16_f2 x3_x6_x2_net4 x3_SY x3_x6_x2_net7 VDD pfet_06v0 L=1.0u W=10.0u
Mx3_x6_x2_XM17 x3_x6_x2_net8 x3_x6_net2 x3_x6_x2_net1 VSS nfet_06v0 L=1.0u W=5.0u
Mx3_x6_x2_XM18 x3_x6_x2_net1 x3_x6_net1 VSS VSS nfet_06v0 L=1.0u W=5.0u
Mx3_x6_x2_XM19 x3_x6_x2_net8 x3_x6_net2 x3_x6_x2_net20 VSS nfet_06v0 L=1.0u W=5.0u
Mx3_x6_x2_XM20 x3_x6_x2_net20 x3_x6_net1 VSS VSS nfet_06v0 L=1.0u W=5.0u
Mx3_x6_x2_XM21_f1 x3_x6_x2_net6 x3_SZ x3_x6_x2_net8 VSS nfet_06v0 L=1.0u W=5u
Mx3_x6_x2_XM21_f2 x3_x6_x2_net6 x3_SZ x3_x6_x2_net8 VSS nfet_06v0 L=1.0u W=5u
Mx3_x6_x2_XM22_f1 x3_x6_x2_net3 x3_SY x3_x6_x2_net8 VSS nfet_06v0 L=1.0u W=5u
Mx3_x6_x2_XM22_f2 x3_x6_x2_net3 x3_SY x3_x6_x2_net8 VSS nfet_06v0 L=1.0u W=5u
Mx3_x6_x2_XM29_f1 x3_x6_x2_net9 x3_x6_net3 x3_x6_x2_net3 VDD pfet_06v0 L=1.0u W=5u
Mx3_x6_x2_XM29_f2 x3_x6_x2_net9 x3_x6_net3 x3_x6_x2_net3 VDD pfet_06v0 L=1.0u W=5u
Mx3_x6_x2_XM30_f1 x3_x6_x2_net12 x3_x6_net3 x3_x6_x2_net6 VDD pfet_06v0 L=1.0u W=5.0u
Mx3_x6_x2_XM30_f2 x3_x6_x2_net12 x3_x6_net3 x3_x6_x2_net6 VDD pfet_06v0 L=1.0u W=5.0u
Mx3_x6_x2_XM31_f1 x3_x6_x2_net3 x3_x6_x2_net9 VDD VDD pfet_06v0 L=1.0u W=5u
Mx3_x6_x2_XM31_f2 x3_x6_x2_net3 x3_x6_x2_net9 VDD VDD pfet_06v0 L=1.0u W=5u
Mx3_x6_x2_XM31_f3 x3_x6_x2_net3 x3_x6_x2_net9 VDD VDD pfet_06v0 L=1.0u W=5u
Mx3_x6_x2_XM31_f4 x3_x6_x2_net3 x3_x6_x2_net9 VDD VDD pfet_06v0 L=1.0u W=5u
Mx3_x6_x2_XM35_f1 x3_x6_x2_net6 x3_x6_x2_net9 VDD VDD pfet_06v0 L=1.0u W=5.0u
Mx3_x6_x2_XM35_f2 x3_x6_x2_net6 x3_x6_x2_net9 VDD VDD pfet_06v0 L=1.0u W=5.0u
Mx3_x6_x2_XM35_f3 x3_x6_x2_net6 x3_x6_x2_net9 VDD VDD pfet_06v0 L=1.0u W=5.0u
Mx3_x6_x2_XM35_f4 x3_x6_x2_net6 x3_x6_x2_net9 VDD VDD pfet_06v0 L=1.0u W=5.0u
Mx3_x6_x2_XM32 x3_x6_x2_net10 x3_x6_x2_net21 x3_x6_x2_net9 VDD pfet_06v0 L=1.0u W=5u
Mx3_x6_x2_XM33 x3_x6_x2_net22 x3_x6_x2_net21 x3_x6_x2_net12 VDD pfet_06v0 L=1.0u W=5.0u
Mx3_x6_x2_XM23_f1 x3_x6_x2_net10 x3_x6_net2 x3_x6_x2_net4 VSS nfet_06v0 L=1.0u W=2.5u
Mx3_x6_x2_XM23_f2 x3_x6_x2_net10 x3_x6_net2 x3_x6_x2_net4 VSS nfet_06v0 L=1.0u W=2.5u
Mx3_x6_x2_XM24_f1 x3_x6_x2_net22 x3_x6_net2 x3_x6_x2_net5 VSS nfet_06v0 L=1.0u W=2.5u
Mx3_x6_x2_XM24_f2 x3_x6_x2_net22 x3_x6_net2 x3_x6_x2_net5 VSS nfet_06v0 L=1.0u W=2.5u
Mx3_x6_x2_XM25_f1 x3_x6_x2_net4 x3_x6_x2_net10 VSS VSS nfet_06v0 L=1.0u W=2.5u
Mx3_x6_x2_XM25_f2 x3_x6_x2_net4 x3_x6_x2_net10 VSS VSS nfet_06v0 L=1.0u W=2.5u
Mx3_x6_x2_XM25_f3 x3_x6_x2_net4 x3_x6_x2_net10 VSS VSS nfet_06v0 L=1.0u W=2.5u
Mx3_x6_x2_XM25_f4 x3_x6_x2_net4 x3_x6_x2_net10 VSS VSS nfet_06v0 L=1.0u W=2.5u
Mx3_x6_x2_XM26_f1 x3_x6_x2_net5 x3_x6_x2_net10 VSS VSS nfet_06v0 L=1.0u W=2.5u
Mx3_x6_x2_XM26_f2 x3_x6_x2_net5 x3_x6_x2_net10 VSS VSS nfet_06v0 L=1.0u W=2.5u
Mx3_x6_x2_XM26_f3 x3_x6_x2_net5 x3_x6_x2_net10 VSS VSS nfet_06v0 L=1.0u W=2.5u
Mx3_x6_x2_XM26_f4 x3_x6_x2_net5 x3_x6_x2_net10 VSS VSS nfet_06v0 L=1.0u W=2.5u
Mx3_x6_x2_XM27 x3_x6_x2_net9 x3_x6_x2_net11 x3_x6_x2_net10 VSS nfet_06v0 L=1.0u W=2.5u
Mx3_x6_x2_XM28 x3_x6_x2_net12 x3_x6_x2_net11 x3_x6_x2_net22 VSS nfet_06v0 L=1.0u W=2.5u
Mx3_x6_x2_XM34 x3_x6_x2_net13 x3_x6_x2_net14 VDD VDD pfet_06v0 L=1.0u W=10.0u
Mx3_x6_x2_XM36 x3_x6_x2_net14 x3_x6_net3 x3_x6_x2_net13 VDD pfet_06v0 L=1.0u W=10.0u
Mx3_x6_x2_XM37 x3_x6_x2_net21 x3_x6_x2_net21 x3_x6_x2_net14 VDD pfet_06v0 L=1.0u W=10.0u
Mx3_x6_x2_XM38 x3_x6_x2_net21 x3_x6_net2 x3_x6_x2_net15 VSS nfet_06v0 L=1.0u W=5.0u
Mx3_x6_x2_XM39 x3_x6_x2_net15 x3_x6_net1 VSS VSS nfet_06v0 L=1.0u W=5.0u
Mx3_x6_x2_XM45 x3_x6_x2_net16 x3_x6_net4 VDD VDD pfet_06v0 L=1.0u W=10.0u
Mx3_x6_x2_XM46 x3_x6_x2_net11 x3_x6_net3 x3_x6_x2_net16 VDD pfet_06v0 L=1.0u W=10.0u
Mx3_x6_x2_XM40 x3_x6_x2_net11 x3_x6_x2_net11 x3_x6_x2_net18 VSS nfet_06v0 L=1.0u W=5.0u
Mx3_x6_x2_XM41 x3_x6_x2_net18 x3_x6_net2 x3_x6_x2_net17 VSS nfet_06v0 L=1.0u W=5.0u
Mx3_x6_x2_XM42 x3_x6_x2_net17 x3_x6_x2_net18 VSS VSS nfet_06v0 L=1.0u W=5.0u
Mx3_x6_x2_XM43_f1 x3_net3 x3_x6_x2_net12 VDD VDD pfet_06v0 L=1.0u W=10u
Mx3_x6_x2_XM43_f2 x3_net3 x3_x6_x2_net12 VDD VDD pfet_06v0 L=1.0u W=10u
Mx3_x6_x2_XM43_f3 x3_net3 x3_x6_x2_net12 VDD VDD pfet_06v0 L=1.0u W=10u
Mx3_x6_x2_XM44_f1 x3_net3 x3_x6_x2_net22 VSS VSS nfet_06v0 L=1.0u W=5u
Mx3_x6_x2_XM44_f2 x3_net3 x3_x6_x2_net22 VSS VSS nfet_06v0 L=1.0u W=5u
Mx3_x6_x2_XM44_f3 x3_net3 x3_x6_x2_net22 VSS VSS nfet_06v0 L=1.0u W=5u
Mx3_x7_x2_x2_XM4 x3_x7_x2_net1 x3_net1 VDD VDD pfet_06v0 L=1.0u W=3.0u
Mx3_x7_x2_x2_XM5 VSS x3_net1 x3_x7_x2_net1 VSS nfet_06v0 L=1u W=1u
Mx3_x7_x2_x3_XM4 Y3 x3_x7_x2_x3_net1 VDD VDD pfet_06v0 L=1.0u W=3.0u
Mx3_x7_x2_x3_XM5 VSS x3_x7_x2_x3_net1 Y3 VSS nfet_06v0 L=1u W=1u
Mx3_x7_x2_x3_XM2 VDD x3_net3 x3_x7_x2_x3_net1 VDD pfet_06v0 L=1.0u W=3.0u
Mx3_x7_x2_x3_XM1 VDD x3_x7_x2_net1 x3_x7_x2_x3_net1 VDD pfet_06v0 L=1.0u W=3.0u
Mx3_x7_x2_x3_XM3 VSS x3_net3 x3_x7_x2_x3_net2 VSS nfet_06v0 L=1u W=1u
Mx3_x7_x2_x3_XM6 x3_x7_x2_x3_net2 x3_x7_x2_net1 x3_x7_x2_x3_net1 VSS nfet_06v0 L=1u W=1u
Mx3_x7_x1_XM4 x3_x7_x1_net1 x3_net3 Z3 VDD pfet_06v0 L=1.0u W=3.0u
Mx3_x7_x1_XM5 VDD x3_net2 x3_x7_x1_net1 VDD pfet_06v0 L=1.0u W=3.0u
Mx3_x7_x1_XM7 VSS x3_net3 Z3 VSS nfet_06v0 L=1u W=1u
Mx3_x7_x1_XM1 VSS x3_net2 Z3 VSS nfet_06v0 L=1u W=1u
Mx3_x7_x3_x2_XM4 X3 x3_x7_x3_x2_net1 VDD VDD pfet_06v0 L=1.0u W=3.0u
Mx3_x7_x3_x2_XM5 VSS x3_x7_x3_x2_net1 X3 VSS nfet_06v0 L=1u W=1u
Mx3_x7_x3_x2_XM2 VDD x3_net1 x3_x7_x3_x2_net1 VDD pfet_06v0 L=1.0u W=3.0u
Mx3_x7_x3_x2_XM1 VDD x3_net2 x3_x7_x3_x2_net1 VDD pfet_06v0 L=1.0u W=3.0u
Mx3_x7_x3_x2_XM3 VSS x3_net1 x3_x7_x3_x2_net2 VSS nfet_06v0 L=1u W=1u
Mx3_x7_x3_x2_XM6 x3_x7_x3_x2_net2 x3_net2 x3_x7_x3_x2_net1 VSS nfet_06v0 L=1u W=1u
Mx3_x8_x1_XM4 x3_x8_x1_net3 x3_x8_net3 VDD VDD pfet_06v0 L=1.0u W=10.0u
Mx3_x8_x1_XM5 x3_x8_net2 x3_x8_net4 x3_x8_x1_net3 VDD pfet_06v0 L=1.0u W=10.0u
Mx3_x8_x1_XM6 x3_x8_net2 x3_x8_net2 VSS VSS nfet_06v0 L=1.0u W=1.0u
Mx3_x8_x1_XM7 x3_x8_x1_net2 x3_x8_net3 VDD VDD pfet_06v0 L=1.0u W=10.0u
Mx3_x8_x1_XM8 x3_x8_net1 x3_x8_net4 x3_x8_x1_net2 VDD pfet_06v0 L=1.0u W=10.0u
Mx3_x8_x1_XM9 x3_x8_net1 x3_x8_net2 x3_x8_x1_net1 VSS nfet_06v0 L=1.0u W=5.0u
Mx3_x8_x1_XM10 x3_x8_x1_net1 x3_x8_net1 VSS VSS nfet_06v0 L=1.0u W=5.0u
Mx3_x8_x1_XM1 x3_x8_net4 x3_x8_net4 VDD VDD pfet_06v0 L=1.0u W=2u
Mx3_x8_x1_XM2 x3_x8_x1_net4 x3_x8_net3 VDD VDD pfet_06v0 L=1.0u W=10.0u
Mx3_x8_x1_XM3 x3_x8_net3 x3_x8_net4 x3_x8_x1_net4 VDD pfet_06v0 L=1.0u W=10.0u
Mx3_x8_x1_XM47 x3_x8_x1_net5 x3_x8_net4 VSS VSS nfet_06v0 L=1.0u W=1.0u
Mx3_x8_x1_XM48 x3_x8_x1_net6 x3_x8_net4 VSS VSS nfet_06v0 L=1.0u W=1.0u
Mx3_x8_x1_XM49 x3_x8_net4 x3_x8_net4 x3_x8_x1_net6 VSS nfet_06v0 L=1.0u W=1.0u
Mx3_x8_x1_XM50 x3_x8_net3 x3_x8_net4 x3_x8_x1_net5 VSS nfet_06v0 L=1.0u W=1.0u
Mx3_x8_x2_XM11 x3_x8_x2_net2 x3_x8_net3 VDD VDD pfet_06v0 L=1.0u W=10.0u
Mx3_x8_x2_XM12 x3_x8_x2_net7 x3_x8_net4 x3_x8_x2_net2 VDD pfet_06v0 L=1.0u W=10.0u
Mx3_x8_x2_XM13 x3_x8_x2_net18 x3_x8_net3 VDD VDD pfet_06v0 L=1.0u W=10.0u
Mx3_x8_x2_XM14 x3_x8_x2_net7 x3_x8_net4 x3_x8_x2_net18 VDD pfet_06v0 L=1.0u W=10.0u
Mx3_x8_x2_XM15 x3_x8_x2_net5 S3P x3_x8_x2_net7 VDD pfet_06v0 L=1.0u W=0.55u
Mx3_x8_x2_XM16 x3_x8_x2_net4 S3N x3_x8_x2_net7 VDD pfet_06v0 L=1.0u W=0.5u
Mx3_x8_x2_XM17 x3_x8_x2_net8 x3_x8_net2 x3_x8_x2_net1 VSS nfet_06v0 L=1.0u W=5.0u
Mx3_x8_x2_XM18 x3_x8_x2_net1 x3_x8_net1 VSS VSS nfet_06v0 L=1.0u W=5.0u
Mx3_x8_x2_XM19 x3_x8_x2_net8 x3_x8_net2 x3_x8_x2_net19 VSS nfet_06v0 L=1.0u W=5.0u
Mx3_x8_x2_XM20 x3_x8_x2_net19 x3_x8_net1 VSS VSS nfet_06v0 L=1.0u W=5.0u
Mx3_x8_x2_XM21 x3_x8_x2_net6 S3P x3_x8_x2_net8 VSS nfet_06v0 L=1.0u W=7.5u
Mx3_x8_x2_XM22 x3_x8_x2_net3 S3N x3_x8_x2_net8 VSS nfet_06v0 L=1.0u W=8.5u
Mx3_x8_x2_XM29 x3_x8_x2_net9 x3_x8_net4 x3_x8_x2_net3 VDD pfet_06v0 L=1.0u W=10u
Mx3_x8_x2_XM30 x3_x8_x2_G_OUT_P x3_x8_net4 x3_x8_x2_net6 VDD pfet_06v0 L=1.0u W=10u
Mx3_x8_x2_XM31 x3_x8_x2_net3 x3_x8_x2_net9 VDD VDD pfet_06v0 L=1.0u W=5u
Mx3_x8_x2_XM35 x3_x8_x2_net6 x3_x8_x2_net9 VDD VDD pfet_06v0 L=1.0u W=5u
Mx3_x8_x2_XM32 x3_x8_x2_net10 x3_x8_x2_net20 x3_x8_x2_net9 VDD pfet_06v0 L=1.0u W=4.0u
Mx3_x8_x2_XM33 x3_x8_x2_net21 x3_x8_x2_net20 x3_x8_x2_G_OUT_P VDD pfet_06v0 L=1.0u W=4.0u
Mx3_x8_x2_XM23 x3_x8_x2_net10 x3_x8_net2 x3_x8_x2_net4 VSS nfet_06v0 L=1.0u W=2.5u
Mx3_x8_x2_XM24 x3_x8_x2_net21 x3_x8_net2 x3_x8_x2_net5 VSS nfet_06v0 L=1.0u W=2.5u
Mx3_x8_x2_XM25 x3_x8_x2_net4 x3_x8_x2_net10 VSS VSS nfet_06v0 L=1.0u W=2.5u
Mx3_x8_x2_XM26 x3_x8_x2_net5 x3_x8_x2_net10 VSS VSS nfet_06v0 L=1.0u W=2.5u
Mx3_x8_x2_XM27 x3_x8_x2_net9 x3_x8_x2_net11 x3_x8_x2_net10 VSS nfet_06v0 L=1.0u W=2.0u
Mx3_x8_x2_XM28 x3_x8_x2_G_OUT_P x3_x8_x2_net11 x3_x8_x2_net21 VSS nfet_06v0 L=1.0u W=2.0u
Mx3_x8_x2_XM34 x3_x8_x2_net12 x3_x8_x2_net13 VDD VDD pfet_06v0 L=1.0u W=10.0u
Mx3_x8_x2_XM36 x3_x8_x2_net13 x3_x8_net4 x3_x8_x2_net12 VDD pfet_06v0 L=1.0u W=10.0u
Mx3_x8_x2_XM37 x3_x8_x2_net20 x3_x8_x2_net20 x3_x8_x2_net13 VDD pfet_06v0 L=1.0u W=10.0u
Mx3_x8_x2_XM38 x3_x8_x2_net20 x3_x8_net2 x3_x8_x2_net14 VSS nfet_06v0 L=1.0u W=5.0u
Mx3_x8_x2_XM39 x3_x8_x2_net14 x3_x8_net1 VSS VSS nfet_06v0 L=1.0u W=5.0u
Mx3_x8_x2_XM45 x3_x8_x2_net15 x3_x8_net3 VDD VDD pfet_06v0 L=1.0u W=10.0u
Mx3_x8_x2_XM46 x3_x8_x2_net11 x3_x8_net4 x3_x8_x2_net15 VDD pfet_06v0 L=1.0u W=10.0u
Mx3_x8_x2_XM40 x3_x8_x2_net11 x3_x8_x2_net11 x3_x8_x2_net17 VSS nfet_06v0 L=1.0u W=5.0u
Mx3_x8_x2_XM41 x3_x8_x2_net17 x3_x8_net2 x3_x8_x2_net16 VSS nfet_06v0 L=1.0u W=5.0u
Mx3_x8_x2_XM42 x3_x8_x2_net16 x3_x8_x2_net17 VSS VSS nfet_06v0 L=1.0u W=5.0u
Mx3_x8_x2_XM43_m1 x3_SX x3_x8_x2_G_OUT_P VDD VDD pfet_06v0 L=1.0u W=1.0u
Mx3_x8_x2_XM43_m2 x3_SX x3_x8_x2_G_OUT_P VDD VDD pfet_06v0 L=1.0u W=1.0u
Mx3_x8_x2_XM43_m3 x3_SX x3_x8_x2_G_OUT_P VDD VDD pfet_06v0 L=1.0u W=1.0u
Mx3_x8_x2_XM43_m4 x3_SX x3_x8_x2_G_OUT_P VDD VDD pfet_06v0 L=1.0u W=1.0u
Mx3_x8_x2_XM44 x3_SX x3_x8_x2_net21 VSS VSS nfet_06v0 L=1.0u W=1.0u
Mx3_x1_x1_XM4 x3_x1_x1_net3 x3_x1_net3 VDD VDD pfet_06v0 L=1.0u W=10.0u
Mx3_x1_x1_XM5 x3_x1_net2 x3_x1_net4 x3_x1_x1_net3 VDD pfet_06v0 L=1.0u W=10.0u
Mx3_x1_x1_XM6 x3_x1_net2 x3_x1_net2 VSS VSS nfet_06v0 L=1.0u W=1.0u
Mx3_x1_x1_XM7 x3_x1_x1_net2 x3_x1_net3 VDD VDD pfet_06v0 L=1.0u W=10.0u
Mx3_x1_x1_XM8 x3_x1_net1 x3_x1_net4 x3_x1_x1_net2 VDD pfet_06v0 L=1.0u W=10.0u
Mx3_x1_x1_XM9 x3_x1_net1 x3_x1_net2 x3_x1_x1_net1 VSS nfet_06v0 L=1.0u W=5.0u
Mx3_x1_x1_XM10 x3_x1_x1_net1 x3_x1_net1 VSS VSS nfet_06v0 L=1.0u W=5.0u
Mx3_x1_x1_XM1 x3_x1_net4 x3_x1_net4 VDD VDD pfet_06v0 L=1.0u W=2u
Mx3_x1_x1_XM2 x3_x1_x1_net4 x3_x1_net3 VDD VDD pfet_06v0 L=1.0u W=10.0u
Mx3_x1_x1_XM3 x3_x1_net3 x3_x1_net4 x3_x1_x1_net4 VDD pfet_06v0 L=1.0u W=10.0u
Mx3_x1_x1_XM47 x3_x1_x1_net5 x3_x1_net4 VSS VSS nfet_06v0 L=1.0u W=1.0u
Mx3_x1_x1_XM48 x3_x1_x1_net6 x3_x1_net4 VSS VSS nfet_06v0 L=1.0u W=1.0u
Mx3_x1_x1_XM49 x3_x1_net4 x3_x1_net4 x3_x1_x1_net6 VSS nfet_06v0 L=1.0u W=1.0u
Mx3_x1_x1_XM50 x3_x1_net3 x3_x1_net4 x3_x1_x1_net5 VSS nfet_06v0 L=1.0u W=1.0u
Mx3_x1_x2_XM11 x3_x1_x2_net2 x3_x1_net3 VDD VDD pfet_06v0 L=1.0u W=10.0u
Mx3_x1_x2_XM12 x3_x1_x2_net7 x3_x1_net4 x3_x1_x2_net2 VDD pfet_06v0 L=1.0u W=10.0u
Mx3_x1_x2_XM13 x3_x1_x2_net18 x3_x1_net3 VDD VDD pfet_06v0 L=1.0u W=10.0u
Mx3_x1_x2_XM14 x3_x1_x2_net7 x3_x1_net4 x3_x1_x2_net18 VDD pfet_06v0 L=1.0u W=10.0u
Mx3_x1_x2_XM15 x3_x1_x2_net5 S4P x3_x1_x2_net7 VDD pfet_06v0 L=1.0u W=0.55u
Mx3_x1_x2_XM16 x3_x1_x2_net4 S4N x3_x1_x2_net7 VDD pfet_06v0 L=1.0u W=0.5u
Mx3_x1_x2_XM17 x3_x1_x2_net8 x3_x1_net2 x3_x1_x2_net1 VSS nfet_06v0 L=1.0u W=5.0u
Mx3_x1_x2_XM18 x3_x1_x2_net1 x3_x1_net1 VSS VSS nfet_06v0 L=1.0u W=5.0u
Mx3_x1_x2_XM19 x3_x1_x2_net8 x3_x1_net2 x3_x1_x2_net19 VSS nfet_06v0 L=1.0u W=5.0u
Mx3_x1_x2_XM20 x3_x1_x2_net19 x3_x1_net1 VSS VSS nfet_06v0 L=1.0u W=5.0u
Mx3_x1_x2_XM21 x3_x1_x2_net6 S4P x3_x1_x2_net8 VSS nfet_06v0 L=1.0u W=7.5u
Mx3_x1_x2_XM22 x3_x1_x2_net3 S4N x3_x1_x2_net8 VSS nfet_06v0 L=1.0u W=8.5u
Mx3_x1_x2_XM29 x3_x1_x2_net9 x3_x1_net4 x3_x1_x2_net3 VDD pfet_06v0 L=1.0u W=10u
Mx3_x1_x2_XM30 x3_x1_x2_G_OUT_P x3_x1_net4 x3_x1_x2_net6 VDD pfet_06v0 L=1.0u W=10u
Mx3_x1_x2_XM31 x3_x1_x2_net3 x3_x1_x2_net9 VDD VDD pfet_06v0 L=1.0u W=5u
Mx3_x1_x2_XM35 x3_x1_x2_net6 x3_x1_x2_net9 VDD VDD pfet_06v0 L=1.0u W=5u
Mx3_x1_x2_XM32 x3_x1_x2_net10 x3_x1_x2_net20 x3_x1_x2_net9 VDD pfet_06v0 L=1.0u W=4.0u
Mx3_x1_x2_XM33 x3_x1_x2_net21 x3_x1_x2_net20 x3_x1_x2_G_OUT_P VDD pfet_06v0 L=1.0u W=4.0u
Mx3_x1_x2_XM23 x3_x1_x2_net10 x3_x1_net2 x3_x1_x2_net4 VSS nfet_06v0 L=1.0u W=2.5u
Mx3_x1_x2_XM24 x3_x1_x2_net21 x3_x1_net2 x3_x1_x2_net5 VSS nfet_06v0 L=1.0u W=2.5u
Mx3_x1_x2_XM25 x3_x1_x2_net4 x3_x1_x2_net10 VSS VSS nfet_06v0 L=1.0u W=2.5u
Mx3_x1_x2_XM26 x3_x1_x2_net5 x3_x1_x2_net10 VSS VSS nfet_06v0 L=1.0u W=2.5u
Mx3_x1_x2_XM27 x3_x1_x2_net9 x3_x1_x2_net11 x3_x1_x2_net10 VSS nfet_06v0 L=1.0u W=2.0u
Mx3_x1_x2_XM28 x3_x1_x2_G_OUT_P x3_x1_x2_net11 x3_x1_x2_net21 VSS nfet_06v0 L=1.0u W=2.0u
Mx3_x1_x2_XM34 x3_x1_x2_net12 x3_x1_x2_net13 VDD VDD pfet_06v0 L=1.0u W=10.0u
Mx3_x1_x2_XM36 x3_x1_x2_net13 x3_x1_net4 x3_x1_x2_net12 VDD pfet_06v0 L=1.0u W=10.0u
Mx3_x1_x2_XM37 x3_x1_x2_net20 x3_x1_x2_net20 x3_x1_x2_net13 VDD pfet_06v0 L=1.0u W=10.0u
Mx3_x1_x2_XM38 x3_x1_x2_net20 x3_x1_net2 x3_x1_x2_net14 VSS nfet_06v0 L=1.0u W=5.0u
Mx3_x1_x2_XM39 x3_x1_x2_net14 x3_x1_net1 VSS VSS nfet_06v0 L=1.0u W=5.0u
Mx3_x1_x2_XM45 x3_x1_x2_net15 x3_x1_net3 VDD VDD pfet_06v0 L=1.0u W=10.0u
Mx3_x1_x2_XM46 x3_x1_x2_net11 x3_x1_net4 x3_x1_x2_net15 VDD pfet_06v0 L=1.0u W=10.0u
Mx3_x1_x2_XM40 x3_x1_x2_net11 x3_x1_x2_net11 x3_x1_x2_net17 VSS nfet_06v0 L=1.0u W=5.0u
Mx3_x1_x2_XM41 x3_x1_x2_net17 x3_x1_net2 x3_x1_x2_net16 VSS nfet_06v0 L=1.0u W=5.0u
Mx3_x1_x2_XM42 x3_x1_x2_net16 x3_x1_x2_net17 VSS VSS nfet_06v0 L=1.0u W=5.0u
Mx3_x1_x2_XM43_m1 x3_SY x3_x1_x2_G_OUT_P VDD VDD pfet_06v0 L=1.0u W=1.0u
Mx3_x1_x2_XM43_m2 x3_SY x3_x1_x2_G_OUT_P VDD VDD pfet_06v0 L=1.0u W=1.0u
Mx3_x1_x2_XM43_m3 x3_SY x3_x1_x2_G_OUT_P VDD VDD pfet_06v0 L=1.0u W=1.0u
Mx3_x1_x2_XM43_m4 x3_SY x3_x1_x2_G_OUT_P VDD VDD pfet_06v0 L=1.0u W=1.0u
Mx3_x1_x2_XM44 x3_SY x3_x1_x2_net21 VSS VSS nfet_06v0 L=1.0u W=1.0u
Mx3_x2_x1_XM4 x3_x2_x1_net3 x3_x2_net3 VDD VDD pfet_06v0 L=1.0u W=10.0u
Mx3_x2_x1_XM5 x3_x2_net2 x3_x2_net4 x3_x2_x1_net3 VDD pfet_06v0 L=1.0u W=10.0u
Mx3_x2_x1_XM6 x3_x2_net2 x3_x2_net2 VSS VSS nfet_06v0 L=1.0u W=1.0u
Mx3_x2_x1_XM7 x3_x2_x1_net2 x3_x2_net3 VDD VDD pfet_06v0 L=1.0u W=10.0u
Mx3_x2_x1_XM8 x3_x2_net1 x3_x2_net4 x3_x2_x1_net2 VDD pfet_06v0 L=1.0u W=10.0u
Mx3_x2_x1_XM9 x3_x2_net1 x3_x2_net2 x3_x2_x1_net1 VSS nfet_06v0 L=1.0u W=5.0u
Mx3_x2_x1_XM10 x3_x2_x1_net1 x3_x2_net1 VSS VSS nfet_06v0 L=1.0u W=5.0u
Mx3_x2_x1_XM1 x3_x2_net4 x3_x2_net4 VDD VDD pfet_06v0 L=1.0u W=2u
Mx3_x2_x1_XM2 x3_x2_x1_net4 x3_x2_net3 VDD VDD pfet_06v0 L=1.0u W=10.0u
Mx3_x2_x1_XM3 x3_x2_net3 x3_x2_net4 x3_x2_x1_net4 VDD pfet_06v0 L=1.0u W=10.0u
Mx3_x2_x1_XM47 x3_x2_x1_net5 x3_x2_net4 VSS VSS nfet_06v0 L=1.0u W=1.0u
Mx3_x2_x1_XM48 x3_x2_x1_net6 x3_x2_net4 VSS VSS nfet_06v0 L=1.0u W=1.0u
Mx3_x2_x1_XM49 x3_x2_net4 x3_x2_net4 x3_x2_x1_net6 VSS nfet_06v0 L=1.0u W=1.0u
Mx3_x2_x1_XM50 x3_x2_net3 x3_x2_net4 x3_x2_x1_net5 VSS nfet_06v0 L=1.0u W=1.0u
Mx3_x2_x2_XM11 x3_x2_x2_net2 x3_x2_net3 VDD VDD pfet_06v0 L=1.0u W=10.0u
Mx3_x2_x2_XM12 x3_x2_x2_net7 x3_x2_net4 x3_x2_x2_net2 VDD pfet_06v0 L=1.0u W=10.0u
Mx3_x2_x2_XM13 x3_x2_x2_net18 x3_x2_net3 VDD VDD pfet_06v0 L=1.0u W=10.0u
Mx3_x2_x2_XM14 x3_x2_x2_net7 x3_x2_net4 x3_x2_x2_net18 VDD pfet_06v0 L=1.0u W=10.0u
Mx3_x2_x2_XM15 x3_x2_x2_net5 S1P x3_x2_x2_net7 VDD pfet_06v0 L=1.0u W=0.55u
Mx3_x2_x2_XM16 x3_x2_x2_net4 S1N x3_x2_x2_net7 VDD pfet_06v0 L=1.0u W=0.5u
Mx3_x2_x2_XM17 x3_x2_x2_net8 x3_x2_net2 x3_x2_x2_net1 VSS nfet_06v0 L=1.0u W=5.0u
Mx3_x2_x2_XM18 x3_x2_x2_net1 x3_x2_net1 VSS VSS nfet_06v0 L=1.0u W=5.0u
Mx3_x2_x2_XM19 x3_x2_x2_net8 x3_x2_net2 x3_x2_x2_net19 VSS nfet_06v0 L=1.0u W=5.0u
Mx3_x2_x2_XM20 x3_x2_x2_net19 x3_x2_net1 VSS VSS nfet_06v0 L=1.0u W=5.0u
Mx3_x2_x2_XM21 x3_x2_x2_net6 S1P x3_x2_x2_net8 VSS nfet_06v0 L=1.0u W=7.5u
Mx3_x2_x2_XM22 x3_x2_x2_net3 S1N x3_x2_x2_net8 VSS nfet_06v0 L=1.0u W=8.5u
Mx3_x2_x2_XM29 x3_x2_x2_net9 x3_x2_net4 x3_x2_x2_net3 VDD pfet_06v0 L=1.0u W=10u
Mx3_x2_x2_XM30 x3_x2_x2_G_OUT_P x3_x2_net4 x3_x2_x2_net6 VDD pfet_06v0 L=1.0u W=10u
Mx3_x2_x2_XM31 x3_x2_x2_net3 x3_x2_x2_net9 VDD VDD pfet_06v0 L=1.0u W=5u
Mx3_x2_x2_XM35 x3_x2_x2_net6 x3_x2_x2_net9 VDD VDD pfet_06v0 L=1.0u W=5u
Mx3_x2_x2_XM32 x3_x2_x2_net10 x3_x2_x2_net20 x3_x2_x2_net9 VDD pfet_06v0 L=1.0u W=4.0u
Mx3_x2_x2_XM33 x3_x2_x2_net21 x3_x2_x2_net20 x3_x2_x2_G_OUT_P VDD pfet_06v0 L=1.0u W=4.0u
Mx3_x2_x2_XM23 x3_x2_x2_net10 x3_x2_net2 x3_x2_x2_net4 VSS nfet_06v0 L=1.0u W=2.5u
Mx3_x2_x2_XM24 x3_x2_x2_net21 x3_x2_net2 x3_x2_x2_net5 VSS nfet_06v0 L=1.0u W=2.5u
Mx3_x2_x2_XM25 x3_x2_x2_net4 x3_x2_x2_net10 VSS VSS nfet_06v0 L=1.0u W=2.5u
Mx3_x2_x2_XM26 x3_x2_x2_net5 x3_x2_x2_net10 VSS VSS nfet_06v0 L=1.0u W=2.5u
Mx3_x2_x2_XM27 x3_x2_x2_net9 x3_x2_x2_net11 x3_x2_x2_net10 VSS nfet_06v0 L=1.0u W=2.0u
Mx3_x2_x2_XM28 x3_x2_x2_G_OUT_P x3_x2_x2_net11 x3_x2_x2_net21 VSS nfet_06v0 L=1.0u W=2.0u
Mx3_x2_x2_XM34 x3_x2_x2_net12 x3_x2_x2_net13 VDD VDD pfet_06v0 L=1.0u W=10.0u
Mx3_x2_x2_XM36 x3_x2_x2_net13 x3_x2_net4 x3_x2_x2_net12 VDD pfet_06v0 L=1.0u W=10.0u
Mx3_x2_x2_XM37 x3_x2_x2_net20 x3_x2_x2_net20 x3_x2_x2_net13 VDD pfet_06v0 L=1.0u W=10.0u
Mx3_x2_x2_XM38 x3_x2_x2_net20 x3_x2_net2 x3_x2_x2_net14 VSS nfet_06v0 L=1.0u W=5.0u
Mx3_x2_x2_XM39 x3_x2_x2_net14 x3_x2_net1 VSS VSS nfet_06v0 L=1.0u W=5.0u
Mx3_x2_x2_XM45 x3_x2_x2_net15 x3_x2_net3 VDD VDD pfet_06v0 L=1.0u W=10.0u
Mx3_x2_x2_XM46 x3_x2_x2_net11 x3_x2_net4 x3_x2_x2_net15 VDD pfet_06v0 L=1.0u W=10.0u
Mx3_x2_x2_XM40 x3_x2_x2_net11 x3_x2_x2_net11 x3_x2_x2_net17 VSS nfet_06v0 L=1.0u W=5.0u
Mx3_x2_x2_XM41 x3_x2_x2_net17 x3_x2_net2 x3_x2_x2_net16 VSS nfet_06v0 L=1.0u W=5.0u
Mx3_x2_x2_XM42 x3_x2_x2_net16 x3_x2_x2_net17 VSS VSS nfet_06v0 L=1.0u W=5.0u
Mx3_x2_x2_XM43_m1 x3_SZ x3_x2_x2_G_OUT_P VDD VDD pfet_06v0 L=1.0u W=1.0u
Mx3_x2_x2_XM43_m2 x3_SZ x3_x2_x2_G_OUT_P VDD VDD pfet_06v0 L=1.0u W=1.0u
Mx3_x2_x2_XM43_m3 x3_SZ x3_x2_x2_G_OUT_P VDD VDD pfet_06v0 L=1.0u W=1.0u
Mx3_x2_x2_XM43_m4 x3_SZ x3_x2_x2_G_OUT_P VDD VDD pfet_06v0 L=1.0u W=1.0u
Mx3_x2_x2_XM44 x3_SZ x3_x2_x2_net21 VSS VSS nfet_06v0 L=1.0u W=1.0u
Mx4_x4_x1_XM4 x4_x4_x1_net3 x4_x4_net4 VDD VDD pfet_06v0 L=1.0u W=10.0u
Mx4_x4_x1_XM5 x4_x4_net2 x4_x4_net3 x4_x4_x1_net3 VDD pfet_06v0 L=1.0u W=10.0u
Mx4_x4_x1_XM6 x4_x4_net2 x4_x4_net2 VSS VSS nfet_06v0 L=1.0u W=1.0u
Mx4_x4_x1_XM7 x4_x4_x1_net2 x4_x4_net4 VDD VDD pfet_06v0 L=1.0u W=10.0u
Mx4_x4_x1_XM8 x4_x4_net1 x4_x4_net3 x4_x4_x1_net2 VDD pfet_06v0 L=1.0u W=10.0u
Mx4_x4_x1_XM9 x4_x4_net1 x4_x4_net2 x4_x4_x1_net1 VSS nfet_06v0 L=1.0u W=5.0u
Mx4_x4_x1_XM10 x4_x4_x1_net1 x4_x4_net1 VSS VSS nfet_06v0 L=1.0u W=5.0u
Mx4_x4_x1_XM1 x4_x4_net3 x4_x4_net3 VDD VDD pfet_06v0 L=1.0u W=2u
Mx4_x4_x1_XM2 x4_x4_x1_net4 x4_x4_net4 VDD VDD pfet_06v0 L=1.0u W=10.0u
Mx4_x4_x1_XM3 x4_x4_net4 x4_x4_net3 x4_x4_x1_net4 VDD pfet_06v0 L=1.0u W=10.0u
Mx4_x4_x1_XM47 x4_x4_x1_net5 x4_x4_net3 VSS VSS nfet_06v0 L=1.0u W=1.0u
Mx4_x4_x1_XM48 x4_x4_x1_net6 x4_x4_net3 VSS VSS nfet_06v0 L=1.0u W=1.0u
Mx4_x4_x1_XM49 x4_x4_net3 x4_x4_net3 x4_x4_x1_net6 VSS nfet_06v0 L=1.0u W=1.0u
Mx4_x4_x1_XM50 x4_x4_net4 x4_x4_net3 x4_x4_x1_net5 VSS nfet_06v0 L=1.0u W=1.0u
Mx4_x4_x2_XM11 x4_x4_x2_net2 x4_x4_net4 VDD VDD pfet_06v0 L=1.0u W=10.0u
Mx4_x4_x2_XM12 x4_x4_x2_net7 x4_x4_net3 x4_x4_x2_net2 VDD pfet_06v0 L=1.0u W=10.0u
Mx4_x4_x2_XM13 x4_x4_x2_net19 x4_x4_net4 VDD VDD pfet_06v0 L=1.0u W=10.0u
Mx4_x4_x2_XM14 x4_x4_x2_net7 x4_x4_net3 x4_x4_x2_net19 VDD pfet_06v0 L=1.0u W=10.0u
Mx4_x4_x2_XM15_f1 x4_x4_x2_net5 x4_SY x4_x4_x2_net7 VDD pfet_06v0 L=1.0u W=10.0u
Mx4_x4_x2_XM15_f2 x4_x4_x2_net5 x4_SY x4_x4_x2_net7 VDD pfet_06v0 L=1.0u W=10.0u
Mx4_x4_x2_XM16_f1 x4_x4_x2_net4 x4_SX x4_x4_x2_net7 VDD pfet_06v0 L=1.0u W=10.0u
Mx4_x4_x2_XM16_f2 x4_x4_x2_net4 x4_SX x4_x4_x2_net7 VDD pfet_06v0 L=1.0u W=10.0u
Mx4_x4_x2_XM17 x4_x4_x2_net8 x4_x4_net2 x4_x4_x2_net1 VSS nfet_06v0 L=1.0u W=5.0u
Mx4_x4_x2_XM18 x4_x4_x2_net1 x4_x4_net1 VSS VSS nfet_06v0 L=1.0u W=5.0u
Mx4_x4_x2_XM19 x4_x4_x2_net8 x4_x4_net2 x4_x4_x2_net20 VSS nfet_06v0 L=1.0u W=5.0u
Mx4_x4_x2_XM20 x4_x4_x2_net20 x4_x4_net1 VSS VSS nfet_06v0 L=1.0u W=5.0u
Mx4_x4_x2_XM21_f1 x4_x4_x2_net6 x4_SY x4_x4_x2_net8 VSS nfet_06v0 L=1.0u W=5u
Mx4_x4_x2_XM21_f2 x4_x4_x2_net6 x4_SY x4_x4_x2_net8 VSS nfet_06v0 L=1.0u W=5u
Mx4_x4_x2_XM22_f1 x4_x4_x2_net3 x4_SX x4_x4_x2_net8 VSS nfet_06v0 L=1.0u W=5u
Mx4_x4_x2_XM22_f2 x4_x4_x2_net3 x4_SX x4_x4_x2_net8 VSS nfet_06v0 L=1.0u W=5u
Mx4_x4_x2_XM29_f1 x4_x4_x2_net9 x4_x4_net3 x4_x4_x2_net3 VDD pfet_06v0 L=1.0u W=5u
Mx4_x4_x2_XM29_f2 x4_x4_x2_net9 x4_x4_net3 x4_x4_x2_net3 VDD pfet_06v0 L=1.0u W=5u
Mx4_x4_x2_XM30_f1 x4_x4_x2_net12 x4_x4_net3 x4_x4_x2_net6 VDD pfet_06v0 L=1.0u W=5.0u
Mx4_x4_x2_XM30_f2 x4_x4_x2_net12 x4_x4_net3 x4_x4_x2_net6 VDD pfet_06v0 L=1.0u W=5.0u
Mx4_x4_x2_XM31_f1 x4_x4_x2_net3 x4_x4_x2_net9 VDD VDD pfet_06v0 L=1.0u W=5u
Mx4_x4_x2_XM31_f2 x4_x4_x2_net3 x4_x4_x2_net9 VDD VDD pfet_06v0 L=1.0u W=5u
Mx4_x4_x2_XM31_f3 x4_x4_x2_net3 x4_x4_x2_net9 VDD VDD pfet_06v0 L=1.0u W=5u
Mx4_x4_x2_XM31_f4 x4_x4_x2_net3 x4_x4_x2_net9 VDD VDD pfet_06v0 L=1.0u W=5u
Mx4_x4_x2_XM35_f1 x4_x4_x2_net6 x4_x4_x2_net9 VDD VDD pfet_06v0 L=1.0u W=5.0u
Mx4_x4_x2_XM35_f2 x4_x4_x2_net6 x4_x4_x2_net9 VDD VDD pfet_06v0 L=1.0u W=5.0u
Mx4_x4_x2_XM35_f3 x4_x4_x2_net6 x4_x4_x2_net9 VDD VDD pfet_06v0 L=1.0u W=5.0u
Mx4_x4_x2_XM35_f4 x4_x4_x2_net6 x4_x4_x2_net9 VDD VDD pfet_06v0 L=1.0u W=5.0u
Mx4_x4_x2_XM32 x4_x4_x2_net10 x4_x4_x2_net21 x4_x4_x2_net9 VDD pfet_06v0 L=1.0u W=5u
Mx4_x4_x2_XM33 x4_x4_x2_net22 x4_x4_x2_net21 x4_x4_x2_net12 VDD pfet_06v0 L=1.0u W=5.0u
Mx4_x4_x2_XM23_f1 x4_x4_x2_net10 x4_x4_net2 x4_x4_x2_net4 VSS nfet_06v0 L=1.0u W=2.5u
Mx4_x4_x2_XM23_f2 x4_x4_x2_net10 x4_x4_net2 x4_x4_x2_net4 VSS nfet_06v0 L=1.0u W=2.5u
Mx4_x4_x2_XM24_f1 x4_x4_x2_net22 x4_x4_net2 x4_x4_x2_net5 VSS nfet_06v0 L=1.0u W=2.5u
Mx4_x4_x2_XM24_f2 x4_x4_x2_net22 x4_x4_net2 x4_x4_x2_net5 VSS nfet_06v0 L=1.0u W=2.5u
Mx4_x4_x2_XM25_f1 x4_x4_x2_net4 x4_x4_x2_net10 VSS VSS nfet_06v0 L=1.0u W=2.5u
Mx4_x4_x2_XM25_f2 x4_x4_x2_net4 x4_x4_x2_net10 VSS VSS nfet_06v0 L=1.0u W=2.5u
Mx4_x4_x2_XM25_f3 x4_x4_x2_net4 x4_x4_x2_net10 VSS VSS nfet_06v0 L=1.0u W=2.5u
Mx4_x4_x2_XM25_f4 x4_x4_x2_net4 x4_x4_x2_net10 VSS VSS nfet_06v0 L=1.0u W=2.5u
Mx4_x4_x2_XM26_f1 x4_x4_x2_net5 x4_x4_x2_net10 VSS VSS nfet_06v0 L=1.0u W=2.5u
Mx4_x4_x2_XM26_f2 x4_x4_x2_net5 x4_x4_x2_net10 VSS VSS nfet_06v0 L=1.0u W=2.5u
Mx4_x4_x2_XM26_f3 x4_x4_x2_net5 x4_x4_x2_net10 VSS VSS nfet_06v0 L=1.0u W=2.5u
Mx4_x4_x2_XM26_f4 x4_x4_x2_net5 x4_x4_x2_net10 VSS VSS nfet_06v0 L=1.0u W=2.5u
Mx4_x4_x2_XM27 x4_x4_x2_net9 x4_x4_x2_net11 x4_x4_x2_net10 VSS nfet_06v0 L=1.0u W=2.5u
Mx4_x4_x2_XM28 x4_x4_x2_net12 x4_x4_x2_net11 x4_x4_x2_net22 VSS nfet_06v0 L=1.0u W=2.5u
Mx4_x4_x2_XM34 x4_x4_x2_net13 x4_x4_x2_net14 VDD VDD pfet_06v0 L=1.0u W=10.0u
Mx4_x4_x2_XM36 x4_x4_x2_net14 x4_x4_net3 x4_x4_x2_net13 VDD pfet_06v0 L=1.0u W=10.0u
Mx4_x4_x2_XM37 x4_x4_x2_net21 x4_x4_x2_net21 x4_x4_x2_net14 VDD pfet_06v0 L=1.0u W=10.0u
Mx4_x4_x2_XM38 x4_x4_x2_net21 x4_x4_net2 x4_x4_x2_net15 VSS nfet_06v0 L=1.0u W=5.0u
Mx4_x4_x2_XM39 x4_x4_x2_net15 x4_x4_net1 VSS VSS nfet_06v0 L=1.0u W=5.0u
Mx4_x4_x2_XM45 x4_x4_x2_net16 x4_x4_net4 VDD VDD pfet_06v0 L=1.0u W=10.0u
Mx4_x4_x2_XM46 x4_x4_x2_net11 x4_x4_net3 x4_x4_x2_net16 VDD pfet_06v0 L=1.0u W=10.0u
Mx4_x4_x2_XM40 x4_x4_x2_net11 x4_x4_x2_net11 x4_x4_x2_net18 VSS nfet_06v0 L=1.0u W=5.0u
Mx4_x4_x2_XM41 x4_x4_x2_net18 x4_x4_net2 x4_x4_x2_net17 VSS nfet_06v0 L=1.0u W=5.0u
Mx4_x4_x2_XM42 x4_x4_x2_net17 x4_x4_x2_net18 VSS VSS nfet_06v0 L=1.0u W=5.0u
Mx4_x4_x2_XM43_f1 x4_net1 x4_x4_x2_net12 VDD VDD pfet_06v0 L=1.0u W=10u
Mx4_x4_x2_XM43_f2 x4_net1 x4_x4_x2_net12 VDD VDD pfet_06v0 L=1.0u W=10u
Mx4_x4_x2_XM43_f3 x4_net1 x4_x4_x2_net12 VDD VDD pfet_06v0 L=1.0u W=10u
Mx4_x4_x2_XM44_f1 x4_net1 x4_x4_x2_net22 VSS VSS nfet_06v0 L=1.0u W=5u
Mx4_x4_x2_XM44_f2 x4_net1 x4_x4_x2_net22 VSS VSS nfet_06v0 L=1.0u W=5u
Mx4_x4_x2_XM44_f3 x4_net1 x4_x4_x2_net22 VSS VSS nfet_06v0 L=1.0u W=5u
Mx4_x5_x1_XM4 x4_x5_x1_net3 x4_x5_net4 VDD VDD pfet_06v0 L=1.0u W=10.0u
Mx4_x5_x1_XM5 x4_x5_net2 x4_x5_net3 x4_x5_x1_net3 VDD pfet_06v0 L=1.0u W=10.0u
Mx4_x5_x1_XM6 x4_x5_net2 x4_x5_net2 VSS VSS nfet_06v0 L=1.0u W=1.0u
Mx4_x5_x1_XM7 x4_x5_x1_net2 x4_x5_net4 VDD VDD pfet_06v0 L=1.0u W=10.0u
Mx4_x5_x1_XM8 x4_x5_net1 x4_x5_net3 x4_x5_x1_net2 VDD pfet_06v0 L=1.0u W=10.0u
Mx4_x5_x1_XM9 x4_x5_net1 x4_x5_net2 x4_x5_x1_net1 VSS nfet_06v0 L=1.0u W=5.0u
Mx4_x5_x1_XM10 x4_x5_x1_net1 x4_x5_net1 VSS VSS nfet_06v0 L=1.0u W=5.0u
Mx4_x5_x1_XM1 x4_x5_net3 x4_x5_net3 VDD VDD pfet_06v0 L=1.0u W=2u
Mx4_x5_x1_XM2 x4_x5_x1_net4 x4_x5_net4 VDD VDD pfet_06v0 L=1.0u W=10.0u
Mx4_x5_x1_XM3 x4_x5_net4 x4_x5_net3 x4_x5_x1_net4 VDD pfet_06v0 L=1.0u W=10.0u
Mx4_x5_x1_XM47 x4_x5_x1_net5 x4_x5_net3 VSS VSS nfet_06v0 L=1.0u W=1.0u
Mx4_x5_x1_XM48 x4_x5_x1_net6 x4_x5_net3 VSS VSS nfet_06v0 L=1.0u W=1.0u
Mx4_x5_x1_XM49 x4_x5_net3 x4_x5_net3 x4_x5_x1_net6 VSS nfet_06v0 L=1.0u W=1.0u
Mx4_x5_x1_XM50 x4_x5_net4 x4_x5_net3 x4_x5_x1_net5 VSS nfet_06v0 L=1.0u W=1.0u
Mx4_x5_x2_XM11 x4_x5_x2_net2 x4_x5_net4 VDD VDD pfet_06v0 L=1.0u W=10.0u
Mx4_x5_x2_XM12 x4_x5_x2_net7 x4_x5_net3 x4_x5_x2_net2 VDD pfet_06v0 L=1.0u W=10.0u
Mx4_x5_x2_XM13 x4_x5_x2_net19 x4_x5_net4 VDD VDD pfet_06v0 L=1.0u W=10.0u
Mx4_x5_x2_XM14 x4_x5_x2_net7 x4_x5_net3 x4_x5_x2_net19 VDD pfet_06v0 L=1.0u W=10.0u
Mx4_x5_x2_XM15_f1 x4_x5_x2_net5 x4_SZ x4_x5_x2_net7 VDD pfet_06v0 L=1.0u W=10.0u
Mx4_x5_x2_XM15_f2 x4_x5_x2_net5 x4_SZ x4_x5_x2_net7 VDD pfet_06v0 L=1.0u W=10.0u
Mx4_x5_x2_XM16_f1 x4_x5_x2_net4 x4_SX x4_x5_x2_net7 VDD pfet_06v0 L=1.0u W=10.0u
Mx4_x5_x2_XM16_f2 x4_x5_x2_net4 x4_SX x4_x5_x2_net7 VDD pfet_06v0 L=1.0u W=10.0u
Mx4_x5_x2_XM17 x4_x5_x2_net8 x4_x5_net2 x4_x5_x2_net1 VSS nfet_06v0 L=1.0u W=5.0u
Mx4_x5_x2_XM18 x4_x5_x2_net1 x4_x5_net1 VSS VSS nfet_06v0 L=1.0u W=5.0u
Mx4_x5_x2_XM19 x4_x5_x2_net8 x4_x5_net2 x4_x5_x2_net20 VSS nfet_06v0 L=1.0u W=5.0u
Mx4_x5_x2_XM20 x4_x5_x2_net20 x4_x5_net1 VSS VSS nfet_06v0 L=1.0u W=5.0u
Mx4_x5_x2_XM21_f1 x4_x5_x2_net6 x4_SZ x4_x5_x2_net8 VSS nfet_06v0 L=1.0u W=5u
Mx4_x5_x2_XM21_f2 x4_x5_x2_net6 x4_SZ x4_x5_x2_net8 VSS nfet_06v0 L=1.0u W=5u
Mx4_x5_x2_XM22_f1 x4_x5_x2_net3 x4_SX x4_x5_x2_net8 VSS nfet_06v0 L=1.0u W=5u
Mx4_x5_x2_XM22_f2 x4_x5_x2_net3 x4_SX x4_x5_x2_net8 VSS nfet_06v0 L=1.0u W=5u
Mx4_x5_x2_XM29_f1 x4_x5_x2_net9 x4_x5_net3 x4_x5_x2_net3 VDD pfet_06v0 L=1.0u W=5u
Mx4_x5_x2_XM29_f2 x4_x5_x2_net9 x4_x5_net3 x4_x5_x2_net3 VDD pfet_06v0 L=1.0u W=5u
Mx4_x5_x2_XM30_f1 x4_x5_x2_net12 x4_x5_net3 x4_x5_x2_net6 VDD pfet_06v0 L=1.0u W=5.0u
Mx4_x5_x2_XM30_f2 x4_x5_x2_net12 x4_x5_net3 x4_x5_x2_net6 VDD pfet_06v0 L=1.0u W=5.0u
Mx4_x5_x2_XM31_f1 x4_x5_x2_net3 x4_x5_x2_net9 VDD VDD pfet_06v0 L=1.0u W=5u
Mx4_x5_x2_XM31_f2 x4_x5_x2_net3 x4_x5_x2_net9 VDD VDD pfet_06v0 L=1.0u W=5u
Mx4_x5_x2_XM31_f3 x4_x5_x2_net3 x4_x5_x2_net9 VDD VDD pfet_06v0 L=1.0u W=5u
Mx4_x5_x2_XM31_f4 x4_x5_x2_net3 x4_x5_x2_net9 VDD VDD pfet_06v0 L=1.0u W=5u
Mx4_x5_x2_XM35_f1 x4_x5_x2_net6 x4_x5_x2_net9 VDD VDD pfet_06v0 L=1.0u W=5.0u
Mx4_x5_x2_XM35_f2 x4_x5_x2_net6 x4_x5_x2_net9 VDD VDD pfet_06v0 L=1.0u W=5.0u
Mx4_x5_x2_XM35_f3 x4_x5_x2_net6 x4_x5_x2_net9 VDD VDD pfet_06v0 L=1.0u W=5.0u
Mx4_x5_x2_XM35_f4 x4_x5_x2_net6 x4_x5_x2_net9 VDD VDD pfet_06v0 L=1.0u W=5.0u
Mx4_x5_x2_XM32 x4_x5_x2_net10 x4_x5_x2_net21 x4_x5_x2_net9 VDD pfet_06v0 L=1.0u W=5u
Mx4_x5_x2_XM33 x4_x5_x2_net22 x4_x5_x2_net21 x4_x5_x2_net12 VDD pfet_06v0 L=1.0u W=5.0u
Mx4_x5_x2_XM23_f1 x4_x5_x2_net10 x4_x5_net2 x4_x5_x2_net4 VSS nfet_06v0 L=1.0u W=2.5u
Mx4_x5_x2_XM23_f2 x4_x5_x2_net10 x4_x5_net2 x4_x5_x2_net4 VSS nfet_06v0 L=1.0u W=2.5u
Mx4_x5_x2_XM24_f1 x4_x5_x2_net22 x4_x5_net2 x4_x5_x2_net5 VSS nfet_06v0 L=1.0u W=2.5u
Mx4_x5_x2_XM24_f2 x4_x5_x2_net22 x4_x5_net2 x4_x5_x2_net5 VSS nfet_06v0 L=1.0u W=2.5u
Mx4_x5_x2_XM25_f1 x4_x5_x2_net4 x4_x5_x2_net10 VSS VSS nfet_06v0 L=1.0u W=2.5u
Mx4_x5_x2_XM25_f2 x4_x5_x2_net4 x4_x5_x2_net10 VSS VSS nfet_06v0 L=1.0u W=2.5u
Mx4_x5_x2_XM25_f3 x4_x5_x2_net4 x4_x5_x2_net10 VSS VSS nfet_06v0 L=1.0u W=2.5u
Mx4_x5_x2_XM25_f4 x4_x5_x2_net4 x4_x5_x2_net10 VSS VSS nfet_06v0 L=1.0u W=2.5u
Mx4_x5_x2_XM26_f1 x4_x5_x2_net5 x4_x5_x2_net10 VSS VSS nfet_06v0 L=1.0u W=2.5u
Mx4_x5_x2_XM26_f2 x4_x5_x2_net5 x4_x5_x2_net10 VSS VSS nfet_06v0 L=1.0u W=2.5u
Mx4_x5_x2_XM26_f3 x4_x5_x2_net5 x4_x5_x2_net10 VSS VSS nfet_06v0 L=1.0u W=2.5u
Mx4_x5_x2_XM26_f4 x4_x5_x2_net5 x4_x5_x2_net10 VSS VSS nfet_06v0 L=1.0u W=2.5u
Mx4_x5_x2_XM27 x4_x5_x2_net9 x4_x5_x2_net11 x4_x5_x2_net10 VSS nfet_06v0 L=1.0u W=2.5u
Mx4_x5_x2_XM28 x4_x5_x2_net12 x4_x5_x2_net11 x4_x5_x2_net22 VSS nfet_06v0 L=1.0u W=2.5u
Mx4_x5_x2_XM34 x4_x5_x2_net13 x4_x5_x2_net14 VDD VDD pfet_06v0 L=1.0u W=10.0u
Mx4_x5_x2_XM36 x4_x5_x2_net14 x4_x5_net3 x4_x5_x2_net13 VDD pfet_06v0 L=1.0u W=10.0u
Mx4_x5_x2_XM37 x4_x5_x2_net21 x4_x5_x2_net21 x4_x5_x2_net14 VDD pfet_06v0 L=1.0u W=10.0u
Mx4_x5_x2_XM38 x4_x5_x2_net21 x4_x5_net2 x4_x5_x2_net15 VSS nfet_06v0 L=1.0u W=5.0u
Mx4_x5_x2_XM39 x4_x5_x2_net15 x4_x5_net1 VSS VSS nfet_06v0 L=1.0u W=5.0u
Mx4_x5_x2_XM45 x4_x5_x2_net16 x4_x5_net4 VDD VDD pfet_06v0 L=1.0u W=10.0u
Mx4_x5_x2_XM46 x4_x5_x2_net11 x4_x5_net3 x4_x5_x2_net16 VDD pfet_06v0 L=1.0u W=10.0u
Mx4_x5_x2_XM40 x4_x5_x2_net11 x4_x5_x2_net11 x4_x5_x2_net18 VSS nfet_06v0 L=1.0u W=5.0u
Mx4_x5_x2_XM41 x4_x5_x2_net18 x4_x5_net2 x4_x5_x2_net17 VSS nfet_06v0 L=1.0u W=5.0u
Mx4_x5_x2_XM42 x4_x5_x2_net17 x4_x5_x2_net18 VSS VSS nfet_06v0 L=1.0u W=5.0u
Mx4_x5_x2_XM43_f1 x4_net2 x4_x5_x2_net12 VDD VDD pfet_06v0 L=1.0u W=10u
Mx4_x5_x2_XM43_f2 x4_net2 x4_x5_x2_net12 VDD VDD pfet_06v0 L=1.0u W=10u
Mx4_x5_x2_XM43_f3 x4_net2 x4_x5_x2_net12 VDD VDD pfet_06v0 L=1.0u W=10u
Mx4_x5_x2_XM44_f1 x4_net2 x4_x5_x2_net22 VSS VSS nfet_06v0 L=1.0u W=5u
Mx4_x5_x2_XM44_f2 x4_net2 x4_x5_x2_net22 VSS VSS nfet_06v0 L=1.0u W=5u
Mx4_x5_x2_XM44_f3 x4_net2 x4_x5_x2_net22 VSS VSS nfet_06v0 L=1.0u W=5u
Mx4_x6_x1_XM4 x4_x6_x1_net3 x4_x6_net4 VDD VDD pfet_06v0 L=1.0u W=10.0u
Mx4_x6_x1_XM5 x4_x6_net2 x4_x6_net3 x4_x6_x1_net3 VDD pfet_06v0 L=1.0u W=10.0u
Mx4_x6_x1_XM6 x4_x6_net2 x4_x6_net2 VSS VSS nfet_06v0 L=1.0u W=1.0u
Mx4_x6_x1_XM7 x4_x6_x1_net2 x4_x6_net4 VDD VDD pfet_06v0 L=1.0u W=10.0u
Mx4_x6_x1_XM8 x4_x6_net1 x4_x6_net3 x4_x6_x1_net2 VDD pfet_06v0 L=1.0u W=10.0u
Mx4_x6_x1_XM9 x4_x6_net1 x4_x6_net2 x4_x6_x1_net1 VSS nfet_06v0 L=1.0u W=5.0u
Mx4_x6_x1_XM10 x4_x6_x1_net1 x4_x6_net1 VSS VSS nfet_06v0 L=1.0u W=5.0u
Mx4_x6_x1_XM1 x4_x6_net3 x4_x6_net3 VDD VDD pfet_06v0 L=1.0u W=2u
Mx4_x6_x1_XM2 x4_x6_x1_net4 x4_x6_net4 VDD VDD pfet_06v0 L=1.0u W=10.0u
Mx4_x6_x1_XM3 x4_x6_net4 x4_x6_net3 x4_x6_x1_net4 VDD pfet_06v0 L=1.0u W=10.0u
Mx4_x6_x1_XM47 x4_x6_x1_net5 x4_x6_net3 VSS VSS nfet_06v0 L=1.0u W=1.0u
Mx4_x6_x1_XM48 x4_x6_x1_net6 x4_x6_net3 VSS VSS nfet_06v0 L=1.0u W=1.0u
Mx4_x6_x1_XM49 x4_x6_net3 x4_x6_net3 x4_x6_x1_net6 VSS nfet_06v0 L=1.0u W=1.0u
Mx4_x6_x1_XM50 x4_x6_net4 x4_x6_net3 x4_x6_x1_net5 VSS nfet_06v0 L=1.0u W=1.0u
Mx4_x6_x2_XM11 x4_x6_x2_net2 x4_x6_net4 VDD VDD pfet_06v0 L=1.0u W=10.0u
Mx4_x6_x2_XM12 x4_x6_x2_net7 x4_x6_net3 x4_x6_x2_net2 VDD pfet_06v0 L=1.0u W=10.0u
Mx4_x6_x2_XM13 x4_x6_x2_net19 x4_x6_net4 VDD VDD pfet_06v0 L=1.0u W=10.0u
Mx4_x6_x2_XM14 x4_x6_x2_net7 x4_x6_net3 x4_x6_x2_net19 VDD pfet_06v0 L=1.0u W=10.0u
Mx4_x6_x2_XM15_f1 x4_x6_x2_net5 x4_SZ x4_x6_x2_net7 VDD pfet_06v0 L=1.0u W=10.0u
Mx4_x6_x2_XM15_f2 x4_x6_x2_net5 x4_SZ x4_x6_x2_net7 VDD pfet_06v0 L=1.0u W=10.0u
Mx4_x6_x2_XM16_f1 x4_x6_x2_net4 x4_SY x4_x6_x2_net7 VDD pfet_06v0 L=1.0u W=10.0u
Mx4_x6_x2_XM16_f2 x4_x6_x2_net4 x4_SY x4_x6_x2_net7 VDD pfet_06v0 L=1.0u W=10.0u
Mx4_x6_x2_XM17 x4_x6_x2_net8 x4_x6_net2 x4_x6_x2_net1 VSS nfet_06v0 L=1.0u W=5.0u
Mx4_x6_x2_XM18 x4_x6_x2_net1 x4_x6_net1 VSS VSS nfet_06v0 L=1.0u W=5.0u
Mx4_x6_x2_XM19 x4_x6_x2_net8 x4_x6_net2 x4_x6_x2_net20 VSS nfet_06v0 L=1.0u W=5.0u
Mx4_x6_x2_XM20 x4_x6_x2_net20 x4_x6_net1 VSS VSS nfet_06v0 L=1.0u W=5.0u
Mx4_x6_x2_XM21_f1 x4_x6_x2_net6 x4_SZ x4_x6_x2_net8 VSS nfet_06v0 L=1.0u W=5u
Mx4_x6_x2_XM21_f2 x4_x6_x2_net6 x4_SZ x4_x6_x2_net8 VSS nfet_06v0 L=1.0u W=5u
Mx4_x6_x2_XM22_f1 x4_x6_x2_net3 x4_SY x4_x6_x2_net8 VSS nfet_06v0 L=1.0u W=5u
Mx4_x6_x2_XM22_f2 x4_x6_x2_net3 x4_SY x4_x6_x2_net8 VSS nfet_06v0 L=1.0u W=5u
Mx4_x6_x2_XM29_f1 x4_x6_x2_net9 x4_x6_net3 x4_x6_x2_net3 VDD pfet_06v0 L=1.0u W=5u
Mx4_x6_x2_XM29_f2 x4_x6_x2_net9 x4_x6_net3 x4_x6_x2_net3 VDD pfet_06v0 L=1.0u W=5u
Mx4_x6_x2_XM30_f1 x4_x6_x2_net12 x4_x6_net3 x4_x6_x2_net6 VDD pfet_06v0 L=1.0u W=5.0u
Mx4_x6_x2_XM30_f2 x4_x6_x2_net12 x4_x6_net3 x4_x6_x2_net6 VDD pfet_06v0 L=1.0u W=5.0u
Mx4_x6_x2_XM31_f1 x4_x6_x2_net3 x4_x6_x2_net9 VDD VDD pfet_06v0 L=1.0u W=5u
Mx4_x6_x2_XM31_f2 x4_x6_x2_net3 x4_x6_x2_net9 VDD VDD pfet_06v0 L=1.0u W=5u
Mx4_x6_x2_XM31_f3 x4_x6_x2_net3 x4_x6_x2_net9 VDD VDD pfet_06v0 L=1.0u W=5u
Mx4_x6_x2_XM31_f4 x4_x6_x2_net3 x4_x6_x2_net9 VDD VDD pfet_06v0 L=1.0u W=5u
Mx4_x6_x2_XM35_f1 x4_x6_x2_net6 x4_x6_x2_net9 VDD VDD pfet_06v0 L=1.0u W=5.0u
Mx4_x6_x2_XM35_f2 x4_x6_x2_net6 x4_x6_x2_net9 VDD VDD pfet_06v0 L=1.0u W=5.0u
Mx4_x6_x2_XM35_f3 x4_x6_x2_net6 x4_x6_x2_net9 VDD VDD pfet_06v0 L=1.0u W=5.0u
Mx4_x6_x2_XM35_f4 x4_x6_x2_net6 x4_x6_x2_net9 VDD VDD pfet_06v0 L=1.0u W=5.0u
Mx4_x6_x2_XM32 x4_x6_x2_net10 x4_x6_x2_net21 x4_x6_x2_net9 VDD pfet_06v0 L=1.0u W=5u
Mx4_x6_x2_XM33 x4_x6_x2_net22 x4_x6_x2_net21 x4_x6_x2_net12 VDD pfet_06v0 L=1.0u W=5.0u
Mx4_x6_x2_XM23_f1 x4_x6_x2_net10 x4_x6_net2 x4_x6_x2_net4 VSS nfet_06v0 L=1.0u W=2.5u
Mx4_x6_x2_XM23_f2 x4_x6_x2_net10 x4_x6_net2 x4_x6_x2_net4 VSS nfet_06v0 L=1.0u W=2.5u
Mx4_x6_x2_XM24_f1 x4_x6_x2_net22 x4_x6_net2 x4_x6_x2_net5 VSS nfet_06v0 L=1.0u W=2.5u
Mx4_x6_x2_XM24_f2 x4_x6_x2_net22 x4_x6_net2 x4_x6_x2_net5 VSS nfet_06v0 L=1.0u W=2.5u
Mx4_x6_x2_XM25_f1 x4_x6_x2_net4 x4_x6_x2_net10 VSS VSS nfet_06v0 L=1.0u W=2.5u
Mx4_x6_x2_XM25_f2 x4_x6_x2_net4 x4_x6_x2_net10 VSS VSS nfet_06v0 L=1.0u W=2.5u
Mx4_x6_x2_XM25_f3 x4_x6_x2_net4 x4_x6_x2_net10 VSS VSS nfet_06v0 L=1.0u W=2.5u
Mx4_x6_x2_XM25_f4 x4_x6_x2_net4 x4_x6_x2_net10 VSS VSS nfet_06v0 L=1.0u W=2.5u
Mx4_x6_x2_XM26_f1 x4_x6_x2_net5 x4_x6_x2_net10 VSS VSS nfet_06v0 L=1.0u W=2.5u
Mx4_x6_x2_XM26_f2 x4_x6_x2_net5 x4_x6_x2_net10 VSS VSS nfet_06v0 L=1.0u W=2.5u
Mx4_x6_x2_XM26_f3 x4_x6_x2_net5 x4_x6_x2_net10 VSS VSS nfet_06v0 L=1.0u W=2.5u
Mx4_x6_x2_XM26_f4 x4_x6_x2_net5 x4_x6_x2_net10 VSS VSS nfet_06v0 L=1.0u W=2.5u
Mx4_x6_x2_XM27 x4_x6_x2_net9 x4_x6_x2_net11 x4_x6_x2_net10 VSS nfet_06v0 L=1.0u W=2.5u
Mx4_x6_x2_XM28 x4_x6_x2_net12 x4_x6_x2_net11 x4_x6_x2_net22 VSS nfet_06v0 L=1.0u W=2.5u
Mx4_x6_x2_XM34 x4_x6_x2_net13 x4_x6_x2_net14 VDD VDD pfet_06v0 L=1.0u W=10.0u
Mx4_x6_x2_XM36 x4_x6_x2_net14 x4_x6_net3 x4_x6_x2_net13 VDD pfet_06v0 L=1.0u W=10.0u
Mx4_x6_x2_XM37 x4_x6_x2_net21 x4_x6_x2_net21 x4_x6_x2_net14 VDD pfet_06v0 L=1.0u W=10.0u
Mx4_x6_x2_XM38 x4_x6_x2_net21 x4_x6_net2 x4_x6_x2_net15 VSS nfet_06v0 L=1.0u W=5.0u
Mx4_x6_x2_XM39 x4_x6_x2_net15 x4_x6_net1 VSS VSS nfet_06v0 L=1.0u W=5.0u
Mx4_x6_x2_XM45 x4_x6_x2_net16 x4_x6_net4 VDD VDD pfet_06v0 L=1.0u W=10.0u
Mx4_x6_x2_XM46 x4_x6_x2_net11 x4_x6_net3 x4_x6_x2_net16 VDD pfet_06v0 L=1.0u W=10.0u
Mx4_x6_x2_XM40 x4_x6_x2_net11 x4_x6_x2_net11 x4_x6_x2_net18 VSS nfet_06v0 L=1.0u W=5.0u
Mx4_x6_x2_XM41 x4_x6_x2_net18 x4_x6_net2 x4_x6_x2_net17 VSS nfet_06v0 L=1.0u W=5.0u
Mx4_x6_x2_XM42 x4_x6_x2_net17 x4_x6_x2_net18 VSS VSS nfet_06v0 L=1.0u W=5.0u
Mx4_x6_x2_XM43_f1 x4_net3 x4_x6_x2_net12 VDD VDD pfet_06v0 L=1.0u W=10u
Mx4_x6_x2_XM43_f2 x4_net3 x4_x6_x2_net12 VDD VDD pfet_06v0 L=1.0u W=10u
Mx4_x6_x2_XM43_f3 x4_net3 x4_x6_x2_net12 VDD VDD pfet_06v0 L=1.0u W=10u
Mx4_x6_x2_XM44_f1 x4_net3 x4_x6_x2_net22 VSS VSS nfet_06v0 L=1.0u W=5u
Mx4_x6_x2_XM44_f2 x4_net3 x4_x6_x2_net22 VSS VSS nfet_06v0 L=1.0u W=5u
Mx4_x6_x2_XM44_f3 x4_net3 x4_x6_x2_net22 VSS VSS nfet_06v0 L=1.0u W=5u
Mx4_x7_x2_x2_XM4 x4_x7_x2_net1 x4_net1 VDD VDD pfet_06v0 L=1.0u W=3.0u
Mx4_x7_x2_x2_XM5 VSS x4_net1 x4_x7_x2_net1 VSS nfet_06v0 L=1u W=1u
Mx4_x7_x2_x3_XM4 Y4 x4_x7_x2_x3_net1 VDD VDD pfet_06v0 L=1.0u W=3.0u
Mx4_x7_x2_x3_XM5 VSS x4_x7_x2_x3_net1 Y4 VSS nfet_06v0 L=1u W=1u
Mx4_x7_x2_x3_XM2 VDD x4_net3 x4_x7_x2_x3_net1 VDD pfet_06v0 L=1.0u W=3.0u
Mx4_x7_x2_x3_XM1 VDD x4_x7_x2_net1 x4_x7_x2_x3_net1 VDD pfet_06v0 L=1.0u W=3.0u
Mx4_x7_x2_x3_XM3 VSS x4_net3 x4_x7_x2_x3_net2 VSS nfet_06v0 L=1u W=1u
Mx4_x7_x2_x3_XM6 x4_x7_x2_x3_net2 x4_x7_x2_net1 x4_x7_x2_x3_net1 VSS nfet_06v0 L=1u W=1u
Mx4_x7_x1_XM4 x4_x7_x1_net1 x4_net3 Z4 VDD pfet_06v0 L=1.0u W=3.0u
Mx4_x7_x1_XM5 VDD x4_net2 x4_x7_x1_net1 VDD pfet_06v0 L=1.0u W=3.0u
Mx4_x7_x1_XM7 VSS x4_net3 Z4 VSS nfet_06v0 L=1u W=1u
Mx4_x7_x1_XM1 VSS x4_net2 Z4 VSS nfet_06v0 L=1u W=1u
Mx4_x7_x3_x2_XM4 X4 x4_x7_x3_x2_net1 VDD VDD pfet_06v0 L=1.0u W=3.0u
Mx4_x7_x3_x2_XM5 VSS x4_x7_x3_x2_net1 X4 VSS nfet_06v0 L=1u W=1u
Mx4_x7_x3_x2_XM2 VDD x4_net1 x4_x7_x3_x2_net1 VDD pfet_06v0 L=1.0u W=3.0u
Mx4_x7_x3_x2_XM1 VDD x4_net2 x4_x7_x3_x2_net1 VDD pfet_06v0 L=1.0u W=3.0u
Mx4_x7_x3_x2_XM3 VSS x4_net1 x4_x7_x3_x2_net2 VSS nfet_06v0 L=1u W=1u
Mx4_x7_x3_x2_XM6 x4_x7_x3_x2_net2 x4_net2 x4_x7_x3_x2_net1 VSS nfet_06v0 L=1u W=1u
Mx4_x8_x1_XM4 x4_x8_x1_net3 x4_x8_net3 VDD VDD pfet_06v0 L=1.0u W=10.0u
Mx4_x8_x1_XM5 x4_x8_net2 x4_x8_net4 x4_x8_x1_net3 VDD pfet_06v0 L=1.0u W=10.0u
Mx4_x8_x1_XM6 x4_x8_net2 x4_x8_net2 VSS VSS nfet_06v0 L=1.0u W=1.0u
Mx4_x8_x1_XM7 x4_x8_x1_net2 x4_x8_net3 VDD VDD pfet_06v0 L=1.0u W=10.0u
Mx4_x8_x1_XM8 x4_x8_net1 x4_x8_net4 x4_x8_x1_net2 VDD pfet_06v0 L=1.0u W=10.0u
Mx4_x8_x1_XM9 x4_x8_net1 x4_x8_net2 x4_x8_x1_net1 VSS nfet_06v0 L=1.0u W=5.0u
Mx4_x8_x1_XM10 x4_x8_x1_net1 x4_x8_net1 VSS VSS nfet_06v0 L=1.0u W=5.0u
Mx4_x8_x1_XM1 x4_x8_net4 x4_x8_net4 VDD VDD pfet_06v0 L=1.0u W=2u
Mx4_x8_x1_XM2 x4_x8_x1_net4 x4_x8_net3 VDD VDD pfet_06v0 L=1.0u W=10.0u
Mx4_x8_x1_XM3 x4_x8_net3 x4_x8_net4 x4_x8_x1_net4 VDD pfet_06v0 L=1.0u W=10.0u
Mx4_x8_x1_XM47 x4_x8_x1_net5 x4_x8_net4 VSS VSS nfet_06v0 L=1.0u W=1.0u
Mx4_x8_x1_XM48 x4_x8_x1_net6 x4_x8_net4 VSS VSS nfet_06v0 L=1.0u W=1.0u
Mx4_x8_x1_XM49 x4_x8_net4 x4_x8_net4 x4_x8_x1_net6 VSS nfet_06v0 L=1.0u W=1.0u
Mx4_x8_x1_XM50 x4_x8_net3 x4_x8_net4 x4_x8_x1_net5 VSS nfet_06v0 L=1.0u W=1.0u
Mx4_x8_x2_XM11 x4_x8_x2_net2 x4_x8_net3 VDD VDD pfet_06v0 L=1.0u W=10.0u
Mx4_x8_x2_XM12 x4_x8_x2_net7 x4_x8_net4 x4_x8_x2_net2 VDD pfet_06v0 L=1.0u W=10.0u
Mx4_x8_x2_XM13 x4_x8_x2_net18 x4_x8_net3 VDD VDD pfet_06v0 L=1.0u W=10.0u
Mx4_x8_x2_XM14 x4_x8_x2_net7 x4_x8_net4 x4_x8_x2_net18 VDD pfet_06v0 L=1.0u W=10.0u
Mx4_x8_x2_XM15 x4_x8_x2_net5 S2P x4_x8_x2_net7 VDD pfet_06v0 L=1.0u W=0.55u
Mx4_x8_x2_XM16 x4_x8_x2_net4 S2N x4_x8_x2_net7 VDD pfet_06v0 L=1.0u W=0.5u
Mx4_x8_x2_XM17 x4_x8_x2_net8 x4_x8_net2 x4_x8_x2_net1 VSS nfet_06v0 L=1.0u W=5.0u
Mx4_x8_x2_XM18 x4_x8_x2_net1 x4_x8_net1 VSS VSS nfet_06v0 L=1.0u W=5.0u
Mx4_x8_x2_XM19 x4_x8_x2_net8 x4_x8_net2 x4_x8_x2_net19 VSS nfet_06v0 L=1.0u W=5.0u
Mx4_x8_x2_XM20 x4_x8_x2_net19 x4_x8_net1 VSS VSS nfet_06v0 L=1.0u W=5.0u
Mx4_x8_x2_XM21 x4_x8_x2_net6 S2P x4_x8_x2_net8 VSS nfet_06v0 L=1.0u W=7.5u
Mx4_x8_x2_XM22 x4_x8_x2_net3 S2N x4_x8_x2_net8 VSS nfet_06v0 L=1.0u W=8.5u
Mx4_x8_x2_XM29 x4_x8_x2_net9 x4_x8_net4 x4_x8_x2_net3 VDD pfet_06v0 L=1.0u W=10u
Mx4_x8_x2_XM30 x4_x8_x2_G_OUT_P x4_x8_net4 x4_x8_x2_net6 VDD pfet_06v0 L=1.0u W=10u
Mx4_x8_x2_XM31 x4_x8_x2_net3 x4_x8_x2_net9 VDD VDD pfet_06v0 L=1.0u W=5u
Mx4_x8_x2_XM35 x4_x8_x2_net6 x4_x8_x2_net9 VDD VDD pfet_06v0 L=1.0u W=5u
Mx4_x8_x2_XM32 x4_x8_x2_net10 x4_x8_x2_net20 x4_x8_x2_net9 VDD pfet_06v0 L=1.0u W=4.0u
Mx4_x8_x2_XM33 x4_x8_x2_net21 x4_x8_x2_net20 x4_x8_x2_G_OUT_P VDD pfet_06v0 L=1.0u W=4.0u
Mx4_x8_x2_XM23 x4_x8_x2_net10 x4_x8_net2 x4_x8_x2_net4 VSS nfet_06v0 L=1.0u W=2.5u
Mx4_x8_x2_XM24 x4_x8_x2_net21 x4_x8_net2 x4_x8_x2_net5 VSS nfet_06v0 L=1.0u W=2.5u
Mx4_x8_x2_XM25 x4_x8_x2_net4 x4_x8_x2_net10 VSS VSS nfet_06v0 L=1.0u W=2.5u
Mx4_x8_x2_XM26 x4_x8_x2_net5 x4_x8_x2_net10 VSS VSS nfet_06v0 L=1.0u W=2.5u
Mx4_x8_x2_XM27 x4_x8_x2_net9 x4_x8_x2_net11 x4_x8_x2_net10 VSS nfet_06v0 L=1.0u W=2.0u
Mx4_x8_x2_XM28 x4_x8_x2_G_OUT_P x4_x8_x2_net11 x4_x8_x2_net21 VSS nfet_06v0 L=1.0u W=2.0u
Mx4_x8_x2_XM34 x4_x8_x2_net12 x4_x8_x2_net13 VDD VDD pfet_06v0 L=1.0u W=10.0u
Mx4_x8_x2_XM36 x4_x8_x2_net13 x4_x8_net4 x4_x8_x2_net12 VDD pfet_06v0 L=1.0u W=10.0u
Mx4_x8_x2_XM37 x4_x8_x2_net20 x4_x8_x2_net20 x4_x8_x2_net13 VDD pfet_06v0 L=1.0u W=10.0u
Mx4_x8_x2_XM38 x4_x8_x2_net20 x4_x8_net2 x4_x8_x2_net14 VSS nfet_06v0 L=1.0u W=5.0u
Mx4_x8_x2_XM39 x4_x8_x2_net14 x4_x8_net1 VSS VSS nfet_06v0 L=1.0u W=5.0u
Mx4_x8_x2_XM45 x4_x8_x2_net15 x4_x8_net3 VDD VDD pfet_06v0 L=1.0u W=10.0u
Mx4_x8_x2_XM46 x4_x8_x2_net11 x4_x8_net4 x4_x8_x2_net15 VDD pfet_06v0 L=1.0u W=10.0u
Mx4_x8_x2_XM40 x4_x8_x2_net11 x4_x8_x2_net11 x4_x8_x2_net17 VSS nfet_06v0 L=1.0u W=5.0u
Mx4_x8_x2_XM41 x4_x8_x2_net17 x4_x8_net2 x4_x8_x2_net16 VSS nfet_06v0 L=1.0u W=5.0u
Mx4_x8_x2_XM42 x4_x8_x2_net16 x4_x8_x2_net17 VSS VSS nfet_06v0 L=1.0u W=5.0u
Mx4_x8_x2_XM43_m1 x4_SX x4_x8_x2_G_OUT_P VDD VDD pfet_06v0 L=1.0u W=1.0u
Mx4_x8_x2_XM43_m2 x4_SX x4_x8_x2_G_OUT_P VDD VDD pfet_06v0 L=1.0u W=1.0u
Mx4_x8_x2_XM43_m3 x4_SX x4_x8_x2_G_OUT_P VDD VDD pfet_06v0 L=1.0u W=1.0u
Mx4_x8_x2_XM43_m4 x4_SX x4_x8_x2_G_OUT_P VDD VDD pfet_06v0 L=1.0u W=1.0u
Mx4_x8_x2_XM44 x4_SX x4_x8_x2_net21 VSS VSS nfet_06v0 L=1.0u W=1.0u
Mx4_x1_x1_XM4 x4_x1_x1_net3 x4_x1_net3 VDD VDD pfet_06v0 L=1.0u W=10.0u
Mx4_x1_x1_XM5 x4_x1_net2 x4_x1_net4 x4_x1_x1_net3 VDD pfet_06v0 L=1.0u W=10.0u
Mx4_x1_x1_XM6 x4_x1_net2 x4_x1_net2 VSS VSS nfet_06v0 L=1.0u W=1.0u
Mx4_x1_x1_XM7 x4_x1_x1_net2 x4_x1_net3 VDD VDD pfet_06v0 L=1.0u W=10.0u
Mx4_x1_x1_XM8 x4_x1_net1 x4_x1_net4 x4_x1_x1_net2 VDD pfet_06v0 L=1.0u W=10.0u
Mx4_x1_x1_XM9 x4_x1_net1 x4_x1_net2 x4_x1_x1_net1 VSS nfet_06v0 L=1.0u W=5.0u
Mx4_x1_x1_XM10 x4_x1_x1_net1 x4_x1_net1 VSS VSS nfet_06v0 L=1.0u W=5.0u
Mx4_x1_x1_XM1 x4_x1_net4 x4_x1_net4 VDD VDD pfet_06v0 L=1.0u W=2u
Mx4_x1_x1_XM2 x4_x1_x1_net4 x4_x1_net3 VDD VDD pfet_06v0 L=1.0u W=10.0u
Mx4_x1_x1_XM3 x4_x1_net3 x4_x1_net4 x4_x1_x1_net4 VDD pfet_06v0 L=1.0u W=10.0u
Mx4_x1_x1_XM47 x4_x1_x1_net5 x4_x1_net4 VSS VSS nfet_06v0 L=1.0u W=1.0u
Mx4_x1_x1_XM48 x4_x1_x1_net6 x4_x1_net4 VSS VSS nfet_06v0 L=1.0u W=1.0u
Mx4_x1_x1_XM49 x4_x1_net4 x4_x1_net4 x4_x1_x1_net6 VSS nfet_06v0 L=1.0u W=1.0u
Mx4_x1_x1_XM50 x4_x1_net3 x4_x1_net4 x4_x1_x1_net5 VSS nfet_06v0 L=1.0u W=1.0u
Mx4_x1_x2_XM11 x4_x1_x2_net2 x4_x1_net3 VDD VDD pfet_06v0 L=1.0u W=10.0u
Mx4_x1_x2_XM12 x4_x1_x2_net7 x4_x1_net4 x4_x1_x2_net2 VDD pfet_06v0 L=1.0u W=10.0u
Mx4_x1_x2_XM13 x4_x1_x2_net18 x4_x1_net3 VDD VDD pfet_06v0 L=1.0u W=10.0u
Mx4_x1_x2_XM14 x4_x1_x2_net7 x4_x1_net4 x4_x1_x2_net18 VDD pfet_06v0 L=1.0u W=10.0u
Mx4_x1_x2_XM15 x4_x1_x2_net5 S3P x4_x1_x2_net7 VDD pfet_06v0 L=1.0u W=0.55u
Mx4_x1_x2_XM16 x4_x1_x2_net4 S3N x4_x1_x2_net7 VDD pfet_06v0 L=1.0u W=0.5u
Mx4_x1_x2_XM17 x4_x1_x2_net8 x4_x1_net2 x4_x1_x2_net1 VSS nfet_06v0 L=1.0u W=5.0u
Mx4_x1_x2_XM18 x4_x1_x2_net1 x4_x1_net1 VSS VSS nfet_06v0 L=1.0u W=5.0u
Mx4_x1_x2_XM19 x4_x1_x2_net8 x4_x1_net2 x4_x1_x2_net19 VSS nfet_06v0 L=1.0u W=5.0u
Mx4_x1_x2_XM20 x4_x1_x2_net19 x4_x1_net1 VSS VSS nfet_06v0 L=1.0u W=5.0u
Mx4_x1_x2_XM21 x4_x1_x2_net6 S3P x4_x1_x2_net8 VSS nfet_06v0 L=1.0u W=7.5u
Mx4_x1_x2_XM22 x4_x1_x2_net3 S3N x4_x1_x2_net8 VSS nfet_06v0 L=1.0u W=8.5u
Mx4_x1_x2_XM29 x4_x1_x2_net9 x4_x1_net4 x4_x1_x2_net3 VDD pfet_06v0 L=1.0u W=10u
Mx4_x1_x2_XM30 x4_x1_x2_G_OUT_P x4_x1_net4 x4_x1_x2_net6 VDD pfet_06v0 L=1.0u W=10u
Mx4_x1_x2_XM31 x4_x1_x2_net3 x4_x1_x2_net9 VDD VDD pfet_06v0 L=1.0u W=5u
Mx4_x1_x2_XM35 x4_x1_x2_net6 x4_x1_x2_net9 VDD VDD pfet_06v0 L=1.0u W=5u
Mx4_x1_x2_XM32 x4_x1_x2_net10 x4_x1_x2_net20 x4_x1_x2_net9 VDD pfet_06v0 L=1.0u W=4.0u
Mx4_x1_x2_XM33 x4_x1_x2_net21 x4_x1_x2_net20 x4_x1_x2_G_OUT_P VDD pfet_06v0 L=1.0u W=4.0u
Mx4_x1_x2_XM23 x4_x1_x2_net10 x4_x1_net2 x4_x1_x2_net4 VSS nfet_06v0 L=1.0u W=2.5u
Mx4_x1_x2_XM24 x4_x1_x2_net21 x4_x1_net2 x4_x1_x2_net5 VSS nfet_06v0 L=1.0u W=2.5u
Mx4_x1_x2_XM25 x4_x1_x2_net4 x4_x1_x2_net10 VSS VSS nfet_06v0 L=1.0u W=2.5u
Mx4_x1_x2_XM26 x4_x1_x2_net5 x4_x1_x2_net10 VSS VSS nfet_06v0 L=1.0u W=2.5u
Mx4_x1_x2_XM27 x4_x1_x2_net9 x4_x1_x2_net11 x4_x1_x2_net10 VSS nfet_06v0 L=1.0u W=2.0u
Mx4_x1_x2_XM28 x4_x1_x2_G_OUT_P x4_x1_x2_net11 x4_x1_x2_net21 VSS nfet_06v0 L=1.0u W=2.0u
Mx4_x1_x2_XM34 x4_x1_x2_net12 x4_x1_x2_net13 VDD VDD pfet_06v0 L=1.0u W=10.0u
Mx4_x1_x2_XM36 x4_x1_x2_net13 x4_x1_net4 x4_x1_x2_net12 VDD pfet_06v0 L=1.0u W=10.0u
Mx4_x1_x2_XM37 x4_x1_x2_net20 x4_x1_x2_net20 x4_x1_x2_net13 VDD pfet_06v0 L=1.0u W=10.0u
Mx4_x1_x2_XM38 x4_x1_x2_net20 x4_x1_net2 x4_x1_x2_net14 VSS nfet_06v0 L=1.0u W=5.0u
Mx4_x1_x2_XM39 x4_x1_x2_net14 x4_x1_net1 VSS VSS nfet_06v0 L=1.0u W=5.0u
Mx4_x1_x2_XM45 x4_x1_x2_net15 x4_x1_net3 VDD VDD pfet_06v0 L=1.0u W=10.0u
Mx4_x1_x2_XM46 x4_x1_x2_net11 x4_x1_net4 x4_x1_x2_net15 VDD pfet_06v0 L=1.0u W=10.0u
Mx4_x1_x2_XM40 x4_x1_x2_net11 x4_x1_x2_net11 x4_x1_x2_net17 VSS nfet_06v0 L=1.0u W=5.0u
Mx4_x1_x2_XM41 x4_x1_x2_net17 x4_x1_net2 x4_x1_x2_net16 VSS nfet_06v0 L=1.0u W=5.0u
Mx4_x1_x2_XM42 x4_x1_x2_net16 x4_x1_x2_net17 VSS VSS nfet_06v0 L=1.0u W=5.0u
Mx4_x1_x2_XM43_m1 x4_SY x4_x1_x2_G_OUT_P VDD VDD pfet_06v0 L=1.0u W=1.0u
Mx4_x1_x2_XM43_m2 x4_SY x4_x1_x2_G_OUT_P VDD VDD pfet_06v0 L=1.0u W=1.0u
Mx4_x1_x2_XM43_m3 x4_SY x4_x1_x2_G_OUT_P VDD VDD pfet_06v0 L=1.0u W=1.0u
Mx4_x1_x2_XM43_m4 x4_SY x4_x1_x2_G_OUT_P VDD VDD pfet_06v0 L=1.0u W=1.0u
Mx4_x1_x2_XM44 x4_SY x4_x1_x2_net21 VSS VSS nfet_06v0 L=1.0u W=1.0u
Mx4_x2_x1_XM4 x4_x2_x1_net3 x4_x2_net3 VDD VDD pfet_06v0 L=1.0u W=10.0u
Mx4_x2_x1_XM5 x4_x2_net2 x4_x2_net4 x4_x2_x1_net3 VDD pfet_06v0 L=1.0u W=10.0u
Mx4_x2_x1_XM6 x4_x2_net2 x4_x2_net2 VSS VSS nfet_06v0 L=1.0u W=1.0u
Mx4_x2_x1_XM7 x4_x2_x1_net2 x4_x2_net3 VDD VDD pfet_06v0 L=1.0u W=10.0u
Mx4_x2_x1_XM8 x4_x2_net1 x4_x2_net4 x4_x2_x1_net2 VDD pfet_06v0 L=1.0u W=10.0u
Mx4_x2_x1_XM9 x4_x2_net1 x4_x2_net2 x4_x2_x1_net1 VSS nfet_06v0 L=1.0u W=5.0u
Mx4_x2_x1_XM10 x4_x2_x1_net1 x4_x2_net1 VSS VSS nfet_06v0 L=1.0u W=5.0u
Mx4_x2_x1_XM1 x4_x2_net4 x4_x2_net4 VDD VDD pfet_06v0 L=1.0u W=2u
Mx4_x2_x1_XM2 x4_x2_x1_net4 x4_x2_net3 VDD VDD pfet_06v0 L=1.0u W=10.0u
Mx4_x2_x1_XM3 x4_x2_net3 x4_x2_net4 x4_x2_x1_net4 VDD pfet_06v0 L=1.0u W=10.0u
Mx4_x2_x1_XM47 x4_x2_x1_net5 x4_x2_net4 VSS VSS nfet_06v0 L=1.0u W=1.0u
Mx4_x2_x1_XM48 x4_x2_x1_net6 x4_x2_net4 VSS VSS nfet_06v0 L=1.0u W=1.0u
Mx4_x2_x1_XM49 x4_x2_net4 x4_x2_net4 x4_x2_x1_net6 VSS nfet_06v0 L=1.0u W=1.0u
Mx4_x2_x1_XM50 x4_x2_net3 x4_x2_net4 x4_x2_x1_net5 VSS nfet_06v0 L=1.0u W=1.0u
Mx4_x2_x2_XM11 x4_x2_x2_net2 x4_x2_net3 VDD VDD pfet_06v0 L=1.0u W=10.0u
Mx4_x2_x2_XM12 x4_x2_x2_net7 x4_x2_net4 x4_x2_x2_net2 VDD pfet_06v0 L=1.0u W=10.0u
Mx4_x2_x2_XM13 x4_x2_x2_net18 x4_x2_net3 VDD VDD pfet_06v0 L=1.0u W=10.0u
Mx4_x2_x2_XM14 x4_x2_x2_net7 x4_x2_net4 x4_x2_x2_net18 VDD pfet_06v0 L=1.0u W=10.0u
Mx4_x2_x2_XM15 x4_x2_x2_net5 S4P x4_x2_x2_net7 VDD pfet_06v0 L=1.0u W=0.55u
Mx4_x2_x2_XM16 x4_x2_x2_net4 S4N x4_x2_x2_net7 VDD pfet_06v0 L=1.0u W=0.5u
Mx4_x2_x2_XM17 x4_x2_x2_net8 x4_x2_net2 x4_x2_x2_net1 VSS nfet_06v0 L=1.0u W=5.0u
Mx4_x2_x2_XM18 x4_x2_x2_net1 x4_x2_net1 VSS VSS nfet_06v0 L=1.0u W=5.0u
Mx4_x2_x2_XM19 x4_x2_x2_net8 x4_x2_net2 x4_x2_x2_net19 VSS nfet_06v0 L=1.0u W=5.0u
Mx4_x2_x2_XM20 x4_x2_x2_net19 x4_x2_net1 VSS VSS nfet_06v0 L=1.0u W=5.0u
Mx4_x2_x2_XM21 x4_x2_x2_net6 S4P x4_x2_x2_net8 VSS nfet_06v0 L=1.0u W=7.5u
Mx4_x2_x2_XM22 x4_x2_x2_net3 S4N x4_x2_x2_net8 VSS nfet_06v0 L=1.0u W=8.5u
Mx4_x2_x2_XM29 x4_x2_x2_net9 x4_x2_net4 x4_x2_x2_net3 VDD pfet_06v0 L=1.0u W=10u
Mx4_x2_x2_XM30 x4_x2_x2_G_OUT_P x4_x2_net4 x4_x2_x2_net6 VDD pfet_06v0 L=1.0u W=10u
Mx4_x2_x2_XM31 x4_x2_x2_net3 x4_x2_x2_net9 VDD VDD pfet_06v0 L=1.0u W=5u
Mx4_x2_x2_XM35 x4_x2_x2_net6 x4_x2_x2_net9 VDD VDD pfet_06v0 L=1.0u W=5u
Mx4_x2_x2_XM32 x4_x2_x2_net10 x4_x2_x2_net20 x4_x2_x2_net9 VDD pfet_06v0 L=1.0u W=4.0u
Mx4_x2_x2_XM33 x4_x2_x2_net21 x4_x2_x2_net20 x4_x2_x2_G_OUT_P VDD pfet_06v0 L=1.0u W=4.0u
Mx4_x2_x2_XM23 x4_x2_x2_net10 x4_x2_net2 x4_x2_x2_net4 VSS nfet_06v0 L=1.0u W=2.5u
Mx4_x2_x2_XM24 x4_x2_x2_net21 x4_x2_net2 x4_x2_x2_net5 VSS nfet_06v0 L=1.0u W=2.5u
Mx4_x2_x2_XM25 x4_x2_x2_net4 x4_x2_x2_net10 VSS VSS nfet_06v0 L=1.0u W=2.5u
Mx4_x2_x2_XM26 x4_x2_x2_net5 x4_x2_x2_net10 VSS VSS nfet_06v0 L=1.0u W=2.5u
Mx4_x2_x2_XM27 x4_x2_x2_net9 x4_x2_x2_net11 x4_x2_x2_net10 VSS nfet_06v0 L=1.0u W=2.0u
Mx4_x2_x2_XM28 x4_x2_x2_G_OUT_P x4_x2_x2_net11 x4_x2_x2_net21 VSS nfet_06v0 L=1.0u W=2.0u
Mx4_x2_x2_XM34 x4_x2_x2_net12 x4_x2_x2_net13 VDD VDD pfet_06v0 L=1.0u W=10.0u
Mx4_x2_x2_XM36 x4_x2_x2_net13 x4_x2_net4 x4_x2_x2_net12 VDD pfet_06v0 L=1.0u W=10.0u
Mx4_x2_x2_XM37 x4_x2_x2_net20 x4_x2_x2_net20 x4_x2_x2_net13 VDD pfet_06v0 L=1.0u W=10.0u
Mx4_x2_x2_XM38 x4_x2_x2_net20 x4_x2_net2 x4_x2_x2_net14 VSS nfet_06v0 L=1.0u W=5.0u
Mx4_x2_x2_XM39 x4_x2_x2_net14 x4_x2_net1 VSS VSS nfet_06v0 L=1.0u W=5.0u
Mx4_x2_x2_XM45 x4_x2_x2_net15 x4_x2_net3 VDD VDD pfet_06v0 L=1.0u W=10.0u
Mx4_x2_x2_XM46 x4_x2_x2_net11 x4_x2_net4 x4_x2_x2_net15 VDD pfet_06v0 L=1.0u W=10.0u
Mx4_x2_x2_XM40 x4_x2_x2_net11 x4_x2_x2_net11 x4_x2_x2_net17 VSS nfet_06v0 L=1.0u W=5.0u
Mx4_x2_x2_XM41 x4_x2_x2_net17 x4_x2_net2 x4_x2_x2_net16 VSS nfet_06v0 L=1.0u W=5.0u
Mx4_x2_x2_XM42 x4_x2_x2_net16 x4_x2_x2_net17 VSS VSS nfet_06v0 L=1.0u W=5.0u
Mx4_x2_x2_XM43_m1 x4_SZ x4_x2_x2_G_OUT_P VDD VDD pfet_06v0 L=1.0u W=1.0u
Mx4_x2_x2_XM43_m2 x4_SZ x4_x2_x2_G_OUT_P VDD VDD pfet_06v0 L=1.0u W=1.0u
Mx4_x2_x2_XM43_m3 x4_SZ x4_x2_x2_G_OUT_P VDD VDD pfet_06v0 L=1.0u W=1.0u
Mx4_x2_x2_XM43_m4 x4_SZ x4_x2_x2_G_OUT_P VDD VDD pfet_06v0 L=1.0u W=1.0u
Mx4_x2_x2_XM44 x4_SZ x4_x2_x2_net21 VSS VSS nfet_06v0 L=1.0u W=1.0u
Mdecn0 VSS VDD VSS VSS nfet_06v0 L=2.0u W=1.0u
Mdecn1 VSS VDD VSS VSS nfet_06v0 L=2.0u W=1.0u
Mdecn2 VSS VDD VSS VSS nfet_06v0 L=2.0u W=1.0u
Mdecn3 VSS VDD VSS VSS nfet_06v0 L=2.0u W=1.0u
Mdecn4 VSS VDD VSS VSS nfet_06v0 L=2.0u W=1.0u
Mdecn5 VSS VDD VSS VSS nfet_06v0 L=2.0u W=1.0u
Mdecn6 VSS VDD VSS VSS nfet_06v0 L=2.0u W=1.0u
Mdecn7 VSS VDD VSS VSS nfet_06v0 L=2.0u W=1.0u
Mdecn8 VSS VDD VSS VSS nfet_06v0 L=2.0u W=1.0u
Mdecn9 VSS VDD VSS VSS nfet_06v0 L=2.0u W=1.0u
Mdecn10 VSS VDD VSS VSS nfet_06v0 L=2.0u W=1.0u
Mdecn11 VSS VDD VSS VSS nfet_06v0 L=2.0u W=1.0u
Mdecn12 VSS VDD VSS VSS nfet_06v0 L=2.0u W=1.0u
Mdecp13 VDD VSS VDD VDD pfet_06v0 L=2.0u W=1.0u
Mdecp14 VDD VSS VDD VDD pfet_06v0 L=2.0u W=1.0u
Mdecp15 VDD VSS VDD VDD pfet_06v0 L=2.0u W=1.0u
Mdecp16 VDD VSS VDD VDD pfet_06v0 L=2.0u W=1.0u
Mdecp17 VDD VSS VDD VDD pfet_06v0 L=2.0u W=1.0u
Mdecp18 VDD VSS VDD VDD pfet_06v0 L=2.0u W=1.0u
Mdecp19 VDD VSS VDD VDD pfet_06v0 L=2.0u W=1.0u
Mdecp20 VDD VSS VDD VDD pfet_06v0 L=2.0u W=1.0u
Mdecp21 VDD VSS VDD VDD pfet_06v0 L=2.0u W=1.0u
Mdecp22 VDD VSS VDD VDD pfet_06v0 L=2.0u W=1.0u
Mdecp23 VDD VSS VDD VDD pfet_06v0 L=2.0u W=1.0u
Mdecp24 VDD VSS VDD VDD pfet_06v0 L=2.0u W=1.0u
Mdecn25 VSS VDD VSS VSS nfet_06v0 L=2.0u W=18.0u
Mdecn26 VSS VDD VSS VSS nfet_06v0 L=2.0u W=18.0u
Mdecn27 VSS VDD VSS VSS nfet_06v0 L=2.0u W=18.0u
Mdecp28 VDD VSS VDD VDD pfet_06v0 L=2.0u W=18.0u
Mdecp29 VDD VSS VDD VDD pfet_06v0 L=2.0u W=18.0u
Mdecn30 VSS VDD VSS VSS nfet_06v0 L=2.0u W=18.0u
Mdecn31 VSS VDD VSS VSS nfet_06v0 L=2.0u W=18.0u
Mdecn32 VSS VDD VSS VSS nfet_06v0 L=2.0u W=18.0u
Mdecp33 VDD VSS VDD VDD pfet_06v0 L=2.0u W=18.0u
Mdecp34 VDD VSS VDD VDD pfet_06v0 L=2.0u W=18.0u
Mdecn35 VSS VDD VSS VSS nfet_06v0 L=2.0u W=18.0u
Mdecn36 VSS VDD VSS VSS nfet_06v0 L=2.0u W=18.0u
Mdecn37 VSS VDD VSS VSS nfet_06v0 L=2.0u W=18.0u
Mdecp38 VDD VSS VDD VDD pfet_06v0 L=2.0u W=18.0u
Mdecp39 VDD VSS VDD VDD pfet_06v0 L=2.0u W=18.0u
Mdecn40 VSS VDD VSS VSS nfet_06v0 L=2.0u W=18.0u
Mdecn41 VSS VDD VSS VSS nfet_06v0 L=2.0u W=18.0u
Mdecp42 VDD VSS VDD VDD pfet_06v0 L=2.0u W=18.0u
Mdecp43 VDD VSS VDD VDD pfet_06v0 L=2.0u W=18.0u
Mdecn44 VSS VDD VSS VSS nfet_06v0 L=2.0u W=18.0u
Mdecn45 VSS VDD VSS VSS nfet_06v0 L=2.0u W=18.0u
Mdecp46 VDD VSS VDD VDD pfet_06v0 L=2.0u W=18.0u
Mdecp47 VDD VSS VDD VDD pfet_06v0 L=2.0u W=18.0u
Mdecn48 VSS VDD VSS VSS nfet_06v0 L=2.0u W=18.0u
Mdecn49 VSS VDD VSS VSS nfet_06v0 L=2.0u W=18.0u
Mdecp50 VDD VSS VDD VDD pfet_06v0 L=2.0u W=18.0u
Mdecp51 VDD VSS VDD VDD pfet_06v0 L=2.0u W=18.0u
Mdecn52 VSS VDD VSS VSS nfet_06v0 L=2.0u W=18.0u
Mdecn53 VSS VDD VSS VSS nfet_06v0 L=2.0u W=18.0u
Mdecp54 VDD VSS VDD VDD pfet_06v0 L=2.0u W=18.0u
Mdecp55 VDD VSS VDD VDD pfet_06v0 L=2.0u W=18.0u
Mdecn56 VSS VDD VSS VSS nfet_06v0 L=2.0u W=18.0u
Mdecn57 VSS VDD VSS VSS nfet_06v0 L=2.0u W=18.0u
Mdecp58 VDD VSS VDD VDD pfet_06v0 L=2.0u W=18.0u
Mdecp59 VDD VSS VDD VDD pfet_06v0 L=2.0u W=18.0u
Mdecn60 VSS VDD VSS VSS nfet_06v0 L=2.0u W=18.0u
Mdecn61 VSS VDD VSS VSS nfet_06v0 L=2.0u W=18.0u
Mdecp62 VDD VSS VDD VDD pfet_06v0 L=2.0u W=18.0u
Mdecp63 VDD VSS VDD VDD pfet_06v0 L=2.0u W=18.0u
Mdecn64 VSS VDD VSS VSS nfet_06v0 L=2.0u W=18.0u
Mdecn65 VSS VDD VSS VSS nfet_06v0 L=2.0u W=18.0u
Mdecp66 VDD VSS VDD VDD pfet_06v0 L=2.0u W=18.0u
Mdecp67 VDD VSS VDD VDD pfet_06v0 L=2.0u W=18.0u
Mdecn68 VSS VDD VSS VSS nfet_06v0 L=2.0u W=18.0u
Mdecn69 VSS VDD VSS VSS nfet_06v0 L=2.0u W=18.0u
Mdecp70 VDD VSS VDD VDD pfet_06v0 L=2.0u W=18.0u
Mdecp71 VDD VSS VDD VDD pfet_06v0 L=2.0u W=18.0u
Mdecn72 VSS VDD VSS VSS nfet_06v0 L=2.0u W=18.0u
Mdecn73 VSS VDD VSS VSS nfet_06v0 L=2.0u W=18.0u
Mdecp74 VDD VSS VDD VDD pfet_06v0 L=2.0u W=18.0u
Mdecp75 VDD VSS VDD VDD pfet_06v0 L=2.0u W=18.0u
Mdecn76 VSS VDD VSS VSS nfet_06v0 L=2.0u W=9.75u
Mdecn77 VSS VDD VSS VSS nfet_06v0 L=2.0u W=9.75u
Mdecp78 VDD VSS VDD VDD pfet_06v0 L=2.0u W=9.75u
Mdecp79 VDD VSS VDD VDD pfet_06v0 L=2.0u W=9.75u
Mdecn80 VSS VDD VSS VSS nfet_06v0 L=2.0u W=9.75u
Mdecn81 VSS VDD VSS VSS nfet_06v0 L=2.0u W=9.75u
Mdecp82 VDD VSS VDD VDD pfet_06v0 L=2.0u W=9.75u
Mdecp83 VDD VSS VDD VDD pfet_06v0 L=2.0u W=9.75u
Mdecn84 VSS VDD VSS VSS nfet_06v0 L=2.0u W=9.75u
Mdecn85 VSS VDD VSS VSS nfet_06v0 L=2.0u W=9.75u
Mdecp86 VDD VSS VDD VDD pfet_06v0 L=2.0u W=9.75u
Mdecp87 VDD VSS VDD VDD pfet_06v0 L=2.0u W=9.75u
Mdecn88 VSS VDD VSS VSS nfet_06v0 L=2.0u W=9.75u
Mdecn89 VSS VDD VSS VSS nfet_06v0 L=2.0u W=9.75u
Mdecp90 VDD VSS VDD VDD pfet_06v0 L=2.0u W=9.75u
Mdecp91 VDD VSS VDD VDD pfet_06v0 L=2.0u W=9.75u
Mdecn92 VSS VDD VSS VSS nfet_06v0 L=2.0u W=9.75u
Mdecn93 VSS VDD VSS VSS nfet_06v0 L=2.0u W=9.75u
Mdecp94 VDD VSS VDD VDD pfet_06v0 L=2.0u W=9.75u
Mdecp95 VDD VSS VDD VDD pfet_06v0 L=2.0u W=9.75u
Mdecn96 VSS VDD VSS VSS nfet_06v0 L=2.0u W=9.75u
Mdecn97 VSS VDD VSS VSS nfet_06v0 L=2.0u W=9.75u
Mdecp98 VDD VSS VDD VDD pfet_06v0 L=2.0u W=9.75u
Mdecp99 VDD VSS VDD VDD pfet_06v0 L=2.0u W=9.75u
Mdecn100 VSS VDD VSS VSS nfet_06v0 L=2.0u W=9.75u
Mdecn101 VSS VDD VSS VSS nfet_06v0 L=2.0u W=9.75u
Mdecp102 VDD VSS VDD VDD pfet_06v0 L=2.0u W=9.75u
Mdecp103 VDD VSS VDD VDD pfet_06v0 L=2.0u W=9.75u
Mdecn104 VSS VDD VSS VSS nfet_06v0 L=2.0u W=9.75u
Mdecn105 VSS VDD VSS VSS nfet_06v0 L=2.0u W=9.75u
Mdecp106 VDD VSS VDD VDD pfet_06v0 L=2.0u W=9.75u
Mdecp107 VDD VSS VDD VDD pfet_06v0 L=2.0u W=9.75u
Mdecn108 VSS VDD VSS VSS nfet_06v0 L=2.0u W=9.75u
Mdecn109 VSS VDD VSS VSS nfet_06v0 L=2.0u W=9.75u
Mdecp110 VDD VSS VDD VDD pfet_06v0 L=2.0u W=9.75u
Mdecp111 VDD VSS VDD VDD pfet_06v0 L=2.0u W=9.75u
Mdecn112 VSS VDD VSS VSS nfet_06v0 L=2.0u W=9.75u
Mdecn113 VSS VDD VSS VSS nfet_06v0 L=2.0u W=9.75u
Mdecp114 VDD VSS VDD VDD pfet_06v0 L=2.0u W=9.75u
Mdecp115 VDD VSS VDD VDD pfet_06v0 L=2.0u W=9.75u
Mdecn116 VSS VDD VSS VSS nfet_06v0 L=2.0u W=9.75u
Mdecn117 VSS VDD VSS VSS nfet_06v0 L=2.0u W=9.75u
Mdecp118 VDD VSS VDD VDD pfet_06v0 L=2.0u W=9.75u
Mdecp119 VDD VSS VDD VDD pfet_06v0 L=2.0u W=9.75u
Mdecn120 VSS VDD VSS VSS nfet_06v0 L=2.0u W=9.75u
Mdecn121 VSS VDD VSS VSS nfet_06v0 L=2.0u W=9.75u
Mdecp122 VDD VSS VDD VDD pfet_06v0 L=2.0u W=9.75u
Mdecp123 VDD VSS VDD VDD pfet_06v0 L=2.0u W=9.75u
Mdecn124 VSS VDD VSS VSS nfet_06v0 L=2.0u W=18.0u
Mdecp125 VDD VSS VDD VDD pfet_06v0 L=2.0u W=18.0u
Mdecn126 VSS VDD VSS VSS nfet_06v0 L=2.0u W=18.0u
Mdecp127 VDD VSS VDD VDD pfet_06v0 L=2.0u W=18.0u
Mdecn128 VSS VDD VSS VSS nfet_06v0 L=2.0u W=18.0u
Mdecp129 VDD VSS VDD VDD pfet_06v0 L=2.0u W=18.0u
Mdecn130 VSS VDD VSS VSS nfet_06v0 L=2.0u W=9.75u
Mdecp131 VDD VSS VDD VDD pfet_06v0 L=2.0u W=9.75u
Mdecn132 VSS VDD VSS VSS nfet_06v0 L=2.0u W=9.75u
Mdecp133 VDD VSS VDD VDD pfet_06v0 L=2.0u W=9.75u
Mdecn134 VSS VDD VSS VSS nfet_06v0 L=2.0u W=9.75u
Mdecp135 VDD VSS VDD VDD pfet_06v0 L=2.0u W=9.75u
Mdecn136 VSS VDD VSS VSS nfet_06v0 L=2.0u W=9.75u
Mdecp137 VDD VSS VDD VDD pfet_06v0 L=2.0u W=9.75u
Mdecn138 VSS VDD VSS VSS nfet_06v0 L=2.0u W=1.0u
Mdecn139 VSS VDD VSS VSS nfet_06v0 L=2.0u W=1.0u
Mdecp140 VDD VSS VDD VDD pfet_06v0 L=2.0u W=1.0u
Mdecp141 VDD VSS VDD VDD pfet_06v0 L=2.0u W=1.0u
Mdecn142 VSS VDD VSS VSS nfet_06v0 L=2.0u W=1.0u
Mdecn143 VSS VDD VSS VSS nfet_06v0 L=2.0u W=1.0u
Mdecp144 VDD VSS VDD VDD pfet_06v0 L=2.0u W=1.0u
Mdecp145 VDD VSS VDD VDD pfet_06v0 L=2.0u W=1.0u
Mdecn146 VSS VDD VSS VSS nfet_06v0 L=2.0u W=1.0u
Mdecn147 VSS VDD VSS VSS nfet_06v0 L=2.0u W=1.0u
Mdecp148 VDD VSS VDD VDD pfet_06v0 L=2.0u W=1.0u
Mdecp149 VDD VSS VDD VDD pfet_06v0 L=2.0u W=1.0u
Mdecn150 VSS VDD VSS VSS nfet_06v0 L=2.0u W=1.0u
Mdecp151 VDD VSS VDD VDD pfet_06v0 L=2.0u W=1.0u
Mdecn152 VSS VDD VSS VSS nfet_06v0 L=2.0u W=1.0u
Mdecp153 VDD VSS VDD VDD pfet_06v0 L=2.0u W=1.0u
Mdecn154 VSS VDD VSS VSS nfet_06v0 L=2.0u W=1.0u
Mdecp155 VDD VSS VDD VDD pfet_06v0 L=2.0u W=1.0u
* condensadores: elemento 'C' con W/L en METROS, no 'X' con c_width/c_length.
*   El deck de KLayout los lee con un delegate (custom_classes.lvs, SubcircuitModelsReader#element)
*   que SOLO actua si el elemento empieza por 'C', y de ahi saca A=W*L*1e12 y P=2*(W+L)*1e6.
*   Escrito como 'X...' se leeria como llamada a subcircuito y no emparejaria con nada.
Cx1_x4_x2_XC2 x1_net1 x1_x4_x2_net5 cap_mim_2f0fF W=2e-05 L=1e-05
Cx1_x4_x2_XC3 x1_x4_x2_net6 x1_net1 cap_mim_2f0fF W=2e-05 L=1e-05
Cx1_x5_x2_XC2 x1_net2 x1_x5_x2_net5 cap_mim_2f0fF W=2e-05 L=1e-05
Cx1_x5_x2_XC3 x1_x5_x2_net6 x1_net2 cap_mim_2f0fF W=2e-05 L=1e-05
Cx1_x6_x2_XC2 x1_net3 x1_x6_x2_net5 cap_mim_2f0fF W=2e-05 L=1e-05
Cx1_x6_x2_XC3 x1_x6_x2_net6 x1_net3 cap_mim_2f0fF W=2e-05 L=1e-05
Cx1_x8_x2_XC3 x1_x8_x2_net6 x1_SX cap_mim_2f0fF W=8e-06 L=2.5e-05
Cx1_x8_x2_XC1 x1_SX x1_x8_x2_net5 cap_mim_2f0fF W=8e-06 L=2.5e-05
Cx1_x1_x2_XC3 x1_x1_x2_net6 x1_SY cap_mim_2f0fF W=8e-06 L=2.5e-05
Cx1_x1_x2_XC1 x1_SY x1_x1_x2_net5 cap_mim_2f0fF W=8e-06 L=2.5e-05
Cx1_x2_x2_XC3 x1_x2_x2_net6 x1_SZ cap_mim_2f0fF W=8e-06 L=2.5e-05
Cx1_x2_x2_XC1 x1_SZ x1_x2_x2_net5 cap_mim_2f0fF W=8e-06 L=2.5e-05
Cx2_x4_x2_XC2 x2_net1 x2_x4_x2_net5 cap_mim_2f0fF W=2e-05 L=1e-05
Cx2_x4_x2_XC3 x2_x4_x2_net6 x2_net1 cap_mim_2f0fF W=2e-05 L=1e-05
Cx2_x5_x2_XC2 x2_net2 x2_x5_x2_net5 cap_mim_2f0fF W=2e-05 L=1e-05
Cx2_x5_x2_XC3 x2_x5_x2_net6 x2_net2 cap_mim_2f0fF W=2e-05 L=1e-05
Cx2_x6_x2_XC2 x2_net3 x2_x6_x2_net5 cap_mim_2f0fF W=2e-05 L=1e-05
Cx2_x6_x2_XC3 x2_x6_x2_net6 x2_net3 cap_mim_2f0fF W=2e-05 L=1e-05
Cx2_x8_x2_XC3 x2_x8_x2_net6 x2_SX cap_mim_2f0fF W=8e-06 L=2.5e-05
Cx2_x8_x2_XC1 x2_SX x2_x8_x2_net5 cap_mim_2f0fF W=8e-06 L=2.5e-05
Cx2_x1_x2_XC3 x2_x1_x2_net6 x2_SY cap_mim_2f0fF W=8e-06 L=2.5e-05
Cx2_x1_x2_XC1 x2_SY x2_x1_x2_net5 cap_mim_2f0fF W=8e-06 L=2.5e-05
Cx2_x2_x2_XC3 x2_x2_x2_net6 x2_SZ cap_mim_2f0fF W=8e-06 L=2.5e-05
Cx2_x2_x2_XC1 x2_SZ x2_x2_x2_net5 cap_mim_2f0fF W=8e-06 L=2.5e-05
Cx3_x4_x2_XC2 x3_net1 x3_x4_x2_net5 cap_mim_2f0fF W=2e-05 L=1e-05
Cx3_x4_x2_XC3 x3_x4_x2_net6 x3_net1 cap_mim_2f0fF W=2e-05 L=1e-05
Cx3_x5_x2_XC2 x3_net2 x3_x5_x2_net5 cap_mim_2f0fF W=2e-05 L=1e-05
Cx3_x5_x2_XC3 x3_x5_x2_net6 x3_net2 cap_mim_2f0fF W=2e-05 L=1e-05
Cx3_x6_x2_XC2 x3_net3 x3_x6_x2_net5 cap_mim_2f0fF W=2e-05 L=1e-05
Cx3_x6_x2_XC3 x3_x6_x2_net6 x3_net3 cap_mim_2f0fF W=2e-05 L=1e-05
Cx3_x8_x2_XC3 x3_x8_x2_net6 x3_SX cap_mim_2f0fF W=8e-06 L=2.5e-05
Cx3_x8_x2_XC1 x3_SX x3_x8_x2_net5 cap_mim_2f0fF W=8e-06 L=2.5e-05
Cx3_x1_x2_XC3 x3_x1_x2_net6 x3_SY cap_mim_2f0fF W=8e-06 L=2.5e-05
Cx3_x1_x2_XC1 x3_SY x3_x1_x2_net5 cap_mim_2f0fF W=8e-06 L=2.5e-05
Cx3_x2_x2_XC3 x3_x2_x2_net6 x3_SZ cap_mim_2f0fF W=8e-06 L=2.5e-05
Cx3_x2_x2_XC1 x3_SZ x3_x2_x2_net5 cap_mim_2f0fF W=8e-06 L=2.5e-05
Cx4_x4_x2_XC2 x4_net1 x4_x4_x2_net5 cap_mim_2f0fF W=2e-05 L=1e-05
Cx4_x4_x2_XC3 x4_x4_x2_net6 x4_net1 cap_mim_2f0fF W=2e-05 L=1e-05
Cx4_x5_x2_XC2 x4_net2 x4_x5_x2_net5 cap_mim_2f0fF W=2e-05 L=1e-05
Cx4_x5_x2_XC3 x4_x5_x2_net6 x4_net2 cap_mim_2f0fF W=2e-05 L=1e-05
Cx4_x6_x2_XC2 x4_net3 x4_x6_x2_net5 cap_mim_2f0fF W=2e-05 L=1e-05
Cx4_x6_x2_XC3 x4_x6_x2_net6 x4_net3 cap_mim_2f0fF W=2e-05 L=1e-05
Cx4_x8_x2_XC3 x4_x8_x2_net6 x4_SX cap_mim_2f0fF W=8e-06 L=2.5e-05
Cx4_x8_x2_XC1 x4_SX x4_x8_x2_net5 cap_mim_2f0fF W=8e-06 L=2.5e-05
Cx4_x1_x2_XC3 x4_x1_x2_net6 x4_SY cap_mim_2f0fF W=8e-06 L=2.5e-05
Cx4_x1_x2_XC1 x4_SY x4_x1_x2_net5 cap_mim_2f0fF W=8e-06 L=2.5e-05
Cx4_x2_x2_XC3 x4_x2_x2_net6 x4_SZ cap_mim_2f0fF W=8e-06 L=2.5e-05
Cx4_x2_x2_XC1 x4_SZ x4_x2_x2_net5 cap_mim_2f0fF W=8e-06 L=2.5e-05
* resistencias: elemento 'R' con W/L/S en METROS, no 'X' con r_width/r_length.
*   Mismo motivo que los condensadores: el delegate del deck (custom_classes.lvs,
*   SubcircuitModelsReader#element) solo entra por la primera letra, y para 'R' de tres
*   nodos monta un DeviceClassResistorWithBulk con los terminales A, B, W.
*   El deck hace W=W*PAR*1e6 y L=L*S*1e6, o sea que la 'S' MULTIPLICA el largo.
*   Aun asi la serie se escribe TRAMO A TRAMO, no con un 'S=5': el layout dibuja
*   `s` cuerpos de poly encadenados por metal1 y las dos herramientas los extraen
*   como `s` dispositivos. Juntarlos en uno exige la reduccion en serie, y netgen no
*   la aplica aqui porque lee la resistencia de tres nodos como si tuviera dos y le
*   pone de modelo el nodo de sustrato: la clase le sale 'VSS' y su setup no la
*   reconoce. Escribiendo los tramos, las dos partes cuentan lo mismo y no hace falta.
RFB_x1_x8_x2_1 x1_x8_x2_G_OUT_P RFB_x1_x8_x2$1 VSS ppolyf_u_1k W=1e-06 L=7.645e-05 R=76450
RFB_x1_x8_x2_2 RFB_x1_x8_x2$1 RFB_x1_x8_x2$2 VSS ppolyf_u_1k W=1e-06 L=7.645e-05 R=76450
RFB_x1_x8_x2_3 RFB_x1_x8_x2$2 RFB_x1_x8_x2$3 VSS ppolyf_u_1k W=1e-06 L=7.645e-05 R=76450
RFB_x1_x8_x2_4 RFB_x1_x8_x2$3 RFB_x1_x8_x2$4 VSS ppolyf_u_1k W=1e-06 L=7.645e-05 R=76450
RFB_x1_x8_x2_5 RFB_x1_x8_x2$4 x1_SX VSS ppolyf_u_1k W=1e-06 L=7.645e-05 R=76450
RFB_x1_x1_x2_1 x1_x1_x2_G_OUT_P RFB_x1_x1_x2$1 VSS ppolyf_u_1k W=1e-06 L=7.645e-05 R=76450
RFB_x1_x1_x2_2 RFB_x1_x1_x2$1 RFB_x1_x1_x2$2 VSS ppolyf_u_1k W=1e-06 L=7.645e-05 R=76450
RFB_x1_x1_x2_3 RFB_x1_x1_x2$2 RFB_x1_x1_x2$3 VSS ppolyf_u_1k W=1e-06 L=7.645e-05 R=76450
RFB_x1_x1_x2_4 RFB_x1_x1_x2$3 RFB_x1_x1_x2$4 VSS ppolyf_u_1k W=1e-06 L=7.645e-05 R=76450
RFB_x1_x1_x2_5 RFB_x1_x1_x2$4 x1_SY VSS ppolyf_u_1k W=1e-06 L=7.645e-05 R=76450
RFB_x1_x2_x2_1 x1_x2_x2_G_OUT_P RFB_x1_x2_x2$1 VSS ppolyf_u_1k W=1e-06 L=7.645e-05 R=76450
RFB_x1_x2_x2_2 RFB_x1_x2_x2$1 RFB_x1_x2_x2$2 VSS ppolyf_u_1k W=1e-06 L=7.645e-05 R=76450
RFB_x1_x2_x2_3 RFB_x1_x2_x2$2 RFB_x1_x2_x2$3 VSS ppolyf_u_1k W=1e-06 L=7.645e-05 R=76450
RFB_x1_x2_x2_4 RFB_x1_x2_x2$3 RFB_x1_x2_x2$4 VSS ppolyf_u_1k W=1e-06 L=7.645e-05 R=76450
RFB_x1_x2_x2_5 RFB_x1_x2_x2$4 x1_SZ VSS ppolyf_u_1k W=1e-06 L=7.645e-05 R=76450
RFB_x2_x8_x2_1 x2_x8_x2_G_OUT_P RFB_x2_x8_x2$1 VSS ppolyf_u_1k W=1e-06 L=7.645e-05 R=76450
RFB_x2_x8_x2_2 RFB_x2_x8_x2$1 RFB_x2_x8_x2$2 VSS ppolyf_u_1k W=1e-06 L=7.645e-05 R=76450
RFB_x2_x8_x2_3 RFB_x2_x8_x2$2 RFB_x2_x8_x2$3 VSS ppolyf_u_1k W=1e-06 L=7.645e-05 R=76450
RFB_x2_x8_x2_4 RFB_x2_x8_x2$3 RFB_x2_x8_x2$4 VSS ppolyf_u_1k W=1e-06 L=7.645e-05 R=76450
RFB_x2_x8_x2_5 RFB_x2_x8_x2$4 x2_SX VSS ppolyf_u_1k W=1e-06 L=7.645e-05 R=76450
RFB_x2_x1_x2_1 x2_x1_x2_G_OUT_P RFB_x2_x1_x2$1 VSS ppolyf_u_1k W=1e-06 L=7.645e-05 R=76450
RFB_x2_x1_x2_2 RFB_x2_x1_x2$1 RFB_x2_x1_x2$2 VSS ppolyf_u_1k W=1e-06 L=7.645e-05 R=76450
RFB_x2_x1_x2_3 RFB_x2_x1_x2$2 RFB_x2_x1_x2$3 VSS ppolyf_u_1k W=1e-06 L=7.645e-05 R=76450
RFB_x2_x1_x2_4 RFB_x2_x1_x2$3 RFB_x2_x1_x2$4 VSS ppolyf_u_1k W=1e-06 L=7.645e-05 R=76450
RFB_x2_x1_x2_5 RFB_x2_x1_x2$4 x2_SY VSS ppolyf_u_1k W=1e-06 L=7.645e-05 R=76450
RFB_x2_x2_x2_1 x2_x2_x2_G_OUT_P RFB_x2_x2_x2$1 VSS ppolyf_u_1k W=1e-06 L=7.645e-05 R=76450
RFB_x2_x2_x2_2 RFB_x2_x2_x2$1 RFB_x2_x2_x2$2 VSS ppolyf_u_1k W=1e-06 L=7.645e-05 R=76450
RFB_x2_x2_x2_3 RFB_x2_x2_x2$2 RFB_x2_x2_x2$3 VSS ppolyf_u_1k W=1e-06 L=7.645e-05 R=76450
RFB_x2_x2_x2_4 RFB_x2_x2_x2$3 RFB_x2_x2_x2$4 VSS ppolyf_u_1k W=1e-06 L=7.645e-05 R=76450
RFB_x2_x2_x2_5 RFB_x2_x2_x2$4 x2_SZ VSS ppolyf_u_1k W=1e-06 L=7.645e-05 R=76450
RFB_x3_x8_x2_1 x3_x8_x2_G_OUT_P RFB_x3_x8_x2$1 VSS ppolyf_u_1k W=1e-06 L=7.645e-05 R=76450
RFB_x3_x8_x2_2 RFB_x3_x8_x2$1 RFB_x3_x8_x2$2 VSS ppolyf_u_1k W=1e-06 L=7.645e-05 R=76450
RFB_x3_x8_x2_3 RFB_x3_x8_x2$2 RFB_x3_x8_x2$3 VSS ppolyf_u_1k W=1e-06 L=7.645e-05 R=76450
RFB_x3_x8_x2_4 RFB_x3_x8_x2$3 RFB_x3_x8_x2$4 VSS ppolyf_u_1k W=1e-06 L=7.645e-05 R=76450
RFB_x3_x8_x2_5 RFB_x3_x8_x2$4 x3_SX VSS ppolyf_u_1k W=1e-06 L=7.645e-05 R=76450
RFB_x3_x1_x2_1 x3_x1_x2_G_OUT_P RFB_x3_x1_x2$1 VSS ppolyf_u_1k W=1e-06 L=7.645e-05 R=76450
RFB_x3_x1_x2_2 RFB_x3_x1_x2$1 RFB_x3_x1_x2$2 VSS ppolyf_u_1k W=1e-06 L=7.645e-05 R=76450
RFB_x3_x1_x2_3 RFB_x3_x1_x2$2 RFB_x3_x1_x2$3 VSS ppolyf_u_1k W=1e-06 L=7.645e-05 R=76450
RFB_x3_x1_x2_4 RFB_x3_x1_x2$3 RFB_x3_x1_x2$4 VSS ppolyf_u_1k W=1e-06 L=7.645e-05 R=76450
RFB_x3_x1_x2_5 RFB_x3_x1_x2$4 x3_SY VSS ppolyf_u_1k W=1e-06 L=7.645e-05 R=76450
RFB_x3_x2_x2_1 x3_x2_x2_G_OUT_P RFB_x3_x2_x2$1 VSS ppolyf_u_1k W=1e-06 L=7.645e-05 R=76450
RFB_x3_x2_x2_2 RFB_x3_x2_x2$1 RFB_x3_x2_x2$2 VSS ppolyf_u_1k W=1e-06 L=7.645e-05 R=76450
RFB_x3_x2_x2_3 RFB_x3_x2_x2$2 RFB_x3_x2_x2$3 VSS ppolyf_u_1k W=1e-06 L=7.645e-05 R=76450
RFB_x3_x2_x2_4 RFB_x3_x2_x2$3 RFB_x3_x2_x2$4 VSS ppolyf_u_1k W=1e-06 L=7.645e-05 R=76450
RFB_x3_x2_x2_5 RFB_x3_x2_x2$4 x3_SZ VSS ppolyf_u_1k W=1e-06 L=7.645e-05 R=76450
RFB_x4_x8_x2_1 x4_x8_x2_G_OUT_P RFB_x4_x8_x2$1 VSS ppolyf_u_1k W=1e-06 L=7.645e-05 R=76450
RFB_x4_x8_x2_2 RFB_x4_x8_x2$1 RFB_x4_x8_x2$2 VSS ppolyf_u_1k W=1e-06 L=7.645e-05 R=76450
RFB_x4_x8_x2_3 RFB_x4_x8_x2$2 RFB_x4_x8_x2$3 VSS ppolyf_u_1k W=1e-06 L=7.645e-05 R=76450
RFB_x4_x8_x2_4 RFB_x4_x8_x2$3 RFB_x4_x8_x2$4 VSS ppolyf_u_1k W=1e-06 L=7.645e-05 R=76450
RFB_x4_x8_x2_5 RFB_x4_x8_x2$4 x4_SX VSS ppolyf_u_1k W=1e-06 L=7.645e-05 R=76450
RFB_x4_x1_x2_1 x4_x1_x2_G_OUT_P RFB_x4_x1_x2$1 VSS ppolyf_u_1k W=1e-06 L=7.645e-05 R=76450
RFB_x4_x1_x2_2 RFB_x4_x1_x2$1 RFB_x4_x1_x2$2 VSS ppolyf_u_1k W=1e-06 L=7.645e-05 R=76450
RFB_x4_x1_x2_3 RFB_x4_x1_x2$2 RFB_x4_x1_x2$3 VSS ppolyf_u_1k W=1e-06 L=7.645e-05 R=76450
RFB_x4_x1_x2_4 RFB_x4_x1_x2$3 RFB_x4_x1_x2$4 VSS ppolyf_u_1k W=1e-06 L=7.645e-05 R=76450
RFB_x4_x1_x2_5 RFB_x4_x1_x2$4 x4_SY VSS ppolyf_u_1k W=1e-06 L=7.645e-05 R=76450
RFB_x4_x2_x2_1 x4_x2_x2_G_OUT_P RFB_x4_x2_x2$1 VSS ppolyf_u_1k W=1e-06 L=7.645e-05 R=76450
RFB_x4_x2_x2_2 RFB_x4_x2_x2$1 RFB_x4_x2_x2$2 VSS ppolyf_u_1k W=1e-06 L=7.645e-05 R=76450
RFB_x4_x2_x2_3 RFB_x4_x2_x2$2 RFB_x4_x2_x2$3 VSS ppolyf_u_1k W=1e-06 L=7.645e-05 R=76450
RFB_x4_x2_x2_4 RFB_x4_x2_x2$3 RFB_x4_x2_x2$4 VSS ppolyf_u_1k W=1e-06 L=7.645e-05 R=76450
RFB_x4_x2_x2_5 RFB_x4_x2_x2$4 x4_SZ VSS ppolyf_u_1k W=1e-06 L=7.645e-05 R=76450
.ends
