* Extracted by KLayout with GF180MCU LVS runset on : 21/08/2026 04:54

.SUBCKT GRADIENT_NAV2 S1P S3N S1N S2P S2N VDD S4P S4N S3P XN X XP YN Y YP ZN Z
+ ZP VSS
M$1 \$2764 X VDD VDD pfet_05v0 L=0.5U W=1.83U AS=0.8052P AD=0.8052P PS=4.54U
+ PD=4.54U
M$2 XP \$2764 VDD VDD pfet_05v0 L=0.5U W=1.83U AS=0.8052P AD=0.8052P PS=4.54U
+ PD=4.54U
M$3 XN XP VDD VDD pfet_05v0 L=0.5U W=1.83U AS=0.8052P AD=0.8052P PS=4.54U
+ PD=4.54U
M$4 \$4551 Y VDD VDD pfet_05v0 L=0.5U W=1.83U AS=0.8052P AD=0.8052P PS=4.54U
+ PD=4.54U
M$5 YP \$4551 VDD VDD pfet_05v0 L=0.5U W=1.83U AS=0.8052P AD=0.8052P PS=4.54U
+ PD=4.54U
M$6 YN YP VDD VDD pfet_05v0 L=0.5U W=1.83U AS=0.8052P AD=0.8052P PS=4.54U
+ PD=4.54U
M$7 \$6338 Z VDD VDD pfet_05v0 L=0.5U W=1.83U AS=0.8052P AD=0.8052P PS=4.54U
+ PD=4.54U
M$8 ZP \$6338 VDD VDD pfet_05v0 L=0.5U W=1.83U AS=0.8052P AD=0.8052P PS=4.54U
+ PD=4.54U
M$9 ZN ZP VDD VDD pfet_05v0 L=0.5U W=1.83U AS=0.8052P AD=0.8052P PS=4.54U
+ PD=4.54U
M$10 \$896 \$107 VDD VDD pfet_06v0 L=1U W=10U AS=4.4P AD=2.5P PS=20.88U PD=10.5U
M$11 \$111 \$119 \$896 VDD pfet_06v0 L=1U W=10U AS=2.5P AD=4.4P PS=10.5U
+ PD=20.88U
M$12 \$898 \$107 VDD VDD pfet_06v0 L=1U W=10U AS=4.4P AD=2.5P PS=20.88U PD=10.5U
M$13 \$111 \$119 \$898 VDD pfet_06v0 L=1U W=10U AS=2.5P AD=4.4P PS=10.5U
+ PD=20.88U
M$14 \$901 \$102 VDD VDD pfet_06v0 L=1U W=10U AS=4.4P AD=2.5P PS=20.88U PD=10.5U
M$15 \$102 \$119 \$901 VDD pfet_06v0 L=1U W=10U AS=2.5P AD=3.3P PS=10.5U
+ PD=10.66U
M$16 \$15 \$15 \$102 VDD pfet_06v0 L=1U W=10U AS=3.3P AD=4.4P PS=10.66U
+ PD=20.88U
M$17 \$902 \$107 VDD VDD pfet_06v0 L=1U W=10U AS=4.4P AD=2.5P PS=20.88U PD=10.5U
M$18 \$51 \$119 \$902 VDD pfet_06v0 L=1U W=10U AS=2.5P AD=4.4P PS=10.5U
+ PD=20.88U
M$19 \$903 \$107 VDD VDD pfet_06v0 L=1U W=10U AS=4.4P AD=2.5P PS=20.88U PD=10.5U
M$20 \$64 \$119 \$903 VDD pfet_06v0 L=1U W=10U AS=2.5P AD=4.4P PS=10.5U
+ PD=20.88U
M$21 \$904 \$107 VDD VDD pfet_06v0 L=1U W=10U AS=4.4P AD=2.5P PS=20.88U PD=10.5U
M$22 \$63 \$119 \$904 VDD pfet_06v0 L=1U W=10U AS=2.5P AD=4.4P PS=10.5U
+ PD=20.88U
M$23 \$906 \$107 VDD VDD pfet_06v0 L=1U W=10U AS=4.4P AD=2.5P PS=20.88U PD=10.5U
M$24 \$107 \$119 \$906 VDD pfet_06v0 L=1U W=10U AS=2.5P AD=4.4P PS=10.5U
+ PD=20.88U
M$25 \$907 \$108 VDD VDD pfet_06v0 L=1U W=10U AS=4.4P AD=2.5P PS=20.88U PD=10.5U
M$26 \$112 \$120 \$907 VDD pfet_06v0 L=1U W=10U AS=2.5P AD=4.4P PS=10.5U
+ PD=20.88U
M$27 \$908 \$108 VDD VDD pfet_06v0 L=1U W=10U AS=4.4P AD=2.5P PS=20.88U PD=10.5U
M$28 \$112 \$120 \$908 VDD pfet_06v0 L=1U W=10U AS=2.5P AD=4.4P PS=10.5U
+ PD=20.88U
M$29 \$910 \$103 VDD VDD pfet_06v0 L=1U W=10U AS=4.4P AD=2.5P PS=20.88U PD=10.5U
M$30 \$103 \$120 \$910 VDD pfet_06v0 L=1U W=10U AS=2.5P AD=3.3P PS=10.5U
+ PD=10.66U
M$31 \$26 \$26 \$103 VDD pfet_06v0 L=1U W=10U AS=3.3P AD=4.4P PS=10.66U
+ PD=20.88U
M$32 \$911 \$108 VDD VDD pfet_06v0 L=1U W=10U AS=4.4P AD=2.5P PS=20.88U PD=10.5U
M$33 \$52 \$120 \$911 VDD pfet_06v0 L=1U W=10U AS=2.5P AD=4.4P PS=10.5U
+ PD=20.88U
M$34 \$912 \$108 VDD VDD pfet_06v0 L=1U W=10U AS=4.4P AD=2.5P PS=20.88U PD=10.5U
M$35 \$66 \$120 \$912 VDD pfet_06v0 L=1U W=10U AS=2.5P AD=4.4P PS=10.5U
+ PD=20.88U
M$36 \$914 \$108 VDD VDD pfet_06v0 L=1U W=10U AS=4.4P AD=2.5P PS=20.88U PD=10.5U
M$37 \$65 \$120 \$914 VDD pfet_06v0 L=1U W=10U AS=2.5P AD=4.4P PS=10.5U
+ PD=20.88U
M$38 \$915 \$108 VDD VDD pfet_06v0 L=1U W=10U AS=4.4P AD=2.5P PS=20.88U PD=10.5U
M$39 \$108 \$120 \$915 VDD pfet_06v0 L=1U W=10U AS=2.5P AD=4.4P PS=10.5U
+ PD=20.88U
M$40 \$916 \$109 VDD VDD pfet_06v0 L=1U W=10U AS=4.4P AD=2.5P PS=20.88U PD=10.5U
M$41 \$114 \$121 \$916 VDD pfet_06v0 L=1U W=10U AS=2.5P AD=4.4P PS=10.5U
+ PD=20.88U
M$42 \$918 \$109 VDD VDD pfet_06v0 L=1U W=10U AS=4.4P AD=2.5P PS=20.88U PD=10.5U
M$43 \$114 \$121 \$918 VDD pfet_06v0 L=1U W=10U AS=2.5P AD=4.4P PS=10.5U
+ PD=20.88U
M$44 \$920 \$104 VDD VDD pfet_06v0 L=1U W=10U AS=4.4P AD=2.5P PS=20.88U PD=10.5U
M$45 \$104 \$121 \$920 VDD pfet_06v0 L=1U W=10U AS=2.5P AD=3.3P PS=10.5U
+ PD=10.66U
M$46 \$37 \$37 \$104 VDD pfet_06v0 L=1U W=10U AS=3.3P AD=4.4P PS=10.66U
+ PD=20.88U
M$47 \$922 \$109 VDD VDD pfet_06v0 L=1U W=10U AS=4.4P AD=2.5P PS=20.88U PD=10.5U
M$48 \$53 \$121 \$922 VDD pfet_06v0 L=1U W=10U AS=2.5P AD=4.4P PS=10.5U
+ PD=20.88U
M$49 \$923 \$109 VDD VDD pfet_06v0 L=1U W=10U AS=4.4P AD=2.5P PS=20.88U PD=10.5U
M$50 \$68 \$121 \$923 VDD pfet_06v0 L=1U W=10U AS=2.5P AD=4.4P PS=10.5U
+ PD=20.88U
M$51 \$921 \$109 VDD VDD pfet_06v0 L=1U W=10U AS=4.4P AD=2.5P PS=20.88U PD=10.5U
M$52 \$67 \$121 \$921 VDD pfet_06v0 L=1U W=10U AS=2.5P AD=4.4P PS=10.5U
+ PD=20.88U
M$53 \$919 \$109 VDD VDD pfet_06v0 L=1U W=10U AS=4.4P AD=2.5P PS=20.88U PD=10.5U
M$54 \$109 \$121 \$919 VDD pfet_06v0 L=1U W=10U AS=2.5P AD=4.4P PS=10.5U
+ PD=20.88U
M$55 \$917 \$110 VDD VDD pfet_06v0 L=1U W=10U AS=4.4P AD=2.5P PS=20.88U PD=10.5U
M$56 \$116 \$122 \$917 VDD pfet_06v0 L=1U W=10U AS=2.5P AD=4.4P PS=10.5U
+ PD=20.88U
M$57 \$913 \$110 VDD VDD pfet_06v0 L=1U W=10U AS=4.4P AD=2.5P PS=20.88U PD=10.5U
M$58 \$116 \$122 \$913 VDD pfet_06v0 L=1U W=10U AS=2.5P AD=4.4P PS=10.5U
+ PD=20.88U
M$59 \$909 \$106 VDD VDD pfet_06v0 L=1U W=10U AS=4.4P AD=2.5P PS=20.88U PD=10.5U
M$60 \$106 \$122 \$909 VDD pfet_06v0 L=1U W=10U AS=2.5P AD=3.3P PS=10.5U
+ PD=10.66U
M$61 \$48 \$48 \$106 VDD pfet_06v0 L=1U W=10U AS=3.3P AD=4.4P PS=10.66U
+ PD=20.88U
M$62 \$905 \$110 VDD VDD pfet_06v0 L=1U W=10U AS=4.4P AD=2.5P PS=20.88U PD=10.5U
M$63 \$54 \$122 \$905 VDD pfet_06v0 L=1U W=10U AS=2.5P AD=4.4P PS=10.5U
+ PD=20.88U
M$64 \$900 \$110 VDD VDD pfet_06v0 L=1U W=10U AS=4.4P AD=2.5P PS=20.88U PD=10.5U
M$65 \$70 \$122 \$900 VDD pfet_06v0 L=1U W=10U AS=2.5P AD=4.4P PS=10.5U
+ PD=20.88U
M$66 \$899 \$110 VDD VDD pfet_06v0 L=1U W=10U AS=4.4P AD=2.5P PS=20.88U PD=10.5U
M$67 \$69 \$122 \$899 VDD pfet_06v0 L=1U W=10U AS=2.5P AD=4.4P PS=10.5U
+ PD=20.88U
M$68 \$897 \$110 VDD VDD pfet_06v0 L=1U W=10U AS=4.4P AD=2.5P PS=20.88U PD=10.5U
M$69 \$110 \$122 \$897 VDD pfet_06v0 L=1U W=10U AS=2.5P AD=4.4P PS=10.5U
+ PD=20.88U
M$70 \$1814 \$1028 VDD VDD pfet_06v0 L=1U W=10U AS=4.4P AD=2.5P PS=20.88U
+ PD=10.5U
M$71 \$1033 \$1038 \$1814 VDD pfet_06v0 L=1U W=10U AS=2.5P AD=4.4P PS=10.5U
+ PD=20.88U
M$72 \$1816 \$1028 VDD VDD pfet_06v0 L=1U W=10U AS=4.4P AD=2.5P PS=20.88U
+ PD=10.5U
M$73 \$1033 \$1038 \$1816 VDD pfet_06v0 L=1U W=10U AS=2.5P AD=4.4P PS=10.5U
+ PD=20.88U
M$74 \$101 S2P \$111 VDD pfet_06v0 L=1U W=1.1U AS=0.484P AD=0.484P PS=3.08U
+ PD=3.08U
M$75 \$10 S2N \$111 VDD pfet_06v0 L=1U W=1U AS=0.44P AD=0.44P PS=2.88U PD=2.88U
M$76 \$9 \$12 VDD VDD pfet_06v0 L=1U W=5U AS=2.2P AD=1.65P PS=10.88U PD=5.66U
M$77 \$12 \$119 \$9 VDD pfet_06v0 L=1U W=5U AS=1.65P AD=1.65P PS=5.66U PD=5.66U
M$78 \$11 \$15 \$12 VDD pfet_06v0 L=1U W=5U AS=1.65P AD=2.2P PS=5.66U PD=10.88U
M$79 \$8 \$12 VDD VDD pfet_06v0 L=1U W=5U AS=2.2P AD=1.65P PS=10.88U PD=5.66U
M$80 \$14 \$119 \$8 VDD pfet_06v0 L=1U W=5U AS=1.65P AD=1.65P PS=5.66U PD=5.66U
M$81 \$13 \$15 \$14 VDD pfet_06v0 L=1U W=5U AS=1.65P AD=2.2P PS=5.66U PD=10.88U
M$82 \$1819 \$1023 VDD VDD pfet_06v0 L=1U W=10U AS=4.4P AD=2.5P PS=20.88U
+ PD=10.5U
M$83 \$1023 \$1038 \$1819 VDD pfet_06v0 L=1U W=10U AS=2.5P AD=3.3P PS=10.5U
+ PD=10.66U
M$84 \$936 \$936 \$1023 VDD pfet_06v0 L=1U W=10U AS=3.3P AD=4.4P PS=10.66U
+ PD=20.88U
M$85 \$1820 \$1028 VDD VDD pfet_06v0 L=1U W=10U AS=4.4P AD=2.5P PS=20.88U
+ PD=10.5U
M$86 \$972 \$1038 \$1820 VDD pfet_06v0 L=1U W=10U AS=2.5P AD=4.4P PS=10.5U
+ PD=20.88U
M$87 \$17 \$14 VDD VDD pfet_06v0 L=1U W=0.5U AS=0.22P AD=0.22P PS=1.88U PD=1.88U
M$88 \$17 \$14 VDD VDD pfet_06v0 L=1U W=0.5U AS=0.22P AD=0.22P PS=1.88U PD=1.88U
M$89 \$17 \$14 VDD VDD pfet_06v0 L=1U W=0.5U AS=0.22P AD=0.22P PS=1.88U PD=1.88U
M$90 \$17 \$14 VDD VDD pfet_06v0 L=1U W=0.5U AS=0.22P AD=0.22P PS=1.88U PD=1.88U
M$91 \$1823 \$1028 VDD VDD pfet_06v0 L=1U W=10U AS=4.4P AD=2.5P PS=20.88U
+ PD=10.5U
M$92 \$985 \$1038 \$1823 VDD pfet_06v0 L=1U W=10U AS=2.5P AD=4.4P PS=10.5U
+ PD=20.88U
M$93 \$1824 \$1028 VDD VDD pfet_06v0 L=1U W=10U AS=4.4P AD=2.5P PS=20.88U
+ PD=10.5U
M$94 \$984 \$1038 \$1824 VDD pfet_06v0 L=1U W=10U AS=2.5P AD=4.4P PS=10.5U
+ PD=20.88U
M$95 \$119 \$119 VDD VDD pfet_06v0 L=1U W=2U AS=0.88P AD=0.88P PS=4.88U PD=4.88U
M$96 \$1825 \$1028 VDD VDD pfet_06v0 L=1U W=10U AS=4.4P AD=2.5P PS=20.88U
+ PD=10.5U
M$97 \$1028 \$1038 \$1825 VDD pfet_06v0 L=1U W=10U AS=2.5P AD=4.4P PS=10.5U
+ PD=20.88U
M$98 \$1826 \$1029 VDD VDD pfet_06v0 L=1U W=10U AS=4.4P AD=2.5P PS=20.88U
+ PD=10.5U
M$99 \$1035 \$1039 \$1826 VDD pfet_06v0 L=1U W=10U AS=2.5P AD=4.4P PS=10.5U
+ PD=20.88U
M$100 \$1827 \$1029 VDD VDD pfet_06v0 L=1U W=10U AS=4.4P AD=2.5P PS=20.88U
+ PD=10.5U
M$101 \$1035 \$1039 \$1827 VDD pfet_06v0 L=1U W=10U AS=2.5P AD=4.4P PS=10.5U
+ PD=20.88U
M$102 \$95 S3P \$112 VDD pfet_06v0 L=1U W=1.1U AS=0.484P AD=0.484P PS=3.08U
+ PD=3.08U
M$103 \$21 S3N \$112 VDD pfet_06v0 L=1U W=1U AS=0.44P AD=0.44P PS=2.88U PD=2.88U
M$104 \$20 \$23 VDD VDD pfet_06v0 L=1U W=5U AS=2.2P AD=1.65P PS=10.88U PD=5.66U
M$105 \$23 \$120 \$20 VDD pfet_06v0 L=1U W=5U AS=1.65P AD=1.65P PS=5.66U
+ PD=5.66U
M$106 \$22 \$26 \$23 VDD pfet_06v0 L=1U W=5U AS=1.65P AD=2.2P PS=5.66U PD=10.88U
M$107 \$19 \$23 VDD VDD pfet_06v0 L=1U W=5U AS=2.2P AD=1.65P PS=10.88U PD=5.66U
M$108 \$25 \$120 \$19 VDD pfet_06v0 L=1U W=5U AS=1.65P AD=1.65P PS=5.66U
+ PD=5.66U
M$109 \$24 \$26 \$25 VDD pfet_06v0 L=1U W=5U AS=1.65P AD=2.2P PS=5.66U PD=10.88U
M$110 \$1831 \$1024 VDD VDD pfet_06v0 L=1U W=10U AS=4.4P AD=2.5P PS=20.88U
+ PD=10.5U
M$111 \$1024 \$1039 \$1831 VDD pfet_06v0 L=1U W=10U AS=2.5P AD=3.3P PS=10.5U
+ PD=10.66U
M$112 \$947 \$947 \$1024 VDD pfet_06v0 L=1U W=10U AS=3.3P AD=4.4P PS=10.66U
+ PD=20.88U
M$113 \$1832 \$1029 VDD VDD pfet_06v0 L=1U W=10U AS=4.4P AD=2.5P PS=20.88U
+ PD=10.5U
M$114 \$973 \$1039 \$1832 VDD pfet_06v0 L=1U W=10U AS=2.5P AD=4.4P PS=10.5U
+ PD=20.88U
M$115 \$28 \$25 VDD VDD pfet_06v0 L=1U W=0.5U AS=0.22P AD=0.22P PS=1.88U
+ PD=1.88U
M$116 \$28 \$25 VDD VDD pfet_06v0 L=1U W=0.5U AS=0.22P AD=0.22P PS=1.88U
+ PD=1.88U
M$117 \$28 \$25 VDD VDD pfet_06v0 L=1U W=0.5U AS=0.22P AD=0.22P PS=1.88U
+ PD=1.88U
M$118 \$28 \$25 VDD VDD pfet_06v0 L=1U W=0.5U AS=0.22P AD=0.22P PS=1.88U
+ PD=1.88U
M$119 \$1835 \$1029 VDD VDD pfet_06v0 L=1U W=10U AS=4.4P AD=2.5P PS=20.88U
+ PD=10.5U
M$120 \$987 \$1039 \$1835 VDD pfet_06v0 L=1U W=10U AS=2.5P AD=4.4P PS=10.5U
+ PD=20.88U
M$121 \$1836 \$1029 VDD VDD pfet_06v0 L=1U W=10U AS=4.4P AD=2.5P PS=20.88U
+ PD=10.5U
M$122 \$986 \$1039 \$1836 VDD pfet_06v0 L=1U W=10U AS=2.5P AD=4.4P PS=10.5U
+ PD=20.88U
M$123 \$120 \$120 VDD VDD pfet_06v0 L=1U W=2U AS=0.88P AD=0.88P PS=4.88U
+ PD=4.88U
M$124 \$1838 \$1029 VDD VDD pfet_06v0 L=1U W=10U AS=4.4P AD=2.5P PS=20.88U
+ PD=10.5U
M$125 \$1029 \$1039 \$1838 VDD pfet_06v0 L=1U W=10U AS=2.5P AD=4.4P PS=10.5U
+ PD=20.88U
M$126 \$1839 \$1030 VDD VDD pfet_06v0 L=1U W=10U AS=4.4P AD=2.5P PS=20.88U
+ PD=10.5U
M$127 \$1036 \$1040 \$1839 VDD pfet_06v0 L=1U W=10U AS=2.5P AD=4.4P PS=10.5U
+ PD=20.88U
M$128 \$1841 \$1030 VDD VDD pfet_06v0 L=1U W=10U AS=4.4P AD=2.5P PS=20.88U
+ PD=10.5U
M$129 \$1036 \$1040 \$1841 VDD pfet_06v0 L=1U W=10U AS=2.5P AD=4.4P PS=10.5U
+ PD=20.88U
M$130 \$97 S1P \$114 VDD pfet_06v0 L=1U W=1.1U AS=0.484P AD=0.484P PS=3.08U
+ PD=3.08U
M$131 \$32 S1N \$114 VDD pfet_06v0 L=1U W=1U AS=0.44P AD=0.44P PS=2.88U PD=2.88U
M$132 \$31 \$34 VDD VDD pfet_06v0 L=1U W=5U AS=2.2P AD=1.65P PS=10.88U PD=5.66U
M$133 \$34 \$121 \$31 VDD pfet_06v0 L=1U W=5U AS=1.65P AD=1.65P PS=5.66U
+ PD=5.66U
M$134 \$33 \$37 \$34 VDD pfet_06v0 L=1U W=5U AS=1.65P AD=2.2P PS=5.66U PD=10.88U
M$135 \$30 \$34 VDD VDD pfet_06v0 L=1U W=5U AS=2.2P AD=1.65P PS=10.88U PD=5.66U
M$136 \$36 \$121 \$30 VDD pfet_06v0 L=1U W=5U AS=1.65P AD=1.65P PS=5.66U
+ PD=5.66U
M$137 \$35 \$37 \$36 VDD pfet_06v0 L=1U W=5U AS=1.65P AD=2.2P PS=5.66U PD=10.88U
M$138 \$1840 \$1026 VDD VDD pfet_06v0 L=1U W=10U AS=4.4P AD=2.5P PS=20.88U
+ PD=10.5U
M$139 \$1026 \$1040 \$1840 VDD pfet_06v0 L=1U W=10U AS=2.5P AD=3.3P PS=10.5U
+ PD=10.66U
M$140 \$958 \$958 \$1026 VDD pfet_06v0 L=1U W=10U AS=3.3P AD=4.4P PS=10.66U
+ PD=20.88U
M$141 \$1837 \$1030 VDD VDD pfet_06v0 L=1U W=10U AS=4.4P AD=2.5P PS=20.88U
+ PD=10.5U
M$142 \$974 \$1040 \$1837 VDD pfet_06v0 L=1U W=10U AS=2.5P AD=4.4P PS=10.5U
+ PD=20.88U
M$143 \$39 \$36 VDD VDD pfet_06v0 L=1U W=0.5U AS=0.22P AD=0.22P PS=1.88U
+ PD=1.88U
M$144 \$39 \$36 VDD VDD pfet_06v0 L=1U W=0.5U AS=0.22P AD=0.22P PS=1.88U
+ PD=1.88U
M$145 \$39 \$36 VDD VDD pfet_06v0 L=1U W=0.5U AS=0.22P AD=0.22P PS=1.88U
+ PD=1.88U
M$146 \$39 \$36 VDD VDD pfet_06v0 L=1U W=0.5U AS=0.22P AD=0.22P PS=1.88U
+ PD=1.88U
M$147 \$1834 \$1030 VDD VDD pfet_06v0 L=1U W=10U AS=4.4P AD=2.5P PS=20.88U
+ PD=10.5U
M$148 \$989 \$1040 \$1834 VDD pfet_06v0 L=1U W=10U AS=2.5P AD=4.4P PS=10.5U
+ PD=20.88U
M$149 \$1833 \$1030 VDD VDD pfet_06v0 L=1U W=10U AS=4.4P AD=2.5P PS=20.88U
+ PD=10.5U
M$150 \$988 \$1040 \$1833 VDD pfet_06v0 L=1U W=10U AS=2.5P AD=4.4P PS=10.5U
+ PD=20.88U
M$151 \$121 \$121 VDD VDD pfet_06v0 L=1U W=2U AS=0.88P AD=0.88P PS=4.88U
+ PD=4.88U
M$152 \$1830 \$1030 VDD VDD pfet_06v0 L=1U W=10U AS=4.4P AD=2.5P PS=20.88U
+ PD=10.5U
M$153 \$1030 \$1040 \$1830 VDD pfet_06v0 L=1U W=10U AS=2.5P AD=4.4P PS=10.5U
+ PD=20.88U
M$154 \$1829 \$1031 VDD VDD pfet_06v0 L=1U W=10U AS=4.4P AD=2.5P PS=20.88U
+ PD=10.5U
M$155 \$1037 \$1041 \$1829 VDD pfet_06v0 L=1U W=10U AS=2.5P AD=4.4P PS=10.5U
+ PD=20.88U
M$156 \$1828 \$1031 VDD VDD pfet_06v0 L=1U W=10U AS=4.4P AD=2.5P PS=20.88U
+ PD=10.5U
M$157 \$1037 \$1041 \$1828 VDD pfet_06v0 L=1U W=10U AS=2.5P AD=4.4P PS=10.5U
+ PD=20.88U
M$158 \$105 S2P \$116 VDD pfet_06v0 L=1U W=1.1U AS=0.484P AD=0.484P PS=3.08U
+ PD=3.08U
M$159 \$43 S2N \$116 VDD pfet_06v0 L=1U W=1U AS=0.44P AD=0.44P PS=2.88U PD=2.88U
M$160 \$42 \$45 VDD VDD pfet_06v0 L=1U W=5U AS=2.2P AD=1.65P PS=10.88U PD=5.66U
M$161 \$45 \$122 \$42 VDD pfet_06v0 L=1U W=5U AS=1.65P AD=1.65P PS=5.66U
+ PD=5.66U
M$162 \$44 \$48 \$45 VDD pfet_06v0 L=1U W=5U AS=1.65P AD=2.2P PS=5.66U PD=10.88U
M$163 \$41 \$45 VDD VDD pfet_06v0 L=1U W=5U AS=2.2P AD=1.65P PS=10.88U PD=5.66U
M$164 \$47 \$122 \$41 VDD pfet_06v0 L=1U W=5U AS=1.65P AD=1.65P PS=5.66U
+ PD=5.66U
M$165 \$46 \$48 \$47 VDD pfet_06v0 L=1U W=5U AS=1.65P AD=2.2P PS=5.66U PD=10.88U
M$166 \$1822 \$1027 VDD VDD pfet_06v0 L=1U W=10U AS=4.4P AD=2.5P PS=20.88U
+ PD=10.5U
M$167 \$1027 \$1041 \$1822 VDD pfet_06v0 L=1U W=10U AS=2.5P AD=3.3P PS=10.5U
+ PD=10.66U
M$168 \$969 \$969 \$1027 VDD pfet_06v0 L=1U W=10U AS=3.3P AD=4.4P PS=10.66U
+ PD=20.88U
M$169 \$1821 \$1031 VDD VDD pfet_06v0 L=1U W=10U AS=4.4P AD=2.5P PS=20.88U
+ PD=10.5U
M$170 \$975 \$1041 \$1821 VDD pfet_06v0 L=1U W=10U AS=2.5P AD=4.4P PS=10.5U
+ PD=20.88U
M$171 \$50 \$47 VDD VDD pfet_06v0 L=1U W=0.5U AS=0.22P AD=0.22P PS=1.88U
+ PD=1.88U
M$172 \$50 \$47 VDD VDD pfet_06v0 L=1U W=0.5U AS=0.22P AD=0.22P PS=1.88U
+ PD=1.88U
M$173 \$50 \$47 VDD VDD pfet_06v0 L=1U W=0.5U AS=0.22P AD=0.22P PS=1.88U
+ PD=1.88U
M$174 \$50 \$47 VDD VDD pfet_06v0 L=1U W=0.5U AS=0.22P AD=0.22P PS=1.88U
+ PD=1.88U
M$175 \$1818 \$1031 VDD VDD pfet_06v0 L=1U W=10U AS=4.4P AD=2.5P PS=20.88U
+ PD=10.5U
M$176 \$991 \$1041 \$1818 VDD pfet_06v0 L=1U W=10U AS=2.5P AD=4.4P PS=10.5U
+ PD=20.88U
M$177 \$1817 \$1031 VDD VDD pfet_06v0 L=1U W=10U AS=4.4P AD=2.5P PS=20.88U
+ PD=10.5U
M$178 \$990 \$1041 \$1817 VDD pfet_06v0 L=1U W=10U AS=2.5P AD=4.4P PS=10.5U
+ PD=20.88U
M$179 \$122 \$122 VDD VDD pfet_06v0 L=1U W=2U AS=0.88P AD=0.88P PS=4.88U
+ PD=4.88U
M$180 \$1815 \$1031 VDD VDD pfet_06v0 L=1U W=10U AS=4.4P AD=2.5P PS=20.88U
+ PD=10.5U
M$181 \$1031 \$1041 \$1815 VDD pfet_06v0 L=1U W=10U AS=2.5P AD=4.4P PS=10.5U
+ PD=20.88U
M$182 \$2731 \$1943 VDD VDD pfet_06v0 L=1U W=10U AS=4.4P AD=2.5P PS=20.88U
+ PD=10.5U
M$183 \$1951 \$1955 \$2731 VDD pfet_06v0 L=1U W=10U AS=2.5P AD=4.4P PS=10.5U
+ PD=20.88U
M$184 \$2733 \$1943 VDD VDD pfet_06v0 L=1U W=10U AS=4.4P AD=2.5P PS=20.88U
+ PD=10.5U
M$185 \$1951 \$1955 \$2733 VDD pfet_06v0 L=1U W=10U AS=2.5P AD=4.4P PS=10.5U
+ PD=20.88U
M$186 \$1013 S4P \$1033 VDD pfet_06v0 L=1U W=1.1U AS=0.484P AD=0.484P PS=3.08U
+ PD=3.08U
M$187 \$931 S4N \$1033 VDD pfet_06v0 L=1U W=1U AS=0.44P AD=0.44P PS=2.88U
+ PD=2.88U
M$188 \$930 \$933 VDD VDD pfet_06v0 L=1U W=5U AS=2.2P AD=1.65P PS=10.88U
+ PD=5.66U
M$189 \$933 \$1038 \$930 VDD pfet_06v0 L=1U W=5U AS=1.65P AD=1.65P PS=5.66U
+ PD=5.66U
M$190 \$932 \$936 \$933 VDD pfet_06v0 L=1U W=5U AS=1.65P AD=2.2P PS=5.66U
+ PD=10.88U
M$191 \$929 \$933 VDD VDD pfet_06v0 L=1U W=5U AS=2.2P AD=1.65P PS=10.88U
+ PD=5.66U
M$192 \$935 \$1038 \$929 VDD pfet_06v0 L=1U W=5U AS=1.65P AD=1.65P PS=5.66U
+ PD=5.66U
M$193 \$934 \$936 \$935 VDD pfet_06v0 L=1U W=5U AS=1.65P AD=2.2P PS=5.66U
+ PD=10.88U
M$194 \$2736 \$1944 VDD VDD pfet_06v0 L=1U W=10U AS=4.4P AD=2.5P PS=20.88U
+ PD=10.5U
M$195 \$1944 \$1955 \$2736 VDD pfet_06v0 L=1U W=10U AS=2.5P AD=3.3P PS=10.5U
+ PD=10.66U
M$196 \$1854 \$1854 \$1944 VDD pfet_06v0 L=1U W=10U AS=3.3P AD=4.4P PS=10.66U
+ PD=20.88U
M$197 \$2737 \$1943 VDD VDD pfet_06v0 L=1U W=10U AS=4.4P AD=2.5P PS=20.88U
+ PD=10.5U
M$198 \$1898 \$1955 \$2737 VDD pfet_06v0 L=1U W=10U AS=2.5P AD=4.4P PS=10.5U
+ PD=20.88U
M$199 \$938 \$935 VDD VDD pfet_06v0 L=1U W=0.5U AS=0.22P AD=0.22P PS=1.88U
+ PD=1.88U
M$200 \$938 \$935 VDD VDD pfet_06v0 L=1U W=0.5U AS=0.22P AD=0.22P PS=1.88U
+ PD=1.88U
M$201 \$938 \$935 VDD VDD pfet_06v0 L=1U W=0.5U AS=0.22P AD=0.22P PS=1.88U
+ PD=1.88U
M$202 \$938 \$935 VDD VDD pfet_06v0 L=1U W=0.5U AS=0.22P AD=0.22P PS=1.88U
+ PD=1.88U
M$203 \$2739 \$1943 VDD VDD pfet_06v0 L=1U W=10U AS=4.4P AD=2.5P PS=20.88U
+ PD=10.5U
M$204 \$1903 \$1955 \$2739 VDD pfet_06v0 L=1U W=10U AS=2.5P AD=4.4P PS=10.5U
+ PD=20.88U
M$205 \$2741 \$1943 VDD VDD pfet_06v0 L=1U W=10U AS=4.4P AD=2.5P PS=20.88U
+ PD=10.5U
M$206 \$1902 \$1955 \$2741 VDD pfet_06v0 L=1U W=10U AS=2.5P AD=4.4P PS=10.5U
+ PD=20.88U
M$207 \$1038 \$1038 VDD VDD pfet_06v0 L=1U W=2U AS=0.88P AD=0.88P PS=4.88U
+ PD=4.88U
M$208 \$2742 \$1943 VDD VDD pfet_06v0 L=1U W=10U AS=4.4P AD=2.5P PS=20.88U
+ PD=10.5U
M$209 \$1943 \$1955 \$2742 VDD pfet_06v0 L=1U W=10U AS=2.5P AD=4.4P PS=10.5U
+ PD=20.88U
M$210 \$2743 \$1945 VDD VDD pfet_06v0 L=1U W=10U AS=4.4P AD=2.5P PS=20.88U
+ PD=10.5U
M$211 \$1952 \$1956 \$2743 VDD pfet_06v0 L=1U W=10U AS=2.5P AD=4.4P PS=10.5U
+ PD=20.88U
M$212 \$2744 \$1945 VDD VDD pfet_06v0 L=1U W=10U AS=4.4P AD=2.5P PS=20.88U
+ PD=10.5U
M$213 \$1952 \$1956 \$2744 VDD pfet_06v0 L=1U W=10U AS=2.5P AD=4.4P PS=10.5U
+ PD=20.88U
M$214 \$1016 S1P \$1035 VDD pfet_06v0 L=1U W=1.1U AS=0.484P AD=0.484P PS=3.08U
+ PD=3.08U
M$215 \$942 S1N \$1035 VDD pfet_06v0 L=1U W=1U AS=0.44P AD=0.44P PS=2.88U
+ PD=2.88U
M$216 \$941 \$944 VDD VDD pfet_06v0 L=1U W=5U AS=2.2P AD=1.65P PS=10.88U
+ PD=5.66U
M$217 \$944 \$1039 \$941 VDD pfet_06v0 L=1U W=5U AS=1.65P AD=1.65P PS=5.66U
+ PD=5.66U
M$218 \$943 \$947 \$944 VDD pfet_06v0 L=1U W=5U AS=1.65P AD=2.2P PS=5.66U
+ PD=10.88U
M$219 \$940 \$944 VDD VDD pfet_06v0 L=1U W=5U AS=2.2P AD=1.65P PS=10.88U
+ PD=5.66U
M$220 \$946 \$1039 \$940 VDD pfet_06v0 L=1U W=5U AS=1.65P AD=1.65P PS=5.66U
+ PD=5.66U
M$221 \$945 \$947 \$946 VDD pfet_06v0 L=1U W=5U AS=1.65P AD=2.2P PS=5.66U
+ PD=10.88U
M$222 \$2747 \$1946 VDD VDD pfet_06v0 L=1U W=10U AS=4.4P AD=2.5P PS=20.88U
+ PD=10.5U
M$223 \$1946 \$1956 \$2747 VDD pfet_06v0 L=1U W=10U AS=2.5P AD=3.3P PS=10.5U
+ PD=10.66U
M$224 \$1865 \$1865 \$1946 VDD pfet_06v0 L=1U W=10U AS=3.3P AD=4.4P PS=10.66U
+ PD=20.88U
M$225 \$2749 \$1945 VDD VDD pfet_06v0 L=1U W=10U AS=4.4P AD=2.5P PS=20.88U
+ PD=10.5U
M$226 \$1899 \$1956 \$2749 VDD pfet_06v0 L=1U W=10U AS=2.5P AD=4.4P PS=10.5U
+ PD=20.88U
M$227 \$949 \$946 VDD VDD pfet_06v0 L=1U W=0.5U AS=0.22P AD=0.22P PS=1.88U
+ PD=1.88U
M$228 \$949 \$946 VDD VDD pfet_06v0 L=1U W=0.5U AS=0.22P AD=0.22P PS=1.88U
+ PD=1.88U
M$229 \$949 \$946 VDD VDD pfet_06v0 L=1U W=0.5U AS=0.22P AD=0.22P PS=1.88U
+ PD=1.88U
M$230 \$949 \$946 VDD VDD pfet_06v0 L=1U W=0.5U AS=0.22P AD=0.22P PS=1.88U
+ PD=1.88U
M$231 \$2752 \$1945 VDD VDD pfet_06v0 L=1U W=10U AS=4.4P AD=2.5P PS=20.88U
+ PD=10.5U
M$232 \$1905 \$1956 \$2752 VDD pfet_06v0 L=1U W=10U AS=2.5P AD=4.4P PS=10.5U
+ PD=20.88U
M$233 \$2753 \$1945 VDD VDD pfet_06v0 L=1U W=10U AS=4.4P AD=2.5P PS=20.88U
+ PD=10.5U
M$234 \$1904 \$1956 \$2753 VDD pfet_06v0 L=1U W=10U AS=2.5P AD=4.4P PS=10.5U
+ PD=20.88U
M$235 \$1039 \$1039 VDD VDD pfet_06v0 L=1U W=2U AS=0.88P AD=0.88P PS=4.88U
+ PD=4.88U
M$236 \$2754 \$1945 VDD VDD pfet_06v0 L=1U W=10U AS=4.4P AD=2.5P PS=20.88U
+ PD=10.5U
M$237 \$1945 \$1956 \$2754 VDD pfet_06v0 L=1U W=10U AS=2.5P AD=4.4P PS=10.5U
+ PD=20.88U
M$238 \$2756 \$1947 VDD VDD pfet_06v0 L=1U W=10U AS=4.4P AD=2.5P PS=20.88U
+ PD=10.5U
M$239 \$1953 \$1957 \$2756 VDD pfet_06v0 L=1U W=10U AS=2.5P AD=4.4P PS=10.5U
+ PD=20.88U
M$240 \$2757 \$1947 VDD VDD pfet_06v0 L=1U W=10U AS=4.4P AD=2.5P PS=20.88U
+ PD=10.5U
M$241 \$1953 \$1957 \$2757 VDD pfet_06v0 L=1U W=10U AS=2.5P AD=4.4P PS=10.5U
+ PD=20.88U
M$242 \$1025 S4P \$1036 VDD pfet_06v0 L=1U W=1.1U AS=0.484P AD=0.484P PS=3.08U
+ PD=3.08U
M$243 \$953 S4N \$1036 VDD pfet_06v0 L=1U W=1U AS=0.44P AD=0.44P PS=2.88U
+ PD=2.88U
M$244 \$952 \$955 VDD VDD pfet_06v0 L=1U W=5U AS=2.2P AD=1.65P PS=10.88U
+ PD=5.66U
M$245 \$955 \$1040 \$952 VDD pfet_06v0 L=1U W=5U AS=1.65P AD=1.65P PS=5.66U
+ PD=5.66U
M$246 \$954 \$958 \$955 VDD pfet_06v0 L=1U W=5U AS=1.65P AD=2.2P PS=5.66U
+ PD=10.88U
M$247 \$951 \$955 VDD VDD pfet_06v0 L=1U W=5U AS=2.2P AD=1.65P PS=10.88U
+ PD=5.66U
M$248 \$957 \$1040 \$951 VDD pfet_06v0 L=1U W=5U AS=1.65P AD=1.65P PS=5.66U
+ PD=5.66U
M$249 \$956 \$958 \$957 VDD pfet_06v0 L=1U W=5U AS=1.65P AD=2.2P PS=5.66U
+ PD=10.88U
M$250 \$2758 \$1948 VDD VDD pfet_06v0 L=1U W=10U AS=4.4P AD=2.5P PS=20.88U
+ PD=10.5U
M$251 \$1948 \$1957 \$2758 VDD pfet_06v0 L=1U W=10U AS=2.5P AD=3.3P PS=10.5U
+ PD=10.66U
M$252 \$1876 \$1876 \$1948 VDD pfet_06v0 L=1U W=10U AS=3.3P AD=4.4P PS=10.66U
+ PD=20.88U
M$253 \$2755 \$1947 VDD VDD pfet_06v0 L=1U W=10U AS=4.4P AD=2.5P PS=20.88U
+ PD=10.5U
M$254 \$1900 \$1957 \$2755 VDD pfet_06v0 L=1U W=10U AS=2.5P AD=4.4P PS=10.5U
+ PD=20.88U
M$255 \$960 \$957 VDD VDD pfet_06v0 L=1U W=0.5U AS=0.22P AD=0.22P PS=1.88U
+ PD=1.88U
M$256 \$960 \$957 VDD VDD pfet_06v0 L=1U W=0.5U AS=0.22P AD=0.22P PS=1.88U
+ PD=1.88U
M$257 \$960 \$957 VDD VDD pfet_06v0 L=1U W=0.5U AS=0.22P AD=0.22P PS=1.88U
+ PD=1.88U
M$258 \$960 \$957 VDD VDD pfet_06v0 L=1U W=0.5U AS=0.22P AD=0.22P PS=1.88U
+ PD=1.88U
M$259 \$2751 \$1947 VDD VDD pfet_06v0 L=1U W=10U AS=4.4P AD=2.5P PS=20.88U
+ PD=10.5U
M$260 \$1907 \$1957 \$2751 VDD pfet_06v0 L=1U W=10U AS=2.5P AD=4.4P PS=10.5U
+ PD=20.88U
M$261 \$2750 \$1947 VDD VDD pfet_06v0 L=1U W=10U AS=4.4P AD=2.5P PS=20.88U
+ PD=10.5U
M$262 \$1906 \$1957 \$2750 VDD pfet_06v0 L=1U W=10U AS=2.5P AD=4.4P PS=10.5U
+ PD=20.88U
M$263 \$1040 \$1040 VDD VDD pfet_06v0 L=1U W=2U AS=0.88P AD=0.88P PS=4.88U
+ PD=4.88U
M$264 \$2748 \$1947 VDD VDD pfet_06v0 L=1U W=10U AS=4.4P AD=2.5P PS=20.88U
+ PD=10.5U
M$265 \$1947 \$1957 \$2748 VDD pfet_06v0 L=1U W=10U AS=2.5P AD=4.4P PS=10.5U
+ PD=20.88U
M$266 \$2746 \$1949 VDD VDD pfet_06v0 L=1U W=10U AS=4.4P AD=2.5P PS=20.88U
+ PD=10.5U
M$267 \$1954 \$1958 \$2746 VDD pfet_06v0 L=1U W=10U AS=2.5P AD=4.4P PS=10.5U
+ PD=20.88U
M$268 \$2745 \$1949 VDD VDD pfet_06v0 L=1U W=10U AS=4.4P AD=2.5P PS=20.88U
+ PD=10.5U
M$269 \$1954 \$1958 \$2745 VDD pfet_06v0 L=1U W=10U AS=2.5P AD=4.4P PS=10.5U
+ PD=20.88U
M$270 \$1022 S1P \$1037 VDD pfet_06v0 L=1U W=1.1U AS=0.484P AD=0.484P PS=3.08U
+ PD=3.08U
M$271 \$964 S1N \$1037 VDD pfet_06v0 L=1U W=1U AS=0.44P AD=0.44P PS=2.88U
+ PD=2.88U
M$272 \$963 \$966 VDD VDD pfet_06v0 L=1U W=5U AS=2.2P AD=1.65P PS=10.88U
+ PD=5.66U
M$273 \$966 \$1041 \$963 VDD pfet_06v0 L=1U W=5U AS=1.65P AD=1.65P PS=5.66U
+ PD=5.66U
M$274 \$965 \$969 \$966 VDD pfet_06v0 L=1U W=5U AS=1.65P AD=2.2P PS=5.66U
+ PD=10.88U
M$275 \$962 \$966 VDD VDD pfet_06v0 L=1U W=5U AS=2.2P AD=1.65P PS=10.88U
+ PD=5.66U
M$276 \$968 \$1041 \$962 VDD pfet_06v0 L=1U W=5U AS=1.65P AD=1.65P PS=5.66U
+ PD=5.66U
M$277 \$967 \$969 \$968 VDD pfet_06v0 L=1U W=5U AS=1.65P AD=2.2P PS=5.66U
+ PD=10.88U
M$278 \$2740 \$1950 VDD VDD pfet_06v0 L=1U W=10U AS=4.4P AD=2.5P PS=20.88U
+ PD=10.5U
M$279 \$1950 \$1958 \$2740 VDD pfet_06v0 L=1U W=10U AS=2.5P AD=3.3P PS=10.5U
+ PD=10.66U
M$280 \$1887 \$1887 \$1950 VDD pfet_06v0 L=1U W=10U AS=3.3P AD=4.4P PS=10.66U
+ PD=20.88U
M$281 \$2738 \$1949 VDD VDD pfet_06v0 L=1U W=10U AS=4.4P AD=2.5P PS=20.88U
+ PD=10.5U
M$282 \$1901 \$1958 \$2738 VDD pfet_06v0 L=1U W=10U AS=2.5P AD=4.4P PS=10.5U
+ PD=20.88U
M$283 \$971 \$968 VDD VDD pfet_06v0 L=1U W=0.5U AS=0.22P AD=0.22P PS=1.88U
+ PD=1.88U
M$284 \$971 \$968 VDD VDD pfet_06v0 L=1U W=0.5U AS=0.22P AD=0.22P PS=1.88U
+ PD=1.88U
M$285 \$971 \$968 VDD VDD pfet_06v0 L=1U W=0.5U AS=0.22P AD=0.22P PS=1.88U
+ PD=1.88U
M$286 \$971 \$968 VDD VDD pfet_06v0 L=1U W=0.5U AS=0.22P AD=0.22P PS=1.88U
+ PD=1.88U
M$287 \$2735 \$1949 VDD VDD pfet_06v0 L=1U W=10U AS=4.4P AD=2.5P PS=20.88U
+ PD=10.5U
M$288 \$1909 \$1958 \$2735 VDD pfet_06v0 L=1U W=10U AS=2.5P AD=4.4P PS=10.5U
+ PD=20.88U
M$289 \$2734 \$1949 VDD VDD pfet_06v0 L=1U W=10U AS=4.4P AD=2.5P PS=20.88U
+ PD=10.5U
M$290 \$1908 \$1958 \$2734 VDD pfet_06v0 L=1U W=10U AS=2.5P AD=4.4P PS=10.5U
+ PD=20.88U
M$291 \$1041 \$1041 VDD VDD pfet_06v0 L=1U W=2U AS=0.88P AD=0.88P PS=4.88U
+ PD=4.88U
M$292 \$2732 \$1949 VDD VDD pfet_06v0 L=1U W=10U AS=4.4P AD=2.5P PS=20.88U
+ PD=10.5U
M$293 \$1949 \$1958 \$2732 VDD pfet_06v0 L=1U W=10U AS=2.5P AD=4.4P PS=10.5U
+ PD=20.88U
M$294 \$1931 S3P \$1951 VDD pfet_06v0 L=1U W=1.1U AS=0.484P AD=0.484P PS=3.08U
+ PD=3.08U
M$295 \$1849 S3N \$1951 VDD pfet_06v0 L=1U W=1U AS=0.44P AD=0.44P PS=2.88U
+ PD=2.88U
M$296 \$1848 \$1851 VDD VDD pfet_06v0 L=1U W=5U AS=2.2P AD=1.65P PS=10.88U
+ PD=5.66U
M$297 \$1851 \$1955 \$1848 VDD pfet_06v0 L=1U W=5U AS=1.65P AD=1.65P PS=5.66U
+ PD=5.66U
M$298 \$1850 \$1854 \$1851 VDD pfet_06v0 L=1U W=5U AS=1.65P AD=2.2P PS=5.66U
+ PD=10.88U
M$299 \$1847 \$1851 VDD VDD pfet_06v0 L=1U W=5U AS=2.2P AD=1.65P PS=10.88U
+ PD=5.66U
M$300 \$1853 \$1955 \$1847 VDD pfet_06v0 L=1U W=5U AS=1.65P AD=1.65P PS=5.66U
+ PD=5.66U
M$301 \$1852 \$1854 \$1853 VDD pfet_06v0 L=1U W=5U AS=1.65P AD=2.2P PS=5.66U
+ PD=10.88U
M$302 \$2786 \$17 \$2930 VDD pfet_06v0 L=1U W=10U AS=4.4P AD=2.6P PS=20.88U
+ PD=10.52U
M$303 \$2930 \$17 \$2786 VDD pfet_06v0 L=1U W=10U AS=2.6P AD=4.4P PS=10.52U
+ PD=20.88U
M$304 \$2784 \$39 \$2930 VDD pfet_06v0 L=1U W=10U AS=4.4P AD=2.6P PS=20.88U
+ PD=10.52U
M$305 \$2930 \$39 \$2784 VDD pfet_06v0 L=1U W=10U AS=2.6P AD=4.4P PS=10.52U
+ PD=20.88U
M$306 \$1856 \$1853 VDD VDD pfet_06v0 L=1U W=0.5U AS=0.22P AD=0.22P PS=1.88U
+ PD=1.88U
M$307 \$1856 \$1853 VDD VDD pfet_06v0 L=1U W=0.5U AS=0.22P AD=0.22P PS=1.88U
+ PD=1.88U
M$308 \$1856 \$1853 VDD VDD pfet_06v0 L=1U W=0.5U AS=0.22P AD=0.22P PS=1.88U
+ PD=1.88U
M$309 \$1856 \$1853 VDD VDD pfet_06v0 L=1U W=0.5U AS=0.22P AD=0.22P PS=1.88U
+ PD=1.88U
M$310 \$1955 \$1955 VDD VDD pfet_06v0 L=1U W=2U AS=0.88P AD=0.88P PS=4.88U
+ PD=4.88U
M$311 \$2788 \$2766 VDD VDD pfet_06v0 L=1U W=10U AS=4.4P AD=2.6P PS=20.88U
+ PD=10.52U
M$312 VDD \$2766 \$2788 VDD pfet_06v0 L=1U W=10U AS=2.6P AD=2.6P PS=10.52U
+ PD=10.52U
M$313 \$2788 \$2766 VDD VDD pfet_06v0 L=1U W=10U AS=2.6P AD=4.4P PS=10.52U
+ PD=20.88U
M$314 \$1934 S4P \$1952 VDD pfet_06v0 L=1U W=1.1U AS=0.484P AD=0.484P PS=3.08U
+ PD=3.08U
M$315 \$1860 S4N \$1952 VDD pfet_06v0 L=1U W=1U AS=0.44P AD=0.44P PS=2.88U
+ PD=2.88U
M$316 \$1859 \$1862 VDD VDD pfet_06v0 L=1U W=5U AS=2.2P AD=1.65P PS=10.88U
+ PD=5.66U
M$317 \$1862 \$1956 \$1859 VDD pfet_06v0 L=1U W=5U AS=1.65P AD=1.65P PS=5.66U
+ PD=5.66U
M$318 \$1861 \$1865 \$1862 VDD pfet_06v0 L=1U W=5U AS=1.65P AD=2.2P PS=5.66U
+ PD=10.88U
M$319 \$1858 \$1862 VDD VDD pfet_06v0 L=1U W=5U AS=2.2P AD=1.65P PS=10.88U
+ PD=5.66U
M$320 \$1864 \$1956 \$1858 VDD pfet_06v0 L=1U W=5U AS=1.65P AD=1.65P PS=5.66U
+ PD=5.66U
M$321 \$1863 \$1865 \$1864 VDD pfet_06v0 L=1U W=5U AS=1.65P AD=2.2P PS=5.66U
+ PD=10.88U
M$322 \$2795 \$28 \$2932 VDD pfet_06v0 L=1U W=10U AS=4.4P AD=2.6P PS=20.88U
+ PD=10.52U
M$323 \$2932 \$28 \$2795 VDD pfet_06v0 L=1U W=10U AS=2.6P AD=4.4P PS=10.52U
+ PD=20.88U
M$324 \$1867 \$1864 VDD VDD pfet_06v0 L=1U W=0.5U AS=0.22P AD=0.22P PS=1.88U
+ PD=1.88U
M$325 \$2793 \$39 \$2932 VDD pfet_06v0 L=1U W=10U AS=4.4P AD=2.6P PS=20.88U
+ PD=10.52U
M$326 \$2932 \$39 \$2793 VDD pfet_06v0 L=1U W=10U AS=2.6P AD=4.4P PS=10.52U
+ PD=20.88U
M$327 \$1867 \$1864 VDD VDD pfet_06v0 L=1U W=0.5U AS=0.22P AD=0.22P PS=1.88U
+ PD=1.88U
M$328 \$1867 \$1864 VDD VDD pfet_06v0 L=1U W=0.5U AS=0.22P AD=0.22P PS=1.88U
+ PD=1.88U
M$329 \$1867 \$1864 VDD VDD pfet_06v0 L=1U W=0.5U AS=0.22P AD=0.22P PS=1.88U
+ PD=1.88U
M$330 \$1956 \$1956 VDD VDD pfet_06v0 L=1U W=2U AS=0.88P AD=0.88P PS=4.88U
+ PD=4.88U
M$331 \$2797 \$2770 VDD VDD pfet_06v0 L=1U W=10U AS=4.4P AD=2.6P PS=20.88U
+ PD=10.52U
M$332 VDD \$2770 \$2797 VDD pfet_06v0 L=1U W=10U AS=2.6P AD=2.6P PS=10.52U
+ PD=10.52U
M$333 \$2797 \$2770 VDD VDD pfet_06v0 L=1U W=10U AS=2.6P AD=4.4P PS=10.52U
+ PD=20.88U
M$334 \$1937 S2P \$1953 VDD pfet_06v0 L=1U W=1.1U AS=0.484P AD=0.484P PS=3.08U
+ PD=3.08U
M$335 \$1871 S2N \$1953 VDD pfet_06v0 L=1U W=1U AS=0.44P AD=0.44P PS=2.88U
+ PD=2.88U
M$336 \$1870 \$1873 VDD VDD pfet_06v0 L=1U W=5U AS=2.2P AD=1.65P PS=10.88U
+ PD=5.66U
M$337 \$1873 \$1957 \$1870 VDD pfet_06v0 L=1U W=5U AS=1.65P AD=1.65P PS=5.66U
+ PD=5.66U
M$338 \$1872 \$1876 \$1873 VDD pfet_06v0 L=1U W=5U AS=1.65P AD=2.2P PS=5.66U
+ PD=10.88U
M$339 \$1869 \$1873 VDD VDD pfet_06v0 L=1U W=5U AS=2.2P AD=1.65P PS=10.88U
+ PD=5.66U
M$340 \$1875 \$1957 \$1869 VDD pfet_06v0 L=1U W=5U AS=1.65P AD=1.65P PS=5.66U
+ PD=5.66U
M$341 \$1874 \$1876 \$1875 VDD pfet_06v0 L=1U W=5U AS=1.65P AD=2.2P PS=5.66U
+ PD=10.88U
M$342 \$1878 \$1875 VDD VDD pfet_06v0 L=1U W=0.5U AS=0.22P AD=0.22P PS=1.88U
+ PD=1.88U
M$343 \$1878 \$1875 VDD VDD pfet_06v0 L=1U W=0.5U AS=0.22P AD=0.22P PS=1.88U
+ PD=1.88U
M$344 \$2804 \$28 \$2934 VDD pfet_06v0 L=1U W=10U AS=4.4P AD=2.6P PS=20.88U
+ PD=10.52U
M$345 \$2934 \$28 \$2804 VDD pfet_06v0 L=1U W=10U AS=2.6P AD=4.4P PS=10.52U
+ PD=20.88U
M$346 \$1878 \$1875 VDD VDD pfet_06v0 L=1U W=0.5U AS=0.22P AD=0.22P PS=1.88U
+ PD=1.88U
M$347 \$2802 \$17 \$2934 VDD pfet_06v0 L=1U W=10U AS=4.4P AD=2.6P PS=20.88U
+ PD=10.52U
M$348 \$2934 \$17 \$2802 VDD pfet_06v0 L=1U W=10U AS=2.6P AD=4.4P PS=10.52U
+ PD=20.88U
M$349 \$1878 \$1875 VDD VDD pfet_06v0 L=1U W=0.5U AS=0.22P AD=0.22P PS=1.88U
+ PD=1.88U
M$350 \$1957 \$1957 VDD VDD pfet_06v0 L=1U W=2U AS=0.88P AD=0.88P PS=4.88U
+ PD=4.88U
M$351 \$1940 S3P \$1954 VDD pfet_06v0 L=1U W=1.1U AS=0.484P AD=0.484P PS=3.08U
+ PD=3.08U
M$352 \$2806 \$2775 VDD VDD pfet_06v0 L=1U W=10U AS=4.4P AD=2.6P PS=20.88U
+ PD=10.52U
M$353 VDD \$2775 \$2806 VDD pfet_06v0 L=1U W=10U AS=2.6P AD=2.6P PS=10.52U
+ PD=10.52U
M$354 \$2806 \$2775 VDD VDD pfet_06v0 L=1U W=10U AS=2.6P AD=4.4P PS=10.52U
+ PD=20.88U
M$355 \$1882 S3N \$1954 VDD pfet_06v0 L=1U W=1U AS=0.44P AD=0.44P PS=2.88U
+ PD=2.88U
M$356 \$1881 \$1884 VDD VDD pfet_06v0 L=1U W=5U AS=2.2P AD=1.65P PS=10.88U
+ PD=5.66U
M$357 \$1884 \$1958 \$1881 VDD pfet_06v0 L=1U W=5U AS=1.65P AD=1.65P PS=5.66U
+ PD=5.66U
M$358 \$1883 \$1887 \$1884 VDD pfet_06v0 L=1U W=5U AS=1.65P AD=2.2P PS=5.66U
+ PD=10.88U
M$359 \$1880 \$1884 VDD VDD pfet_06v0 L=1U W=5U AS=2.2P AD=1.65P PS=10.88U
+ PD=5.66U
M$360 \$1886 \$1958 \$1880 VDD pfet_06v0 L=1U W=5U AS=1.65P AD=1.65P PS=5.66U
+ PD=5.66U
M$361 \$1885 \$1887 \$1886 VDD pfet_06v0 L=1U W=5U AS=1.65P AD=2.2P PS=5.66U
+ PD=10.88U
M$362 \$1889 \$1886 VDD VDD pfet_06v0 L=1U W=0.5U AS=0.22P AD=0.22P PS=1.88U
+ PD=1.88U
M$363 \$1889 \$1886 VDD VDD pfet_06v0 L=1U W=0.5U AS=0.22P AD=0.22P PS=1.88U
+ PD=1.88U
M$364 \$1889 \$1886 VDD VDD pfet_06v0 L=1U W=0.5U AS=0.22P AD=0.22P PS=1.88U
+ PD=1.88U
M$365 \$1889 \$1886 VDD VDD pfet_06v0 L=1U W=0.5U AS=0.22P AD=0.22P PS=1.88U
+ PD=1.88U
M$366 \$1958 \$1958 VDD VDD pfet_06v0 L=1U W=2U AS=0.88P AD=0.88P PS=4.88U
+ PD=4.88U
M$367 \$4527 \$3312 VDD VDD pfet_06v0 L=1U W=10U AS=4.4P AD=2.5P PS=20.88U
+ PD=10.5U
M$368 \$2780 \$3391 \$4527 VDD pfet_06v0 L=1U W=10U AS=2.5P AD=4.4P PS=10.5U
+ PD=20.88U
M$369 \$4528 \$3312 VDD VDD pfet_06v0 L=1U W=10U AS=4.4P AD=2.5P PS=20.88U
+ PD=10.5U
M$370 \$2765 \$3391 \$4528 VDD pfet_06v0 L=1U W=10U AS=2.5P AD=4.4P PS=10.5U
+ PD=20.88U
M$371 \$4529 \$3312 VDD VDD pfet_06v0 L=1U W=10U AS=4.4P AD=2.5P PS=20.88U
+ PD=10.5U
M$372 \$3312 \$3391 \$4529 VDD pfet_06v0 L=1U W=10U AS=2.5P AD=4.4P PS=10.5U
+ PD=20.88U
M$373 \$4530 \$3312 VDD VDD pfet_06v0 L=1U W=10U AS=4.4P AD=2.5P PS=20.88U
+ PD=10.5U
M$374 \$2930 \$3391 \$4530 VDD pfet_06v0 L=1U W=10U AS=2.5P AD=3.3P PS=10.5U
+ PD=10.66U
M$375 \$4531 \$3391 \$2930 VDD pfet_06v0 L=1U W=10U AS=3.3P AD=2.5P PS=10.66U
+ PD=10.5U
M$376 VDD \$3312 \$4531 VDD pfet_06v0 L=1U W=10U AS=2.5P AD=4.4P PS=10.5U
+ PD=20.88U
M$377 \$4534 \$2843 VDD VDD pfet_06v0 L=1U W=10U AS=4.4P AD=2.5P PS=20.88U
+ PD=10.5U
M$378 \$2843 \$3391 \$4534 VDD pfet_06v0 L=1U W=10U AS=2.5P AD=3.3P PS=10.5U
+ PD=10.66U
M$379 \$2767 \$2767 \$2843 VDD pfet_06v0 L=1U W=10U AS=3.3P AD=4.4P PS=10.66U
+ PD=20.88U
M$380 \$4535 \$3312 VDD VDD pfet_06v0 L=1U W=10U AS=4.4P AD=2.5P PS=20.88U
+ PD=10.5U
M$381 \$2813 \$3391 \$4535 VDD pfet_06v0 L=1U W=10U AS=2.5P AD=4.4P PS=10.5U
+ PD=20.88U
M$382 \$4536 \$3313 VDD VDD pfet_06v0 L=1U W=10U AS=4.4P AD=2.5P PS=20.88U
+ PD=10.5U
M$383 \$2789 \$3392 \$4536 VDD pfet_06v0 L=1U W=10U AS=2.5P AD=4.4P PS=10.5U
+ PD=20.88U
M$384 \$4537 \$3313 VDD VDD pfet_06v0 L=1U W=10U AS=4.4P AD=2.5P PS=20.88U
+ PD=10.5U
M$385 \$2769 \$3392 \$4537 VDD pfet_06v0 L=1U W=10U AS=2.5P AD=4.4P PS=10.5U
+ PD=20.88U
M$386 \$4538 \$3313 VDD VDD pfet_06v0 L=1U W=10U AS=4.4P AD=2.5P PS=20.88U
+ PD=10.5U
M$387 \$3313 \$3392 \$4538 VDD pfet_06v0 L=1U W=10U AS=2.5P AD=4.4P PS=10.5U
+ PD=20.88U
M$388 \$4539 \$3313 VDD VDD pfet_06v0 L=1U W=10U AS=4.4P AD=2.5P PS=20.88U
+ PD=10.5U
M$389 \$2932 \$3392 \$4539 VDD pfet_06v0 L=1U W=10U AS=2.5P AD=3.3P PS=10.5U
+ PD=10.66U
M$390 \$4540 \$3392 \$2932 VDD pfet_06v0 L=1U W=10U AS=3.3P AD=2.5P PS=10.66U
+ PD=10.5U
M$391 VDD \$3313 \$4540 VDD pfet_06v0 L=1U W=10U AS=2.5P AD=4.4P PS=10.5U
+ PD=20.88U
M$392 \$4541 \$2846 VDD VDD pfet_06v0 L=1U W=10U AS=4.4P AD=2.5P PS=20.88U
+ PD=10.5U
M$393 \$2846 \$3392 \$4541 VDD pfet_06v0 L=1U W=10U AS=2.5P AD=3.3P PS=10.5U
+ PD=10.66U
M$394 \$2771 \$2771 \$2846 VDD pfet_06v0 L=1U W=10U AS=3.3P AD=4.4P PS=10.66U
+ PD=20.88U
M$395 \$4542 \$3313 VDD VDD pfet_06v0 L=1U W=10U AS=4.4P AD=2.5P PS=20.88U
+ PD=10.5U
M$396 \$2814 \$3392 \$4542 VDD pfet_06v0 L=1U W=10U AS=2.5P AD=4.4P PS=10.5U
+ PD=20.88U
M$397 \$4543 \$3314 VDD VDD pfet_06v0 L=1U W=10U AS=4.4P AD=2.5P PS=20.88U
+ PD=10.5U
M$398 \$2798 \$3393 \$4543 VDD pfet_06v0 L=1U W=10U AS=2.5P AD=4.4P PS=10.5U
+ PD=20.88U
M$399 \$4544 \$3314 VDD VDD pfet_06v0 L=1U W=10U AS=4.4P AD=2.5P PS=20.88U
+ PD=10.5U
M$400 \$2774 \$3393 \$4544 VDD pfet_06v0 L=1U W=10U AS=2.5P AD=4.4P PS=10.5U
+ PD=20.88U
M$401 \$4545 \$3314 VDD VDD pfet_06v0 L=1U W=10U AS=4.4P AD=2.5P PS=20.88U
+ PD=10.5U
M$402 \$3314 \$3393 \$4545 VDD pfet_06v0 L=1U W=10U AS=2.5P AD=4.4P PS=10.5U
+ PD=20.88U
M$403 \$4546 \$3314 VDD VDD pfet_06v0 L=1U W=10U AS=4.4P AD=2.5P PS=20.88U
+ PD=10.5U
M$404 \$2934 \$3393 \$4546 VDD pfet_06v0 L=1U W=10U AS=2.5P AD=3.3P PS=10.5U
+ PD=10.66U
M$405 \$4547 \$3393 \$2934 VDD pfet_06v0 L=1U W=10U AS=3.3P AD=2.5P PS=10.66U
+ PD=10.5U
M$406 VDD \$3314 \$4547 VDD pfet_06v0 L=1U W=10U AS=2.5P AD=4.4P PS=10.5U
+ PD=20.88U
M$407 \$4533 \$2849 VDD VDD pfet_06v0 L=1U W=10U AS=4.4P AD=2.5P PS=20.88U
+ PD=10.5U
M$408 \$2849 \$3393 \$4533 VDD pfet_06v0 L=1U W=10U AS=2.5P AD=3.3P PS=10.5U
+ PD=10.66U
M$409 \$2776 \$2776 \$2849 VDD pfet_06v0 L=1U W=10U AS=3.3P AD=4.4P PS=10.66U
+ PD=20.88U
M$410 \$4532 \$3314 VDD VDD pfet_06v0 L=1U W=10U AS=4.4P AD=2.5P PS=20.88U
+ PD=10.5U
M$411 \$2815 \$3393 \$4532 VDD pfet_06v0 L=1U W=10U AS=2.5P AD=4.4P PS=10.5U
+ PD=20.88U
M$412 \$3391 \$3391 VDD VDD pfet_06v0 L=1U W=2U AS=0.88P AD=0.88P PS=4.88U
+ PD=4.88U
M$413 \$4573 \$50 \$4719 VDD pfet_06v0 L=1U W=10U AS=4.4P AD=2.6P PS=20.88U
+ PD=10.52U
M$414 \$4719 \$50 \$4573 VDD pfet_06v0 L=1U W=10U AS=2.6P AD=4.4P PS=10.52U
+ PD=20.88U
M$415 \$4571 \$949 \$4719 VDD pfet_06v0 L=1U W=10U AS=4.4P AD=2.6P PS=20.88U
+ PD=10.52U
M$416 \$4719 \$949 \$4571 VDD pfet_06v0 L=1U W=10U AS=2.6P AD=4.4P PS=10.52U
+ PD=20.88U
M$417 \$2931 \$3391 \$2783 VDD pfet_06v0 L=1U W=5U AS=2.2P AD=1.3P PS=10.88U
+ PD=5.52U
M$418 \$2783 \$3391 \$2931 VDD pfet_06v0 L=1U W=5U AS=1.3P AD=2.2P PS=5.52U
+ PD=10.88U
M$419 \$2766 \$3391 \$2782 VDD pfet_06v0 L=1U W=5U AS=2.2P AD=1.3P PS=10.88U
+ PD=5.52U
M$420 \$2782 \$3391 \$2766 VDD pfet_06v0 L=1U W=5U AS=1.3P AD=2.2P PS=5.52U
+ PD=10.88U
M$421 \$2783 \$2931 VDD VDD pfet_06v0 L=1U W=5U AS=2.2P AD=1.3P PS=10.88U
+ PD=5.52U
M$422 VDD \$2931 \$2783 VDD pfet_06v0 L=1U W=5U AS=1.3P AD=1.3P PS=5.52U
+ PD=5.52U
M$423 \$2783 \$2931 VDD VDD pfet_06v0 L=1U W=5U AS=1.3P AD=1.3P PS=5.52U
+ PD=5.52U
M$424 VDD \$2931 \$2783 VDD pfet_06v0 L=1U W=5U AS=1.3P AD=2.2P PS=5.52U
+ PD=10.88U
M$425 \$2782 \$2931 VDD VDD pfet_06v0 L=1U W=5U AS=2.2P AD=1.3P PS=10.88U
+ PD=5.52U
M$426 VDD \$2931 \$2782 VDD pfet_06v0 L=1U W=5U AS=1.3P AD=1.3P PS=5.52U
+ PD=5.52U
M$427 \$2782 \$2931 VDD VDD pfet_06v0 L=1U W=5U AS=1.3P AD=1.3P PS=5.52U
+ PD=5.52U
M$428 VDD \$2931 \$2782 VDD pfet_06v0 L=1U W=5U AS=1.3P AD=2.2P PS=5.52U
+ PD=10.88U
M$429 \$2785 \$2767 \$2931 VDD pfet_06v0 L=1U W=5U AS=2.2P AD=2.2P PS=10.88U
+ PD=10.88U
M$430 \$2787 \$2767 \$2766 VDD pfet_06v0 L=1U W=5U AS=2.2P AD=2.2P PS=10.88U
+ PD=10.88U
M$431 \$4575 \$4553 VDD VDD pfet_06v0 L=1U W=10U AS=4.4P AD=2.6P PS=20.88U
+ PD=10.52U
M$432 VDD \$4553 \$4575 VDD pfet_06v0 L=1U W=10U AS=2.6P AD=2.6P PS=10.52U
+ PD=10.52U
M$433 \$4575 \$4553 VDD VDD pfet_06v0 L=1U W=10U AS=2.6P AD=4.4P PS=10.52U
+ PD=20.88U
M$434 \$3392 \$3392 VDD VDD pfet_06v0 L=1U W=2U AS=0.88P AD=0.88P PS=4.88U
+ PD=4.88U
M$435 \$4582 \$938 \$4721 VDD pfet_06v0 L=1U W=10U AS=4.4P AD=2.6P PS=20.88U
+ PD=10.52U
M$436 \$4721 \$938 \$4582 VDD pfet_06v0 L=1U W=10U AS=2.6P AD=4.4P PS=10.52U
+ PD=20.88U
M$437 \$4580 \$949 \$4721 VDD pfet_06v0 L=1U W=10U AS=4.4P AD=2.6P PS=20.88U
+ PD=10.52U
M$438 \$4721 \$949 \$4580 VDD pfet_06v0 L=1U W=10U AS=2.6P AD=4.4P PS=10.52U
+ PD=20.88U
M$439 \$2933 \$3392 \$2792 VDD pfet_06v0 L=1U W=5U AS=2.2P AD=1.3P PS=10.88U
+ PD=5.52U
M$440 \$2792 \$3392 \$2933 VDD pfet_06v0 L=1U W=5U AS=1.3P AD=2.2P PS=5.52U
+ PD=10.88U
M$441 \$2770 \$3392 \$2791 VDD pfet_06v0 L=1U W=5U AS=2.2P AD=1.3P PS=10.88U
+ PD=5.52U
M$442 \$2791 \$3392 \$2770 VDD pfet_06v0 L=1U W=5U AS=1.3P AD=2.2P PS=5.52U
+ PD=10.88U
M$443 \$2792 \$2933 VDD VDD pfet_06v0 L=1U W=5U AS=2.2P AD=1.3P PS=10.88U
+ PD=5.52U
M$444 VDD \$2933 \$2792 VDD pfet_06v0 L=1U W=5U AS=1.3P AD=1.3P PS=5.52U
+ PD=5.52U
M$445 \$2792 \$2933 VDD VDD pfet_06v0 L=1U W=5U AS=1.3P AD=1.3P PS=5.52U
+ PD=5.52U
M$446 VDD \$2933 \$2792 VDD pfet_06v0 L=1U W=5U AS=1.3P AD=2.2P PS=5.52U
+ PD=10.88U
M$447 \$2791 \$2933 VDD VDD pfet_06v0 L=1U W=5U AS=2.2P AD=1.3P PS=10.88U
+ PD=5.52U
M$448 VDD \$2933 \$2791 VDD pfet_06v0 L=1U W=5U AS=1.3P AD=1.3P PS=5.52U
+ PD=5.52U
M$449 \$2791 \$2933 VDD VDD pfet_06v0 L=1U W=5U AS=1.3P AD=1.3P PS=5.52U
+ PD=5.52U
M$450 VDD \$2933 \$2791 VDD pfet_06v0 L=1U W=5U AS=1.3P AD=2.2P PS=5.52U
+ PD=10.88U
M$451 \$2794 \$2771 \$2933 VDD pfet_06v0 L=1U W=5U AS=2.2P AD=2.2P PS=10.88U
+ PD=10.88U
M$452 \$2796 \$2771 \$2770 VDD pfet_06v0 L=1U W=5U AS=2.2P AD=2.2P PS=10.88U
+ PD=10.88U
M$453 \$4584 \$4558 VDD VDD pfet_06v0 L=1U W=10U AS=4.4P AD=2.6P PS=20.88U
+ PD=10.52U
M$454 VDD \$4558 \$4584 VDD pfet_06v0 L=1U W=10U AS=2.6P AD=2.6P PS=10.52U
+ PD=10.52U
M$455 \$4584 \$4558 VDD VDD pfet_06v0 L=1U W=10U AS=2.6P AD=4.4P PS=10.52U
+ PD=20.88U
M$456 \$3393 \$3393 VDD VDD pfet_06v0 L=1U W=2U AS=0.88P AD=0.88P PS=4.88U
+ PD=4.88U
M$457 \$4591 \$938 \$4723 VDD pfet_06v0 L=1U W=10U AS=4.4P AD=2.6P PS=20.88U
+ PD=10.52U
M$458 \$4723 \$938 \$4591 VDD pfet_06v0 L=1U W=10U AS=2.6P AD=4.4P PS=10.52U
+ PD=20.88U
M$459 \$4589 \$50 \$4723 VDD pfet_06v0 L=1U W=10U AS=4.4P AD=2.6P PS=20.88U
+ PD=10.52U
M$460 \$4723 \$50 \$4589 VDD pfet_06v0 L=1U W=10U AS=2.6P AD=4.4P PS=10.52U
+ PD=20.88U
M$461 \$2935 \$3393 \$2801 VDD pfet_06v0 L=1U W=5U AS=2.2P AD=1.3P PS=10.88U
+ PD=5.52U
M$462 \$2801 \$3393 \$2935 VDD pfet_06v0 L=1U W=5U AS=1.3P AD=2.2P PS=5.52U
+ PD=10.88U
M$463 \$2775 \$3393 \$2800 VDD pfet_06v0 L=1U W=5U AS=2.2P AD=1.3P PS=10.88U
+ PD=5.52U
M$464 \$2800 \$3393 \$2775 VDD pfet_06v0 L=1U W=5U AS=1.3P AD=2.2P PS=5.52U
+ PD=10.88U
M$465 \$2801 \$2935 VDD VDD pfet_06v0 L=1U W=5U AS=2.2P AD=1.3P PS=10.88U
+ PD=5.52U
M$466 VDD \$2935 \$2801 VDD pfet_06v0 L=1U W=5U AS=1.3P AD=1.3P PS=5.52U
+ PD=5.52U
M$467 \$2801 \$2935 VDD VDD pfet_06v0 L=1U W=5U AS=1.3P AD=1.3P PS=5.52U
+ PD=5.52U
M$468 VDD \$2935 \$2801 VDD pfet_06v0 L=1U W=5U AS=1.3P AD=2.2P PS=5.52U
+ PD=10.88U
M$469 \$2800 \$2935 VDD VDD pfet_06v0 L=1U W=5U AS=2.2P AD=1.3P PS=10.88U
+ PD=5.52U
M$470 VDD \$2935 \$2800 VDD pfet_06v0 L=1U W=5U AS=1.3P AD=1.3P PS=5.52U
+ PD=5.52U
M$471 \$2800 \$2935 VDD VDD pfet_06v0 L=1U W=5U AS=1.3P AD=1.3P PS=5.52U
+ PD=5.52U
M$472 VDD \$2935 \$2800 VDD pfet_06v0 L=1U W=5U AS=1.3P AD=2.2P PS=5.52U
+ PD=10.88U
M$473 \$2803 \$2776 \$2935 VDD pfet_06v0 L=1U W=5U AS=2.2P AD=2.2P PS=10.88U
+ PD=10.88U
M$474 \$2805 \$2776 \$2775 VDD pfet_06v0 L=1U W=5U AS=2.2P AD=2.2P PS=10.88U
+ PD=10.88U
M$475 \$4593 \$4562 VDD VDD pfet_06v0 L=1U W=10U AS=4.4P AD=2.6P PS=20.88U
+ PD=10.52U
M$476 VDD \$4562 \$4593 VDD pfet_06v0 L=1U W=10U AS=2.6P AD=2.6P PS=10.52U
+ PD=10.52U
M$477 \$4593 \$4562 VDD VDD pfet_06v0 L=1U W=10U AS=2.6P AD=4.4P PS=10.52U
+ PD=20.88U
M$478 X X VDD VDD pfet_06v0 L=1U W=2U AS=0.88P AD=0.52P PS=4.88U PD=2.52U
M$479 VDD X X VDD pfet_06v0 L=1U W=2U AS=0.52P AD=0.52P PS=2.52U PD=2.52U
M$480 X X VDD VDD pfet_06v0 L=1U W=2U AS=0.52P AD=0.52P PS=2.52U PD=2.52U
M$481 VDD X X VDD pfet_06v0 L=1U W=2U AS=0.52P AD=0.52P PS=2.52U PD=2.52U
M$482 X X VDD VDD pfet_06v0 L=1U W=2U AS=0.52P AD=0.52P PS=2.52U PD=2.52U
M$483 VDD X X VDD pfet_06v0 L=1U W=2U AS=0.52P AD=0.88P PS=2.52U PD=4.88U
M$484 \$2778 \$2778 VDD VDD pfet_06v0 L=1U W=2U AS=0.88P AD=0.88P PS=4.88U
+ PD=4.88U
M$485 \$6314 \$5101 VDD VDD pfet_06v0 L=1U W=10U AS=4.4P AD=2.5P PS=20.88U
+ PD=10.5U
M$486 \$4567 \$5179 \$6314 VDD pfet_06v0 L=1U W=10U AS=2.5P AD=4.4P PS=10.5U
+ PD=20.88U
M$487 \$6315 \$5101 VDD VDD pfet_06v0 L=1U W=10U AS=4.4P AD=2.5P PS=20.88U
+ PD=10.5U
M$488 \$4552 \$5179 \$6315 VDD pfet_06v0 L=1U W=10U AS=2.5P AD=4.4P PS=10.5U
+ PD=20.88U
M$489 \$6317 \$5101 VDD VDD pfet_06v0 L=1U W=10U AS=4.4P AD=2.5P PS=20.88U
+ PD=10.5U
M$490 \$5101 \$5179 \$6317 VDD pfet_06v0 L=1U W=10U AS=2.5P AD=4.4P PS=10.5U
+ PD=20.88U
M$491 \$6318 \$5101 VDD VDD pfet_06v0 L=1U W=10U AS=4.4P AD=2.5P PS=20.88U
+ PD=10.5U
M$492 \$4719 \$5179 \$6318 VDD pfet_06v0 L=1U W=10U AS=2.5P AD=3.3P PS=10.5U
+ PD=10.66U
M$493 \$6319 \$5179 \$4719 VDD pfet_06v0 L=1U W=10U AS=3.3P AD=2.5P PS=10.66U
+ PD=10.5U
M$494 VDD \$5101 \$6319 VDD pfet_06v0 L=1U W=10U AS=2.5P AD=4.4P PS=10.5U
+ PD=20.88U
M$495 \$6321 \$4632 VDD VDD pfet_06v0 L=1U W=10U AS=4.4P AD=2.5P PS=20.88U
+ PD=10.5U
M$496 \$4632 \$5179 \$6321 VDD pfet_06v0 L=1U W=10U AS=2.5P AD=3.3P PS=10.5U
+ PD=10.66U
M$497 \$4554 \$4554 \$4632 VDD pfet_06v0 L=1U W=10U AS=3.3P AD=4.4P PS=10.66U
+ PD=20.88U
M$498 \$6322 \$5101 VDD VDD pfet_06v0 L=1U W=10U AS=4.4P AD=2.5P PS=20.88U
+ PD=10.5U
M$499 \$4600 \$5179 \$6322 VDD pfet_06v0 L=1U W=10U AS=2.5P AD=4.4P PS=10.5U
+ PD=20.88U
M$500 \$6323 \$5102 VDD VDD pfet_06v0 L=1U W=10U AS=4.4P AD=2.5P PS=20.88U
+ PD=10.5U
M$501 \$4576 \$5180 \$6323 VDD pfet_06v0 L=1U W=10U AS=2.5P AD=4.4P PS=10.5U
+ PD=20.88U
M$502 \$6324 \$5102 VDD VDD pfet_06v0 L=1U W=10U AS=4.4P AD=2.5P PS=20.88U
+ PD=10.5U
M$503 \$4557 \$5180 \$6324 VDD pfet_06v0 L=1U W=10U AS=2.5P AD=4.4P PS=10.5U
+ PD=20.88U
M$504 \$6325 \$5102 VDD VDD pfet_06v0 L=1U W=10U AS=4.4P AD=2.5P PS=20.88U
+ PD=10.5U
M$505 \$5102 \$5180 \$6325 VDD pfet_06v0 L=1U W=10U AS=2.5P AD=4.4P PS=10.5U
+ PD=20.88U
M$506 \$6326 \$5102 VDD VDD pfet_06v0 L=1U W=10U AS=4.4P AD=2.5P PS=20.88U
+ PD=10.5U
M$507 \$4721 \$5180 \$6326 VDD pfet_06v0 L=1U W=10U AS=2.5P AD=3.3P PS=10.5U
+ PD=10.66U
M$508 \$6327 \$5180 \$4721 VDD pfet_06v0 L=1U W=10U AS=3.3P AD=2.5P PS=10.66U
+ PD=10.5U
M$509 VDD \$5102 \$6327 VDD pfet_06v0 L=1U W=10U AS=2.5P AD=4.4P PS=10.5U
+ PD=20.88U
M$510 \$6328 \$4635 VDD VDD pfet_06v0 L=1U W=10U AS=4.4P AD=2.5P PS=20.88U
+ PD=10.5U
M$511 \$4635 \$5180 \$6328 VDD pfet_06v0 L=1U W=10U AS=2.5P AD=3.3P PS=10.5U
+ PD=10.66U
M$512 \$4559 \$4559 \$4635 VDD pfet_06v0 L=1U W=10U AS=3.3P AD=4.4P PS=10.66U
+ PD=20.88U
M$513 \$6329 \$5102 VDD VDD pfet_06v0 L=1U W=10U AS=4.4P AD=2.5P PS=20.88U
+ PD=10.5U
M$514 \$4601 \$5180 \$6329 VDD pfet_06v0 L=1U W=10U AS=2.5P AD=4.4P PS=10.5U
+ PD=20.88U
M$515 \$6330 \$5103 VDD VDD pfet_06v0 L=1U W=10U AS=4.4P AD=2.5P PS=20.88U
+ PD=10.5U
M$516 \$4585 \$5181 \$6330 VDD pfet_06v0 L=1U W=10U AS=2.5P AD=4.4P PS=10.5U
+ PD=20.88U
M$517 \$6331 \$5103 VDD VDD pfet_06v0 L=1U W=10U AS=4.4P AD=2.5P PS=20.88U
+ PD=10.5U
M$518 \$4561 \$5181 \$6331 VDD pfet_06v0 L=1U W=10U AS=2.5P AD=4.4P PS=10.5U
+ PD=20.88U
M$519 \$6332 \$5103 VDD VDD pfet_06v0 L=1U W=10U AS=4.4P AD=2.5P PS=20.88U
+ PD=10.5U
M$520 \$5103 \$5181 \$6332 VDD pfet_06v0 L=1U W=10U AS=2.5P AD=4.4P PS=10.5U
+ PD=20.88U
M$521 \$6333 \$5103 VDD VDD pfet_06v0 L=1U W=10U AS=4.4P AD=2.5P PS=20.88U
+ PD=10.5U
M$522 \$4723 \$5181 \$6333 VDD pfet_06v0 L=1U W=10U AS=2.5P AD=3.3P PS=10.5U
+ PD=10.66U
M$523 \$6334 \$5181 \$4723 VDD pfet_06v0 L=1U W=10U AS=3.3P AD=2.5P PS=10.66U
+ PD=10.5U
M$524 VDD \$5103 \$6334 VDD pfet_06v0 L=1U W=10U AS=2.5P AD=4.4P PS=10.5U
+ PD=20.88U
M$525 \$6320 \$4638 VDD VDD pfet_06v0 L=1U W=10U AS=4.4P AD=2.5P PS=20.88U
+ PD=10.5U
M$526 \$4638 \$5181 \$6320 VDD pfet_06v0 L=1U W=10U AS=2.5P AD=3.3P PS=10.5U
+ PD=10.66U
M$527 \$4563 \$4563 \$4638 VDD pfet_06v0 L=1U W=10U AS=3.3P AD=4.4P PS=10.66U
+ PD=20.88U
M$528 \$6316 \$5103 VDD VDD pfet_06v0 L=1U W=10U AS=4.4P AD=2.5P PS=20.88U
+ PD=10.5U
M$529 \$4602 \$5181 \$6316 VDD pfet_06v0 L=1U W=10U AS=2.5P AD=4.4P PS=10.5U
+ PD=20.88U
M$530 \$5179 \$5179 VDD VDD pfet_06v0 L=1U W=2U AS=0.88P AD=0.88P PS=4.88U
+ PD=4.88U
M$531 \$6360 \$960 \$6505 VDD pfet_06v0 L=1U W=10U AS=4.4P AD=2.6P PS=20.88U
+ PD=10.52U
M$532 \$6505 \$960 \$6360 VDD pfet_06v0 L=1U W=10U AS=2.6P AD=4.4P PS=10.52U
+ PD=20.88U
M$533 \$6358 \$1856 \$6505 VDD pfet_06v0 L=1U W=10U AS=4.4P AD=2.6P PS=20.88U
+ PD=10.52U
M$534 \$6505 \$1856 \$6358 VDD pfet_06v0 L=1U W=10U AS=2.6P AD=4.4P PS=10.52U
+ PD=20.88U
M$535 \$4720 \$5179 \$4570 VDD pfet_06v0 L=1U W=5U AS=2.2P AD=1.3P PS=10.88U
+ PD=5.52U
M$536 \$4570 \$5179 \$4720 VDD pfet_06v0 L=1U W=5U AS=1.3P AD=2.2P PS=5.52U
+ PD=10.88U
M$537 \$4553 \$5179 \$4569 VDD pfet_06v0 L=1U W=5U AS=2.2P AD=1.3P PS=10.88U
+ PD=5.52U
M$538 \$4569 \$5179 \$4553 VDD pfet_06v0 L=1U W=5U AS=1.3P AD=2.2P PS=5.52U
+ PD=10.88U
M$539 \$4570 \$4720 VDD VDD pfet_06v0 L=1U W=5U AS=2.2P AD=1.3P PS=10.88U
+ PD=5.52U
M$540 VDD \$4720 \$4570 VDD pfet_06v0 L=1U W=5U AS=1.3P AD=1.3P PS=5.52U
+ PD=5.52U
M$541 \$4570 \$4720 VDD VDD pfet_06v0 L=1U W=5U AS=1.3P AD=1.3P PS=5.52U
+ PD=5.52U
M$542 VDD \$4720 \$4570 VDD pfet_06v0 L=1U W=5U AS=1.3P AD=2.2P PS=5.52U
+ PD=10.88U
M$543 \$4569 \$4720 VDD VDD pfet_06v0 L=1U W=5U AS=2.2P AD=1.3P PS=10.88U
+ PD=5.52U
M$544 VDD \$4720 \$4569 VDD pfet_06v0 L=1U W=5U AS=1.3P AD=1.3P PS=5.52U
+ PD=5.52U
M$545 \$4569 \$4720 VDD VDD pfet_06v0 L=1U W=5U AS=1.3P AD=1.3P PS=5.52U
+ PD=5.52U
M$546 VDD \$4720 \$4569 VDD pfet_06v0 L=1U W=5U AS=1.3P AD=2.2P PS=5.52U
+ PD=10.88U
M$547 \$4572 \$4554 \$4720 VDD pfet_06v0 L=1U W=5U AS=2.2P AD=2.2P PS=10.88U
+ PD=10.88U
M$548 \$4574 \$4554 \$4553 VDD pfet_06v0 L=1U W=5U AS=2.2P AD=2.2P PS=10.88U
+ PD=10.88U
M$549 \$6362 \$6340 VDD VDD pfet_06v0 L=1U W=10U AS=4.4P AD=2.6P PS=20.88U
+ PD=10.52U
M$550 VDD \$6340 \$6362 VDD pfet_06v0 L=1U W=10U AS=2.6P AD=2.6P PS=10.52U
+ PD=10.52U
M$551 \$6362 \$6340 VDD VDD pfet_06v0 L=1U W=10U AS=2.6P AD=4.4P PS=10.52U
+ PD=20.88U
M$552 \$5180 \$5180 VDD VDD pfet_06v0 L=1U W=2U AS=0.88P AD=0.88P PS=4.88U
+ PD=4.88U
M$553 \$6369 \$971 \$6507 VDD pfet_06v0 L=1U W=10U AS=4.4P AD=2.6P PS=20.88U
+ PD=10.52U
M$554 \$6507 \$971 \$6369 VDD pfet_06v0 L=1U W=10U AS=2.6P AD=4.4P PS=10.52U
+ PD=20.88U
M$555 \$6367 \$1856 \$6507 VDD pfet_06v0 L=1U W=10U AS=4.4P AD=2.6P PS=20.88U
+ PD=10.52U
M$556 \$6507 \$1856 \$6367 VDD pfet_06v0 L=1U W=10U AS=2.6P AD=4.4P PS=10.52U
+ PD=20.88U
M$557 \$4722 \$5180 \$4579 VDD pfet_06v0 L=1U W=5U AS=2.2P AD=1.3P PS=10.88U
+ PD=5.52U
M$558 \$4579 \$5180 \$4722 VDD pfet_06v0 L=1U W=5U AS=1.3P AD=2.2P PS=5.52U
+ PD=10.88U
M$559 \$4558 \$5180 \$4578 VDD pfet_06v0 L=1U W=5U AS=2.2P AD=1.3P PS=10.88U
+ PD=5.52U
M$560 \$4578 \$5180 \$4558 VDD pfet_06v0 L=1U W=5U AS=1.3P AD=2.2P PS=5.52U
+ PD=10.88U
M$561 \$4579 \$4722 VDD VDD pfet_06v0 L=1U W=5U AS=2.2P AD=1.3P PS=10.88U
+ PD=5.52U
M$562 VDD \$4722 \$4579 VDD pfet_06v0 L=1U W=5U AS=1.3P AD=1.3P PS=5.52U
+ PD=5.52U
M$563 \$4579 \$4722 VDD VDD pfet_06v0 L=1U W=5U AS=1.3P AD=1.3P PS=5.52U
+ PD=5.52U
M$564 VDD \$4722 \$4579 VDD pfet_06v0 L=1U W=5U AS=1.3P AD=2.2P PS=5.52U
+ PD=10.88U
M$565 \$4578 \$4722 VDD VDD pfet_06v0 L=1U W=5U AS=2.2P AD=1.3P PS=10.88U
+ PD=5.52U
M$566 VDD \$4722 \$4578 VDD pfet_06v0 L=1U W=5U AS=1.3P AD=1.3P PS=5.52U
+ PD=5.52U
M$567 \$4578 \$4722 VDD VDD pfet_06v0 L=1U W=5U AS=1.3P AD=1.3P PS=5.52U
+ PD=5.52U
M$568 VDD \$4722 \$4578 VDD pfet_06v0 L=1U W=5U AS=1.3P AD=2.2P PS=5.52U
+ PD=10.88U
M$569 \$4581 \$4559 \$4722 VDD pfet_06v0 L=1U W=5U AS=2.2P AD=2.2P PS=10.88U
+ PD=10.88U
M$570 \$4583 \$4559 \$4558 VDD pfet_06v0 L=1U W=5U AS=2.2P AD=2.2P PS=10.88U
+ PD=10.88U
M$571 \$6371 \$6344 VDD VDD pfet_06v0 L=1U W=10U AS=4.4P AD=2.6P PS=20.88U
+ PD=10.52U
M$572 VDD \$6344 \$6371 VDD pfet_06v0 L=1U W=10U AS=2.6P AD=2.6P PS=10.52U
+ PD=10.52U
M$573 \$6371 \$6344 VDD VDD pfet_06v0 L=1U W=10U AS=2.6P AD=4.4P PS=10.52U
+ PD=20.88U
M$574 \$5181 \$5181 VDD VDD pfet_06v0 L=1U W=2U AS=0.88P AD=0.88P PS=4.88U
+ PD=4.88U
M$575 \$6378 \$971 \$6509 VDD pfet_06v0 L=1U W=10U AS=4.4P AD=2.6P PS=20.88U
+ PD=10.52U
M$576 \$6509 \$971 \$6378 VDD pfet_06v0 L=1U W=10U AS=2.6P AD=4.4P PS=10.52U
+ PD=20.88U
M$577 \$6376 \$960 \$6509 VDD pfet_06v0 L=1U W=10U AS=4.4P AD=2.6P PS=20.88U
+ PD=10.52U
M$578 \$6509 \$960 \$6376 VDD pfet_06v0 L=1U W=10U AS=2.6P AD=4.4P PS=10.52U
+ PD=20.88U
M$579 \$4724 \$5181 \$4588 VDD pfet_06v0 L=1U W=5U AS=2.2P AD=1.3P PS=10.88U
+ PD=5.52U
M$580 \$4588 \$5181 \$4724 VDD pfet_06v0 L=1U W=5U AS=1.3P AD=2.2P PS=5.52U
+ PD=10.88U
M$581 \$4562 \$5181 \$4587 VDD pfet_06v0 L=1U W=5U AS=2.2P AD=1.3P PS=10.88U
+ PD=5.52U
M$582 \$4587 \$5181 \$4562 VDD pfet_06v0 L=1U W=5U AS=1.3P AD=2.2P PS=5.52U
+ PD=10.88U
M$583 \$4588 \$4724 VDD VDD pfet_06v0 L=1U W=5U AS=2.2P AD=1.3P PS=10.88U
+ PD=5.52U
M$584 VDD \$4724 \$4588 VDD pfet_06v0 L=1U W=5U AS=1.3P AD=1.3P PS=5.52U
+ PD=5.52U
M$585 \$4588 \$4724 VDD VDD pfet_06v0 L=1U W=5U AS=1.3P AD=1.3P PS=5.52U
+ PD=5.52U
M$586 VDD \$4724 \$4588 VDD pfet_06v0 L=1U W=5U AS=1.3P AD=2.2P PS=5.52U
+ PD=10.88U
M$587 \$4587 \$4724 VDD VDD pfet_06v0 L=1U W=5U AS=2.2P AD=1.3P PS=10.88U
+ PD=5.52U
M$588 VDD \$4724 \$4587 VDD pfet_06v0 L=1U W=5U AS=1.3P AD=1.3P PS=5.52U
+ PD=5.52U
M$589 \$4587 \$4724 VDD VDD pfet_06v0 L=1U W=5U AS=1.3P AD=1.3P PS=5.52U
+ PD=5.52U
M$590 VDD \$4724 \$4587 VDD pfet_06v0 L=1U W=5U AS=1.3P AD=2.2P PS=5.52U
+ PD=10.88U
M$591 \$4590 \$4563 \$4724 VDD pfet_06v0 L=1U W=5U AS=2.2P AD=2.2P PS=10.88U
+ PD=10.88U
M$592 \$4592 \$4563 \$4562 VDD pfet_06v0 L=1U W=5U AS=2.2P AD=2.2P PS=10.88U
+ PD=10.88U
M$593 \$6380 \$6349 VDD VDD pfet_06v0 L=1U W=10U AS=4.4P AD=2.6P PS=20.88U
+ PD=10.52U
M$594 VDD \$6349 \$6380 VDD pfet_06v0 L=1U W=10U AS=2.6P AD=2.6P PS=10.52U
+ PD=10.52U
M$595 \$6380 \$6349 VDD VDD pfet_06v0 L=1U W=10U AS=2.6P AD=4.4P PS=10.52U
+ PD=20.88U
M$596 Y Y VDD VDD pfet_06v0 L=1U W=2U AS=0.88P AD=0.52P PS=4.88U PD=2.52U
M$597 VDD Y Y VDD pfet_06v0 L=1U W=2U AS=0.52P AD=0.52P PS=2.52U PD=2.52U
M$598 Y Y VDD VDD pfet_06v0 L=1U W=2U AS=0.52P AD=0.52P PS=2.52U PD=2.52U
M$599 VDD Y Y VDD pfet_06v0 L=1U W=2U AS=0.52P AD=0.52P PS=2.52U PD=2.52U
M$600 Y Y VDD VDD pfet_06v0 L=1U W=2U AS=0.52P AD=0.52P PS=2.52U PD=2.52U
M$601 VDD Y Y VDD pfet_06v0 L=1U W=2U AS=0.52P AD=0.88P PS=2.52U PD=4.88U
M$602 \$4565 \$4565 VDD VDD pfet_06v0 L=1U W=2U AS=0.88P AD=0.88P PS=4.88U
+ PD=4.88U
M$603 \$8101 \$6887 VDD VDD pfet_06v0 L=1U W=10U AS=4.4P AD=2.5P PS=20.88U
+ PD=10.5U
M$604 \$6354 \$6965 \$8101 VDD pfet_06v0 L=1U W=10U AS=2.5P AD=4.4P PS=10.5U
+ PD=20.88U
M$605 \$8102 \$6887 VDD VDD pfet_06v0 L=1U W=10U AS=4.4P AD=2.5P PS=20.88U
+ PD=10.5U
M$606 \$6339 \$6965 \$8102 VDD pfet_06v0 L=1U W=10U AS=2.5P AD=4.4P PS=10.5U
+ PD=20.88U
M$607 \$8103 \$6887 VDD VDD pfet_06v0 L=1U W=10U AS=4.4P AD=2.5P PS=20.88U
+ PD=10.5U
M$608 \$6887 \$6965 \$8103 VDD pfet_06v0 L=1U W=10U AS=2.5P AD=4.4P PS=10.5U
+ PD=20.88U
M$609 \$8104 \$6887 VDD VDD pfet_06v0 L=1U W=10U AS=4.4P AD=2.5P PS=20.88U
+ PD=10.5U
M$610 \$6505 \$6965 \$8104 VDD pfet_06v0 L=1U W=10U AS=2.5P AD=3.3P PS=10.5U
+ PD=10.66U
M$611 \$8105 \$6965 \$6505 VDD pfet_06v0 L=1U W=10U AS=3.3P AD=2.5P PS=10.66U
+ PD=10.5U
M$612 VDD \$6887 \$8105 VDD pfet_06v0 L=1U W=10U AS=2.5P AD=4.4P PS=10.5U
+ PD=20.88U
M$613 \$8106 \$6416 VDD VDD pfet_06v0 L=1U W=10U AS=4.4P AD=2.5P PS=20.88U
+ PD=10.5U
M$614 \$6416 \$6965 \$8106 VDD pfet_06v0 L=1U W=10U AS=2.5P AD=3.3P PS=10.5U
+ PD=10.66U
M$615 \$6341 \$6341 \$6416 VDD pfet_06v0 L=1U W=10U AS=3.3P AD=4.4P PS=10.66U
+ PD=20.88U
M$616 \$8107 \$6887 VDD VDD pfet_06v0 L=1U W=10U AS=4.4P AD=2.5P PS=20.88U
+ PD=10.5U
M$617 \$6387 \$6965 \$8107 VDD pfet_06v0 L=1U W=10U AS=2.5P AD=4.4P PS=10.5U
+ PD=20.88U
M$618 \$8109 \$6888 VDD VDD pfet_06v0 L=1U W=10U AS=4.4P AD=2.5P PS=20.88U
+ PD=10.5U
M$619 \$6363 \$6966 \$8109 VDD pfet_06v0 L=1U W=10U AS=2.5P AD=4.4P PS=10.5U
+ PD=20.88U
M$620 \$8110 \$6888 VDD VDD pfet_06v0 L=1U W=10U AS=4.4P AD=2.5P PS=20.88U
+ PD=10.5U
M$621 \$6343 \$6966 \$8110 VDD pfet_06v0 L=1U W=10U AS=2.5P AD=4.4P PS=10.5U
+ PD=20.88U
M$622 \$8111 \$6888 VDD VDD pfet_06v0 L=1U W=10U AS=4.4P AD=2.5P PS=20.88U
+ PD=10.5U
M$623 \$6888 \$6966 \$8111 VDD pfet_06v0 L=1U W=10U AS=2.5P AD=4.4P PS=10.5U
+ PD=20.88U
M$624 \$8112 \$6888 VDD VDD pfet_06v0 L=1U W=10U AS=4.4P AD=2.5P PS=20.88U
+ PD=10.5U
M$625 \$6507 \$6966 \$8112 VDD pfet_06v0 L=1U W=10U AS=2.5P AD=3.3P PS=10.5U
+ PD=10.66U
M$626 \$8113 \$6966 \$6507 VDD pfet_06v0 L=1U W=10U AS=3.3P AD=2.5P PS=10.66U
+ PD=10.5U
M$627 VDD \$6888 \$8113 VDD pfet_06v0 L=1U W=10U AS=2.5P AD=4.4P PS=10.5U
+ PD=20.88U
M$628 \$8115 \$6419 VDD VDD pfet_06v0 L=1U W=10U AS=4.4P AD=2.5P PS=20.88U
+ PD=10.5U
M$629 \$6419 \$6966 \$8115 VDD pfet_06v0 L=1U W=10U AS=2.5P AD=3.3P PS=10.5U
+ PD=10.66U
M$630 \$6345 \$6345 \$6419 VDD pfet_06v0 L=1U W=10U AS=3.3P AD=4.4P PS=10.66U
+ PD=20.88U
M$631 \$8116 \$6888 VDD VDD pfet_06v0 L=1U W=10U AS=4.4P AD=2.5P PS=20.88U
+ PD=10.5U
M$632 \$6388 \$6966 \$8116 VDD pfet_06v0 L=1U W=10U AS=2.5P AD=4.4P PS=10.5U
+ PD=20.88U
M$633 \$8117 \$6889 VDD VDD pfet_06v0 L=1U W=10U AS=4.4P AD=2.5P PS=20.88U
+ PD=10.5U
M$634 \$6372 \$6967 \$8117 VDD pfet_06v0 L=1U W=10U AS=2.5P AD=4.4P PS=10.5U
+ PD=20.88U
M$635 \$8118 \$6889 VDD VDD pfet_06v0 L=1U W=10U AS=4.4P AD=2.5P PS=20.88U
+ PD=10.5U
M$636 \$6348 \$6967 \$8118 VDD pfet_06v0 L=1U W=10U AS=2.5P AD=4.4P PS=10.5U
+ PD=20.88U
M$637 \$8119 \$6889 VDD VDD pfet_06v0 L=1U W=10U AS=4.4P AD=2.5P PS=20.88U
+ PD=10.5U
M$638 \$6889 \$6967 \$8119 VDD pfet_06v0 L=1U W=10U AS=2.5P AD=4.4P PS=10.5U
+ PD=20.88U
M$639 \$8120 \$6889 VDD VDD pfet_06v0 L=1U W=10U AS=4.4P AD=2.5P PS=20.88U
+ PD=10.5U
M$640 \$6509 \$6967 \$8120 VDD pfet_06v0 L=1U W=10U AS=2.5P AD=3.3P PS=10.5U
+ PD=10.66U
M$641 \$8121 \$6967 \$6509 VDD pfet_06v0 L=1U W=10U AS=3.3P AD=2.5P PS=10.66U
+ PD=10.5U
M$642 VDD \$6889 \$8121 VDD pfet_06v0 L=1U W=10U AS=2.5P AD=4.4P PS=10.5U
+ PD=20.88U
M$643 \$8114 \$6422 VDD VDD pfet_06v0 L=1U W=10U AS=4.4P AD=2.5P PS=20.88U
+ PD=10.5U
M$644 \$6422 \$6967 \$8114 VDD pfet_06v0 L=1U W=10U AS=2.5P AD=3.3P PS=10.5U
+ PD=10.66U
M$645 \$6350 \$6350 \$6422 VDD pfet_06v0 L=1U W=10U AS=3.3P AD=4.4P PS=10.66U
+ PD=20.88U
M$646 \$8108 \$6889 VDD VDD pfet_06v0 L=1U W=10U AS=4.4P AD=2.5P PS=20.88U
+ PD=10.5U
M$647 \$6389 \$6967 \$8108 VDD pfet_06v0 L=1U W=10U AS=2.5P AD=4.4P PS=10.5U
+ PD=20.88U
M$648 \$6965 \$6965 VDD VDD pfet_06v0 L=1U W=2U AS=0.88P AD=0.88P PS=4.88U
+ PD=4.88U
M$649 \$8130 \$1867 \$8208 VDD pfet_06v0 L=1U W=10U AS=4.4P AD=2.6P PS=20.88U
+ PD=10.52U
M$650 \$8208 \$1867 \$8130 VDD pfet_06v0 L=1U W=10U AS=2.6P AD=4.4P PS=10.52U
+ PD=20.88U
M$651 \$8128 \$1889 \$8208 VDD pfet_06v0 L=1U W=10U AS=4.4P AD=2.6P PS=20.88U
+ PD=10.52U
M$652 \$8208 \$1889 \$8128 VDD pfet_06v0 L=1U W=10U AS=2.6P AD=4.4P PS=10.52U
+ PD=20.88U
M$653 \$6506 \$6965 \$6357 VDD pfet_06v0 L=1U W=5U AS=2.2P AD=1.3P PS=10.88U
+ PD=5.52U
M$654 \$6357 \$6965 \$6506 VDD pfet_06v0 L=1U W=5U AS=1.3P AD=2.2P PS=5.52U
+ PD=10.88U
M$655 \$6340 \$6965 \$6356 VDD pfet_06v0 L=1U W=5U AS=2.2P AD=1.3P PS=10.88U
+ PD=5.52U
M$656 \$6356 \$6965 \$6340 VDD pfet_06v0 L=1U W=5U AS=1.3P AD=2.2P PS=5.52U
+ PD=10.88U
M$657 \$6357 \$6506 VDD VDD pfet_06v0 L=1U W=5U AS=2.2P AD=1.3P PS=10.88U
+ PD=5.52U
M$658 VDD \$6506 \$6357 VDD pfet_06v0 L=1U W=5U AS=1.3P AD=1.3P PS=5.52U
+ PD=5.52U
M$659 \$6357 \$6506 VDD VDD pfet_06v0 L=1U W=5U AS=1.3P AD=1.3P PS=5.52U
+ PD=5.52U
M$660 VDD \$6506 \$6357 VDD pfet_06v0 L=1U W=5U AS=1.3P AD=2.2P PS=5.52U
+ PD=10.88U
M$661 \$6356 \$6506 VDD VDD pfet_06v0 L=1U W=5U AS=2.2P AD=1.3P PS=10.88U
+ PD=5.52U
M$662 VDD \$6506 \$6356 VDD pfet_06v0 L=1U W=5U AS=1.3P AD=1.3P PS=5.52U
+ PD=5.52U
M$663 \$6356 \$6506 VDD VDD pfet_06v0 L=1U W=5U AS=1.3P AD=1.3P PS=5.52U
+ PD=5.52U
M$664 VDD \$6506 \$6356 VDD pfet_06v0 L=1U W=5U AS=1.3P AD=2.2P PS=5.52U
+ PD=10.88U
M$665 \$6359 \$6341 \$6506 VDD pfet_06v0 L=1U W=5U AS=2.2P AD=2.2P PS=10.88U
+ PD=10.88U
M$666 \$6361 \$6341 \$6340 VDD pfet_06v0 L=1U W=5U AS=2.2P AD=2.2P PS=10.88U
+ PD=10.88U
M$667 \$8135 \$8132 VDD VDD pfet_06v0 L=1U W=10U AS=4.4P AD=2.6P PS=20.88U
+ PD=10.52U
M$668 VDD \$8132 \$8135 VDD pfet_06v0 L=1U W=10U AS=2.6P AD=2.6P PS=10.52U
+ PD=10.52U
M$669 \$8135 \$8132 VDD VDD pfet_06v0 L=1U W=10U AS=2.6P AD=4.4P PS=10.52U
+ PD=20.88U
M$670 \$6966 \$6966 VDD VDD pfet_06v0 L=1U W=2U AS=0.88P AD=0.88P PS=4.88U
+ PD=4.88U
M$671 \$8142 \$1878 \$8209 VDD pfet_06v0 L=1U W=10U AS=4.4P AD=2.6P PS=20.88U
+ PD=10.52U
M$672 \$8209 \$1878 \$8142 VDD pfet_06v0 L=1U W=10U AS=2.6P AD=4.4P PS=10.52U
+ PD=20.88U
M$673 \$8140 \$1889 \$8209 VDD pfet_06v0 L=1U W=10U AS=4.4P AD=2.6P PS=20.88U
+ PD=10.52U
M$674 \$8209 \$1889 \$8140 VDD pfet_06v0 L=1U W=10U AS=2.6P AD=4.4P PS=10.52U
+ PD=20.88U
M$675 \$6508 \$6966 \$6366 VDD pfet_06v0 L=1U W=5U AS=2.2P AD=1.3P PS=10.88U
+ PD=5.52U
M$676 \$6366 \$6966 \$6508 VDD pfet_06v0 L=1U W=5U AS=1.3P AD=2.2P PS=5.52U
+ PD=10.88U
M$677 \$6344 \$6966 \$6365 VDD pfet_06v0 L=1U W=5U AS=2.2P AD=1.3P PS=10.88U
+ PD=5.52U
M$678 \$6365 \$6966 \$6344 VDD pfet_06v0 L=1U W=5U AS=1.3P AD=2.2P PS=5.52U
+ PD=10.88U
M$679 \$6366 \$6508 VDD VDD pfet_06v0 L=1U W=5U AS=2.2P AD=1.3P PS=10.88U
+ PD=5.52U
M$680 VDD \$6508 \$6366 VDD pfet_06v0 L=1U W=5U AS=1.3P AD=1.3P PS=5.52U
+ PD=5.52U
M$681 \$6366 \$6508 VDD VDD pfet_06v0 L=1U W=5U AS=1.3P AD=1.3P PS=5.52U
+ PD=5.52U
M$682 VDD \$6508 \$6366 VDD pfet_06v0 L=1U W=5U AS=1.3P AD=2.2P PS=5.52U
+ PD=10.88U
M$683 \$6365 \$6508 VDD VDD pfet_06v0 L=1U W=5U AS=2.2P AD=1.3P PS=10.88U
+ PD=5.52U
M$684 VDD \$6508 \$6365 VDD pfet_06v0 L=1U W=5U AS=1.3P AD=1.3P PS=5.52U
+ PD=5.52U
M$685 \$6365 \$6508 VDD VDD pfet_06v0 L=1U W=5U AS=1.3P AD=1.3P PS=5.52U
+ PD=5.52U
M$686 VDD \$6508 \$6365 VDD pfet_06v0 L=1U W=5U AS=1.3P AD=2.2P PS=5.52U
+ PD=10.88U
M$687 \$6368 \$6345 \$6508 VDD pfet_06v0 L=1U W=5U AS=2.2P AD=2.2P PS=10.88U
+ PD=10.88U
M$688 \$6370 \$6345 \$6344 VDD pfet_06v0 L=1U W=5U AS=2.2P AD=2.2P PS=10.88U
+ PD=10.88U
M$689 \$8147 \$8144 VDD VDD pfet_06v0 L=1U W=10U AS=4.4P AD=2.6P PS=20.88U
+ PD=10.52U
M$690 VDD \$8144 \$8147 VDD pfet_06v0 L=1U W=10U AS=2.6P AD=2.6P PS=10.52U
+ PD=10.52U
M$691 \$8147 \$8144 VDD VDD pfet_06v0 L=1U W=10U AS=2.6P AD=4.4P PS=10.52U
+ PD=20.88U
M$692 \$6967 \$6967 VDD VDD pfet_06v0 L=1U W=2U AS=0.88P AD=0.88P PS=4.88U
+ PD=4.88U
M$693 \$8154 \$1878 \$8210 VDD pfet_06v0 L=1U W=10U AS=4.4P AD=2.6P PS=20.88U
+ PD=10.52U
M$694 \$8210 \$1878 \$8154 VDD pfet_06v0 L=1U W=10U AS=2.6P AD=4.4P PS=10.52U
+ PD=20.88U
M$695 \$8152 \$1867 \$8210 VDD pfet_06v0 L=1U W=10U AS=4.4P AD=2.6P PS=20.88U
+ PD=10.52U
M$696 \$8210 \$1867 \$8152 VDD pfet_06v0 L=1U W=10U AS=2.6P AD=4.4P PS=10.52U
+ PD=20.88U
M$697 \$6510 \$6967 \$6375 VDD pfet_06v0 L=1U W=5U AS=2.2P AD=1.3P PS=10.88U
+ PD=5.52U
M$698 \$6375 \$6967 \$6510 VDD pfet_06v0 L=1U W=5U AS=1.3P AD=2.2P PS=5.52U
+ PD=10.88U
M$699 \$6349 \$6967 \$6374 VDD pfet_06v0 L=1U W=5U AS=2.2P AD=1.3P PS=10.88U
+ PD=5.52U
M$700 \$6374 \$6967 \$6349 VDD pfet_06v0 L=1U W=5U AS=1.3P AD=2.2P PS=5.52U
+ PD=10.88U
M$701 \$6375 \$6510 VDD VDD pfet_06v0 L=1U W=5U AS=2.2P AD=1.3P PS=10.88U
+ PD=5.52U
M$702 VDD \$6510 \$6375 VDD pfet_06v0 L=1U W=5U AS=1.3P AD=1.3P PS=5.52U
+ PD=5.52U
M$703 \$6375 \$6510 VDD VDD pfet_06v0 L=1U W=5U AS=1.3P AD=1.3P PS=5.52U
+ PD=5.52U
M$704 VDD \$6510 \$6375 VDD pfet_06v0 L=1U W=5U AS=1.3P AD=2.2P PS=5.52U
+ PD=10.88U
M$705 \$6374 \$6510 VDD VDD pfet_06v0 L=1U W=5U AS=2.2P AD=1.3P PS=10.88U
+ PD=5.52U
M$706 VDD \$6510 \$6374 VDD pfet_06v0 L=1U W=5U AS=1.3P AD=1.3P PS=5.52U
+ PD=5.52U
M$707 \$6374 \$6510 VDD VDD pfet_06v0 L=1U W=5U AS=1.3P AD=1.3P PS=5.52U
+ PD=5.52U
M$708 VDD \$6510 \$6374 VDD pfet_06v0 L=1U W=5U AS=1.3P AD=2.2P PS=5.52U
+ PD=10.88U
M$709 \$6377 \$6350 \$6510 VDD pfet_06v0 L=1U W=5U AS=2.2P AD=2.2P PS=10.88U
+ PD=10.88U
M$710 \$6379 \$6350 \$6349 VDD pfet_06v0 L=1U W=5U AS=2.2P AD=2.2P PS=10.88U
+ PD=10.88U
M$711 \$8159 \$8156 VDD VDD pfet_06v0 L=1U W=10U AS=4.4P AD=2.6P PS=20.88U
+ PD=10.52U
M$712 VDD \$8156 \$8159 VDD pfet_06v0 L=1U W=10U AS=2.6P AD=2.6P PS=10.52U
+ PD=10.52U
M$713 \$8159 \$8156 VDD VDD pfet_06v0 L=1U W=10U AS=2.6P AD=4.4P PS=10.52U
+ PD=20.88U
M$714 \$8364 \$2806 \$6428 VDD pfet_06v0 L=1U W=3U AS=1.32P AD=0.75P PS=6.88U
+ PD=3.5U
M$715 VDD \$2797 \$8364 VDD pfet_06v0 L=1U W=3U AS=0.75P AD=1.32P PS=3.5U
+ PD=6.88U
M$716 Z Z VDD VDD pfet_06v0 L=1U W=2U AS=0.88P AD=0.52P PS=4.88U PD=2.52U
M$717 VDD Z Z VDD pfet_06v0 L=1U W=2U AS=0.52P AD=0.52P PS=2.52U PD=2.52U
M$718 Z Z VDD VDD pfet_06v0 L=1U W=2U AS=0.52P AD=0.52P PS=2.52U PD=2.52U
M$719 VDD Z Z VDD pfet_06v0 L=1U W=2U AS=0.52P AD=0.52P PS=2.52U PD=2.52U
M$720 Z Z VDD VDD pfet_06v0 L=1U W=2U AS=0.52P AD=0.52P PS=2.52U PD=2.52U
M$721 VDD Z Z VDD pfet_06v0 L=1U W=2U AS=0.52P AD=0.88P PS=2.52U PD=4.88U
M$722 \$8160 \$2788 VDD VDD pfet_06v0 L=1U W=3U AS=1.32P AD=1.32P PS=6.88U
+ PD=6.88U
M$723 \$4629 \$8167 VDD VDD pfet_06v0 L=1U W=3U AS=1.32P AD=1.32P PS=6.88U
+ PD=6.88U
M$724 \$6352 \$6352 VDD VDD pfet_06v0 L=1U W=2U AS=0.88P AD=0.88P PS=4.88U
+ PD=4.88U
M$725 \$8167 \$2806 VDD VDD pfet_06v0 L=1U W=3U AS=1.32P AD=0.99P PS=6.88U
+ PD=3.66U
M$726 VDD \$8160 \$8167 VDD pfet_06v0 L=1U W=3U AS=0.99P AD=1.32P PS=3.66U
+ PD=6.88U
M$727 \$3315 \$8168 VDD VDD pfet_06v0 L=1U W=3U AS=1.32P AD=1.32P PS=6.88U
+ PD=6.88U
M$728 \$8168 \$2788 VDD VDD pfet_06v0 L=1U W=3U AS=1.32P AD=0.99P PS=6.88U
+ PD=3.66U
M$729 VDD \$2797 \$8168 VDD pfet_06v0 L=1U W=3U AS=0.99P AD=1.32P PS=3.66U
+ PD=6.88U
M$730 \$9876 \$8740 VDD VDD pfet_06v0 L=1U W=10U AS=4.4P AD=2.5P PS=20.88U
+ PD=10.5U
M$731 \$8161 \$8818 \$9876 VDD pfet_06v0 L=1U W=10U AS=2.5P AD=4.4P PS=10.5U
+ PD=20.88U
M$732 \$9877 \$8740 VDD VDD pfet_06v0 L=1U W=10U AS=4.4P AD=2.5P PS=20.88U
+ PD=10.5U
M$733 \$8124 \$8818 \$9877 VDD pfet_06v0 L=1U W=10U AS=2.5P AD=4.4P PS=10.5U
+ PD=20.88U
M$734 \$9878 \$8740 VDD VDD pfet_06v0 L=1U W=10U AS=4.4P AD=2.5P PS=20.88U
+ PD=10.5U
M$735 \$8740 \$8818 \$9878 VDD pfet_06v0 L=1U W=10U AS=2.5P AD=4.4P PS=10.5U
+ PD=20.88U
M$736 \$9879 \$8740 VDD VDD pfet_06v0 L=1U W=10U AS=4.4P AD=2.5P PS=20.88U
+ PD=10.5U
M$737 \$8208 \$8818 \$9879 VDD pfet_06v0 L=1U W=10U AS=2.5P AD=3.3P PS=10.5U
+ PD=10.66U
M$738 \$9880 \$8818 \$8208 VDD pfet_06v0 L=1U W=10U AS=3.3P AD=2.5P PS=10.66U
+ PD=10.5U
M$739 VDD \$8740 \$9880 VDD pfet_06v0 L=1U W=10U AS=2.5P AD=4.4P PS=10.5U
+ PD=20.88U
M$740 \$9882 \$8200 VDD VDD pfet_06v0 L=1U W=10U AS=4.4P AD=2.5P PS=20.88U
+ PD=10.5U
M$741 \$8200 \$8818 \$9882 VDD pfet_06v0 L=1U W=10U AS=2.5P AD=3.3P PS=10.5U
+ PD=10.66U
M$742 \$8133 \$8133 \$8200 VDD pfet_06v0 L=1U W=10U AS=3.3P AD=4.4P PS=10.66U
+ PD=20.88U
M$743 \$9883 \$8740 VDD VDD pfet_06v0 L=1U W=10U AS=4.4P AD=2.5P PS=20.88U
+ PD=10.5U
M$744 \$8162 \$8818 \$9883 VDD pfet_06v0 L=1U W=10U AS=2.5P AD=4.4P PS=10.5U
+ PD=20.88U
M$745 \$9885 \$8741 VDD VDD pfet_06v0 L=1U W=10U AS=4.4P AD=2.5P PS=20.88U
+ PD=10.5U
M$746 \$8163 \$8819 \$9885 VDD pfet_06v0 L=1U W=10U AS=2.5P AD=4.4P PS=10.5U
+ PD=20.88U
M$747 \$9886 \$8741 VDD VDD pfet_06v0 L=1U W=10U AS=4.4P AD=2.5P PS=20.88U
+ PD=10.5U
M$748 \$8136 \$8819 \$9886 VDD pfet_06v0 L=1U W=10U AS=2.5P AD=4.4P PS=10.5U
+ PD=20.88U
M$749 \$9887 \$8741 VDD VDD pfet_06v0 L=1U W=10U AS=4.4P AD=2.5P PS=20.88U
+ PD=10.5U
M$750 \$8741 \$8819 \$9887 VDD pfet_06v0 L=1U W=10U AS=2.5P AD=4.4P PS=10.5U
+ PD=20.88U
M$751 \$9888 \$8741 VDD VDD pfet_06v0 L=1U W=10U AS=4.4P AD=2.5P PS=20.88U
+ PD=10.5U
M$752 \$8209 \$8819 \$9888 VDD pfet_06v0 L=1U W=10U AS=2.5P AD=3.3P PS=10.5U
+ PD=10.66U
M$753 \$9889 \$8819 \$8209 VDD pfet_06v0 L=1U W=10U AS=3.3P AD=2.5P PS=10.66U
+ PD=10.5U
M$754 VDD \$8741 \$9889 VDD pfet_06v0 L=1U W=10U AS=2.5P AD=4.4P PS=10.5U
+ PD=20.88U
M$755 \$9890 \$8203 VDD VDD pfet_06v0 L=1U W=10U AS=4.4P AD=2.5P PS=20.88U
+ PD=10.5U
M$756 \$8203 \$8819 \$9890 VDD pfet_06v0 L=1U W=10U AS=2.5P AD=3.3P PS=10.5U
+ PD=10.66U
M$757 \$8145 \$8145 \$8203 VDD pfet_06v0 L=1U W=10U AS=3.3P AD=4.4P PS=10.66U
+ PD=20.88U
M$758 \$9891 \$8741 VDD VDD pfet_06v0 L=1U W=10U AS=4.4P AD=2.5P PS=20.88U
+ PD=10.5U
M$759 \$8164 \$8819 \$9891 VDD pfet_06v0 L=1U W=10U AS=2.5P AD=4.4P PS=10.5U
+ PD=20.88U
M$760 \$9892 \$8742 VDD VDD pfet_06v0 L=1U W=10U AS=4.4P AD=2.5P PS=20.88U
+ PD=10.5U
M$761 \$8165 \$8820 \$9892 VDD pfet_06v0 L=1U W=10U AS=2.5P AD=4.4P PS=10.5U
+ PD=20.88U
M$762 \$9893 \$8742 VDD VDD pfet_06v0 L=1U W=10U AS=4.4P AD=2.5P PS=20.88U
+ PD=10.5U
M$763 \$8148 \$8820 \$9893 VDD pfet_06v0 L=1U W=10U AS=2.5P AD=4.4P PS=10.5U
+ PD=20.88U
M$764 \$9894 \$8742 VDD VDD pfet_06v0 L=1U W=10U AS=4.4P AD=2.5P PS=20.88U
+ PD=10.5U
M$765 \$8742 \$8820 \$9894 VDD pfet_06v0 L=1U W=10U AS=2.5P AD=4.4P PS=10.5U
+ PD=20.88U
M$766 \$9895 \$8742 VDD VDD pfet_06v0 L=1U W=10U AS=4.4P AD=2.5P PS=20.88U
+ PD=10.5U
M$767 \$8210 \$8820 \$9895 VDD pfet_06v0 L=1U W=10U AS=2.5P AD=3.3P PS=10.5U
+ PD=10.66U
M$768 \$9896 \$8820 \$8210 VDD pfet_06v0 L=1U W=10U AS=3.3P AD=2.5P PS=10.66U
+ PD=10.5U
M$769 VDD \$8742 \$9896 VDD pfet_06v0 L=1U W=10U AS=2.5P AD=4.4P PS=10.5U
+ PD=20.88U
M$770 \$9884 \$8206 VDD VDD pfet_06v0 L=1U W=10U AS=4.4P AD=2.5P PS=20.88U
+ PD=10.5U
M$771 \$8206 \$8820 \$9884 VDD pfet_06v0 L=1U W=10U AS=2.5P AD=3.3P PS=10.5U
+ PD=10.66U
M$772 \$8157 \$8157 \$8206 VDD pfet_06v0 L=1U W=10U AS=3.3P AD=4.4P PS=10.66U
+ PD=20.88U
M$773 \$9881 \$8742 VDD VDD pfet_06v0 L=1U W=10U AS=4.4P AD=2.5P PS=20.88U
+ PD=10.5U
M$774 \$8166 \$8820 \$9881 VDD pfet_06v0 L=1U W=10U AS=2.5P AD=4.4P PS=10.5U
+ PD=20.88U
M$775 \$9918 \$4593 \$6968 VDD pfet_06v0 L=1U W=3U AS=1.32P AD=0.75P PS=6.88U
+ PD=3.5U
M$776 VDD \$4584 \$9918 VDD pfet_06v0 L=1U W=3U AS=0.75P AD=1.32P PS=3.5U
+ PD=6.88U
M$777 \$9899 \$4575 VDD VDD pfet_06v0 L=1U W=3U AS=1.32P AD=1.32P PS=6.88U
+ PD=6.88U
M$778 \$4628 \$9900 VDD VDD pfet_06v0 L=1U W=3U AS=1.32P AD=1.32P PS=6.88U
+ PD=6.88U
M$779 \$8818 \$8818 VDD VDD pfet_06v0 L=1U W=2U AS=0.88P AD=0.88P PS=4.88U
+ PD=4.88U
M$780 \$9900 \$4593 VDD VDD pfet_06v0 L=1U W=3U AS=1.32P AD=0.99P PS=6.88U
+ PD=3.66U
M$781 VDD \$9899 \$9900 VDD pfet_06v0 L=1U W=3U AS=0.99P AD=1.32P PS=3.66U
+ PD=6.88U
M$782 \$3394 \$9901 VDD VDD pfet_06v0 L=1U W=3U AS=1.32P AD=1.32P PS=6.88U
+ PD=6.88U
M$783 \$9901 \$4575 VDD VDD pfet_06v0 L=1U W=3U AS=1.32P AD=0.99P PS=6.88U
+ PD=3.66U
M$784 VDD \$4584 \$9901 VDD pfet_06v0 L=1U W=3U AS=0.99P AD=1.32P PS=3.66U
+ PD=6.88U
M$785 \$8286 \$8818 \$8127 VDD pfet_06v0 L=1U W=5U AS=2.2P AD=1.3P PS=10.88U
+ PD=5.52U
M$786 \$8127 \$8818 \$8286 VDD pfet_06v0 L=1U W=5U AS=1.3P AD=2.2P PS=5.52U
+ PD=10.88U
M$787 \$8132 \$8818 \$8126 VDD pfet_06v0 L=1U W=5U AS=2.2P AD=1.3P PS=10.88U
+ PD=5.52U
M$788 \$8126 \$8818 \$8132 VDD pfet_06v0 L=1U W=5U AS=1.3P AD=2.2P PS=5.52U
+ PD=10.88U
M$789 \$9919 \$6380 \$6347 VDD pfet_06v0 L=1U W=3U AS=1.32P AD=0.75P PS=6.88U
+ PD=3.5U
M$790 VDD \$6371 \$9919 VDD pfet_06v0 L=1U W=3U AS=0.75P AD=1.32P PS=3.5U
+ PD=6.88U
M$791 \$8127 \$8286 VDD VDD pfet_06v0 L=1U W=5U AS=2.2P AD=1.3P PS=10.88U
+ PD=5.52U
M$792 VDD \$8286 \$8127 VDD pfet_06v0 L=1U W=5U AS=1.3P AD=1.3P PS=5.52U
+ PD=5.52U
M$793 \$8127 \$8286 VDD VDD pfet_06v0 L=1U W=5U AS=1.3P AD=1.3P PS=5.52U
+ PD=5.52U
M$794 VDD \$8286 \$8127 VDD pfet_06v0 L=1U W=5U AS=1.3P AD=2.2P PS=5.52U
+ PD=10.88U
M$795 \$9902 \$6362 VDD VDD pfet_06v0 L=1U W=3U AS=1.32P AD=1.32P PS=6.88U
+ PD=6.88U
M$796 \$4556 \$9903 VDD VDD pfet_06v0 L=1U W=3U AS=1.32P AD=1.32P PS=6.88U
+ PD=6.88U
M$797 \$8126 \$8286 VDD VDD pfet_06v0 L=1U W=5U AS=2.2P AD=1.3P PS=10.88U
+ PD=5.52U
M$798 VDD \$8286 \$8126 VDD pfet_06v0 L=1U W=5U AS=1.3P AD=1.3P PS=5.52U
+ PD=5.52U
M$799 \$8126 \$8286 VDD VDD pfet_06v0 L=1U W=5U AS=1.3P AD=1.3P PS=5.52U
+ PD=5.52U
M$800 VDD \$8286 \$8126 VDD pfet_06v0 L=1U W=5U AS=1.3P AD=2.2P PS=5.52U
+ PD=10.88U
M$801 \$9903 \$6380 VDD VDD pfet_06v0 L=1U W=3U AS=1.32P AD=0.99P PS=6.88U
+ PD=3.66U
M$802 VDD \$9902 \$9903 VDD pfet_06v0 L=1U W=3U AS=0.99P AD=1.32P PS=3.66U
+ PD=6.88U
M$803 \$8129 \$8133 \$8286 VDD pfet_06v0 L=1U W=5U AS=2.2P AD=2.2P PS=10.88U
+ PD=10.88U
M$804 \$2773 \$9904 VDD VDD pfet_06v0 L=1U W=3U AS=1.32P AD=1.32P PS=6.88U
+ PD=6.88U
M$805 \$8131 \$8133 \$8132 VDD pfet_06v0 L=1U W=5U AS=2.2P AD=2.2P PS=10.88U
+ PD=10.88U
M$806 \$9904 \$6362 VDD VDD pfet_06v0 L=1U W=3U AS=1.32P AD=0.99P PS=6.88U
+ PD=3.66U
M$807 VDD \$6371 \$9904 VDD pfet_06v0 L=1U W=3U AS=0.99P AD=1.32P PS=3.66U
+ PD=6.88U
M$808 \$9920 \$8159 \$6424 VDD pfet_06v0 L=1U W=3U AS=1.32P AD=0.75P PS=6.88U
+ PD=3.5U
M$809 VDD \$8147 \$9920 VDD pfet_06v0 L=1U W=3U AS=0.75P AD=1.32P PS=3.5U
+ PD=6.88U
M$810 \$9905 \$8135 VDD VDD pfet_06v0 L=1U W=3U AS=1.32P AD=1.32P PS=6.88U
+ PD=6.88U
M$811 \$4627 \$9906 VDD VDD pfet_06v0 L=1U W=3U AS=1.32P AD=1.32P PS=6.88U
+ PD=6.88U
M$812 \$9906 \$8159 VDD VDD pfet_06v0 L=1U W=3U AS=1.32P AD=0.99P PS=6.88U
+ PD=3.66U
M$813 VDD \$9905 \$9906 VDD pfet_06v0 L=1U W=3U AS=0.99P AD=1.32P PS=3.66U
+ PD=6.88U
M$814 \$2840 \$9907 VDD VDD pfet_06v0 L=1U W=3U AS=1.32P AD=1.32P PS=6.88U
+ PD=6.88U
M$815 \$9907 \$8135 VDD VDD pfet_06v0 L=1U W=3U AS=1.32P AD=0.99P PS=6.88U
+ PD=3.66U
M$816 VDD \$8147 \$9907 VDD pfet_06v0 L=1U W=3U AS=0.99P AD=1.32P PS=3.66U
+ PD=6.88U
M$817 \$8819 \$8819 VDD VDD pfet_06v0 L=1U W=2U AS=0.88P AD=0.88P PS=4.88U
+ PD=4.88U
M$818 \$8287 \$8819 \$8139 VDD pfet_06v0 L=1U W=5U AS=2.2P AD=1.3P PS=10.88U
+ PD=5.52U
M$819 \$8139 \$8819 \$8287 VDD pfet_06v0 L=1U W=5U AS=1.3P AD=2.2P PS=5.52U
+ PD=10.88U
M$820 \$8144 \$8819 \$8138 VDD pfet_06v0 L=1U W=5U AS=2.2P AD=1.3P PS=10.88U
+ PD=5.52U
M$821 \$8138 \$8819 \$8144 VDD pfet_06v0 L=1U W=5U AS=1.3P AD=2.2P PS=5.52U
+ PD=10.88U
M$822 \$8139 \$8287 VDD VDD pfet_06v0 L=1U W=5U AS=2.2P AD=1.3P PS=10.88U
+ PD=5.52U
M$823 VDD \$8287 \$8139 VDD pfet_06v0 L=1U W=5U AS=1.3P AD=1.3P PS=5.52U
+ PD=5.52U
M$824 \$8139 \$8287 VDD VDD pfet_06v0 L=1U W=5U AS=1.3P AD=1.3P PS=5.52U
+ PD=5.52U
M$825 VDD \$8287 \$8139 VDD pfet_06v0 L=1U W=5U AS=1.3P AD=2.2P PS=5.52U
+ PD=10.88U
M$826 \$8138 \$8287 VDD VDD pfet_06v0 L=1U W=5U AS=2.2P AD=1.3P PS=10.88U
+ PD=5.52U
M$827 VDD \$8287 \$8138 VDD pfet_06v0 L=1U W=5U AS=1.3P AD=1.3P PS=5.52U
+ PD=5.52U
M$828 \$8138 \$8287 VDD VDD pfet_06v0 L=1U W=5U AS=1.3P AD=1.3P PS=5.52U
+ PD=5.52U
M$829 VDD \$8287 \$8138 VDD pfet_06v0 L=1U W=5U AS=1.3P AD=2.2P PS=5.52U
+ PD=10.88U
M$830 \$8141 \$8145 \$8287 VDD pfet_06v0 L=1U W=5U AS=2.2P AD=2.2P PS=10.88U
+ PD=10.88U
M$831 \$8143 \$8145 \$8144 VDD pfet_06v0 L=1U W=5U AS=2.2P AD=2.2P PS=10.88U
+ PD=10.88U
M$832 \$8820 \$8820 VDD VDD pfet_06v0 L=1U W=2U AS=0.88P AD=0.88P PS=4.88U
+ PD=4.88U
M$833 \$8288 \$8820 \$8151 VDD pfet_06v0 L=1U W=5U AS=2.2P AD=1.3P PS=10.88U
+ PD=5.52U
M$834 \$8151 \$8820 \$8288 VDD pfet_06v0 L=1U W=5U AS=1.3P AD=2.2P PS=5.52U
+ PD=10.88U
M$835 \$8156 \$8820 \$8150 VDD pfet_06v0 L=1U W=5U AS=2.2P AD=1.3P PS=10.88U
+ PD=5.52U
M$836 \$8150 \$8820 \$8156 VDD pfet_06v0 L=1U W=5U AS=1.3P AD=2.2P PS=5.52U
+ PD=10.88U
M$837 \$8151 \$8288 VDD VDD pfet_06v0 L=1U W=5U AS=2.2P AD=1.3P PS=10.88U
+ PD=5.52U
M$838 VDD \$8288 \$8151 VDD pfet_06v0 L=1U W=5U AS=1.3P AD=1.3P PS=5.52U
+ PD=5.52U
M$839 \$8151 \$8288 VDD VDD pfet_06v0 L=1U W=5U AS=1.3P AD=1.3P PS=5.52U
+ PD=5.52U
M$840 VDD \$8288 \$8151 VDD pfet_06v0 L=1U W=5U AS=1.3P AD=2.2P PS=5.52U
+ PD=10.88U
M$841 \$8150 \$8288 VDD VDD pfet_06v0 L=1U W=5U AS=2.2P AD=1.3P PS=10.88U
+ PD=5.52U
M$842 VDD \$8288 \$8150 VDD pfet_06v0 L=1U W=5U AS=1.3P AD=1.3P PS=5.52U
+ PD=5.52U
M$843 \$8150 \$8288 VDD VDD pfet_06v0 L=1U W=5U AS=1.3P AD=1.3P PS=5.52U
+ PD=5.52U
M$844 VDD \$8288 \$8150 VDD pfet_06v0 L=1U W=5U AS=1.3P AD=2.2P PS=5.52U
+ PD=10.88U
M$845 \$8153 \$8157 \$8288 VDD pfet_06v0 L=1U W=5U AS=2.2P AD=2.2P PS=10.88U
+ PD=10.88U
M$846 \$8155 \$8157 \$8156 VDD pfet_06v0 L=1U W=5U AS=2.2P AD=2.2P PS=10.88U
+ PD=10.88U
M$847 \$2764 X VSS VSS nfet_05v0 L=0.6U W=1.32U AS=0.5808P AD=0.5808P PS=3.52U
+ PD=3.52U
M$848 XP \$2764 VSS VSS nfet_05v0 L=0.6U W=1.32U AS=0.5808P AD=0.5808P PS=3.52U
+ PD=3.52U
M$849 XN XP VSS VSS nfet_05v0 L=0.6U W=1.32U AS=0.5808P AD=0.5808P PS=3.52U
+ PD=3.52U
M$850 \$4551 Y VSS VSS nfet_05v0 L=0.6U W=1.32U AS=0.5808P AD=0.5808P PS=3.52U
+ PD=3.52U
M$851 YP \$4551 VSS VSS nfet_05v0 L=0.6U W=1.32U AS=0.5808P AD=0.5808P PS=3.52U
+ PD=3.52U
M$852 YN YP VSS VSS nfet_05v0 L=0.6U W=1.32U AS=0.5808P AD=0.5808P PS=3.52U
+ PD=3.52U
M$853 \$6338 Z VSS VSS nfet_05v0 L=0.6U W=1.32U AS=0.5808P AD=0.5808P PS=3.52U
+ PD=3.52U
M$854 ZP \$6338 VSS VSS nfet_05v0 L=0.6U W=1.32U AS=0.5808P AD=0.5808P PS=3.52U
+ PD=3.52U
M$855 ZN ZP VSS VSS nfet_05v0 L=0.6U W=1.32U AS=0.5808P AD=0.5808P PS=3.52U
+ PD=3.52U
M$856 \$71 \$63 VSS VSS nfet_06v0 L=1U W=5U AS=2.2P AD=1.25P PS=10.88U PD=5.5U
M$857 \$7 \$64 \$71 VSS nfet_06v0 L=1U W=5U AS=1.25P AD=2.2P PS=5.5U PD=10.88U
M$858 \$73 \$63 VSS VSS nfet_06v0 L=1U W=5U AS=2.2P AD=1.25P PS=10.88U PD=5.5U
M$859 \$7 \$64 \$73 VSS nfet_06v0 L=1U W=5U AS=1.25P AD=2.2P PS=5.5U PD=10.88U
M$860 \$8 S2P \$7 VSS nfet_06v0 L=1U W=1U AS=0.44P AD=0.44P PS=2.88U PD=2.88U
M$861 \$9 S2N \$7 VSS nfet_06v0 L=1U W=1U AS=0.44P AD=0.44P PS=2.88U PD=2.88U
M$862 \$10 \$11 VSS VSS nfet_06v0 L=1U W=2.5U AS=1.1P AD=0.825P PS=5.88U
+ PD=3.16U
M$863 \$11 \$64 \$10 VSS nfet_06v0 L=1U W=2.5U AS=0.825P AD=0.825P PS=3.16U
+ PD=3.16U
M$864 \$12 \$51 \$11 VSS nfet_06v0 L=1U W=2.5U AS=0.825P AD=1.1P PS=3.16U
+ PD=5.88U
M$865 \$101 \$11 VSS VSS nfet_06v0 L=1U W=2.5U AS=1.1P AD=0.825P PS=5.88U
+ PD=3.16U
M$866 \$13 \$64 \$101 VSS nfet_06v0 L=1U W=2.5U AS=0.825P AD=0.825P PS=3.16U
+ PD=3.16U
M$867 \$14 \$51 \$13 VSS nfet_06v0 L=1U W=2.5U AS=0.825P AD=1.1P PS=3.16U
+ PD=5.88U
M$868 \$76 \$63 VSS VSS nfet_06v0 L=1U W=5U AS=2.2P AD=1.25P PS=10.88U PD=5.5U
M$869 \$15 \$64 \$76 VSS nfet_06v0 L=1U W=5U AS=1.25P AD=2.2P PS=5.5U PD=10.88U
M$870 \$77 \$16 VSS VSS nfet_06v0 L=1U W=5U AS=2.2P AD=1.25P PS=10.88U PD=5.5U
M$871 \$16 \$64 \$77 VSS nfet_06v0 L=1U W=5U AS=1.25P AD=1.65P PS=5.5U PD=5.66U
M$872 \$51 \$51 \$16 VSS nfet_06v0 L=1U W=5U AS=1.65P AD=2.2P PS=5.66U PD=10.88U
M$873 \$17 \$13 VSS VSS nfet_06v0 L=1U W=1U AS=0.44P AD=0.44P PS=2.88U PD=2.88U
M$874 \$64 \$64 VSS VSS nfet_06v0 L=1U W=1U AS=0.44P AD=0.44P PS=2.88U PD=2.88U
M$875 \$78 \$63 VSS VSS nfet_06v0 L=1U W=5U AS=2.2P AD=1.25P PS=10.88U PD=5.5U
M$876 \$63 \$64 \$78 VSS nfet_06v0 L=1U W=5U AS=1.25P AD=2.2P PS=5.5U PD=10.88U
M$877 \$57 \$119 VSS VSS nfet_06v0 L=1U W=1U AS=0.44P AD=0.25P PS=2.88U PD=1.5U
M$878 \$107 \$119 \$57 VSS nfet_06v0 L=1U W=1U AS=0.25P AD=0.44P PS=1.5U
+ PD=2.88U
M$879 \$58 \$119 VSS VSS nfet_06v0 L=1U W=1U AS=0.44P AD=0.25P PS=2.88U PD=1.5U
M$880 \$119 \$119 \$58 VSS nfet_06v0 L=1U W=1U AS=0.25P AD=0.44P PS=1.5U
+ PD=2.88U
M$881 \$79 \$65 VSS VSS nfet_06v0 L=1U W=5U AS=2.2P AD=1.25P PS=10.88U PD=5.5U
M$882 \$18 \$66 \$79 VSS nfet_06v0 L=1U W=5U AS=1.25P AD=2.2P PS=5.5U PD=10.88U
M$883 \$81 \$65 VSS VSS nfet_06v0 L=1U W=5U AS=2.2P AD=1.25P PS=10.88U PD=5.5U
M$884 \$18 \$66 \$81 VSS nfet_06v0 L=1U W=5U AS=1.25P AD=2.2P PS=5.5U PD=10.88U
M$885 \$19 S3P \$18 VSS nfet_06v0 L=1U W=1U AS=0.44P AD=0.44P PS=2.88U PD=2.88U
M$886 \$20 S3N \$18 VSS nfet_06v0 L=1U W=1U AS=0.44P AD=0.44P PS=2.88U PD=2.88U
M$887 \$21 \$22 VSS VSS nfet_06v0 L=1U W=2.5U AS=1.1P AD=0.825P PS=5.88U
+ PD=3.16U
M$888 \$22 \$66 \$21 VSS nfet_06v0 L=1U W=2.5U AS=0.825P AD=0.825P PS=3.16U
+ PD=3.16U
M$889 \$23 \$52 \$22 VSS nfet_06v0 L=1U W=2.5U AS=0.825P AD=1.1P PS=3.16U
+ PD=5.88U
M$890 \$95 \$22 VSS VSS nfet_06v0 L=1U W=2.5U AS=1.1P AD=0.825P PS=5.88U
+ PD=3.16U
M$891 \$24 \$66 \$95 VSS nfet_06v0 L=1U W=2.5U AS=0.825P AD=0.825P PS=3.16U
+ PD=3.16U
M$892 \$25 \$52 \$24 VSS nfet_06v0 L=1U W=2.5U AS=0.825P AD=1.1P PS=3.16U
+ PD=5.88U
M$893 \$84 \$65 VSS VSS nfet_06v0 L=1U W=5U AS=2.2P AD=1.25P PS=10.88U PD=5.5U
M$894 \$26 \$66 \$84 VSS nfet_06v0 L=1U W=5U AS=1.25P AD=2.2P PS=5.5U PD=10.88U
M$895 \$85 \$27 VSS VSS nfet_06v0 L=1U W=5U AS=2.2P AD=1.25P PS=10.88U PD=5.5U
M$896 \$27 \$66 \$85 VSS nfet_06v0 L=1U W=5U AS=1.25P AD=1.65P PS=5.5U PD=5.66U
M$897 \$52 \$52 \$27 VSS nfet_06v0 L=1U W=5U AS=1.65P AD=2.2P PS=5.66U PD=10.88U
M$898 \$28 \$24 VSS VSS nfet_06v0 L=1U W=1U AS=0.44P AD=0.44P PS=2.88U PD=2.88U
M$899 \$66 \$66 VSS VSS nfet_06v0 L=1U W=1U AS=0.44P AD=0.44P PS=2.88U PD=2.88U
M$900 \$88 \$65 VSS VSS nfet_06v0 L=1U W=5U AS=2.2P AD=1.25P PS=10.88U PD=5.5U
M$901 \$65 \$66 \$88 VSS nfet_06v0 L=1U W=5U AS=1.25P AD=2.2P PS=5.5U PD=10.88U
M$902 \$60 \$120 VSS VSS nfet_06v0 L=1U W=1U AS=0.44P AD=0.25P PS=2.88U PD=1.5U
M$903 \$108 \$120 \$60 VSS nfet_06v0 L=1U W=1U AS=0.25P AD=0.44P PS=1.5U
+ PD=2.88U
M$904 \$61 \$120 VSS VSS nfet_06v0 L=1U W=1U AS=0.44P AD=0.25P PS=2.88U PD=1.5U
M$905 \$120 \$120 \$61 VSS nfet_06v0 L=1U W=1U AS=0.25P AD=0.44P PS=1.5U
+ PD=2.88U
M$906 \$89 \$67 VSS VSS nfet_06v0 L=1U W=5U AS=2.2P AD=1.25P PS=10.88U PD=5.5U
M$907 \$29 \$68 \$89 VSS nfet_06v0 L=1U W=5U AS=1.25P AD=2.2P PS=5.5U PD=10.88U
M$908 \$90 \$67 VSS VSS nfet_06v0 L=1U W=5U AS=2.2P AD=1.25P PS=10.88U PD=5.5U
M$909 \$29 \$68 \$90 VSS nfet_06v0 L=1U W=5U AS=1.25P AD=2.2P PS=5.5U PD=10.88U
M$910 \$30 S1P \$29 VSS nfet_06v0 L=1U W=1U AS=0.44P AD=0.44P PS=2.88U PD=2.88U
M$911 \$31 S1N \$29 VSS nfet_06v0 L=1U W=1U AS=0.44P AD=0.44P PS=2.88U PD=2.88U
M$912 \$32 \$33 VSS VSS nfet_06v0 L=1U W=2.5U AS=1.1P AD=0.825P PS=5.88U
+ PD=3.16U
M$913 \$33 \$68 \$32 VSS nfet_06v0 L=1U W=2.5U AS=0.825P AD=0.825P PS=3.16U
+ PD=3.16U
M$914 \$34 \$53 \$33 VSS nfet_06v0 L=1U W=2.5U AS=0.825P AD=1.1P PS=3.16U
+ PD=5.88U
M$915 \$97 \$33 VSS VSS nfet_06v0 L=1U W=2.5U AS=1.1P AD=0.825P PS=5.88U
+ PD=3.16U
M$916 \$35 \$68 \$97 VSS nfet_06v0 L=1U W=2.5U AS=0.825P AD=0.825P PS=3.16U
+ PD=3.16U
M$917 \$36 \$53 \$35 VSS nfet_06v0 L=1U W=2.5U AS=0.825P AD=1.1P PS=3.16U
+ PD=5.88U
M$918 \$87 \$67 VSS VSS nfet_06v0 L=1U W=5U AS=2.2P AD=1.25P PS=10.88U PD=5.5U
M$919 \$37 \$68 \$87 VSS nfet_06v0 L=1U W=5U AS=1.25P AD=2.2P PS=5.5U PD=10.88U
M$920 \$86 \$38 VSS VSS nfet_06v0 L=1U W=5U AS=2.2P AD=1.25P PS=10.88U PD=5.5U
M$921 \$38 \$68 \$86 VSS nfet_06v0 L=1U W=5U AS=1.25P AD=1.65P PS=5.5U PD=5.66U
M$922 \$53 \$53 \$38 VSS nfet_06v0 L=1U W=5U AS=1.65P AD=2.2P PS=5.66U PD=10.88U
M$923 \$39 \$35 VSS VSS nfet_06v0 L=1U W=1U AS=0.44P AD=0.44P PS=2.88U PD=2.88U
M$924 \$68 \$68 VSS VSS nfet_06v0 L=1U W=1U AS=0.44P AD=0.44P PS=2.88U PD=2.88U
M$925 \$83 \$67 VSS VSS nfet_06v0 L=1U W=5U AS=2.2P AD=1.25P PS=10.88U PD=5.5U
M$926 \$67 \$68 \$83 VSS nfet_06v0 L=1U W=5U AS=1.25P AD=2.2P PS=5.5U PD=10.88U
M$927 \$62 \$121 VSS VSS nfet_06v0 L=1U W=1U AS=0.44P AD=0.25P PS=2.88U PD=1.5U
M$928 \$109 \$121 \$62 VSS nfet_06v0 L=1U W=1U AS=0.25P AD=0.44P PS=1.5U
+ PD=2.88U
M$929 \$59 \$121 VSS VSS nfet_06v0 L=1U W=1U AS=0.44P AD=0.25P PS=2.88U PD=1.5U
M$930 \$121 \$121 \$59 VSS nfet_06v0 L=1U W=1U AS=0.25P AD=0.44P PS=1.5U
+ PD=2.88U
M$931 \$82 \$69 VSS VSS nfet_06v0 L=1U W=5U AS=2.2P AD=1.25P PS=10.88U PD=5.5U
M$932 \$40 \$70 \$82 VSS nfet_06v0 L=1U W=5U AS=1.25P AD=2.2P PS=5.5U PD=10.88U
M$933 \$80 \$69 VSS VSS nfet_06v0 L=1U W=5U AS=2.2P AD=1.25P PS=10.88U PD=5.5U
M$934 \$40 \$70 \$80 VSS nfet_06v0 L=1U W=5U AS=1.25P AD=2.2P PS=5.5U PD=10.88U
M$935 \$41 S2P \$40 VSS nfet_06v0 L=1U W=1U AS=0.44P AD=0.44P PS=2.88U PD=2.88U
M$936 \$42 S2N \$40 VSS nfet_06v0 L=1U W=1U AS=0.44P AD=0.44P PS=2.88U PD=2.88U
M$937 \$43 \$44 VSS VSS nfet_06v0 L=1U W=2.5U AS=1.1P AD=0.825P PS=5.88U
+ PD=3.16U
M$938 \$44 \$70 \$43 VSS nfet_06v0 L=1U W=2.5U AS=0.825P AD=0.825P PS=3.16U
+ PD=3.16U
M$939 \$45 \$54 \$44 VSS nfet_06v0 L=1U W=2.5U AS=0.825P AD=1.1P PS=3.16U
+ PD=5.88U
M$940 \$105 \$44 VSS VSS nfet_06v0 L=1U W=2.5U AS=1.1P AD=0.825P PS=5.88U
+ PD=3.16U
M$941 \$46 \$70 \$105 VSS nfet_06v0 L=1U W=2.5U AS=0.825P AD=0.825P PS=3.16U
+ PD=3.16U
M$942 \$47 \$54 \$46 VSS nfet_06v0 L=1U W=2.5U AS=0.825P AD=1.1P PS=3.16U
+ PD=5.88U
M$943 \$75 \$69 VSS VSS nfet_06v0 L=1U W=5U AS=2.2P AD=1.25P PS=10.88U PD=5.5U
M$944 \$48 \$70 \$75 VSS nfet_06v0 L=1U W=5U AS=1.25P AD=2.2P PS=5.5U PD=10.88U
M$945 \$74 \$49 VSS VSS nfet_06v0 L=1U W=5U AS=2.2P AD=1.25P PS=10.88U PD=5.5U
M$946 \$49 \$70 \$74 VSS nfet_06v0 L=1U W=5U AS=1.25P AD=1.65P PS=5.5U PD=5.66U
M$947 \$54 \$54 \$49 VSS nfet_06v0 L=1U W=5U AS=1.65P AD=2.2P PS=5.66U PD=10.88U
M$948 \$50 \$46 VSS VSS nfet_06v0 L=1U W=1U AS=0.44P AD=0.44P PS=2.88U PD=2.88U
M$949 \$70 \$70 VSS VSS nfet_06v0 L=1U W=1U AS=0.44P AD=0.44P PS=2.88U PD=2.88U
M$950 \$72 \$69 VSS VSS nfet_06v0 L=1U W=5U AS=2.2P AD=1.25P PS=10.88U PD=5.5U
M$951 \$69 \$70 \$72 VSS nfet_06v0 L=1U W=5U AS=1.25P AD=2.2P PS=5.5U PD=10.88U
M$952 \$56 \$122 VSS VSS nfet_06v0 L=1U W=1U AS=0.44P AD=0.25P PS=2.88U PD=1.5U
M$953 \$110 \$122 \$56 VSS nfet_06v0 L=1U W=1U AS=0.25P AD=0.44P PS=1.5U
+ PD=2.88U
M$954 \$55 \$122 VSS VSS nfet_06v0 L=1U W=1U AS=0.44P AD=0.25P PS=2.88U PD=1.5U
M$955 \$122 \$122 \$55 VSS nfet_06v0 L=1U W=1U AS=0.25P AD=0.44P PS=1.5U
+ PD=2.88U
M$956 \$992 \$984 VSS VSS nfet_06v0 L=1U W=5U AS=2.2P AD=1.25P PS=10.88U PD=5.5U
M$957 \$928 \$985 \$992 VSS nfet_06v0 L=1U W=5U AS=1.25P AD=2.2P PS=5.5U
+ PD=10.88U
M$958 \$994 \$984 VSS VSS nfet_06v0 L=1U W=5U AS=2.2P AD=1.25P PS=10.88U PD=5.5U
M$959 \$928 \$985 \$994 VSS nfet_06v0 L=1U W=5U AS=1.25P AD=2.2P PS=5.5U
+ PD=10.88U
M$960 \$929 S4P \$928 VSS nfet_06v0 L=1U W=1U AS=0.44P AD=0.44P PS=2.88U
+ PD=2.88U
M$961 \$930 S4N \$928 VSS nfet_06v0 L=1U W=1U AS=0.44P AD=0.44P PS=2.88U
+ PD=2.88U
M$962 \$931 \$932 VSS VSS nfet_06v0 L=1U W=2.5U AS=1.1P AD=0.825P PS=5.88U
+ PD=3.16U
M$963 \$932 \$985 \$931 VSS nfet_06v0 L=1U W=2.5U AS=0.825P AD=0.825P PS=3.16U
+ PD=3.16U
M$964 \$933 \$972 \$932 VSS nfet_06v0 L=1U W=2.5U AS=0.825P AD=1.1P PS=3.16U
+ PD=5.88U
M$965 \$1013 \$932 VSS VSS nfet_06v0 L=1U W=2.5U AS=1.1P AD=0.825P PS=5.88U
+ PD=3.16U
M$966 \$934 \$985 \$1013 VSS nfet_06v0 L=1U W=2.5U AS=0.825P AD=0.825P PS=3.16U
+ PD=3.16U
M$967 \$935 \$972 \$934 VSS nfet_06v0 L=1U W=2.5U AS=0.825P AD=1.1P PS=3.16U
+ PD=5.88U
M$968 \$997 \$984 VSS VSS nfet_06v0 L=1U W=5U AS=2.2P AD=1.25P PS=10.88U PD=5.5U
M$969 \$936 \$985 \$997 VSS nfet_06v0 L=1U W=5U AS=1.25P AD=2.2P PS=5.5U
+ PD=10.88U
M$970 \$998 \$937 VSS VSS nfet_06v0 L=1U W=5U AS=2.2P AD=1.25P PS=10.88U PD=5.5U
M$971 \$937 \$985 \$998 VSS nfet_06v0 L=1U W=5U AS=1.25P AD=1.65P PS=5.5U
+ PD=5.66U
M$972 \$972 \$972 \$937 VSS nfet_06v0 L=1U W=5U AS=1.65P AD=2.2P PS=5.66U
+ PD=10.88U
M$973 \$938 \$934 VSS VSS nfet_06v0 L=1U W=1U AS=0.44P AD=0.44P PS=2.88U
+ PD=2.88U
M$974 \$985 \$985 VSS VSS nfet_06v0 L=1U W=1U AS=0.44P AD=0.44P PS=2.88U
+ PD=2.88U
M$975 \$999 \$984 VSS VSS nfet_06v0 L=1U W=5U AS=2.2P AD=1.25P PS=10.88U PD=5.5U
M$976 \$984 \$985 \$999 VSS nfet_06v0 L=1U W=5U AS=1.25P AD=2.2P PS=5.5U
+ PD=10.88U
M$977 \$978 \$1038 VSS VSS nfet_06v0 L=1U W=1U AS=0.44P AD=0.25P PS=2.88U
+ PD=1.5U
M$978 \$1028 \$1038 \$978 VSS nfet_06v0 L=1U W=1U AS=0.25P AD=0.44P PS=1.5U
+ PD=2.88U
M$979 \$979 \$1038 VSS VSS nfet_06v0 L=1U W=1U AS=0.44P AD=0.25P PS=2.88U
+ PD=1.5U
M$980 \$1038 \$1038 \$979 VSS nfet_06v0 L=1U W=1U AS=0.25P AD=0.44P PS=1.5U
+ PD=2.88U
M$981 \$1001 \$986 VSS VSS nfet_06v0 L=1U W=5U AS=2.2P AD=1.25P PS=10.88U
+ PD=5.5U
M$982 \$939 \$987 \$1001 VSS nfet_06v0 L=1U W=5U AS=1.25P AD=2.2P PS=5.5U
+ PD=10.88U
M$983 \$1003 \$986 VSS VSS nfet_06v0 L=1U W=5U AS=2.2P AD=1.25P PS=10.88U
+ PD=5.5U
M$984 \$939 \$987 \$1003 VSS nfet_06v0 L=1U W=5U AS=1.25P AD=2.2P PS=5.5U
+ PD=10.88U
M$985 \$940 S1P \$939 VSS nfet_06v0 L=1U W=1U AS=0.44P AD=0.44P PS=2.88U
+ PD=2.88U
M$986 \$941 S1N \$939 VSS nfet_06v0 L=1U W=1U AS=0.44P AD=0.44P PS=2.88U
+ PD=2.88U
M$987 \$942 \$943 VSS VSS nfet_06v0 L=1U W=2.5U AS=1.1P AD=0.825P PS=5.88U
+ PD=3.16U
M$988 \$943 \$987 \$942 VSS nfet_06v0 L=1U W=2.5U AS=0.825P AD=0.825P PS=3.16U
+ PD=3.16U
M$989 \$944 \$973 \$943 VSS nfet_06v0 L=1U W=2.5U AS=0.825P AD=1.1P PS=3.16U
+ PD=5.88U
M$990 \$1016 \$943 VSS VSS nfet_06v0 L=1U W=2.5U AS=1.1P AD=0.825P PS=5.88U
+ PD=3.16U
M$991 \$945 \$987 \$1016 VSS nfet_06v0 L=1U W=2.5U AS=0.825P AD=0.825P PS=3.16U
+ PD=3.16U
M$992 \$946 \$973 \$945 VSS nfet_06v0 L=1U W=2.5U AS=0.825P AD=1.1P PS=3.16U
+ PD=5.88U
M$993 \$1006 \$986 VSS VSS nfet_06v0 L=1U W=5U AS=2.2P AD=1.25P PS=10.88U
+ PD=5.5U
M$994 \$947 \$987 \$1006 VSS nfet_06v0 L=1U W=5U AS=1.25P AD=2.2P PS=5.5U
+ PD=10.88U
M$995 \$1008 \$948 VSS VSS nfet_06v0 L=1U W=5U AS=2.2P AD=1.25P PS=10.88U
+ PD=5.5U
M$996 \$948 \$987 \$1008 VSS nfet_06v0 L=1U W=5U AS=1.25P AD=1.65P PS=5.5U
+ PD=5.66U
M$997 \$973 \$973 \$948 VSS nfet_06v0 L=1U W=5U AS=1.65P AD=2.2P PS=5.66U
+ PD=10.88U
M$998 \$949 \$945 VSS VSS nfet_06v0 L=1U W=1U AS=0.44P AD=0.44P PS=2.88U
+ PD=2.88U
M$999 \$987 \$987 VSS VSS nfet_06v0 L=1U W=1U AS=0.44P AD=0.44P PS=2.88U
+ PD=2.88U
M$1000 \$1009 \$986 VSS VSS nfet_06v0 L=1U W=5U AS=2.2P AD=1.25P PS=10.88U
+ PD=5.5U
M$1001 \$986 \$987 \$1009 VSS nfet_06v0 L=1U W=5U AS=1.25P AD=2.2P PS=5.5U
+ PD=10.88U
M$1002 \$981 \$1039 VSS VSS nfet_06v0 L=1U W=1U AS=0.44P AD=0.25P PS=2.88U
+ PD=1.5U
M$1003 \$1029 \$1039 \$981 VSS nfet_06v0 L=1U W=1U AS=0.25P AD=0.44P PS=1.5U
+ PD=2.88U
M$1004 \$982 \$1039 VSS VSS nfet_06v0 L=1U W=1U AS=0.44P AD=0.25P PS=2.88U
+ PD=1.5U
M$1005 \$1039 \$1039 \$982 VSS nfet_06v0 L=1U W=1U AS=0.25P AD=0.44P PS=1.5U
+ PD=2.88U
M$1006 \$1011 \$988 VSS VSS nfet_06v0 L=1U W=5U AS=2.2P AD=1.25P PS=10.88U
+ PD=5.5U
M$1007 \$950 \$989 \$1011 VSS nfet_06v0 L=1U W=5U AS=1.25P AD=2.2P PS=5.5U
+ PD=10.88U
M$1008 \$1010 \$988 VSS VSS nfet_06v0 L=1U W=5U AS=2.2P AD=1.25P PS=10.88U
+ PD=5.5U
M$1009 \$950 \$989 \$1010 VSS nfet_06v0 L=1U W=5U AS=1.25P AD=2.2P PS=5.5U
+ PD=10.88U
M$1010 \$951 S4P \$950 VSS nfet_06v0 L=1U W=1U AS=0.44P AD=0.44P PS=2.88U
+ PD=2.88U
M$1011 \$952 S4N \$950 VSS nfet_06v0 L=1U W=1U AS=0.44P AD=0.44P PS=2.88U
+ PD=2.88U
M$1012 \$953 \$954 VSS VSS nfet_06v0 L=1U W=2.5U AS=1.1P AD=0.825P PS=5.88U
+ PD=3.16U
M$1013 \$954 \$989 \$953 VSS nfet_06v0 L=1U W=2.5U AS=0.825P AD=0.825P PS=3.16U
+ PD=3.16U
M$1014 \$955 \$974 \$954 VSS nfet_06v0 L=1U W=2.5U AS=0.825P AD=1.1P PS=3.16U
+ PD=5.88U
M$1015 \$1025 \$954 VSS VSS nfet_06v0 L=1U W=2.5U AS=1.1P AD=0.825P PS=5.88U
+ PD=3.16U
M$1016 \$956 \$989 \$1025 VSS nfet_06v0 L=1U W=2.5U AS=0.825P AD=0.825P
+ PS=3.16U PD=3.16U
M$1017 \$957 \$974 \$956 VSS nfet_06v0 L=1U W=2.5U AS=0.825P AD=1.1P PS=3.16U
+ PD=5.88U
M$1018 \$1007 \$988 VSS VSS nfet_06v0 L=1U W=5U AS=2.2P AD=1.25P PS=10.88U
+ PD=5.5U
M$1019 \$958 \$989 \$1007 VSS nfet_06v0 L=1U W=5U AS=1.25P AD=2.2P PS=5.5U
+ PD=10.88U
M$1020 \$1005 \$959 VSS VSS nfet_06v0 L=1U W=5U AS=2.2P AD=1.25P PS=10.88U
+ PD=5.5U
M$1021 \$959 \$989 \$1005 VSS nfet_06v0 L=1U W=5U AS=1.25P AD=1.65P PS=5.5U
+ PD=5.66U
M$1022 \$974 \$974 \$959 VSS nfet_06v0 L=1U W=5U AS=1.65P AD=2.2P PS=5.66U
+ PD=10.88U
M$1023 \$960 \$956 VSS VSS nfet_06v0 L=1U W=1U AS=0.44P AD=0.44P PS=2.88U
+ PD=2.88U
M$1024 \$989 \$989 VSS VSS nfet_06v0 L=1U W=1U AS=0.44P AD=0.44P PS=2.88U
+ PD=2.88U
M$1025 \$1004 \$988 VSS VSS nfet_06v0 L=1U W=5U AS=2.2P AD=1.25P PS=10.88U
+ PD=5.5U
M$1026 \$988 \$989 \$1004 VSS nfet_06v0 L=1U W=5U AS=1.25P AD=2.2P PS=5.5U
+ PD=10.88U
M$1027 \$983 \$1040 VSS VSS nfet_06v0 L=1U W=1U AS=0.44P AD=0.25P PS=2.88U
+ PD=1.5U
M$1028 \$1030 \$1040 \$983 VSS nfet_06v0 L=1U W=1U AS=0.25P AD=0.44P PS=1.5U
+ PD=2.88U
M$1029 \$980 \$1040 VSS VSS nfet_06v0 L=1U W=1U AS=0.44P AD=0.25P PS=2.88U
+ PD=1.5U
M$1030 \$1040 \$1040 \$980 VSS nfet_06v0 L=1U W=1U AS=0.25P AD=0.44P PS=1.5U
+ PD=2.88U
M$1031 \$1002 \$990 VSS VSS nfet_06v0 L=1U W=5U AS=2.2P AD=1.25P PS=10.88U
+ PD=5.5U
M$1032 \$961 \$991 \$1002 VSS nfet_06v0 L=1U W=5U AS=1.25P AD=2.2P PS=5.5U
+ PD=10.88U
M$1033 \$1000 \$990 VSS VSS nfet_06v0 L=1U W=5U AS=2.2P AD=1.25P PS=10.88U
+ PD=5.5U
M$1034 \$961 \$991 \$1000 VSS nfet_06v0 L=1U W=5U AS=1.25P AD=2.2P PS=5.5U
+ PD=10.88U
M$1035 \$962 S1P \$961 VSS nfet_06v0 L=1U W=1U AS=0.44P AD=0.44P PS=2.88U
+ PD=2.88U
M$1036 \$963 S1N \$961 VSS nfet_06v0 L=1U W=1U AS=0.44P AD=0.44P PS=2.88U
+ PD=2.88U
M$1037 \$964 \$965 VSS VSS nfet_06v0 L=1U W=2.5U AS=1.1P AD=0.825P PS=5.88U
+ PD=3.16U
M$1038 \$965 \$991 \$964 VSS nfet_06v0 L=1U W=2.5U AS=0.825P AD=0.825P PS=3.16U
+ PD=3.16U
M$1039 \$966 \$975 \$965 VSS nfet_06v0 L=1U W=2.5U AS=0.825P AD=1.1P PS=3.16U
+ PD=5.88U
M$1040 \$1022 \$965 VSS VSS nfet_06v0 L=1U W=2.5U AS=1.1P AD=0.825P PS=5.88U
+ PD=3.16U
M$1041 \$967 \$991 \$1022 VSS nfet_06v0 L=1U W=2.5U AS=0.825P AD=0.825P
+ PS=3.16U PD=3.16U
M$1042 \$968 \$975 \$967 VSS nfet_06v0 L=1U W=2.5U AS=0.825P AD=1.1P PS=3.16U
+ PD=5.88U
M$1043 \$996 \$990 VSS VSS nfet_06v0 L=1U W=5U AS=2.2P AD=1.25P PS=10.88U
+ PD=5.5U
M$1044 \$969 \$991 \$996 VSS nfet_06v0 L=1U W=5U AS=1.25P AD=2.2P PS=5.5U
+ PD=10.88U
M$1045 \$995 \$970 VSS VSS nfet_06v0 L=1U W=5U AS=2.2P AD=1.25P PS=10.88U
+ PD=5.5U
M$1046 \$970 \$991 \$995 VSS nfet_06v0 L=1U W=5U AS=1.25P AD=1.65P PS=5.5U
+ PD=5.66U
M$1047 \$975 \$975 \$970 VSS nfet_06v0 L=1U W=5U AS=1.65P AD=2.2P PS=5.66U
+ PD=10.88U
M$1048 \$971 \$967 VSS VSS nfet_06v0 L=1U W=1U AS=0.44P AD=0.44P PS=2.88U
+ PD=2.88U
M$1049 \$991 \$991 VSS VSS nfet_06v0 L=1U W=1U AS=0.44P AD=0.44P PS=2.88U
+ PD=2.88U
M$1050 \$993 \$990 VSS VSS nfet_06v0 L=1U W=5U AS=2.2P AD=1.25P PS=10.88U
+ PD=5.5U
M$1051 \$990 \$991 \$993 VSS nfet_06v0 L=1U W=5U AS=1.25P AD=2.2P PS=5.5U
+ PD=10.88U
M$1052 \$977 \$1041 VSS VSS nfet_06v0 L=1U W=1U AS=0.44P AD=0.25P PS=2.88U
+ PD=1.5U
M$1053 \$1031 \$1041 \$977 VSS nfet_06v0 L=1U W=1U AS=0.25P AD=0.44P PS=1.5U
+ PD=2.88U
M$1054 \$976 \$1041 VSS VSS nfet_06v0 L=1U W=1U AS=0.44P AD=0.25P PS=2.88U
+ PD=1.5U
M$1055 \$1041 \$1041 \$976 VSS nfet_06v0 L=1U W=1U AS=0.25P AD=0.44P PS=1.5U
+ PD=2.88U
M$1056 \$1910 \$1902 VSS VSS nfet_06v0 L=1U W=5U AS=2.2P AD=1.25P PS=10.88U
+ PD=5.5U
M$1057 \$1846 \$1903 \$1910 VSS nfet_06v0 L=1U W=5U AS=1.25P AD=2.2P PS=5.5U
+ PD=10.88U
M$1058 \$1912 \$1902 VSS VSS nfet_06v0 L=1U W=5U AS=2.2P AD=1.25P PS=10.88U
+ PD=5.5U
M$1059 \$1846 \$1903 \$1912 VSS nfet_06v0 L=1U W=5U AS=1.25P AD=2.2P PS=5.5U
+ PD=10.88U
M$1060 \$1847 S3P \$1846 VSS nfet_06v0 L=1U W=1U AS=0.44P AD=0.44P PS=2.88U
+ PD=2.88U
M$1061 \$1848 S3N \$1846 VSS nfet_06v0 L=1U W=1U AS=0.44P AD=0.44P PS=2.88U
+ PD=2.88U
M$1062 \$1849 \$1850 VSS VSS nfet_06v0 L=1U W=2.5U AS=1.1P AD=0.825P PS=5.88U
+ PD=3.16U
M$1063 \$1850 \$1903 \$1849 VSS nfet_06v0 L=1U W=2.5U AS=0.825P AD=0.825P
+ PS=3.16U PD=3.16U
M$1064 \$1851 \$1898 \$1850 VSS nfet_06v0 L=1U W=2.5U AS=0.825P AD=1.1P
+ PS=3.16U PD=5.88U
M$1065 \$1931 \$1850 VSS VSS nfet_06v0 L=1U W=2.5U AS=1.1P AD=0.825P PS=5.88U
+ PD=3.16U
M$1066 \$1852 \$1903 \$1931 VSS nfet_06v0 L=1U W=2.5U AS=0.825P AD=0.825P
+ PS=3.16U PD=3.16U
M$1067 \$1853 \$1898 \$1852 VSS nfet_06v0 L=1U W=2.5U AS=0.825P AD=1.1P
+ PS=3.16U PD=5.88U
M$1068 \$1915 \$1902 VSS VSS nfet_06v0 L=1U W=5U AS=2.2P AD=1.25P PS=10.88U
+ PD=5.5U
M$1069 \$1854 \$1903 \$1915 VSS nfet_06v0 L=1U W=5U AS=1.25P AD=2.2P PS=5.5U
+ PD=10.88U
M$1070 \$1916 \$1855 VSS VSS nfet_06v0 L=1U W=5U AS=2.2P AD=1.25P PS=10.88U
+ PD=5.5U
M$1071 \$1855 \$1903 \$1916 VSS nfet_06v0 L=1U W=5U AS=1.25P AD=1.65P PS=5.5U
+ PD=5.66U
M$1072 \$1898 \$1898 \$1855 VSS nfet_06v0 L=1U W=5U AS=1.65P AD=2.2P PS=5.66U
+ PD=10.88U
M$1073 \$1856 \$1852 VSS VSS nfet_06v0 L=1U W=1U AS=0.44P AD=0.44P PS=2.88U
+ PD=2.88U
M$1074 \$1903 \$1903 VSS VSS nfet_06v0 L=1U W=1U AS=0.44P AD=0.44P PS=2.88U
+ PD=2.88U
M$1075 \$1917 \$1902 VSS VSS nfet_06v0 L=1U W=5U AS=2.2P AD=1.25P PS=10.88U
+ PD=5.5U
M$1076 \$1902 \$1903 \$1917 VSS nfet_06v0 L=1U W=5U AS=1.25P AD=2.2P PS=5.5U
+ PD=10.88U
M$1077 \$1892 \$1955 VSS VSS nfet_06v0 L=1U W=1U AS=0.44P AD=0.25P PS=2.88U
+ PD=1.5U
M$1078 \$1943 \$1955 \$1892 VSS nfet_06v0 L=1U W=1U AS=0.25P AD=0.44P PS=1.5U
+ PD=2.88U
M$1079 \$1893 \$1955 VSS VSS nfet_06v0 L=1U W=1U AS=0.44P AD=0.25P PS=2.88U
+ PD=1.5U
M$1080 \$1955 \$1955 \$1893 VSS nfet_06v0 L=1U W=1U AS=0.25P AD=0.44P PS=1.5U
+ PD=2.88U
M$1081 \$1919 \$1904 VSS VSS nfet_06v0 L=1U W=5U AS=2.2P AD=1.25P PS=10.88U
+ PD=5.5U
M$1082 \$1857 \$1905 \$1919 VSS nfet_06v0 L=1U W=5U AS=1.25P AD=2.2P PS=5.5U
+ PD=10.88U
M$1083 \$1920 \$1904 VSS VSS nfet_06v0 L=1U W=5U AS=2.2P AD=1.25P PS=10.88U
+ PD=5.5U
M$1084 \$1857 \$1905 \$1920 VSS nfet_06v0 L=1U W=5U AS=1.25P AD=2.2P PS=5.5U
+ PD=10.88U
M$1085 \$1858 S4P \$1857 VSS nfet_06v0 L=1U W=1U AS=0.44P AD=0.44P PS=2.88U
+ PD=2.88U
M$1086 \$1859 S4N \$1857 VSS nfet_06v0 L=1U W=1U AS=0.44P AD=0.44P PS=2.88U
+ PD=2.88U
M$1087 \$1860 \$1861 VSS VSS nfet_06v0 L=1U W=2.5U AS=1.1P AD=0.825P PS=5.88U
+ PD=3.16U
M$1088 \$1861 \$1905 \$1860 VSS nfet_06v0 L=1U W=2.5U AS=0.825P AD=0.825P
+ PS=3.16U PD=3.16U
M$1089 \$1862 \$1899 \$1861 VSS nfet_06v0 L=1U W=2.5U AS=0.825P AD=1.1P
+ PS=3.16U PD=5.88U
M$1090 \$1934 \$1861 VSS VSS nfet_06v0 L=1U W=2.5U AS=1.1P AD=0.825P PS=5.88U
+ PD=3.16U
M$1091 \$1863 \$1905 \$1934 VSS nfet_06v0 L=1U W=2.5U AS=0.825P AD=0.825P
+ PS=3.16U PD=3.16U
M$1092 \$1864 \$1899 \$1863 VSS nfet_06v0 L=1U W=2.5U AS=0.825P AD=1.1P
+ PS=3.16U PD=5.88U
M$1093 \$1923 \$1904 VSS VSS nfet_06v0 L=1U W=5U AS=2.2P AD=1.25P PS=10.88U
+ PD=5.5U
M$1094 \$1865 \$1905 \$1923 VSS nfet_06v0 L=1U W=5U AS=1.25P AD=2.2P PS=5.5U
+ PD=10.88U
M$1095 \$1925 \$1866 VSS VSS nfet_06v0 L=1U W=5U AS=2.2P AD=1.25P PS=10.88U
+ PD=5.5U
M$1096 \$1866 \$1905 \$1925 VSS nfet_06v0 L=1U W=5U AS=1.25P AD=1.65P PS=5.5U
+ PD=5.66U
M$1097 \$1899 \$1899 \$1866 VSS nfet_06v0 L=1U W=5U AS=1.65P AD=2.2P PS=5.66U
+ PD=10.88U
M$1098 \$1867 \$1863 VSS VSS nfet_06v0 L=1U W=1U AS=0.44P AD=0.44P PS=2.88U
+ PD=2.88U
M$1099 \$1905 \$1905 VSS VSS nfet_06v0 L=1U W=1U AS=0.44P AD=0.44P PS=2.88U
+ PD=2.88U
M$1100 \$1927 \$1904 VSS VSS nfet_06v0 L=1U W=5U AS=2.2P AD=1.25P PS=10.88U
+ PD=5.5U
M$1101 \$1904 \$1905 \$1927 VSS nfet_06v0 L=1U W=5U AS=1.25P AD=2.2P PS=5.5U
+ PD=10.88U
M$1102 \$1894 \$1956 VSS VSS nfet_06v0 L=1U W=1U AS=0.44P AD=0.25P PS=2.88U
+ PD=1.5U
M$1103 \$1945 \$1956 \$1894 VSS nfet_06v0 L=1U W=1U AS=0.25P AD=0.44P PS=1.5U
+ PD=2.88U
M$1104 \$1895 \$1956 VSS VSS nfet_06v0 L=1U W=1U AS=0.44P AD=0.25P PS=2.88U
+ PD=1.5U
M$1105 \$1956 \$1956 \$1895 VSS nfet_06v0 L=1U W=1U AS=0.25P AD=0.44P PS=1.5U
+ PD=2.88U
M$1106 \$1928 \$1906 VSS VSS nfet_06v0 L=1U W=5U AS=2.2P AD=1.25P PS=10.88U
+ PD=5.5U
M$1107 \$1868 \$1907 \$1928 VSS nfet_06v0 L=1U W=5U AS=1.25P AD=2.2P PS=5.5U
+ PD=10.88U
M$1108 \$1929 \$1906 VSS VSS nfet_06v0 L=1U W=5U AS=2.2P AD=1.25P PS=10.88U
+ PD=5.5U
M$1109 \$1868 \$1907 \$1929 VSS nfet_06v0 L=1U W=5U AS=1.25P AD=2.2P PS=5.5U
+ PD=10.88U
M$1110 \$1869 S2P \$1868 VSS nfet_06v0 L=1U W=1U AS=0.44P AD=0.44P PS=2.88U
+ PD=2.88U
M$1111 \$1870 S2N \$1868 VSS nfet_06v0 L=1U W=1U AS=0.44P AD=0.44P PS=2.88U
+ PD=2.88U
M$1112 \$1871 \$1872 VSS VSS nfet_06v0 L=1U W=2.5U AS=1.1P AD=0.825P PS=5.88U
+ PD=3.16U
M$1113 \$1872 \$1907 \$1871 VSS nfet_06v0 L=1U W=2.5U AS=0.825P AD=0.825P
+ PS=3.16U PD=3.16U
M$1114 \$1873 \$1900 \$1872 VSS nfet_06v0 L=1U W=2.5U AS=0.825P AD=1.1P
+ PS=3.16U PD=5.88U
M$1115 \$1937 \$1872 VSS VSS nfet_06v0 L=1U W=2.5U AS=1.1P AD=0.825P PS=5.88U
+ PD=3.16U
M$1116 \$1874 \$1907 \$1937 VSS nfet_06v0 L=1U W=2.5U AS=0.825P AD=0.825P
+ PS=3.16U PD=3.16U
M$1117 \$1875 \$1900 \$1874 VSS nfet_06v0 L=1U W=2.5U AS=0.825P AD=1.1P
+ PS=3.16U PD=5.88U
M$1118 \$1926 \$1906 VSS VSS nfet_06v0 L=1U W=5U AS=2.2P AD=1.25P PS=10.88U
+ PD=5.5U
M$1119 \$1876 \$1907 \$1926 VSS nfet_06v0 L=1U W=5U AS=1.25P AD=2.2P PS=5.5U
+ PD=10.88U
M$1120 \$1924 \$1877 VSS VSS nfet_06v0 L=1U W=5U AS=2.2P AD=1.25P PS=10.88U
+ PD=5.5U
M$1121 \$1877 \$1907 \$1924 VSS nfet_06v0 L=1U W=5U AS=1.25P AD=1.65P PS=5.5U
+ PD=5.66U
M$1122 \$1900 \$1900 \$1877 VSS nfet_06v0 L=1U W=5U AS=1.65P AD=2.2P PS=5.66U
+ PD=10.88U
M$1123 \$1878 \$1874 VSS VSS nfet_06v0 L=1U W=1U AS=0.44P AD=0.44P PS=2.88U
+ PD=2.88U
M$1124 \$1907 \$1907 VSS VSS nfet_06v0 L=1U W=1U AS=0.44P AD=0.44P PS=2.88U
+ PD=2.88U
M$1125 \$1922 \$1906 VSS VSS nfet_06v0 L=1U W=5U AS=2.2P AD=1.25P PS=10.88U
+ PD=5.5U
M$1126 \$1906 \$1907 \$1922 VSS nfet_06v0 L=1U W=5U AS=1.25P AD=2.2P PS=5.5U
+ PD=10.88U
M$1127 \$1897 \$1957 VSS VSS nfet_06v0 L=1U W=1U AS=0.44P AD=0.25P PS=2.88U
+ PD=1.5U
M$1128 \$1947 \$1957 \$1897 VSS nfet_06v0 L=1U W=1U AS=0.25P AD=0.44P PS=1.5U
+ PD=2.88U
M$1129 \$1896 \$1957 VSS VSS nfet_06v0 L=1U W=1U AS=0.44P AD=0.25P PS=2.88U
+ PD=1.5U
M$1130 \$1957 \$1957 \$1896 VSS nfet_06v0 L=1U W=1U AS=0.25P AD=0.44P PS=1.5U
+ PD=2.88U
M$1131 \$1921 \$1908 VSS VSS nfet_06v0 L=1U W=5U AS=2.2P AD=1.25P PS=10.88U
+ PD=5.5U
M$1132 \$1879 \$1909 \$1921 VSS nfet_06v0 L=1U W=5U AS=1.25P AD=2.2P PS=5.5U
+ PD=10.88U
M$1133 \$1918 \$1908 VSS VSS nfet_06v0 L=1U W=5U AS=2.2P AD=1.25P PS=10.88U
+ PD=5.5U
M$1134 \$1879 \$1909 \$1918 VSS nfet_06v0 L=1U W=5U AS=1.25P AD=2.2P PS=5.5U
+ PD=10.88U
M$1135 \$1880 S3P \$1879 VSS nfet_06v0 L=1U W=1U AS=0.44P AD=0.44P PS=2.88U
+ PD=2.88U
M$1136 \$1881 S3N \$1879 VSS nfet_06v0 L=1U W=1U AS=0.44P AD=0.44P PS=2.88U
+ PD=2.88U
M$1137 \$1882 \$1883 VSS VSS nfet_06v0 L=1U W=2.5U AS=1.1P AD=0.825P PS=5.88U
+ PD=3.16U
M$1138 \$1883 \$1909 \$1882 VSS nfet_06v0 L=1U W=2.5U AS=0.825P AD=0.825P
+ PS=3.16U PD=3.16U
M$1139 \$1884 \$1901 \$1883 VSS nfet_06v0 L=1U W=2.5U AS=0.825P AD=1.1P
+ PS=3.16U PD=5.88U
M$1140 \$1940 \$1883 VSS VSS nfet_06v0 L=1U W=2.5U AS=1.1P AD=0.825P PS=5.88U
+ PD=3.16U
M$1141 \$1885 \$1909 \$1940 VSS nfet_06v0 L=1U W=2.5U AS=0.825P AD=0.825P
+ PS=3.16U PD=3.16U
M$1142 \$1886 \$1901 \$1885 VSS nfet_06v0 L=1U W=2.5U AS=0.825P AD=1.1P
+ PS=3.16U PD=5.88U
M$1143 \$1914 \$1908 VSS VSS nfet_06v0 L=1U W=5U AS=2.2P AD=1.25P PS=10.88U
+ PD=5.5U
M$1144 \$1887 \$1909 \$1914 VSS nfet_06v0 L=1U W=5U AS=1.25P AD=2.2P PS=5.5U
+ PD=10.88U
M$1145 \$1913 \$1888 VSS VSS nfet_06v0 L=1U W=5U AS=2.2P AD=1.25P PS=10.88U
+ PD=5.5U
M$1146 \$1888 \$1909 \$1913 VSS nfet_06v0 L=1U W=5U AS=1.25P AD=1.65P PS=5.5U
+ PD=5.66U
M$1147 \$1901 \$1901 \$1888 VSS nfet_06v0 L=1U W=5U AS=1.65P AD=2.2P PS=5.66U
+ PD=10.88U
M$1148 \$1889 \$1885 VSS VSS nfet_06v0 L=1U W=1U AS=0.44P AD=0.44P PS=2.88U
+ PD=2.88U
M$1149 \$1909 \$1909 VSS VSS nfet_06v0 L=1U W=1U AS=0.44P AD=0.44P PS=2.88U
+ PD=2.88U
M$1150 \$1911 \$1908 VSS VSS nfet_06v0 L=1U W=5U AS=2.2P AD=1.25P PS=10.88U
+ PD=5.5U
M$1151 \$1908 \$1909 \$1911 VSS nfet_06v0 L=1U W=5U AS=1.25P AD=2.2P PS=5.5U
+ PD=10.88U
M$1152 \$1891 \$1958 VSS VSS nfet_06v0 L=1U W=1U AS=0.44P AD=0.25P PS=2.88U
+ PD=1.5U
M$1153 \$1949 \$1958 \$1891 VSS nfet_06v0 L=1U W=1U AS=0.25P AD=0.44P PS=1.5U
+ PD=2.88U
M$1154 \$1890 \$1958 VSS VSS nfet_06v0 L=1U W=1U AS=0.44P AD=0.25P PS=2.88U
+ PD=1.5U
M$1155 \$1958 \$1958 \$1890 VSS nfet_06v0 L=1U W=1U AS=0.25P AD=0.44P PS=1.5U
+ PD=2.88U
M$1156 \$2780 \$2780 VSS VSS nfet_06v0 L=1U W=1U AS=0.44P AD=0.44P PS=2.88U
+ PD=2.88U
M$1157 \$2825 \$2765 VSS VSS nfet_06v0 L=1U W=5U AS=2.2P AD=1.25P PS=10.88U
+ PD=5.5U
M$1158 \$2765 \$2780 \$2825 VSS nfet_06v0 L=1U W=5U AS=1.25P AD=2.2P PS=5.5U
+ PD=10.88U
M$1159 \$2807 \$3391 VSS VSS nfet_06v0 L=1U W=1U AS=0.44P AD=0.25P PS=2.88U
+ PD=1.5U
M$1160 \$3312 \$3391 \$2807 VSS nfet_06v0 L=1U W=1U AS=0.25P AD=0.44P PS=1.5U
+ PD=2.88U
M$1161 \$2808 \$3391 VSS VSS nfet_06v0 L=1U W=1U AS=0.44P AD=0.25P PS=2.88U
+ PD=1.5U
M$1162 \$3391 \$3391 \$2808 VSS nfet_06v0 L=1U W=1U AS=0.25P AD=0.44P PS=1.5U
+ PD=2.88U
M$1163 \$2826 \$2765 VSS VSS nfet_06v0 L=1U W=5U AS=2.2P AD=1.25P PS=10.88U
+ PD=5.5U
M$1164 \$2781 \$2780 \$2826 VSS nfet_06v0 L=1U W=5U AS=1.25P AD=1.65P PS=5.5U
+ PD=5.66U
M$1165 \$2827 \$2780 \$2781 VSS nfet_06v0 L=1U W=5U AS=1.65P AD=1.25P PS=5.66U
+ PD=5.5U
M$1166 VSS \$2765 \$2827 VSS nfet_06v0 L=1U W=5U AS=1.25P AD=2.2P PS=5.5U
+ PD=10.88U
M$1167 \$2782 \$17 \$2781 VSS nfet_06v0 L=1U W=5U AS=2.2P AD=1.3P PS=10.88U
+ PD=5.52U
M$1168 \$2781 \$17 \$2782 VSS nfet_06v0 L=1U W=5U AS=1.3P AD=2.2P PS=5.52U
+ PD=10.88U
M$1169 \$2783 \$39 \$2781 VSS nfet_06v0 L=1U W=5U AS=2.2P AD=1.3P PS=10.88U
+ PD=5.52U
M$1170 \$2781 \$39 \$2783 VSS nfet_06v0 L=1U W=5U AS=1.3P AD=2.2P PS=5.52U
+ PD=10.88U
M$1171 \$2785 \$2780 \$2784 VSS nfet_06v0 L=1U W=2.5U AS=1.1P AD=0.65P PS=5.88U
+ PD=3.02U
M$1172 \$2784 \$2780 \$2785 VSS nfet_06v0 L=1U W=2.5U AS=0.65P AD=1.1P PS=3.02U
+ PD=5.88U
M$1173 \$2787 \$2780 \$2786 VSS nfet_06v0 L=1U W=2.5U AS=1.1P AD=0.65P PS=5.88U
+ PD=3.02U
M$1174 \$2786 \$2780 \$2787 VSS nfet_06v0 L=1U W=2.5U AS=0.65P AD=1.1P PS=3.02U
+ PD=5.88U
M$1175 \$2784 \$2785 VSS VSS nfet_06v0 L=1U W=2.5U AS=1.1P AD=0.65P PS=5.88U
+ PD=3.02U
M$1176 VSS \$2785 \$2784 VSS nfet_06v0 L=1U W=2.5U AS=0.65P AD=0.65P PS=3.02U
+ PD=3.02U
M$1177 \$2784 \$2785 VSS VSS nfet_06v0 L=1U W=2.5U AS=0.65P AD=0.65P PS=3.02U
+ PD=3.02U
M$1178 VSS \$2785 \$2784 VSS nfet_06v0 L=1U W=2.5U AS=0.65P AD=1.1P PS=3.02U
+ PD=5.88U
M$1179 \$2786 \$2785 VSS VSS nfet_06v0 L=1U W=2.5U AS=1.1P AD=0.65P PS=5.88U
+ PD=3.02U
M$1180 VSS \$2785 \$2786 VSS nfet_06v0 L=1U W=2.5U AS=0.65P AD=0.65P PS=3.02U
+ PD=3.02U
M$1181 \$2786 \$2785 VSS VSS nfet_06v0 L=1U W=2.5U AS=0.65P AD=0.65P PS=3.02U
+ PD=3.02U
M$1182 VSS \$2785 \$2786 VSS nfet_06v0 L=1U W=2.5U AS=0.65P AD=1.1P PS=3.02U
+ PD=5.88U
M$1183 \$2931 \$2813 \$2785 VSS nfet_06v0 L=1U W=2.5U AS=1.1P AD=1.1P PS=5.88U
+ PD=5.88U
M$1184 \$2766 \$2813 \$2787 VSS nfet_06v0 L=1U W=2.5U AS=1.1P AD=1.1P PS=5.88U
+ PD=5.88U
M$1185 \$2828 \$2765 VSS VSS nfet_06v0 L=1U W=5U AS=2.2P AD=1.25P PS=10.88U
+ PD=5.5U
M$1186 \$2767 \$2780 \$2828 VSS nfet_06v0 L=1U W=5U AS=1.25P AD=2.2P PS=5.5U
+ PD=10.88U
M$1187 \$2829 \$2768 VSS VSS nfet_06v0 L=1U W=5U AS=2.2P AD=1.25P PS=10.88U
+ PD=5.5U
M$1188 \$2768 \$2780 \$2829 VSS nfet_06v0 L=1U W=5U AS=1.25P AD=1.65P PS=5.5U
+ PD=5.66U
M$1189 \$2813 \$2813 \$2768 VSS nfet_06v0 L=1U W=5U AS=1.65P AD=2.2P PS=5.66U
+ PD=10.88U
M$1190 \$2788 \$2787 VSS VSS nfet_06v0 L=1U W=5U AS=2.2P AD=1.3P PS=10.88U
+ PD=5.52U
M$1191 VSS \$2787 \$2788 VSS nfet_06v0 L=1U W=5U AS=1.3P AD=1.3P PS=5.52U
+ PD=5.52U
M$1192 \$2788 \$2787 VSS VSS nfet_06v0 L=1U W=5U AS=1.3P AD=2.2P PS=5.52U
+ PD=10.88U
M$1193 \$2789 \$2789 VSS VSS nfet_06v0 L=1U W=1U AS=0.44P AD=0.44P PS=2.88U
+ PD=2.88U
M$1194 \$2830 \$2769 VSS VSS nfet_06v0 L=1U W=5U AS=2.2P AD=1.25P PS=10.88U
+ PD=5.5U
M$1195 \$2769 \$2789 \$2830 VSS nfet_06v0 L=1U W=5U AS=1.25P AD=2.2P PS=5.5U
+ PD=10.88U
M$1196 \$2811 \$3392 VSS VSS nfet_06v0 L=1U W=1U AS=0.44P AD=0.25P PS=2.88U
+ PD=1.5U
M$1197 \$3313 \$3392 \$2811 VSS nfet_06v0 L=1U W=1U AS=0.25P AD=0.44P PS=1.5U
+ PD=2.88U
M$1198 \$2812 \$3392 VSS VSS nfet_06v0 L=1U W=1U AS=0.44P AD=0.25P PS=2.88U
+ PD=1.5U
M$1199 \$3392 \$3392 \$2812 VSS nfet_06v0 L=1U W=1U AS=0.25P AD=0.44P PS=1.5U
+ PD=2.88U
M$1200 \$2831 \$2769 VSS VSS nfet_06v0 L=1U W=5U AS=2.2P AD=1.25P PS=10.88U
+ PD=5.5U
M$1201 \$2790 \$2789 \$2831 VSS nfet_06v0 L=1U W=5U AS=1.25P AD=1.65P PS=5.5U
+ PD=5.66U
M$1202 \$2832 \$2789 \$2790 VSS nfet_06v0 L=1U W=5U AS=1.65P AD=1.25P PS=5.66U
+ PD=5.5U
M$1203 VSS \$2769 \$2832 VSS nfet_06v0 L=1U W=5U AS=1.25P AD=2.2P PS=5.5U
+ PD=10.88U
M$1204 \$2791 \$28 \$2790 VSS nfet_06v0 L=1U W=5U AS=2.2P AD=1.3P PS=10.88U
+ PD=5.52U
M$1205 \$2790 \$28 \$2791 VSS nfet_06v0 L=1U W=5U AS=1.3P AD=2.2P PS=5.52U
+ PD=10.88U
M$1206 \$2792 \$39 \$2790 VSS nfet_06v0 L=1U W=5U AS=2.2P AD=1.3P PS=10.88U
+ PD=5.52U
M$1207 \$2790 \$39 \$2792 VSS nfet_06v0 L=1U W=5U AS=1.3P AD=2.2P PS=5.52U
+ PD=10.88U
M$1208 \$2794 \$2789 \$2793 VSS nfet_06v0 L=1U W=2.5U AS=1.1P AD=0.65P PS=5.88U
+ PD=3.02U
M$1209 \$2793 \$2789 \$2794 VSS nfet_06v0 L=1U W=2.5U AS=0.65P AD=1.1P PS=3.02U
+ PD=5.88U
M$1210 \$2796 \$2789 \$2795 VSS nfet_06v0 L=1U W=2.5U AS=1.1P AD=0.65P PS=5.88U
+ PD=3.02U
M$1211 \$2795 \$2789 \$2796 VSS nfet_06v0 L=1U W=2.5U AS=0.65P AD=1.1P PS=3.02U
+ PD=5.88U
M$1212 \$2793 \$2794 VSS VSS nfet_06v0 L=1U W=2.5U AS=1.1P AD=0.65P PS=5.88U
+ PD=3.02U
M$1213 VSS \$2794 \$2793 VSS nfet_06v0 L=1U W=2.5U AS=0.65P AD=0.65P PS=3.02U
+ PD=3.02U
M$1214 \$2793 \$2794 VSS VSS nfet_06v0 L=1U W=2.5U AS=0.65P AD=0.65P PS=3.02U
+ PD=3.02U
M$1215 VSS \$2794 \$2793 VSS nfet_06v0 L=1U W=2.5U AS=0.65P AD=1.1P PS=3.02U
+ PD=5.88U
M$1216 \$2795 \$2794 VSS VSS nfet_06v0 L=1U W=2.5U AS=1.1P AD=0.65P PS=5.88U
+ PD=3.02U
M$1217 VSS \$2794 \$2795 VSS nfet_06v0 L=1U W=2.5U AS=0.65P AD=0.65P PS=3.02U
+ PD=3.02U
M$1218 \$2795 \$2794 VSS VSS nfet_06v0 L=1U W=2.5U AS=0.65P AD=0.65P PS=3.02U
+ PD=3.02U
M$1219 VSS \$2794 \$2795 VSS nfet_06v0 L=1U W=2.5U AS=0.65P AD=1.1P PS=3.02U
+ PD=5.88U
M$1220 \$2933 \$2814 \$2794 VSS nfet_06v0 L=1U W=2.5U AS=1.1P AD=1.1P PS=5.88U
+ PD=5.88U
M$1221 \$2770 \$2814 \$2796 VSS nfet_06v0 L=1U W=2.5U AS=1.1P AD=1.1P PS=5.88U
+ PD=5.88U
M$1222 \$2833 \$2769 VSS VSS nfet_06v0 L=1U W=5U AS=2.2P AD=1.25P PS=10.88U
+ PD=5.5U
M$1223 \$2771 \$2789 \$2833 VSS nfet_06v0 L=1U W=5U AS=1.25P AD=2.2P PS=5.5U
+ PD=10.88U
M$1224 \$2834 \$2772 VSS VSS nfet_06v0 L=1U W=5U AS=2.2P AD=1.25P PS=10.88U
+ PD=5.5U
M$1225 \$2772 \$2789 \$2834 VSS nfet_06v0 L=1U W=5U AS=1.25P AD=1.65P PS=5.5U
+ PD=5.66U
M$1226 \$2814 \$2814 \$2772 VSS nfet_06v0 L=1U W=5U AS=1.65P AD=2.2P PS=5.66U
+ PD=10.88U
M$1227 \$2797 \$2796 VSS VSS nfet_06v0 L=1U W=5U AS=2.2P AD=1.3P PS=10.88U
+ PD=5.52U
M$1228 VSS \$2796 \$2797 VSS nfet_06v0 L=1U W=5U AS=1.3P AD=1.3P PS=5.52U
+ PD=5.52U
M$1229 \$2797 \$2796 VSS VSS nfet_06v0 L=1U W=5U AS=1.3P AD=2.2P PS=5.52U
+ PD=10.88U
M$1230 \$2798 \$2798 VSS VSS nfet_06v0 L=1U W=1U AS=0.44P AD=0.44P PS=2.88U
+ PD=2.88U
M$1231 \$2837 \$2774 VSS VSS nfet_06v0 L=1U W=5U AS=2.2P AD=1.25P PS=10.88U
+ PD=5.5U
M$1232 \$2774 \$2798 \$2837 VSS nfet_06v0 L=1U W=5U AS=1.25P AD=2.2P PS=5.5U
+ PD=10.88U
M$1233 \$2810 \$3393 VSS VSS nfet_06v0 L=1U W=1U AS=0.44P AD=0.25P PS=2.88U
+ PD=1.5U
M$1234 \$3314 \$3393 \$2810 VSS nfet_06v0 L=1U W=1U AS=0.25P AD=0.44P PS=1.5U
+ PD=2.88U
M$1235 \$2809 \$3393 VSS VSS nfet_06v0 L=1U W=1U AS=0.44P AD=0.25P PS=2.88U
+ PD=1.5U
M$1236 \$3393 \$3393 \$2809 VSS nfet_06v0 L=1U W=1U AS=0.25P AD=0.44P PS=1.5U
+ PD=2.88U
M$1237 \$2838 \$2774 VSS VSS nfet_06v0 L=1U W=5U AS=2.2P AD=1.25P PS=10.88U
+ PD=5.5U
M$1238 \$2799 \$2798 \$2838 VSS nfet_06v0 L=1U W=5U AS=1.25P AD=1.65P PS=5.5U
+ PD=5.66U
M$1239 \$2839 \$2798 \$2799 VSS nfet_06v0 L=1U W=5U AS=1.65P AD=1.25P PS=5.66U
+ PD=5.5U
M$1240 VSS \$2774 \$2839 VSS nfet_06v0 L=1U W=5U AS=1.25P AD=2.2P PS=5.5U
+ PD=10.88U
M$1241 \$2800 \$28 \$2799 VSS nfet_06v0 L=1U W=5U AS=2.2P AD=1.3P PS=10.88U
+ PD=5.52U
M$1242 \$2799 \$28 \$2800 VSS nfet_06v0 L=1U W=5U AS=1.3P AD=2.2P PS=5.52U
+ PD=10.88U
M$1243 \$2801 \$17 \$2799 VSS nfet_06v0 L=1U W=5U AS=2.2P AD=1.3P PS=10.88U
+ PD=5.52U
M$1244 \$2799 \$17 \$2801 VSS nfet_06v0 L=1U W=5U AS=1.3P AD=2.2P PS=5.52U
+ PD=10.88U
M$1245 \$2803 \$2798 \$2802 VSS nfet_06v0 L=1U W=2.5U AS=1.1P AD=0.65P PS=5.88U
+ PD=3.02U
M$1246 \$2802 \$2798 \$2803 VSS nfet_06v0 L=1U W=2.5U AS=0.65P AD=1.1P PS=3.02U
+ PD=5.88U
M$1247 \$2805 \$2798 \$2804 VSS nfet_06v0 L=1U W=2.5U AS=1.1P AD=0.65P PS=5.88U
+ PD=3.02U
M$1248 \$2804 \$2798 \$2805 VSS nfet_06v0 L=1U W=2.5U AS=0.65P AD=1.1P PS=3.02U
+ PD=5.88U
M$1249 \$2802 \$2803 VSS VSS nfet_06v0 L=1U W=2.5U AS=1.1P AD=0.65P PS=5.88U
+ PD=3.02U
M$1250 VSS \$2803 \$2802 VSS nfet_06v0 L=1U W=2.5U AS=0.65P AD=0.65P PS=3.02U
+ PD=3.02U
M$1251 \$2802 \$2803 VSS VSS nfet_06v0 L=1U W=2.5U AS=0.65P AD=0.65P PS=3.02U
+ PD=3.02U
M$1252 VSS \$2803 \$2802 VSS nfet_06v0 L=1U W=2.5U AS=0.65P AD=1.1P PS=3.02U
+ PD=5.88U
M$1253 \$2804 \$2803 VSS VSS nfet_06v0 L=1U W=2.5U AS=1.1P AD=0.65P PS=5.88U
+ PD=3.02U
M$1254 VSS \$2803 \$2804 VSS nfet_06v0 L=1U W=2.5U AS=0.65P AD=0.65P PS=3.02U
+ PD=3.02U
M$1255 \$2804 \$2803 VSS VSS nfet_06v0 L=1U W=2.5U AS=0.65P AD=0.65P PS=3.02U
+ PD=3.02U
M$1256 VSS \$2803 \$2804 VSS nfet_06v0 L=1U W=2.5U AS=0.65P AD=1.1P PS=3.02U
+ PD=5.88U
M$1257 \$2935 \$2815 \$2803 VSS nfet_06v0 L=1U W=2.5U AS=1.1P AD=1.1P PS=5.88U
+ PD=5.88U
M$1258 \$2775 \$2815 \$2805 VSS nfet_06v0 L=1U W=2.5U AS=1.1P AD=1.1P PS=5.88U
+ PD=5.88U
M$1259 \$2836 \$2774 VSS VSS nfet_06v0 L=1U W=5U AS=2.2P AD=1.25P PS=10.88U
+ PD=5.5U
M$1260 \$2776 \$2798 \$2836 VSS nfet_06v0 L=1U W=5U AS=1.25P AD=2.2P PS=5.5U
+ PD=10.88U
M$1261 \$2835 \$2777 VSS VSS nfet_06v0 L=1U W=5U AS=2.2P AD=1.25P PS=10.88U
+ PD=5.5U
M$1262 \$2777 \$2798 \$2835 VSS nfet_06v0 L=1U W=5U AS=1.25P AD=1.65P PS=5.5U
+ PD=5.66U
M$1263 \$2815 \$2815 \$2777 VSS nfet_06v0 L=1U W=5U AS=1.65P AD=2.2P PS=5.66U
+ PD=10.88U
M$1264 \$2806 \$2805 VSS VSS nfet_06v0 L=1U W=5U AS=2.2P AD=1.3P PS=10.88U
+ PD=5.52U
M$1265 VSS \$2805 \$2806 VSS nfet_06v0 L=1U W=5U AS=1.3P AD=1.3P PS=5.52U
+ PD=5.52U
M$1266 \$2806 \$2805 VSS VSS nfet_06v0 L=1U W=5U AS=1.3P AD=2.2P PS=5.52U
+ PD=10.88U
M$1267 \$4567 \$4567 VSS VSS nfet_06v0 L=1U W=1U AS=0.44P AD=0.44P PS=2.88U
+ PD=2.88U
M$1268 \$4612 \$4552 VSS VSS nfet_06v0 L=1U W=5U AS=2.2P AD=1.25P PS=10.88U
+ PD=5.5U
M$1269 \$4552 \$4567 \$4612 VSS nfet_06v0 L=1U W=5U AS=1.25P AD=2.2P PS=5.5U
+ PD=10.88U
M$1270 \$4594 \$5179 VSS VSS nfet_06v0 L=1U W=1U AS=0.44P AD=0.25P PS=2.88U
+ PD=1.5U
M$1271 \$5101 \$5179 \$4594 VSS nfet_06v0 L=1U W=1U AS=0.25P AD=0.44P PS=1.5U
+ PD=2.88U
M$1272 \$4595 \$5179 VSS VSS nfet_06v0 L=1U W=1U AS=0.44P AD=0.25P PS=2.88U
+ PD=1.5U
M$1273 \$5179 \$5179 \$4595 VSS nfet_06v0 L=1U W=1U AS=0.25P AD=0.44P PS=1.5U
+ PD=2.88U
M$1274 \$4613 \$4552 VSS VSS nfet_06v0 L=1U W=5U AS=2.2P AD=1.25P PS=10.88U
+ PD=5.5U
M$1275 \$4568 \$4567 \$4613 VSS nfet_06v0 L=1U W=5U AS=1.25P AD=1.65P PS=5.5U
+ PD=5.66U
M$1276 \$4614 \$4567 \$4568 VSS nfet_06v0 L=1U W=5U AS=1.65P AD=1.25P PS=5.66U
+ PD=5.5U
M$1277 VSS \$4552 \$4614 VSS nfet_06v0 L=1U W=5U AS=1.25P AD=2.2P PS=5.5U
+ PD=10.88U
M$1278 \$4569 \$50 \$4568 VSS nfet_06v0 L=1U W=5U AS=2.2P AD=1.3P PS=10.88U
+ PD=5.52U
M$1279 \$4568 \$50 \$4569 VSS nfet_06v0 L=1U W=5U AS=1.3P AD=2.2P PS=5.52U
+ PD=10.88U
M$1280 \$4570 \$949 \$4568 VSS nfet_06v0 L=1U W=5U AS=2.2P AD=1.3P PS=10.88U
+ PD=5.52U
M$1281 \$4568 \$949 \$4570 VSS nfet_06v0 L=1U W=5U AS=1.3P AD=2.2P PS=5.52U
+ PD=10.88U
M$1282 \$4572 \$4567 \$4571 VSS nfet_06v0 L=1U W=2.5U AS=1.1P AD=0.65P PS=5.88U
+ PD=3.02U
M$1283 \$4571 \$4567 \$4572 VSS nfet_06v0 L=1U W=2.5U AS=0.65P AD=1.1P PS=3.02U
+ PD=5.88U
M$1284 \$4574 \$4567 \$4573 VSS nfet_06v0 L=1U W=2.5U AS=1.1P AD=0.65P PS=5.88U
+ PD=3.02U
M$1285 \$4573 \$4567 \$4574 VSS nfet_06v0 L=1U W=2.5U AS=0.65P AD=1.1P PS=3.02U
+ PD=5.88U
M$1286 \$4571 \$4572 VSS VSS nfet_06v0 L=1U W=2.5U AS=1.1P AD=0.65P PS=5.88U
+ PD=3.02U
M$1287 VSS \$4572 \$4571 VSS nfet_06v0 L=1U W=2.5U AS=0.65P AD=0.65P PS=3.02U
+ PD=3.02U
M$1288 \$4571 \$4572 VSS VSS nfet_06v0 L=1U W=2.5U AS=0.65P AD=0.65P PS=3.02U
+ PD=3.02U
M$1289 VSS \$4572 \$4571 VSS nfet_06v0 L=1U W=2.5U AS=0.65P AD=1.1P PS=3.02U
+ PD=5.88U
M$1290 \$4573 \$4572 VSS VSS nfet_06v0 L=1U W=2.5U AS=1.1P AD=0.65P PS=5.88U
+ PD=3.02U
M$1291 VSS \$4572 \$4573 VSS nfet_06v0 L=1U W=2.5U AS=0.65P AD=0.65P PS=3.02U
+ PD=3.02U
M$1292 \$4573 \$4572 VSS VSS nfet_06v0 L=1U W=2.5U AS=0.65P AD=0.65P PS=3.02U
+ PD=3.02U
M$1293 VSS \$4572 \$4573 VSS nfet_06v0 L=1U W=2.5U AS=0.65P AD=1.1P PS=3.02U
+ PD=5.88U
M$1294 \$4720 \$4600 \$4572 VSS nfet_06v0 L=1U W=2.5U AS=1.1P AD=1.1P PS=5.88U
+ PD=5.88U
M$1295 \$4553 \$4600 \$4574 VSS nfet_06v0 L=1U W=2.5U AS=1.1P AD=1.1P PS=5.88U
+ PD=5.88U
M$1296 \$4615 \$4552 VSS VSS nfet_06v0 L=1U W=5U AS=2.2P AD=1.25P PS=10.88U
+ PD=5.5U
M$1297 \$4554 \$4567 \$4615 VSS nfet_06v0 L=1U W=5U AS=1.25P AD=2.2P PS=5.5U
+ PD=10.88U
M$1298 \$4616 \$4555 VSS VSS nfet_06v0 L=1U W=5U AS=2.2P AD=1.25P PS=10.88U
+ PD=5.5U
M$1299 \$4555 \$4567 \$4616 VSS nfet_06v0 L=1U W=5U AS=1.25P AD=1.65P PS=5.5U
+ PD=5.66U
M$1300 \$4600 \$4600 \$4555 VSS nfet_06v0 L=1U W=5U AS=1.65P AD=2.2P PS=5.66U
+ PD=10.88U
M$1301 \$4575 \$4574 VSS VSS nfet_06v0 L=1U W=5U AS=2.2P AD=1.3P PS=10.88U
+ PD=5.52U
M$1302 VSS \$4574 \$4575 VSS nfet_06v0 L=1U W=5U AS=1.3P AD=1.3P PS=5.52U
+ PD=5.52U
M$1303 \$4575 \$4574 VSS VSS nfet_06v0 L=1U W=5U AS=1.3P AD=2.2P PS=5.52U
+ PD=10.88U
M$1304 \$4576 \$4576 VSS VSS nfet_06v0 L=1U W=1U AS=0.44P AD=0.44P PS=2.88U
+ PD=2.88U
M$1305 \$4618 \$4557 VSS VSS nfet_06v0 L=1U W=5U AS=2.2P AD=1.25P PS=10.88U
+ PD=5.5U
M$1306 \$4557 \$4576 \$4618 VSS nfet_06v0 L=1U W=5U AS=1.25P AD=2.2P PS=5.5U
+ PD=10.88U
M$1307 \$4598 \$5180 VSS VSS nfet_06v0 L=1U W=1U AS=0.44P AD=0.25P PS=2.88U
+ PD=1.5U
M$1308 \$5102 \$5180 \$4598 VSS nfet_06v0 L=1U W=1U AS=0.25P AD=0.44P PS=1.5U
+ PD=2.88U
M$1309 \$4599 \$5180 VSS VSS nfet_06v0 L=1U W=1U AS=0.44P AD=0.25P PS=2.88U
+ PD=1.5U
M$1310 \$5180 \$5180 \$4599 VSS nfet_06v0 L=1U W=1U AS=0.25P AD=0.44P PS=1.5U
+ PD=2.88U
M$1311 \$4619 \$4557 VSS VSS nfet_06v0 L=1U W=5U AS=2.2P AD=1.25P PS=10.88U
+ PD=5.5U
M$1312 \$4577 \$4576 \$4619 VSS nfet_06v0 L=1U W=5U AS=1.25P AD=1.65P PS=5.5U
+ PD=5.66U
M$1313 \$4621 \$4576 \$4577 VSS nfet_06v0 L=1U W=5U AS=1.65P AD=1.25P PS=5.66U
+ PD=5.5U
M$1314 VSS \$4557 \$4621 VSS nfet_06v0 L=1U W=5U AS=1.25P AD=2.2P PS=5.5U
+ PD=10.88U
M$1315 \$4578 \$938 \$4577 VSS nfet_06v0 L=1U W=5U AS=2.2P AD=1.3P PS=10.88U
+ PD=5.52U
M$1316 \$4577 \$938 \$4578 VSS nfet_06v0 L=1U W=5U AS=1.3P AD=2.2P PS=5.52U
+ PD=10.88U
M$1317 \$4579 \$949 \$4577 VSS nfet_06v0 L=1U W=5U AS=2.2P AD=1.3P PS=10.88U
+ PD=5.52U
M$1318 \$4577 \$949 \$4579 VSS nfet_06v0 L=1U W=5U AS=1.3P AD=2.2P PS=5.52U
+ PD=10.88U
M$1319 \$4581 \$4576 \$4580 VSS nfet_06v0 L=1U W=2.5U AS=1.1P AD=0.65P PS=5.88U
+ PD=3.02U
M$1320 \$4580 \$4576 \$4581 VSS nfet_06v0 L=1U W=2.5U AS=0.65P AD=1.1P PS=3.02U
+ PD=5.88U
M$1321 \$4583 \$4576 \$4582 VSS nfet_06v0 L=1U W=2.5U AS=1.1P AD=0.65P PS=5.88U
+ PD=3.02U
M$1322 \$4582 \$4576 \$4583 VSS nfet_06v0 L=1U W=2.5U AS=0.65P AD=1.1P PS=3.02U
+ PD=5.88U
M$1323 \$4580 \$4581 VSS VSS nfet_06v0 L=1U W=2.5U AS=1.1P AD=0.65P PS=5.88U
+ PD=3.02U
M$1324 VSS \$4581 \$4580 VSS nfet_06v0 L=1U W=2.5U AS=0.65P AD=0.65P PS=3.02U
+ PD=3.02U
M$1325 \$4580 \$4581 VSS VSS nfet_06v0 L=1U W=2.5U AS=0.65P AD=0.65P PS=3.02U
+ PD=3.02U
M$1326 VSS \$4581 \$4580 VSS nfet_06v0 L=1U W=2.5U AS=0.65P AD=1.1P PS=3.02U
+ PD=5.88U
M$1327 \$4582 \$4581 VSS VSS nfet_06v0 L=1U W=2.5U AS=1.1P AD=0.65P PS=5.88U
+ PD=3.02U
M$1328 VSS \$4581 \$4582 VSS nfet_06v0 L=1U W=2.5U AS=0.65P AD=0.65P PS=3.02U
+ PD=3.02U
M$1329 \$4582 \$4581 VSS VSS nfet_06v0 L=1U W=2.5U AS=0.65P AD=0.65P PS=3.02U
+ PD=3.02U
M$1330 VSS \$4581 \$4582 VSS nfet_06v0 L=1U W=2.5U AS=0.65P AD=1.1P PS=3.02U
+ PD=5.88U
M$1331 \$4722 \$4601 \$4581 VSS nfet_06v0 L=1U W=2.5U AS=1.1P AD=1.1P PS=5.88U
+ PD=5.88U
M$1332 \$4558 \$4601 \$4583 VSS nfet_06v0 L=1U W=2.5U AS=1.1P AD=1.1P PS=5.88U
+ PD=5.88U
M$1333 \$4622 \$4557 VSS VSS nfet_06v0 L=1U W=5U AS=2.2P AD=1.25P PS=10.88U
+ PD=5.5U
M$1334 \$4559 \$4576 \$4622 VSS nfet_06v0 L=1U W=5U AS=1.25P AD=2.2P PS=5.5U
+ PD=10.88U
M$1335 \$4623 \$4560 VSS VSS nfet_06v0 L=1U W=5U AS=2.2P AD=1.25P PS=10.88U
+ PD=5.5U
M$1336 \$4560 \$4576 \$4623 VSS nfet_06v0 L=1U W=5U AS=1.25P AD=1.65P PS=5.5U
+ PD=5.66U
M$1337 \$4601 \$4601 \$4560 VSS nfet_06v0 L=1U W=5U AS=1.65P AD=2.2P PS=5.66U
+ PD=10.88U
M$1338 \$4584 \$4583 VSS VSS nfet_06v0 L=1U W=5U AS=2.2P AD=1.3P PS=10.88U
+ PD=5.52U
M$1339 VSS \$4583 \$4584 VSS nfet_06v0 L=1U W=5U AS=1.3P AD=1.3P PS=5.52U
+ PD=5.52U
M$1340 \$4584 \$4583 VSS VSS nfet_06v0 L=1U W=5U AS=1.3P AD=2.2P PS=5.52U
+ PD=10.88U
M$1341 \$4585 \$4585 VSS VSS nfet_06v0 L=1U W=1U AS=0.44P AD=0.44P PS=2.88U
+ PD=2.88U
M$1342 \$4624 \$4561 VSS VSS nfet_06v0 L=1U W=5U AS=2.2P AD=1.25P PS=10.88U
+ PD=5.5U
M$1343 \$4561 \$4585 \$4624 VSS nfet_06v0 L=1U W=5U AS=1.25P AD=2.2P PS=5.5U
+ PD=10.88U
M$1344 \$4597 \$5181 VSS VSS nfet_06v0 L=1U W=1U AS=0.44P AD=0.25P PS=2.88U
+ PD=1.5U
M$1345 \$5103 \$5181 \$4597 VSS nfet_06v0 L=1U W=1U AS=0.25P AD=0.44P PS=1.5U
+ PD=2.88U
M$1346 \$4596 \$5181 VSS VSS nfet_06v0 L=1U W=1U AS=0.44P AD=0.25P PS=2.88U
+ PD=1.5U
M$1347 \$5181 \$5181 \$4596 VSS nfet_06v0 L=1U W=1U AS=0.25P AD=0.44P PS=1.5U
+ PD=2.88U
M$1348 \$4625 \$4561 VSS VSS nfet_06v0 L=1U W=5U AS=2.2P AD=1.25P PS=10.88U
+ PD=5.5U
M$1349 \$4586 \$4585 \$4625 VSS nfet_06v0 L=1U W=5U AS=1.25P AD=1.65P PS=5.5U
+ PD=5.66U
M$1350 \$4626 \$4585 \$4586 VSS nfet_06v0 L=1U W=5U AS=1.65P AD=1.25P PS=5.66U
+ PD=5.5U
M$1351 VSS \$4561 \$4626 VSS nfet_06v0 L=1U W=5U AS=1.25P AD=2.2P PS=5.5U
+ PD=10.88U
M$1352 \$4587 \$938 \$4586 VSS nfet_06v0 L=1U W=5U AS=2.2P AD=1.3P PS=10.88U
+ PD=5.52U
M$1353 \$4586 \$938 \$4587 VSS nfet_06v0 L=1U W=5U AS=1.3P AD=2.2P PS=5.52U
+ PD=10.88U
M$1354 \$4588 \$50 \$4586 VSS nfet_06v0 L=1U W=5U AS=2.2P AD=1.3P PS=10.88U
+ PD=5.52U
M$1355 \$4586 \$50 \$4588 VSS nfet_06v0 L=1U W=5U AS=1.3P AD=2.2P PS=5.52U
+ PD=10.88U
M$1356 \$4590 \$4585 \$4589 VSS nfet_06v0 L=1U W=2.5U AS=1.1P AD=0.65P PS=5.88U
+ PD=3.02U
M$1357 \$4589 \$4585 \$4590 VSS nfet_06v0 L=1U W=2.5U AS=0.65P AD=1.1P PS=3.02U
+ PD=5.88U
M$1358 \$4592 \$4585 \$4591 VSS nfet_06v0 L=1U W=2.5U AS=1.1P AD=0.65P PS=5.88U
+ PD=3.02U
M$1359 \$4591 \$4585 \$4592 VSS nfet_06v0 L=1U W=2.5U AS=0.65P AD=1.1P PS=3.02U
+ PD=5.88U
M$1360 \$4589 \$4590 VSS VSS nfet_06v0 L=1U W=2.5U AS=1.1P AD=0.65P PS=5.88U
+ PD=3.02U
M$1361 VSS \$4590 \$4589 VSS nfet_06v0 L=1U W=2.5U AS=0.65P AD=0.65P PS=3.02U
+ PD=3.02U
M$1362 \$4589 \$4590 VSS VSS nfet_06v0 L=1U W=2.5U AS=0.65P AD=0.65P PS=3.02U
+ PD=3.02U
M$1363 VSS \$4590 \$4589 VSS nfet_06v0 L=1U W=2.5U AS=0.65P AD=1.1P PS=3.02U
+ PD=5.88U
M$1364 \$4591 \$4590 VSS VSS nfet_06v0 L=1U W=2.5U AS=1.1P AD=0.65P PS=5.88U
+ PD=3.02U
M$1365 VSS \$4590 \$4591 VSS nfet_06v0 L=1U W=2.5U AS=0.65P AD=0.65P PS=3.02U
+ PD=3.02U
M$1366 \$4591 \$4590 VSS VSS nfet_06v0 L=1U W=2.5U AS=0.65P AD=0.65P PS=3.02U
+ PD=3.02U
M$1367 VSS \$4590 \$4591 VSS nfet_06v0 L=1U W=2.5U AS=0.65P AD=1.1P PS=3.02U
+ PD=5.88U
M$1368 \$4724 \$4602 \$4590 VSS nfet_06v0 L=1U W=2.5U AS=1.1P AD=1.1P PS=5.88U
+ PD=5.88U
M$1369 \$4562 \$4602 \$4592 VSS nfet_06v0 L=1U W=2.5U AS=1.1P AD=1.1P PS=5.88U
+ PD=5.88U
M$1370 \$4620 \$4561 VSS VSS nfet_06v0 L=1U W=5U AS=2.2P AD=1.25P PS=10.88U
+ PD=5.5U
M$1371 \$4563 \$4585 \$4620 VSS nfet_06v0 L=1U W=5U AS=1.25P AD=2.2P PS=5.5U
+ PD=10.88U
M$1372 \$4617 \$4564 VSS VSS nfet_06v0 L=1U W=5U AS=2.2P AD=1.25P PS=10.88U
+ PD=5.5U
M$1373 \$4564 \$4585 \$4617 VSS nfet_06v0 L=1U W=5U AS=1.25P AD=1.65P PS=5.5U
+ PD=5.66U
M$1374 \$4602 \$4602 \$4564 VSS nfet_06v0 L=1U W=5U AS=1.65P AD=2.2P PS=5.66U
+ PD=10.88U
M$1375 \$4593 \$4592 VSS VSS nfet_06v0 L=1U W=5U AS=2.2P AD=1.3P PS=10.88U
+ PD=5.52U
M$1376 VSS \$4592 \$4593 VSS nfet_06v0 L=1U W=5U AS=1.3P AD=1.3P PS=5.52U
+ PD=5.52U
M$1377 \$4593 \$4592 VSS VSS nfet_06v0 L=1U W=5U AS=1.3P AD=2.2P PS=5.52U
+ PD=10.88U
M$1378 X \$2840 \$2850 VSS nfet_06v0 L=1U W=2.48U AS=1.0912P AD=0.6448P
+ PS=5.84U PD=3U
M$1379 \$2850 \$2840 X VSS nfet_06v0 L=1U W=2.48U AS=0.6448P AD=1.0912P PS=3U
+ PD=5.84U
M$1380 X \$2773 \$2763 VSS nfet_06v0 L=1U W=2.48U AS=1.0912P AD=0.6448P
+ PS=5.84U PD=3U
M$1381 \$2763 \$2773 X VSS nfet_06v0 L=1U W=2.48U AS=0.6448P AD=1.0912P PS=3U
+ PD=5.84U
M$1382 X \$3394 \$2852 VSS nfet_06v0 L=1U W=2.48U AS=1.0912P AD=0.6448P
+ PS=5.84U PD=3U
M$1383 \$2852 \$3394 X VSS nfet_06v0 L=1U W=2.48U AS=0.6448P AD=1.0912P PS=3U
+ PD=5.84U
M$1384 \$2763 \$2778 VSS VSS nfet_06v0 L=1U W=1.24U AS=0.5456P AD=0.5456P
+ PS=3.36U PD=3.36U
M$1385 \$2850 \$2778 VSS VSS nfet_06v0 L=1U W=1.24U AS=0.5456P AD=0.5456P
+ PS=3.36U PD=3.36U
M$1386 \$2852 \$2778 VSS VSS nfet_06v0 L=1U W=1.24U AS=0.5456P AD=0.5456P
+ PS=3.36U PD=3.36U
M$1387 \$2818 \$2778 VSS VSS nfet_06v0 L=1U W=0.7U AS=0.308P AD=0.175P PS=2.28U
+ PD=1.2U
M$1388 \$2817 \$2778 \$2818 VSS nfet_06v0 L=1U W=0.7U AS=0.175P AD=0.175P
+ PS=1.2U PD=1.2U
M$1389 \$2816 \$2778 \$2817 VSS nfet_06v0 L=1U W=0.7U AS=0.175P AD=0.175P
+ PS=1.2U PD=1.2U
M$1390 \$2778 \$2778 \$2816 VSS nfet_06v0 L=1U W=0.7U AS=0.175P AD=0.308P
+ PS=1.2U PD=2.28U
M$1391 X X \$2853 VSS nfet_06v0 L=1U W=2U AS=0.88P AD=0.52P PS=4.88U PD=2.52U
M$1392 \$2853 X X VSS nfet_06v0 L=1U W=2U AS=0.52P AD=0.88P PS=2.52U PD=4.88U
M$1393 \$2936 X VSS VSS nfet_06v0 L=1U W=2U AS=0.88P AD=0.5P PS=4.88U PD=2.5U
M$1394 \$2853 X \$2936 VSS nfet_06v0 L=1U W=2U AS=0.5P AD=0.88P PS=2.5U PD=4.88U
M$1395 X \$3315 \$2854 VSS nfet_06v0 L=1U W=2.48U AS=1.0912P AD=0.6448P
+ PS=5.84U PD=3U
M$1396 \$2854 \$3315 X VSS nfet_06v0 L=1U W=2.48U AS=0.6448P AD=1.0912P PS=3U
+ PD=5.84U
M$1397 \$2854 \$2778 VSS VSS nfet_06v0 L=1U W=1.24U AS=0.5456P AD=0.5456P
+ PS=3.36U PD=3.36U
M$1398 \$6354 \$6354 VSS VSS nfet_06v0 L=1U W=1U AS=0.44P AD=0.44P PS=2.88U
+ PD=2.88U
M$1399 \$6399 \$6339 VSS VSS nfet_06v0 L=1U W=5U AS=2.2P AD=1.25P PS=10.88U
+ PD=5.5U
M$1400 \$6339 \$6354 \$6399 VSS nfet_06v0 L=1U W=5U AS=1.25P AD=2.2P PS=5.5U
+ PD=10.88U
M$1401 \$6381 \$6965 VSS VSS nfet_06v0 L=1U W=1U AS=0.44P AD=0.25P PS=2.88U
+ PD=1.5U
M$1402 \$6887 \$6965 \$6381 VSS nfet_06v0 L=1U W=1U AS=0.25P AD=0.44P PS=1.5U
+ PD=2.88U
M$1403 \$6382 \$6965 VSS VSS nfet_06v0 L=1U W=1U AS=0.44P AD=0.25P PS=2.88U
+ PD=1.5U
M$1404 \$6965 \$6965 \$6382 VSS nfet_06v0 L=1U W=1U AS=0.25P AD=0.44P PS=1.5U
+ PD=2.88U
M$1405 \$6400 \$6339 VSS VSS nfet_06v0 L=1U W=5U AS=2.2P AD=1.25P PS=10.88U
+ PD=5.5U
M$1406 \$6355 \$6354 \$6400 VSS nfet_06v0 L=1U W=5U AS=1.25P AD=1.65P PS=5.5U
+ PD=5.66U
M$1407 \$6401 \$6354 \$6355 VSS nfet_06v0 L=1U W=5U AS=1.65P AD=1.25P PS=5.66U
+ PD=5.5U
M$1408 VSS \$6339 \$6401 VSS nfet_06v0 L=1U W=5U AS=1.25P AD=2.2P PS=5.5U
+ PD=10.88U
M$1409 \$6356 \$960 \$6355 VSS nfet_06v0 L=1U W=5U AS=2.2P AD=1.3P PS=10.88U
+ PD=5.52U
M$1410 \$6355 \$960 \$6356 VSS nfet_06v0 L=1U W=5U AS=1.3P AD=2.2P PS=5.52U
+ PD=10.88U
M$1411 \$6357 \$1856 \$6355 VSS nfet_06v0 L=1U W=5U AS=2.2P AD=1.3P PS=10.88U
+ PD=5.52U
M$1412 \$6355 \$1856 \$6357 VSS nfet_06v0 L=1U W=5U AS=1.3P AD=2.2P PS=5.52U
+ PD=10.88U
M$1413 \$6359 \$6354 \$6358 VSS nfet_06v0 L=1U W=2.5U AS=1.1P AD=0.65P PS=5.88U
+ PD=3.02U
M$1414 \$6358 \$6354 \$6359 VSS nfet_06v0 L=1U W=2.5U AS=0.65P AD=1.1P PS=3.02U
+ PD=5.88U
M$1415 \$6361 \$6354 \$6360 VSS nfet_06v0 L=1U W=2.5U AS=1.1P AD=0.65P PS=5.88U
+ PD=3.02U
M$1416 \$6360 \$6354 \$6361 VSS nfet_06v0 L=1U W=2.5U AS=0.65P AD=1.1P PS=3.02U
+ PD=5.88U
M$1417 \$6358 \$6359 VSS VSS nfet_06v0 L=1U W=2.5U AS=1.1P AD=0.65P PS=5.88U
+ PD=3.02U
M$1418 VSS \$6359 \$6358 VSS nfet_06v0 L=1U W=2.5U AS=0.65P AD=0.65P PS=3.02U
+ PD=3.02U
M$1419 \$6358 \$6359 VSS VSS nfet_06v0 L=1U W=2.5U AS=0.65P AD=0.65P PS=3.02U
+ PD=3.02U
M$1420 VSS \$6359 \$6358 VSS nfet_06v0 L=1U W=2.5U AS=0.65P AD=1.1P PS=3.02U
+ PD=5.88U
M$1421 \$6360 \$6359 VSS VSS nfet_06v0 L=1U W=2.5U AS=1.1P AD=0.65P PS=5.88U
+ PD=3.02U
M$1422 VSS \$6359 \$6360 VSS nfet_06v0 L=1U W=2.5U AS=0.65P AD=0.65P PS=3.02U
+ PD=3.02U
M$1423 \$6360 \$6359 VSS VSS nfet_06v0 L=1U W=2.5U AS=0.65P AD=0.65P PS=3.02U
+ PD=3.02U
M$1424 VSS \$6359 \$6360 VSS nfet_06v0 L=1U W=2.5U AS=0.65P AD=1.1P PS=3.02U
+ PD=5.88U
M$1425 \$6506 \$6387 \$6359 VSS nfet_06v0 L=1U W=2.5U AS=1.1P AD=1.1P PS=5.88U
+ PD=5.88U
M$1426 \$6340 \$6387 \$6361 VSS nfet_06v0 L=1U W=2.5U AS=1.1P AD=1.1P PS=5.88U
+ PD=5.88U
M$1427 \$6402 \$6339 VSS VSS nfet_06v0 L=1U W=5U AS=2.2P AD=1.25P PS=10.88U
+ PD=5.5U
M$1428 \$6341 \$6354 \$6402 VSS nfet_06v0 L=1U W=5U AS=1.25P AD=2.2P PS=5.5U
+ PD=10.88U
M$1429 \$6403 \$6342 VSS VSS nfet_06v0 L=1U W=5U AS=2.2P AD=1.25P PS=10.88U
+ PD=5.5U
M$1430 \$6342 \$6354 \$6403 VSS nfet_06v0 L=1U W=5U AS=1.25P AD=1.65P PS=5.5U
+ PD=5.66U
M$1431 \$6387 \$6387 \$6342 VSS nfet_06v0 L=1U W=5U AS=1.65P AD=2.2P PS=5.66U
+ PD=10.88U
M$1432 \$6362 \$6361 VSS VSS nfet_06v0 L=1U W=5U AS=2.2P AD=1.3P PS=10.88U
+ PD=5.52U
M$1433 VSS \$6361 \$6362 VSS nfet_06v0 L=1U W=5U AS=1.3P AD=1.3P PS=5.52U
+ PD=5.52U
M$1434 \$6362 \$6361 VSS VSS nfet_06v0 L=1U W=5U AS=1.3P AD=2.2P PS=5.52U
+ PD=10.88U
M$1435 \$6363 \$6363 VSS VSS nfet_06v0 L=1U W=1U AS=0.44P AD=0.44P PS=2.88U
+ PD=2.88U
M$1436 \$6405 \$6343 VSS VSS nfet_06v0 L=1U W=5U AS=2.2P AD=1.25P PS=10.88U
+ PD=5.5U
M$1437 \$6343 \$6363 \$6405 VSS nfet_06v0 L=1U W=5U AS=1.25P AD=2.2P PS=5.5U
+ PD=10.88U
M$1438 \$6385 \$6966 VSS VSS nfet_06v0 L=1U W=1U AS=0.44P AD=0.25P PS=2.88U
+ PD=1.5U
M$1439 \$6888 \$6966 \$6385 VSS nfet_06v0 L=1U W=1U AS=0.25P AD=0.44P PS=1.5U
+ PD=2.88U
M$1440 \$6386 \$6966 VSS VSS nfet_06v0 L=1U W=1U AS=0.44P AD=0.25P PS=2.88U
+ PD=1.5U
M$1441 \$6966 \$6966 \$6386 VSS nfet_06v0 L=1U W=1U AS=0.25P AD=0.44P PS=1.5U
+ PD=2.88U
M$1442 \$6407 \$6343 VSS VSS nfet_06v0 L=1U W=5U AS=2.2P AD=1.25P PS=10.88U
+ PD=5.5U
M$1443 \$6364 \$6363 \$6407 VSS nfet_06v0 L=1U W=5U AS=1.25P AD=1.65P PS=5.5U
+ PD=5.66U
M$1444 \$6408 \$6363 \$6364 VSS nfet_06v0 L=1U W=5U AS=1.65P AD=1.25P PS=5.66U
+ PD=5.5U
M$1445 VSS \$6343 \$6408 VSS nfet_06v0 L=1U W=5U AS=1.25P AD=2.2P PS=5.5U
+ PD=10.88U
M$1446 \$6365 \$971 \$6364 VSS nfet_06v0 L=1U W=5U AS=2.2P AD=1.3P PS=10.88U
+ PD=5.52U
M$1447 \$6364 \$971 \$6365 VSS nfet_06v0 L=1U W=5U AS=1.3P AD=2.2P PS=5.52U
+ PD=10.88U
M$1448 \$6366 \$1856 \$6364 VSS nfet_06v0 L=1U W=5U AS=2.2P AD=1.3P PS=10.88U
+ PD=5.52U
M$1449 \$6364 \$1856 \$6366 VSS nfet_06v0 L=1U W=5U AS=1.3P AD=2.2P PS=5.52U
+ PD=10.88U
M$1450 \$6368 \$6363 \$6367 VSS nfet_06v0 L=1U W=2.5U AS=1.1P AD=0.65P PS=5.88U
+ PD=3.02U
M$1451 \$6367 \$6363 \$6368 VSS nfet_06v0 L=1U W=2.5U AS=0.65P AD=1.1P PS=3.02U
+ PD=5.88U
M$1452 \$6370 \$6363 \$6369 VSS nfet_06v0 L=1U W=2.5U AS=1.1P AD=0.65P PS=5.88U
+ PD=3.02U
M$1453 \$6369 \$6363 \$6370 VSS nfet_06v0 L=1U W=2.5U AS=0.65P AD=1.1P PS=3.02U
+ PD=5.88U
M$1454 \$6367 \$6368 VSS VSS nfet_06v0 L=1U W=2.5U AS=1.1P AD=0.65P PS=5.88U
+ PD=3.02U
M$1455 VSS \$6368 \$6367 VSS nfet_06v0 L=1U W=2.5U AS=0.65P AD=0.65P PS=3.02U
+ PD=3.02U
M$1456 \$6367 \$6368 VSS VSS nfet_06v0 L=1U W=2.5U AS=0.65P AD=0.65P PS=3.02U
+ PD=3.02U
M$1457 VSS \$6368 \$6367 VSS nfet_06v0 L=1U W=2.5U AS=0.65P AD=1.1P PS=3.02U
+ PD=5.88U
M$1458 \$6369 \$6368 VSS VSS nfet_06v0 L=1U W=2.5U AS=1.1P AD=0.65P PS=5.88U
+ PD=3.02U
M$1459 VSS \$6368 \$6369 VSS nfet_06v0 L=1U W=2.5U AS=0.65P AD=0.65P PS=3.02U
+ PD=3.02U
M$1460 \$6369 \$6368 VSS VSS nfet_06v0 L=1U W=2.5U AS=0.65P AD=0.65P PS=3.02U
+ PD=3.02U
M$1461 VSS \$6368 \$6369 VSS nfet_06v0 L=1U W=2.5U AS=0.65P AD=1.1P PS=3.02U
+ PD=5.88U
M$1462 \$6508 \$6388 \$6368 VSS nfet_06v0 L=1U W=2.5U AS=1.1P AD=1.1P PS=5.88U
+ PD=5.88U
M$1463 \$6344 \$6388 \$6370 VSS nfet_06v0 L=1U W=2.5U AS=1.1P AD=1.1P PS=5.88U
+ PD=5.88U
M$1464 \$6409 \$6343 VSS VSS nfet_06v0 L=1U W=5U AS=2.2P AD=1.25P PS=10.88U
+ PD=5.5U
M$1465 \$6345 \$6363 \$6409 VSS nfet_06v0 L=1U W=5U AS=1.25P AD=2.2P PS=5.5U
+ PD=10.88U
M$1466 \$6410 \$6346 VSS VSS nfet_06v0 L=1U W=5U AS=2.2P AD=1.25P PS=10.88U
+ PD=5.5U
M$1467 \$6346 \$6363 \$6410 VSS nfet_06v0 L=1U W=5U AS=1.25P AD=1.65P PS=5.5U
+ PD=5.66U
M$1468 \$6388 \$6388 \$6346 VSS nfet_06v0 L=1U W=5U AS=1.65P AD=2.2P PS=5.66U
+ PD=10.88U
M$1469 \$6371 \$6370 VSS VSS nfet_06v0 L=1U W=5U AS=2.2P AD=1.3P PS=10.88U
+ PD=5.52U
M$1470 VSS \$6370 \$6371 VSS nfet_06v0 L=1U W=5U AS=1.3P AD=1.3P PS=5.52U
+ PD=5.52U
M$1471 \$6371 \$6370 VSS VSS nfet_06v0 L=1U W=5U AS=1.3P AD=2.2P PS=5.52U
+ PD=10.88U
M$1472 \$6372 \$6372 VSS VSS nfet_06v0 L=1U W=1U AS=0.44P AD=0.44P PS=2.88U
+ PD=2.88U
M$1473 \$6411 \$6348 VSS VSS nfet_06v0 L=1U W=5U AS=2.2P AD=1.25P PS=10.88U
+ PD=5.5U
M$1474 \$6348 \$6372 \$6411 VSS nfet_06v0 L=1U W=5U AS=1.25P AD=2.2P PS=5.5U
+ PD=10.88U
M$1475 \$6384 \$6967 VSS VSS nfet_06v0 L=1U W=1U AS=0.44P AD=0.25P PS=2.88U
+ PD=1.5U
M$1476 \$6889 \$6967 \$6384 VSS nfet_06v0 L=1U W=1U AS=0.25P AD=0.44P PS=1.5U
+ PD=2.88U
M$1477 \$6383 \$6967 VSS VSS nfet_06v0 L=1U W=1U AS=0.44P AD=0.25P PS=2.88U
+ PD=1.5U
M$1478 \$6967 \$6967 \$6383 VSS nfet_06v0 L=1U W=1U AS=0.25P AD=0.44P PS=1.5U
+ PD=2.88U
M$1479 \$6412 \$6348 VSS VSS nfet_06v0 L=1U W=5U AS=2.2P AD=1.25P PS=10.88U
+ PD=5.5U
M$1480 \$6373 \$6372 \$6412 VSS nfet_06v0 L=1U W=5U AS=1.25P AD=1.65P PS=5.5U
+ PD=5.66U
M$1481 \$6413 \$6372 \$6373 VSS nfet_06v0 L=1U W=5U AS=1.65P AD=1.25P PS=5.66U
+ PD=5.5U
M$1482 VSS \$6348 \$6413 VSS nfet_06v0 L=1U W=5U AS=1.25P AD=2.2P PS=5.5U
+ PD=10.88U
M$1483 \$6374 \$971 \$6373 VSS nfet_06v0 L=1U W=5U AS=2.2P AD=1.3P PS=10.88U
+ PD=5.52U
M$1484 \$6373 \$971 \$6374 VSS nfet_06v0 L=1U W=5U AS=1.3P AD=2.2P PS=5.52U
+ PD=10.88U
M$1485 \$6375 \$960 \$6373 VSS nfet_06v0 L=1U W=5U AS=2.2P AD=1.3P PS=10.88U
+ PD=5.52U
M$1486 \$6373 \$960 \$6375 VSS nfet_06v0 L=1U W=5U AS=1.3P AD=2.2P PS=5.52U
+ PD=10.88U
M$1487 \$6377 \$6372 \$6376 VSS nfet_06v0 L=1U W=2.5U AS=1.1P AD=0.65P PS=5.88U
+ PD=3.02U
M$1488 \$6376 \$6372 \$6377 VSS nfet_06v0 L=1U W=2.5U AS=0.65P AD=1.1P PS=3.02U
+ PD=5.88U
M$1489 \$6379 \$6372 \$6378 VSS nfet_06v0 L=1U W=2.5U AS=1.1P AD=0.65P PS=5.88U
+ PD=3.02U
M$1490 \$6378 \$6372 \$6379 VSS nfet_06v0 L=1U W=2.5U AS=0.65P AD=1.1P PS=3.02U
+ PD=5.88U
M$1491 \$6376 \$6377 VSS VSS nfet_06v0 L=1U W=2.5U AS=1.1P AD=0.65P PS=5.88U
+ PD=3.02U
M$1492 VSS \$6377 \$6376 VSS nfet_06v0 L=1U W=2.5U AS=0.65P AD=0.65P PS=3.02U
+ PD=3.02U
M$1493 \$6376 \$6377 VSS VSS nfet_06v0 L=1U W=2.5U AS=0.65P AD=0.65P PS=3.02U
+ PD=3.02U
M$1494 VSS \$6377 \$6376 VSS nfet_06v0 L=1U W=2.5U AS=0.65P AD=1.1P PS=3.02U
+ PD=5.88U
M$1495 \$6378 \$6377 VSS VSS nfet_06v0 L=1U W=2.5U AS=1.1P AD=0.65P PS=5.88U
+ PD=3.02U
M$1496 VSS \$6377 \$6378 VSS nfet_06v0 L=1U W=2.5U AS=0.65P AD=0.65P PS=3.02U
+ PD=3.02U
M$1497 \$6378 \$6377 VSS VSS nfet_06v0 L=1U W=2.5U AS=0.65P AD=0.65P PS=3.02U
+ PD=3.02U
M$1498 VSS \$6377 \$6378 VSS nfet_06v0 L=1U W=2.5U AS=0.65P AD=1.1P PS=3.02U
+ PD=5.88U
M$1499 \$6510 \$6389 \$6377 VSS nfet_06v0 L=1U W=2.5U AS=1.1P AD=1.1P PS=5.88U
+ PD=5.88U
M$1500 \$6349 \$6389 \$6379 VSS nfet_06v0 L=1U W=2.5U AS=1.1P AD=1.1P PS=5.88U
+ PD=5.88U
M$1501 \$6406 \$6348 VSS VSS nfet_06v0 L=1U W=5U AS=2.2P AD=1.25P PS=10.88U
+ PD=5.5U
M$1502 \$6350 \$6372 \$6406 VSS nfet_06v0 L=1U W=5U AS=1.25P AD=2.2P PS=5.5U
+ PD=10.88U
M$1503 \$6404 \$6351 VSS VSS nfet_06v0 L=1U W=5U AS=2.2P AD=1.25P PS=10.88U
+ PD=5.5U
M$1504 \$6351 \$6372 \$6404 VSS nfet_06v0 L=1U W=5U AS=1.25P AD=1.65P PS=5.5U
+ PD=5.66U
M$1505 \$6389 \$6389 \$6351 VSS nfet_06v0 L=1U W=5U AS=1.65P AD=2.2P PS=5.66U
+ PD=10.88U
M$1506 \$6380 \$6379 VSS VSS nfet_06v0 L=1U W=5U AS=2.2P AD=1.3P PS=10.88U
+ PD=5.52U
M$1507 VSS \$6379 \$6380 VSS nfet_06v0 L=1U W=5U AS=1.3P AD=1.3P PS=5.52U
+ PD=5.52U
M$1508 \$6380 \$6379 VSS VSS nfet_06v0 L=1U W=5U AS=1.3P AD=2.2P PS=5.52U
+ PD=10.88U
M$1509 Y \$4627 \$4639 VSS nfet_06v0 L=1U W=2.48U AS=1.0912P AD=0.6448P
+ PS=5.84U PD=3U
M$1510 \$4639 \$4627 Y VSS nfet_06v0 L=1U W=2.48U AS=0.6448P AD=1.0912P PS=3U
+ PD=5.84U
M$1511 Y \$4556 \$4550 VSS nfet_06v0 L=1U W=2.48U AS=1.0912P AD=0.6448P
+ PS=5.84U PD=3U
M$1512 \$4550 \$4556 Y VSS nfet_06v0 L=1U W=2.48U AS=0.6448P AD=1.0912P PS=3U
+ PD=5.84U
M$1513 Y \$4628 \$4641 VSS nfet_06v0 L=1U W=2.48U AS=1.0912P AD=0.6448P
+ PS=5.84U PD=3U
M$1514 \$4641 \$4628 Y VSS nfet_06v0 L=1U W=2.48U AS=0.6448P AD=1.0912P PS=3U
+ PD=5.84U
M$1515 \$4550 \$4565 VSS VSS nfet_06v0 L=1U W=1.24U AS=0.5456P AD=0.5456P
+ PS=3.36U PD=3.36U
M$1516 \$4639 \$4565 VSS VSS nfet_06v0 L=1U W=1.24U AS=0.5456P AD=0.5456P
+ PS=3.36U PD=3.36U
M$1517 \$4641 \$4565 VSS VSS nfet_06v0 L=1U W=1.24U AS=0.5456P AD=0.5456P
+ PS=3.36U PD=3.36U
M$1518 \$4605 \$4565 VSS VSS nfet_06v0 L=1U W=0.7U AS=0.308P AD=0.175P PS=2.28U
+ PD=1.2U
M$1519 \$4604 \$4565 \$4605 VSS nfet_06v0 L=1U W=0.7U AS=0.175P AD=0.175P
+ PS=1.2U PD=1.2U
M$1520 \$4603 \$4565 \$4604 VSS nfet_06v0 L=1U W=0.7U AS=0.175P AD=0.175P
+ PS=1.2U PD=1.2U
M$1521 \$4565 \$4565 \$4603 VSS nfet_06v0 L=1U W=0.7U AS=0.175P AD=0.308P
+ PS=1.2U PD=2.28U
M$1522 Y Y \$4642 VSS nfet_06v0 L=1U W=2U AS=0.88P AD=0.52P PS=4.88U PD=2.52U
M$1523 \$4642 Y Y VSS nfet_06v0 L=1U W=2U AS=0.52P AD=0.88P PS=2.52U PD=4.88U
M$1524 \$4725 Y VSS VSS nfet_06v0 L=1U W=2U AS=0.88P AD=0.5P PS=4.88U PD=2.5U
M$1525 \$4642 Y \$4725 VSS nfet_06v0 L=1U W=2U AS=0.5P AD=0.88P PS=2.5U PD=4.88U
M$1526 Y \$4629 \$4643 VSS nfet_06v0 L=1U W=2.48U AS=1.0912P AD=0.6448P
+ PS=5.84U PD=3U
M$1527 \$4643 \$4629 Y VSS nfet_06v0 L=1U W=2.48U AS=0.6448P AD=1.0912P PS=3U
+ PD=5.84U
M$1528 \$4643 \$4565 VSS VSS nfet_06v0 L=1U W=1.24U AS=0.5456P AD=0.5456P
+ PS=3.36U PD=3.36U
M$1529 \$8161 \$8161 VSS VSS nfet_06v0 L=1U W=1U AS=0.44P AD=0.44P PS=2.88U
+ PD=2.88U
M$1530 \$8177 \$8124 VSS VSS nfet_06v0 L=1U W=5U AS=2.2P AD=1.25P PS=10.88U
+ PD=5.5U
M$1531 \$8124 \$8161 \$8177 VSS nfet_06v0 L=1U W=5U AS=1.25P AD=2.2P PS=5.5U
+ PD=10.88U
M$1532 \$8170 \$8818 VSS VSS nfet_06v0 L=1U W=1U AS=0.44P AD=0.25P PS=2.88U
+ PD=1.5U
M$1533 \$8740 \$8818 \$8170 VSS nfet_06v0 L=1U W=1U AS=0.25P AD=0.44P PS=1.5U
+ PD=2.88U
M$1534 \$8171 \$8818 VSS VSS nfet_06v0 L=1U W=1U AS=0.44P AD=0.25P PS=2.88U
+ PD=1.5U
M$1535 \$8818 \$8818 \$8171 VSS nfet_06v0 L=1U W=1U AS=0.25P AD=0.44P PS=1.5U
+ PD=2.88U
M$1536 \$8178 \$8124 VSS VSS nfet_06v0 L=1U W=5U AS=2.2P AD=1.25P PS=10.88U
+ PD=5.5U
M$1537 \$8125 \$8161 \$8178 VSS nfet_06v0 L=1U W=5U AS=1.25P AD=1.65P PS=5.5U
+ PD=5.66U
M$1538 \$8179 \$8161 \$8125 VSS nfet_06v0 L=1U W=5U AS=1.65P AD=1.25P PS=5.66U
+ PD=5.5U
M$1539 VSS \$8124 \$8179 VSS nfet_06v0 L=1U W=5U AS=1.25P AD=2.2P PS=5.5U
+ PD=10.88U
M$1540 \$8126 \$1867 \$8125 VSS nfet_06v0 L=1U W=5U AS=2.2P AD=1.3P PS=10.88U
+ PD=5.52U
M$1541 \$8125 \$1867 \$8126 VSS nfet_06v0 L=1U W=5U AS=1.3P AD=2.2P PS=5.52U
+ PD=10.88U
M$1542 \$8127 \$1889 \$8125 VSS nfet_06v0 L=1U W=5U AS=2.2P AD=1.3P PS=10.88U
+ PD=5.52U
M$1543 \$8125 \$1889 \$8127 VSS nfet_06v0 L=1U W=5U AS=1.3P AD=2.2P PS=5.52U
+ PD=10.88U
M$1544 \$8129 \$8161 \$8128 VSS nfet_06v0 L=1U W=2.5U AS=1.1P AD=0.65P PS=5.88U
+ PD=3.02U
M$1545 \$8128 \$8161 \$8129 VSS nfet_06v0 L=1U W=2.5U AS=0.65P AD=1.1P PS=3.02U
+ PD=5.88U
M$1546 \$8131 \$8161 \$8130 VSS nfet_06v0 L=1U W=2.5U AS=1.1P AD=0.65P PS=5.88U
+ PD=3.02U
M$1547 \$8130 \$8161 \$8131 VSS nfet_06v0 L=1U W=2.5U AS=0.65P AD=1.1P PS=3.02U
+ PD=5.88U
M$1548 \$8128 \$8129 VSS VSS nfet_06v0 L=1U W=2.5U AS=1.1P AD=0.65P PS=5.88U
+ PD=3.02U
M$1549 VSS \$8129 \$8128 VSS nfet_06v0 L=1U W=2.5U AS=0.65P AD=0.65P PS=3.02U
+ PD=3.02U
M$1550 \$8128 \$8129 VSS VSS nfet_06v0 L=1U W=2.5U AS=0.65P AD=0.65P PS=3.02U
+ PD=3.02U
M$1551 VSS \$8129 \$8128 VSS nfet_06v0 L=1U W=2.5U AS=0.65P AD=1.1P PS=3.02U
+ PD=5.88U
M$1552 \$8130 \$8129 VSS VSS nfet_06v0 L=1U W=2.5U AS=1.1P AD=0.65P PS=5.88U
+ PD=3.02U
M$1553 VSS \$8129 \$8130 VSS nfet_06v0 L=1U W=2.5U AS=0.65P AD=0.65P PS=3.02U
+ PD=3.02U
M$1554 \$8130 \$8129 VSS VSS nfet_06v0 L=1U W=2.5U AS=0.65P AD=0.65P PS=3.02U
+ PD=3.02U
M$1555 VSS \$8129 \$8130 VSS nfet_06v0 L=1U W=2.5U AS=0.65P AD=1.1P PS=3.02U
+ PD=5.88U
M$1556 \$8286 \$8162 \$8129 VSS nfet_06v0 L=1U W=2.5U AS=1.1P AD=1.1P PS=5.88U
+ PD=5.88U
M$1557 \$8132 \$8162 \$8131 VSS nfet_06v0 L=1U W=2.5U AS=1.1P AD=1.1P PS=5.88U
+ PD=5.88U
M$1558 \$8180 \$8124 VSS VSS nfet_06v0 L=1U W=5U AS=2.2P AD=1.25P PS=10.88U
+ PD=5.5U
M$1559 \$8133 \$8161 \$8180 VSS nfet_06v0 L=1U W=5U AS=1.25P AD=2.2P PS=5.5U
+ PD=10.88U
M$1560 \$8181 \$8134 VSS VSS nfet_06v0 L=1U W=5U AS=2.2P AD=1.25P PS=10.88U
+ PD=5.5U
M$1561 \$8134 \$8161 \$8181 VSS nfet_06v0 L=1U W=5U AS=1.25P AD=1.65P PS=5.5U
+ PD=5.66U
M$1562 \$8162 \$8162 \$8134 VSS nfet_06v0 L=1U W=5U AS=1.65P AD=2.2P PS=5.66U
+ PD=10.88U
M$1563 \$8135 \$8131 VSS VSS nfet_06v0 L=1U W=5U AS=2.2P AD=1.3P PS=10.88U
+ PD=5.52U
M$1564 VSS \$8131 \$8135 VSS nfet_06v0 L=1U W=5U AS=1.3P AD=1.3P PS=5.52U
+ PD=5.52U
M$1565 \$8135 \$8131 VSS VSS nfet_06v0 L=1U W=5U AS=1.3P AD=2.2P PS=5.52U
+ PD=10.88U
M$1566 \$8163 \$8163 VSS VSS nfet_06v0 L=1U W=1U AS=0.44P AD=0.44P PS=2.88U
+ PD=2.88U
M$1567 \$8182 \$8136 VSS VSS nfet_06v0 L=1U W=5U AS=2.2P AD=1.25P PS=10.88U
+ PD=5.5U
M$1568 \$8136 \$8163 \$8182 VSS nfet_06v0 L=1U W=5U AS=1.25P AD=2.2P PS=5.5U
+ PD=10.88U
M$1569 \$8173 \$8819 VSS VSS nfet_06v0 L=1U W=1U AS=0.44P AD=0.25P PS=2.88U
+ PD=1.5U
M$1570 \$8741 \$8819 \$8173 VSS nfet_06v0 L=1U W=1U AS=0.25P AD=0.44P PS=1.5U
+ PD=2.88U
M$1571 \$8174 \$8819 VSS VSS nfet_06v0 L=1U W=1U AS=0.44P AD=0.25P PS=2.88U
+ PD=1.5U
M$1572 \$8819 \$8819 \$8174 VSS nfet_06v0 L=1U W=1U AS=0.25P AD=0.44P PS=1.5U
+ PD=2.88U
M$1573 \$8183 \$8136 VSS VSS nfet_06v0 L=1U W=5U AS=2.2P AD=1.25P PS=10.88U
+ PD=5.5U
M$1574 \$8137 \$8163 \$8183 VSS nfet_06v0 L=1U W=5U AS=1.25P AD=1.65P PS=5.5U
+ PD=5.66U
M$1575 \$8184 \$8163 \$8137 VSS nfet_06v0 L=1U W=5U AS=1.65P AD=1.25P PS=5.66U
+ PD=5.5U
M$1576 VSS \$8136 \$8184 VSS nfet_06v0 L=1U W=5U AS=1.25P AD=2.2P PS=5.5U
+ PD=10.88U
M$1577 \$8138 \$1878 \$8137 VSS nfet_06v0 L=1U W=5U AS=2.2P AD=1.3P PS=10.88U
+ PD=5.52U
M$1578 \$8137 \$1878 \$8138 VSS nfet_06v0 L=1U W=5U AS=1.3P AD=2.2P PS=5.52U
+ PD=10.88U
M$1579 \$8139 \$1889 \$8137 VSS nfet_06v0 L=1U W=5U AS=2.2P AD=1.3P PS=10.88U
+ PD=5.52U
M$1580 \$8137 \$1889 \$8139 VSS nfet_06v0 L=1U W=5U AS=1.3P AD=2.2P PS=5.52U
+ PD=10.88U
M$1581 \$8141 \$8163 \$8140 VSS nfet_06v0 L=1U W=2.5U AS=1.1P AD=0.65P PS=5.88U
+ PD=3.02U
M$1582 \$8140 \$8163 \$8141 VSS nfet_06v0 L=1U W=2.5U AS=0.65P AD=1.1P PS=3.02U
+ PD=5.88U
M$1583 \$8143 \$8163 \$8142 VSS nfet_06v0 L=1U W=2.5U AS=1.1P AD=0.65P PS=5.88U
+ PD=3.02U
M$1584 \$8142 \$8163 \$8143 VSS nfet_06v0 L=1U W=2.5U AS=0.65P AD=1.1P PS=3.02U
+ PD=5.88U
M$1585 \$8140 \$8141 VSS VSS nfet_06v0 L=1U W=2.5U AS=1.1P AD=0.65P PS=5.88U
+ PD=3.02U
M$1586 VSS \$8141 \$8140 VSS nfet_06v0 L=1U W=2.5U AS=0.65P AD=0.65P PS=3.02U
+ PD=3.02U
M$1587 \$8140 \$8141 VSS VSS nfet_06v0 L=1U W=2.5U AS=0.65P AD=0.65P PS=3.02U
+ PD=3.02U
M$1588 VSS \$8141 \$8140 VSS nfet_06v0 L=1U W=2.5U AS=0.65P AD=1.1P PS=3.02U
+ PD=5.88U
M$1589 \$8142 \$8141 VSS VSS nfet_06v0 L=1U W=2.5U AS=1.1P AD=0.65P PS=5.88U
+ PD=3.02U
M$1590 VSS \$8141 \$8142 VSS nfet_06v0 L=1U W=2.5U AS=0.65P AD=0.65P PS=3.02U
+ PD=3.02U
M$1591 \$8142 \$8141 VSS VSS nfet_06v0 L=1U W=2.5U AS=0.65P AD=0.65P PS=3.02U
+ PD=3.02U
M$1592 VSS \$8141 \$8142 VSS nfet_06v0 L=1U W=2.5U AS=0.65P AD=1.1P PS=3.02U
+ PD=5.88U
M$1593 \$8287 \$8164 \$8141 VSS nfet_06v0 L=1U W=2.5U AS=1.1P AD=1.1P PS=5.88U
+ PD=5.88U
M$1594 \$8144 \$8164 \$8143 VSS nfet_06v0 L=1U W=2.5U AS=1.1P AD=1.1P PS=5.88U
+ PD=5.88U
M$1595 \$8185 \$8136 VSS VSS nfet_06v0 L=1U W=5U AS=2.2P AD=1.25P PS=10.88U
+ PD=5.5U
M$1596 \$8145 \$8163 \$8185 VSS nfet_06v0 L=1U W=5U AS=1.25P AD=2.2P PS=5.5U
+ PD=10.88U
M$1597 \$8186 \$8146 VSS VSS nfet_06v0 L=1U W=5U AS=2.2P AD=1.25P PS=10.88U
+ PD=5.5U
M$1598 \$8146 \$8163 \$8186 VSS nfet_06v0 L=1U W=5U AS=1.25P AD=1.65P PS=5.5U
+ PD=5.66U
M$1599 \$8164 \$8164 \$8146 VSS nfet_06v0 L=1U W=5U AS=1.65P AD=2.2P PS=5.66U
+ PD=10.88U
M$1600 \$8147 \$8143 VSS VSS nfet_06v0 L=1U W=5U AS=2.2P AD=1.3P PS=10.88U
+ PD=5.52U
M$1601 VSS \$8143 \$8147 VSS nfet_06v0 L=1U W=5U AS=1.3P AD=1.3P PS=5.52U
+ PD=5.52U
M$1602 \$8147 \$8143 VSS VSS nfet_06v0 L=1U W=5U AS=1.3P AD=2.2P PS=5.52U
+ PD=10.88U
M$1603 \$8165 \$8165 VSS VSS nfet_06v0 L=1U W=1U AS=0.44P AD=0.44P PS=2.88U
+ PD=2.88U
M$1604 \$8188 \$8148 VSS VSS nfet_06v0 L=1U W=5U AS=2.2P AD=1.25P PS=10.88U
+ PD=5.5U
M$1605 \$8148 \$8165 \$8188 VSS nfet_06v0 L=1U W=5U AS=1.25P AD=2.2P PS=5.5U
+ PD=10.88U
M$1606 \$8175 \$8820 VSS VSS nfet_06v0 L=1U W=1U AS=0.44P AD=0.25P PS=2.88U
+ PD=1.5U
M$1607 \$8742 \$8820 \$8175 VSS nfet_06v0 L=1U W=1U AS=0.25P AD=0.44P PS=1.5U
+ PD=2.88U
M$1608 \$8176 \$8820 VSS VSS nfet_06v0 L=1U W=1U AS=0.44P AD=0.25P PS=2.88U
+ PD=1.5U
M$1609 \$8820 \$8820 \$8176 VSS nfet_06v0 L=1U W=1U AS=0.25P AD=0.44P PS=1.5U
+ PD=2.88U
M$1610 \$8189 \$8148 VSS VSS nfet_06v0 L=1U W=5U AS=2.2P AD=1.25P PS=10.88U
+ PD=5.5U
M$1611 \$8149 \$8165 \$8189 VSS nfet_06v0 L=1U W=5U AS=1.25P AD=1.65P PS=5.5U
+ PD=5.66U
M$1612 \$8190 \$8165 \$8149 VSS nfet_06v0 L=1U W=5U AS=1.65P AD=1.25P PS=5.66U
+ PD=5.5U
M$1613 VSS \$8148 \$8190 VSS nfet_06v0 L=1U W=5U AS=1.25P AD=2.2P PS=5.5U
+ PD=10.88U
M$1614 \$8150 \$1878 \$8149 VSS nfet_06v0 L=1U W=5U AS=2.2P AD=1.3P PS=10.88U
+ PD=5.52U
M$1615 \$8149 \$1878 \$8150 VSS nfet_06v0 L=1U W=5U AS=1.3P AD=2.2P PS=5.52U
+ PD=10.88U
M$1616 \$8151 \$1867 \$8149 VSS nfet_06v0 L=1U W=5U AS=2.2P AD=1.3P PS=10.88U
+ PD=5.52U
M$1617 \$8149 \$1867 \$8151 VSS nfet_06v0 L=1U W=5U AS=1.3P AD=2.2P PS=5.52U
+ PD=10.88U
M$1618 \$8153 \$8165 \$8152 VSS nfet_06v0 L=1U W=2.5U AS=1.1P AD=0.65P PS=5.88U
+ PD=3.02U
M$1619 \$8152 \$8165 \$8153 VSS nfet_06v0 L=1U W=2.5U AS=0.65P AD=1.1P PS=3.02U
+ PD=5.88U
M$1620 \$8155 \$8165 \$8154 VSS nfet_06v0 L=1U W=2.5U AS=1.1P AD=0.65P PS=5.88U
+ PD=3.02U
M$1621 \$8154 \$8165 \$8155 VSS nfet_06v0 L=1U W=2.5U AS=0.65P AD=1.1P PS=3.02U
+ PD=5.88U
M$1622 \$8152 \$8153 VSS VSS nfet_06v0 L=1U W=2.5U AS=1.1P AD=0.65P PS=5.88U
+ PD=3.02U
M$1623 VSS \$8153 \$8152 VSS nfet_06v0 L=1U W=2.5U AS=0.65P AD=0.65P PS=3.02U
+ PD=3.02U
M$1624 \$8152 \$8153 VSS VSS nfet_06v0 L=1U W=2.5U AS=0.65P AD=0.65P PS=3.02U
+ PD=3.02U
M$1625 VSS \$8153 \$8152 VSS nfet_06v0 L=1U W=2.5U AS=0.65P AD=1.1P PS=3.02U
+ PD=5.88U
M$1626 \$8154 \$8153 VSS VSS nfet_06v0 L=1U W=2.5U AS=1.1P AD=0.65P PS=5.88U
+ PD=3.02U
M$1627 VSS \$8153 \$8154 VSS nfet_06v0 L=1U W=2.5U AS=0.65P AD=0.65P PS=3.02U
+ PD=3.02U
M$1628 \$8154 \$8153 VSS VSS nfet_06v0 L=1U W=2.5U AS=0.65P AD=0.65P PS=3.02U
+ PD=3.02U
M$1629 VSS \$8153 \$8154 VSS nfet_06v0 L=1U W=2.5U AS=0.65P AD=1.1P PS=3.02U
+ PD=5.88U
M$1630 \$8288 \$8166 \$8153 VSS nfet_06v0 L=1U W=2.5U AS=1.1P AD=1.1P PS=5.88U
+ PD=5.88U
M$1631 \$8156 \$8166 \$8155 VSS nfet_06v0 L=1U W=2.5U AS=1.1P AD=1.1P PS=5.88U
+ PD=5.88U
M$1632 \$8191 \$8148 VSS VSS nfet_06v0 L=1U W=5U AS=2.2P AD=1.25P PS=10.88U
+ PD=5.5U
M$1633 \$8157 \$8165 \$8191 VSS nfet_06v0 L=1U W=5U AS=1.25P AD=2.2P PS=5.5U
+ PD=10.88U
M$1634 \$8187 \$8158 VSS VSS nfet_06v0 L=1U W=5U AS=2.2P AD=1.25P PS=10.88U
+ PD=5.5U
M$1635 \$8158 \$8165 \$8187 VSS nfet_06v0 L=1U W=5U AS=1.25P AD=1.65P PS=5.5U
+ PD=5.66U
M$1636 \$8166 \$8166 \$8158 VSS nfet_06v0 L=1U W=5U AS=1.65P AD=2.2P PS=5.66U
+ PD=10.88U
M$1637 \$8159 \$8155 VSS VSS nfet_06v0 L=1U W=5U AS=2.2P AD=1.3P PS=10.88U
+ PD=5.52U
M$1638 VSS \$8155 \$8159 VSS nfet_06v0 L=1U W=5U AS=1.3P AD=1.3P PS=5.52U
+ PD=5.52U
M$1639 \$8159 \$8155 VSS VSS nfet_06v0 L=1U W=5U AS=1.3P AD=2.2P PS=5.52U
+ PD=10.88U
M$1640 \$6428 \$2806 VSS VSS nfet_06v0 L=1U W=1U AS=0.44P AD=0.33P PS=2.88U
+ PD=1.66U
M$1641 VSS \$2797 \$6428 VSS nfet_06v0 L=1U W=1U AS=0.33P AD=0.44P PS=1.66U
+ PD=2.88U
M$1642 Z \$6347 \$6337 VSS nfet_06v0 L=1U W=2.48U AS=1.0912P AD=0.6448P
+ PS=5.84U PD=3U
M$1643 \$6337 \$6347 Z VSS nfet_06v0 L=1U W=2.48U AS=0.6448P AD=1.0912P PS=3U
+ PD=5.84U
M$1644 Z \$6424 \$6423 VSS nfet_06v0 L=1U W=2.48U AS=1.0912P AD=0.6448P
+ PS=5.84U PD=3U
M$1645 \$6423 \$6424 Z VSS nfet_06v0 L=1U W=2.48U AS=0.6448P AD=1.0912P PS=3U
+ PD=5.84U
M$1646 VSS \$2788 \$8160 VSS nfet_06v0 L=1U W=1U AS=0.44P AD=0.44P PS=2.88U
+ PD=2.88U
M$1647 Z \$6968 \$6425 VSS nfet_06v0 L=1U W=2.48U AS=1.0912P AD=0.6448P
+ PS=5.84U PD=3U
M$1648 \$6425 \$6968 Z VSS nfet_06v0 L=1U W=2.48U AS=0.6448P AD=1.0912P PS=3U
+ PD=5.84U
M$1649 \$6337 \$6352 VSS VSS nfet_06v0 L=1U W=1.24U AS=0.5456P AD=0.5456P
+ PS=3.36U PD=3.36U
M$1650 VSS \$8167 \$4629 VSS nfet_06v0 L=1U W=1U AS=0.44P AD=0.44P PS=2.88U
+ PD=2.88U
M$1651 \$6423 \$6352 VSS VSS nfet_06v0 L=1U W=1.24U AS=0.5456P AD=0.5456P
+ PS=3.36U PD=3.36U
M$1652 \$6425 \$6352 VSS VSS nfet_06v0 L=1U W=1.24U AS=0.5456P AD=0.5456P
+ PS=3.36U PD=3.36U
M$1653 \$8172 \$8160 \$8167 VSS nfet_06v0 L=1U W=1U AS=0.44P AD=0.25P PS=2.88U
+ PD=1.5U
M$1654 VSS \$2806 \$8172 VSS nfet_06v0 L=1U W=1U AS=0.25P AD=0.44P PS=1.5U
+ PD=2.88U
M$1655 \$6392 \$6352 VSS VSS nfet_06v0 L=1U W=0.7U AS=0.308P AD=0.175P PS=2.28U
+ PD=1.2U
M$1656 \$6391 \$6352 \$6392 VSS nfet_06v0 L=1U W=0.7U AS=0.175P AD=0.175P
+ PS=1.2U PD=1.2U
M$1657 \$6390 \$6352 \$6391 VSS nfet_06v0 L=1U W=0.7U AS=0.175P AD=0.175P
+ PS=1.2U PD=1.2U
M$1658 \$6352 \$6352 \$6390 VSS nfet_06v0 L=1U W=0.7U AS=0.175P AD=0.308P
+ PS=1.2U PD=2.28U
M$1659 Z Z \$6426 VSS nfet_06v0 L=1U W=2U AS=0.88P AD=0.52P PS=4.88U PD=2.52U
M$1660 \$6426 Z Z VSS nfet_06v0 L=1U W=2U AS=0.52P AD=0.88P PS=2.52U PD=4.88U
M$1661 VSS \$8168 \$3315 VSS nfet_06v0 L=1U W=1U AS=0.44P AD=0.44P PS=2.88U
+ PD=2.88U
M$1662 \$6511 Z VSS VSS nfet_06v0 L=1U W=2U AS=0.88P AD=0.5P PS=4.88U PD=2.5U
M$1663 \$6426 Z \$6511 VSS nfet_06v0 L=1U W=2U AS=0.5P AD=0.88P PS=2.5U PD=4.88U
M$1664 \$8169 \$2797 \$8168 VSS nfet_06v0 L=1U W=1U AS=0.44P AD=0.25P PS=2.88U
+ PD=1.5U
M$1665 VSS \$2788 \$8169 VSS nfet_06v0 L=1U W=1U AS=0.25P AD=0.44P PS=1.5U
+ PD=2.88U
M$1666 Z \$6428 \$6427 VSS nfet_06v0 L=1U W=2.48U AS=1.0912P AD=0.6448P
+ PS=5.84U PD=3U
M$1667 \$6427 \$6428 Z VSS nfet_06v0 L=1U W=2.48U AS=0.6448P AD=1.0912P PS=3U
+ PD=5.84U
M$1668 \$6427 \$6352 VSS VSS nfet_06v0 L=1U W=1.24U AS=0.5456P AD=0.5456P
+ PS=3.36U PD=3.36U
M$1669 \$6968 \$4593 VSS VSS nfet_06v0 L=1U W=1U AS=0.44P AD=0.33P PS=2.88U
+ PD=1.66U
M$1670 VSS \$4584 \$6968 VSS nfet_06v0 L=1U W=1U AS=0.33P AD=0.44P PS=1.66U
+ PD=2.88U
M$1671 VSS \$4575 \$9899 VSS nfet_06v0 L=1U W=1U AS=0.44P AD=0.44P PS=2.88U
+ PD=2.88U
M$1672 VSS \$9900 \$4628 VSS nfet_06v0 L=1U W=1U AS=0.44P AD=0.44P PS=2.88U
+ PD=2.88U
M$1673 \$9909 \$9899 \$9900 VSS nfet_06v0 L=1U W=1U AS=0.44P AD=0.25P PS=2.88U
+ PD=1.5U
M$1674 VSS \$4593 \$9909 VSS nfet_06v0 L=1U W=1U AS=0.25P AD=0.44P PS=1.5U
+ PD=2.88U
M$1675 VSS \$9901 \$3394 VSS nfet_06v0 L=1U W=1U AS=0.44P AD=0.44P PS=2.88U
+ PD=2.88U
M$1676 \$9911 \$4584 \$9901 VSS nfet_06v0 L=1U W=1U AS=0.44P AD=0.25P PS=2.88U
+ PD=1.5U
M$1677 VSS \$4575 \$9911 VSS nfet_06v0 L=1U W=1U AS=0.25P AD=0.44P PS=1.5U
+ PD=2.88U
M$1678 \$6347 \$6380 VSS VSS nfet_06v0 L=1U W=1U AS=0.44P AD=0.33P PS=2.88U
+ PD=1.66U
M$1679 VSS \$6371 \$6347 VSS nfet_06v0 L=1U W=1U AS=0.33P AD=0.44P PS=1.66U
+ PD=2.88U
M$1680 VSS \$6362 \$9902 VSS nfet_06v0 L=1U W=1U AS=0.44P AD=0.44P PS=2.88U
+ PD=2.88U
M$1681 VSS \$9903 \$4556 VSS nfet_06v0 L=1U W=1U AS=0.44P AD=0.44P PS=2.88U
+ PD=2.88U
M$1682 \$9912 \$9902 \$9903 VSS nfet_06v0 L=1U W=1U AS=0.44P AD=0.25P PS=2.88U
+ PD=1.5U
M$1683 VSS \$6380 \$9912 VSS nfet_06v0 L=1U W=1U AS=0.25P AD=0.44P PS=1.5U
+ PD=2.88U
M$1684 VSS \$9904 \$2773 VSS nfet_06v0 L=1U W=1U AS=0.44P AD=0.44P PS=2.88U
+ PD=2.88U
M$1685 \$9913 \$6371 \$9904 VSS nfet_06v0 L=1U W=1U AS=0.44P AD=0.25P PS=2.88U
+ PD=1.5U
M$1686 VSS \$6362 \$9913 VSS nfet_06v0 L=1U W=1U AS=0.25P AD=0.44P PS=1.5U
+ PD=2.88U
M$1687 \$6424 \$8159 VSS VSS nfet_06v0 L=1U W=1U AS=0.44P AD=0.33P PS=2.88U
+ PD=1.66U
M$1688 VSS \$8147 \$6424 VSS nfet_06v0 L=1U W=1U AS=0.33P AD=0.44P PS=1.66U
+ PD=2.88U
M$1689 VSS \$8135 \$9905 VSS nfet_06v0 L=1U W=1U AS=0.44P AD=0.44P PS=2.88U
+ PD=2.88U
M$1690 VSS \$9906 \$4627 VSS nfet_06v0 L=1U W=1U AS=0.44P AD=0.44P PS=2.88U
+ PD=2.88U
M$1691 \$9910 \$9905 \$9906 VSS nfet_06v0 L=1U W=1U AS=0.44P AD=0.25P PS=2.88U
+ PD=1.5U
M$1692 VSS \$8159 \$9910 VSS nfet_06v0 L=1U W=1U AS=0.25P AD=0.44P PS=1.5U
+ PD=2.88U
M$1693 VSS \$9907 \$2840 VSS nfet_06v0 L=1U W=1U AS=0.44P AD=0.44P PS=2.88U
+ PD=2.88U
M$1694 \$9908 \$8147 \$9907 VSS nfet_06v0 L=1U W=1U AS=0.44P AD=0.25P PS=2.88U
+ PD=1.5U
M$1695 VSS \$8135 \$9908 VSS nfet_06v0 L=1U W=1U AS=0.25P AD=0.44P PS=1.5U
+ PD=2.88U
R$1696 \$380 \$382 VSS 76450 ppolyf_u_3k L=76.45U W=1U
R$1697 \$380 \$381 VSS 76450 ppolyf_u_3k L=76.45U W=1U
R$1698 \$379 \$381 VSS 76450 ppolyf_u_3k L=76.45U W=1U
R$1699 \$379 \$17 VSS 76450 ppolyf_u_3k L=76.45U W=1U
R$1700 \$14 \$382 VSS 76450 ppolyf_u_3k L=76.45U W=1U
R$1701 \$383 \$386 VSS 76450 ppolyf_u_3k L=76.45U W=1U
R$1702 \$383 \$385 VSS 76450 ppolyf_u_3k L=76.45U W=1U
R$1703 \$25 \$386 VSS 76450 ppolyf_u_3k L=76.45U W=1U
R$1704 \$384 \$28 VSS 76450 ppolyf_u_3k L=76.45U W=1U
R$1705 \$384 \$385 VSS 76450 ppolyf_u_3k L=76.45U W=1U
R$1706 \$36 \$389 VSS 76450 ppolyf_u_3k L=76.45U W=1U
R$1707 \$388 \$389 VSS 76450 ppolyf_u_3k L=76.45U W=1U
R$1708 \$387 \$39 VSS 76450 ppolyf_u_3k L=76.45U W=1U
R$1709 \$388 \$390 VSS 76450 ppolyf_u_3k L=76.45U W=1U
R$1710 \$387 \$390 VSS 76450 ppolyf_u_3k L=76.45U W=1U
R$1711 \$391 \$394 VSS 76450 ppolyf_u_3k L=76.45U W=1U
R$1712 \$391 \$393 VSS 76450 ppolyf_u_3k L=76.45U W=1U
R$1713 \$392 \$394 VSS 76450 ppolyf_u_3k L=76.45U W=1U
R$1714 \$392 \$50 VSS 76450 ppolyf_u_3k L=76.45U W=1U
R$1715 \$47 \$393 VSS 76450 ppolyf_u_3k L=76.45U W=1U
R$1716 \$1298 \$938 VSS 76450 ppolyf_u_3k L=76.45U W=1U
R$1717 \$1298 \$1301 VSS 76450 ppolyf_u_3k L=76.45U W=1U
R$1718 \$1299 \$1300 VSS 76450 ppolyf_u_3k L=76.45U W=1U
R$1719 \$1299 \$1301 VSS 76450 ppolyf_u_3k L=76.45U W=1U
R$1720 \$935 \$1300 VSS 76450 ppolyf_u_3k L=76.45U W=1U
R$1721 \$1303 \$1305 VSS 76450 ppolyf_u_3k L=76.45U W=1U
R$1722 \$1302 \$949 VSS 76450 ppolyf_u_3k L=76.45U W=1U
R$1723 \$1303 \$1304 VSS 76450 ppolyf_u_3k L=76.45U W=1U
R$1724 \$946 \$1305 VSS 76450 ppolyf_u_3k L=76.45U W=1U
R$1725 \$1302 \$1304 VSS 76450 ppolyf_u_3k L=76.45U W=1U
R$1726 \$1307 \$1308 VSS 76450 ppolyf_u_3k L=76.45U W=1U
R$1727 \$957 \$1309 VSS 76450 ppolyf_u_3k L=76.45U W=1U
R$1728 \$1306 \$1308 VSS 76450 ppolyf_u_3k L=76.45U W=1U
R$1729 \$1306 \$960 VSS 76450 ppolyf_u_3k L=76.45U W=1U
R$1730 \$1307 \$1309 VSS 76450 ppolyf_u_3k L=76.45U W=1U
R$1731 \$1311 \$1312 VSS 76450 ppolyf_u_3k L=76.45U W=1U
R$1732 \$968 \$1313 VSS 76450 ppolyf_u_3k L=76.45U W=1U
R$1733 \$1310 \$971 VSS 76450 ppolyf_u_3k L=76.45U W=1U
R$1734 \$1311 \$1313 VSS 76450 ppolyf_u_3k L=76.45U W=1U
R$1735 \$1310 \$1312 VSS 76450 ppolyf_u_3k L=76.45U W=1U
R$1736 \$2463 \$1856 VSS 76450 ppolyf_u_3k L=76.45U W=1U
R$1737 \$1853 \$2465 VSS 76450 ppolyf_u_3k L=76.45U W=1U
R$1738 \$2463 \$2466 VSS 76450 ppolyf_u_3k L=76.45U W=1U
R$1739 \$2464 \$2465 VSS 76450 ppolyf_u_3k L=76.45U W=1U
R$1740 \$2464 \$2466 VSS 76450 ppolyf_u_3k L=76.45U W=1U
R$1741 \$2468 \$1867 VSS 76450 ppolyf_u_3k L=76.45U W=1U
R$1742 \$2467 \$2469 VSS 76450 ppolyf_u_3k L=76.45U W=1U
R$1743 \$2467 \$2470 VSS 76450 ppolyf_u_3k L=76.45U W=1U
R$1744 \$1864 \$2469 VSS 76450 ppolyf_u_3k L=76.45U W=1U
R$1745 \$2468 \$2470 VSS 76450 ppolyf_u_3k L=76.45U W=1U
R$1746 \$2472 \$1878 VSS 76450 ppolyf_u_3k L=76.45U W=1U
R$1747 \$2471 \$2473 VSS 76450 ppolyf_u_3k L=76.45U W=1U
R$1748 \$2472 \$2473 VSS 76450 ppolyf_u_3k L=76.45U W=1U
R$1749 \$2471 \$2474 VSS 76450 ppolyf_u_3k L=76.45U W=1U
R$1750 \$1875 \$2474 VSS 76450 ppolyf_u_3k L=76.45U W=1U
R$1751 \$2476 \$2477 VSS 76450 ppolyf_u_3k L=76.45U W=1U
R$1752 \$2475 \$2477 VSS 76450 ppolyf_u_3k L=76.45U W=1U
R$1753 \$2476 \$1889 VSS 76450 ppolyf_u_3k L=76.45U W=1U
R$1754 \$1886 \$2478 VSS 76450 ppolyf_u_3k L=76.45U W=1U
R$1755 \$2475 \$2478 VSS 76450 ppolyf_u_3k L=76.45U W=1U
C$1756 \$1889 \$1940 2e-13 cap_mim_2f0fF A=100P P=58U
C$1757 \$6374 \$6380 4e-13 cap_mim_2f0fF A=200P P=60U
C$1758 \$8150 \$8159 4e-13 cap_mim_2f0fF A=200P P=60U
C$1759 \$2806 \$2804 4e-13 cap_mim_2f0fF A=200P P=60U
C$1760 \$1856 \$1931 2e-13 cap_mim_2f0fF A=100P P=58U
C$1761 \$8138 \$8147 4e-13 cap_mim_2f0fF A=200P P=60U
C$1762 \$1847 \$1856 2e-13 cap_mim_2f0fF A=100P P=58U
C$1763 \$8147 \$8142 4e-13 cap_mim_2f0fF A=200P P=60U
C$1764 \$6371 \$6369 4e-13 cap_mim_2f0fF A=200P P=60U
C$1765 \$4593 \$4591 4e-13 cap_mim_2f0fF A=200P P=60U
C$1766 \$1869 \$1878 2e-13 cap_mim_2f0fF A=100P P=58U
C$1767 \$8126 \$8135 4e-13 cap_mim_2f0fF A=200P P=60U
C$1768 \$8135 \$8130 4e-13 cap_mim_2f0fF A=200P P=60U
C$1769 \$1878 \$1937 2e-13 cap_mim_2f0fF A=100P P=58U
C$1770 \$938 \$1013 2e-13 cap_mim_2f0fF A=100P P=58U
C$1771 \$19 \$28 2e-13 cap_mim_2f0fF A=100P P=58U
C$1772 \$6362 \$6360 4e-13 cap_mim_2f0fF A=200P P=60U
C$1773 \$962 \$971 2e-13 cap_mim_2f0fF A=100P P=58U
C$1774 \$951 \$960 2e-13 cap_mim_2f0fF A=100P P=58U
C$1775 \$39 \$97 2e-13 cap_mim_2f0fF A=100P P=58U
C$1776 \$17 \$101 2e-13 cap_mim_2f0fF A=100P P=58U
C$1777 \$2800 \$2806 4e-13 cap_mim_2f0fF A=200P P=60U
C$1778 \$2782 \$2788 4e-13 cap_mim_2f0fF A=200P P=60U
C$1779 \$2791 \$2797 4e-13 cap_mim_2f0fF A=200P P=60U
C$1780 \$41 \$50 2e-13 cap_mim_2f0fF A=100P P=58U
C$1781 \$8159 \$8154 4e-13 cap_mim_2f0fF A=200P P=60U
C$1782 \$6365 \$6371 4e-13 cap_mim_2f0fF A=200P P=60U
C$1783 \$30 \$39 2e-13 cap_mim_2f0fF A=100P P=58U
C$1784 \$1880 \$1889 2e-13 cap_mim_2f0fF A=100P P=58U
C$1785 \$2788 \$2786 4e-13 cap_mim_2f0fF A=200P P=60U
C$1786 \$6356 \$6362 4e-13 cap_mim_2f0fF A=200P P=60U
C$1787 \$1867 \$1934 2e-13 cap_mim_2f0fF A=100P P=58U
C$1788 \$28 \$95 2e-13 cap_mim_2f0fF A=100P P=58U
C$1789 \$4575 \$4573 4e-13 cap_mim_2f0fF A=200P P=60U
C$1790 \$6380 \$6378 4e-13 cap_mim_2f0fF A=200P P=60U
C$1791 \$971 \$1022 2e-13 cap_mim_2f0fF A=100P P=58U
C$1792 \$2797 \$2795 4e-13 cap_mim_2f0fF A=200P P=60U
C$1793 \$1858 \$1867 2e-13 cap_mim_2f0fF A=100P P=58U
C$1794 \$50 \$105 2e-13 cap_mim_2f0fF A=100P P=58U
C$1795 \$4569 \$4575 4e-13 cap_mim_2f0fF A=200P P=60U
C$1796 \$8 \$17 2e-13 cap_mim_2f0fF A=100P P=58U
C$1797 \$929 \$938 2e-13 cap_mim_2f0fF A=100P P=58U
C$1798 \$960 \$1025 2e-13 cap_mim_2f0fF A=100P P=58U
C$1799 \$4584 \$4582 4e-13 cap_mim_2f0fF A=200P P=60U
C$1800 \$4578 \$4584 4e-13 cap_mim_2f0fF A=200P P=60U
C$1801 \$949 \$1016 2e-13 cap_mim_2f0fF A=100P P=58U
C$1802 \$4587 \$4593 4e-13 cap_mim_2f0fF A=200P P=60U
C$1803 \$940 \$949 2e-13 cap_mim_2f0fF A=100P P=58U
.ENDS GRADIENT_NAV2
