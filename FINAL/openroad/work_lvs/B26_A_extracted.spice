* NGSPICE file created from B26_A.ext - technology: gf180mcuD

.subckt B26_A S1N S1P S2N S2P S3N S3P S4N S4P VDD VSS X XN_IN XN_OUT XP_IN XP_OUT
+ Y YN_IN YN_OUT YP_IN YP_OUT Z ZN_IN ZN_OUT ZP_IN ZP_OUT
X0 a_33946_164973# a_35862_169399# a_36506_165043# VDD pfet_06v0 ad=4.4p pd=20.88u as=2.6p ps=10.52u w=10u l=1u
X1 a_90994_182289# a_75842_182289# a_91194_182333# VDD pfet_06v0 ad=3.3p pd=10.66u as=2.5p ps=10.5u w=10u l=1u
X2 a_52560_157284# a_67978_157284# VSS ppolyf_u_1k r_width=1u r_length=76.45u
X3 a_99296_173976# a_106078_175068# a_23448_131216# VSS nfet_06v0 ad=1.0912p pd=5.84u as=0.6448p ps=3u w=2.48u l=1u
X4 a_81646_165043# a_83430_169943# VSS VSS nfet_06v0 ad=0.65p pd=3.02u as=1.1p ps=5.88u w=2.5u l=1u
X5 a_112558_173624# a_110806_173624# a_111626_173580# VSS nfet_06v0 ad=0.25p pd=1.5u as=0.44p ps=2.88u w=1u l=1u
X6 VDD a_110806_166742# a_111626_166626# VDD pfet_06v0 ad=1.32p pd=6.88u as=0.99p ps=3.66u w=3u l=1u
X7 a_73934_128810# a_74274_135596# a_89822_135712# VDD pfet_06v0 ad=4.4p pd=20.88u as=2.5p ps=10.5u w=10u l=1u
X8 VSS VDD VSS VSS nfet_06v0 ad=7.92p pd=36.88u as=1.23306n ps=6.04388m w=18u l=2u
X9 a_42526_149572# a_29586_140870# VSS VSS nfet_06v0 ad=0.25p pd=1.5u as=0.44p ps=2.88u w=1u l=1u
X10 a_23448_190688# a_99134_167126# a_99046_167170# VSS nfet_06v0 ad=0.6448p pd=3u as=1.0912p ps=5.84u w=2.48u l=1u
X11 a_54110_140914# a_55186_149156# VSS VSS nfet_06v0 ad=0.825p pd=3.16u as=1.1p ps=5.88u w=2.5u l=1u
X12 a_38286_187303# a_29246_187557# a_35390_182403# VSS nfet_06v0 ad=0.65p pd=3.02u as=1.1p ps=5.88u w=2.5u l=1u
X13 a_58990_148772# a_51646_148656# VSS VSS nfet_06v0 ad=1.25p pd=5.5u as=2.2p ps=10.88u w=5u l=1u
X14 VSS a_38286_191067# a_46710_191067# VSS nfet_06v0 ad=1.3p pd=5.52u as=1.3p ps=5.52u w=5u l=1u
X15 a_60418_140870# a_51986_140870# a_60618_140914# VDD pfet_06v0 ad=3.3p pd=10.66u as=2.5p ps=10.5u w=10u l=1u
X16 a_79614_152778# a_74274_159564# a_84350_159680# VDD pfet_06v0 ad=4.4p pd=20.88u as=2.5p ps=10.5u w=10u l=1u
X17 a_83430_187303# a_75502_187557# a_82762_182403# VSS nfet_06v0 ad=0.65p pd=3.02u as=1.1p ps=5.88u w=2.5u l=1u
X18 a_80202_164973# a_75842_164929# a_79902_164973# VDD pfet_06v0 ad=3.3p pd=10.66u as=2.5p ps=10.5u w=10u l=1u
X19 VSS a_61358_173707# a_69782_173707# VSS nfet_06v0 ad=1.3p pd=5.52u as=1.3p ps=5.52u w=5u l=1u
X20 S4N a_23448_50576# VDD ppolyf_u r_width=16u r_length=4u
X21 a_75842_194421# a_75842_194421# a_78498_190997# VSS nfet_06v0 ad=0.44p pd=2.88u as=0.25p ps=1.5u w=1u l=1u
X22 VSS VDD VSS VSS nfet_06v0 ad=4.29p pd=20.38u as=0 ps=0 w=9.75u l=2u
X23 VSS a_83430_191067# a_82762_194467# VSS nfet_06v0 ad=0.65p pd=3.02u as=0.65p ps=3.02u w=2.5u l=1u
X24 a_57822_186759# a_97248_145110# VDD VDD pfet_06v0 ad=0.44p pd=2.88u as=0.44p ps=2.88u w=1u l=1u
X25 a_54110_137602# a_53710_128810# a_52186_135712# VDD pfet_06v0 ad=0.242p pd=1.98u as=0.242p ps=1.98u w=0.55u l=1u
X26 VDD a_75542_177061# a_80534_177177# VDD pfet_06v0 ad=4.4p pd=20.88u as=2.5p ps=10.5u w=10u l=1u
X27 a_32522_164973# a_29286_164929# VDD VDD pfet_06v0 ad=2.5p pd=10.5u as=4.4p ps=20.88u w=10u l=1u
D0 VSS X diode_nd2ps_06v0 pj=40u area=99.99999p
X28 a_36062_186803# a_37622_182403# VDD VDD pfet_06v0 ad=1.3p pd=5.52u as=1.3p ps=5.52u w=5u l=1u
X29 VDD a_29286_182289# a_34278_182333# VDD pfet_06v0 ad=4.4p pd=20.88u as=2.5p ps=10.5u w=10u l=1u
X30 VDD VSS VDD VDD pfet_06v0 ad=7.92p pd=36.88u as=1.86749n ps=8.9035m w=18u l=2u
X31 a_60694_165043# a_52658_164929# a_59134_169443# VDD pfet_06v0 ad=1.3p pd=5.52u as=2.2p ps=10.88u w=5u l=1u
X32 VSS VDD VSS VSS nfet_06v0 ad=4.29p pd=20.38u as=0 ps=0 w=9.75u l=2u
X33 a_59578_194467# a_60246_191067# VSS VSS nfet_06v0 ad=0.65p pd=3.02u as=1.1p ps=5.88u w=2.5u l=1u
X34 a_45346_169513# a_45146_169397# VSS VSS nfet_06v0 ad=1.25p pd=5.5u as=2.2p ps=10.88u w=5u l=1u
X35 a_35390_165043# a_46710_169443# cap_mim_2f0_m4m5_noshield c_width=20u c_length=10u
X36 a_34750_169399# a_30160_133316# VDD VDD pfet_06v0 ad=0.44p pd=2.88u as=0.44p ps=2.88u w=1u l=1u
X37 a_76198_148272# a_78022_140914# VDD VDD pfet_06v0 ad=2.2p pd=10.88u as=2.2p ps=10.88u w=5u l=1u
X38 a_29746_152822# a_29546_152778# a_30478_152822# VSS nfet_06v0 ad=2.2p pd=10.88u as=1.25p ps=5.5u w=5u l=1u
X39 a_39662_140914# a_29286_140870# VDD VDD pfet_06v0 ad=2.5p pd=10.5u as=4.4p ps=20.88u w=10u l=1u
X40 a_30598_182333# a_29286_182289# VDD VDD pfet_06v0 ad=2.5p pd=10.5u as=4.4p ps=20.88u w=10u l=1u
X41 a_77474_152778# a_74234_152778# a_77210_161580# VSS nfet_06v0 ad=1.1p pd=5.88u as=0.825p ps=3.16u w=2.5u l=1u
X42 a_37622_178107# a_29586_177061# a_36062_173707# VDD pfet_06v0 ad=1.3p pd=5.52u as=2.2p ps=10.88u w=5u l=1u
X43 a_85150_152822# a_73934_152778# VSS VSS nfet_06v0 ad=1.25p pd=5.5u as=2.2p ps=10.88u w=5u l=1u
X44 a_34750_190951# a_56794_152822# VSS VSS nfet_06v0 ad=0.44p pd=2.88u as=0.44p ps=2.88u w=1u l=1u
X45 a_59578_177107# a_52318_173593# a_60246_173707# VSS nfet_06v0 ad=1.1p pd=5.88u as=0.65p ps=3.02u w=2.5u l=1u
X46 a_59134_191067# a_52658_194421# a_60694_195467# VDD pfet_06v0 ad=2.2p pd=10.88u as=1.3p ps=5.52u w=5u l=1u
X47 a_102104_185738# a_99096_185942# VSS VSS nfet_06v0 ad=0.5456p pd=3.36u as=0.5456p ps=3.36u w=1.24u l=1u
X48 a_84994_165043# a_75842_164929# a_81206_169443# VDD pfet_06v0 ad=1.3p pd=5.52u as=2.2p ps=10.88u w=5u l=1u
X49 a_76930_152822# a_54442_128810# a_74434_152822# VSS nfet_06v0 ad=3.74p pd=17.88u as=3.74p ps=17.88u w=8.5u l=1u
X50 VDD VSS VDD VDD pfet_06v0 ad=7.92p pd=36.88u as=0 ps=0 w=18u l=2u
X51 VSS VDD VSS VSS nfet_06v0 ad=4.29p pd=20.38u as=0 ps=0 w=9.75u l=2u
X52 a_111110_159680# a_96374_159564# VDD VDD pfet_06v0 ad=2.5p pd=10.5u as=4.4p ps=20.88u w=10u l=1u
X53 a_29746_128854# a_29546_128810# a_30478_128854# VSS nfet_06v0 ad=2.2p pd=10.88u as=1.25p ps=5.5u w=5u l=1u
X54 a_77474_149156# a_81070_140870# a_78022_140914# VDD pfet_06v0 ad=1.76p pd=8.88u as=1.76p ps=8.88u w=4u l=1u
X55 a_35862_190951# a_97248_157284# VDD VDD pfet_06v0 ad=0.44p pd=2.88u as=0.44p ps=2.88u w=1u l=1u
X56 a_99096_168582# a_99096_168582# a_101360_168734# VSS nfet_06v0 ad=0.308p pd=2.28u as=0.175p ps=1.2u w=0.7u l=1u
X57 a_74848_134666# a_35862_169399# VSS ppolyf_u_1k r_width=1u r_length=76.45u
X58 a_77474_128810# a_74234_128810# a_77210_137612# VSS nfet_06v0 ad=1.1p pd=5.88u as=0.825p ps=3.16u w=2.5u l=1u
X59 a_98798_140914# a_57822_186759# cap_mim_2f0_m4m5_noshield c_width=25u c_length=8u
X60 a_99330_152822# a_32042_128810# a_96834_152822# VSS nfet_06v0 ad=3.74p pd=17.88u as=3.74p ps=17.88u w=8.5u l=1u
X61 a_32522_161580# a_32042_152778# a_29786_159680# VDD pfet_06v0 ad=0.22p pd=1.88u as=0.22p ps=1.88u w=0.5u l=1u
X62 a_57822_169399# a_56794_128854# VSS VSS nfet_06v0 ad=0.44p pd=2.88u as=0.44p ps=2.88u w=1u l=1u
X63 a_85150_128854# a_73934_128810# VSS VSS nfet_06v0 ad=1.25p pd=5.5u as=2.2p ps=10.88u w=5u l=1u
X64 a_58462_165043# a_52318_170197# a_61358_169943# VSS nfet_06v0 ad=1.1p pd=5.88u as=0.65p ps=3.02u w=2.5u l=1u
X65 a_91194_177177# a_90994_177061# VDD VDD pfet_06v0 ad=2.5p pd=10.5u as=4.4p ps=20.88u w=10u l=1u
X66 a_76854_182333# a_75542_182289# VDD VDD pfet_06v0 ad=2.5p pd=10.5u as=4.4p ps=20.88u w=10u l=1u
X67 a_96334_148656# a_96634_148656# a_107550_148772# VSS nfet_06v0 ad=2.2p pd=10.88u as=1.25p ps=5.5u w=5u l=1u
X68 a_56718_194537# a_52358_194421# VDD VDD pfet_06v0 ad=2.5p pd=10.5u as=4.4p ps=20.88u w=10u l=1u
X69 a_56658_173637# a_52318_173593# a_56358_173637# VSS nfet_06v0 ad=1.65p pd=5.66u as=1.25p ps=5.5u w=5u l=1u
X70 VSS a_37174_173707# a_35390_177107# VSS nfet_06v0 ad=1.1p pd=5.88u as=0.65p ps=3.02u w=2.5u l=1u
X71 a_65710_187257# a_52658_182289# a_69454_182333# VDD pfet_06v0 ad=4.4p pd=20.88u as=2.5p ps=10.5u w=10u l=1u
X72 a_76930_128854# a_32042_152778# a_74434_128854# VSS nfet_06v0 ad=3.74p pd=17.88u as=3.74p ps=17.88u w=8.5u l=1u
X73 a_51886_135712# a_51686_135596# VDD VDD pfet_06v0 ad=2.5p pd=10.5u as=4.4p ps=20.88u w=10u l=1u
X74 a_97248_134666# a_34750_173591# VSS ppolyf_u_1k r_width=1u r_length=76.45u
X75 VDD a_69782_169443# a_113914_164930# VDD pfet_06v0 ad=1.32p pd=6.88u as=0.75p ps=3.5u w=3u l=1u
X76 a_35862_173591# a_52560_145110# VDD VDD pfet_06v0 ad=0.44p pd=2.88u as=0.44p ps=2.88u w=1u l=1u
X77 VDD VSS VDD VDD pfet_06v0 ad=4.29p pd=20.38u as=0 ps=0 w=9.75u l=2u
X78 VSS VDD VSS VSS nfet_06v0 ad=4.29p pd=20.38u as=0 ps=0 w=9.75u l=2u
X79 a_58462_165043# a_69782_169443# cap_mim_2f0_m4m5_noshield c_width=20u c_length=10u
X80 a_99330_128854# a_23448_50576# a_96834_128854# VSS nfet_06v0 ad=3.74p pd=17.88u as=3.74p ps=17.88u w=8.5u l=1u
X81 a_42526_152822# a_29586_159564# VSS VSS nfet_06v0 ad=0.25p pd=1.5u as=0.44p ps=2.88u w=1u l=1u
X82 a_33646_164973# a_29286_164929# VDD VDD pfet_06v0 ad=2.5p pd=10.5u as=4.4p ps=20.88u w=10u l=1u
X83 a_59134_169443# a_35862_169399# a_56658_169513# VSS nfet_06v0 ad=1.3p pd=5.52u as=2.2p ps=10.88u w=5u l=1u
X84 a_38998_149572# a_31510_148272# cap_mim_2f0_m4m5_noshield c_width=25u c_length=8u
X85 VDD VSS VDD VDD pfet_06v0 ad=4.29p pd=20.38u as=0 ps=0 w=9.75u l=2u
X86 a_29446_152822# a_29246_152778# VSS VSS nfet_06v0 ad=1.25p pd=5.5u as=2.2p ps=10.88u w=5u l=1u
X87 a_58462_182403# a_60246_187303# VSS VSS nfet_06v0 ad=0.65p pd=3.02u as=1.1p ps=5.88u w=2.5u l=1u
X88 a_35390_177107# a_37174_173707# VSS VSS nfet_06v0 ad=0.65p pd=3.02u as=1.1p ps=5.88u w=2.5u l=1u
X89 VDD a_23448_70736# a_23448_70736# VDD pfet_06v0 ad=0.88p pd=4.88u as=0.52p ps=2.52u w=2u l=1u
X90 Y a_23448_131216# VDD ppolyf_u r_width=16u r_length=4u
X91 a_52878_148772# a_51646_148656# VSS VSS nfet_06v0 ad=1.25p pd=5.5u as=2.2p ps=10.88u w=5u l=1u
X92 a_36590_152822# a_29246_152778# VSS VSS nfet_06v0 ad=1.25p pd=5.5u as=2.2p ps=10.88u w=5u l=1u
X93 a_46710_191067# a_38286_191067# VSS VSS nfet_06v0 ad=1.3p pd=5.52u as=2.2p ps=10.88u w=5u l=1u
X94 a_98798_140914# a_99874_149156# VSS VSS nfet_06v0 ad=0.825p pd=3.16u as=1.1p ps=5.88u w=2.5u l=1u
X95 a_32242_187673# a_29586_182289# VSS VSS nfet_06v0 ad=0.25p pd=1.5u as=0.44p ps=2.88u w=1u l=1u
X96 VSS a_92966_169443# a_112558_166742# VSS nfet_06v0 ad=0.44p pd=2.88u as=0.25p ps=1.5u w=1u l=1u
X97 a_69782_173707# a_61358_173707# VSS VSS nfet_06v0 ad=1.3p pd=5.52u as=2.2p ps=10.88u w=5u l=1u
X98 a_52358_194421# a_52658_194421# a_55594_194537# VDD pfet_06v0 ad=4.4p pd=20.88u as=2.5p ps=10.5u w=10u l=1u
X99 a_52558_182333# a_52358_182289# VDD VDD pfet_06v0 ad=2.5p pd=10.5u as=4.4p ps=20.88u w=10u l=1u
X100 a_42526_128854# a_29586_135596# VSS VSS nfet_06v0 ad=0.25p pd=1.5u as=0.44p ps=2.88u w=1u l=1u
X101 S3N a_54442_128810# VDD ppolyf_u r_width=16u r_length=4u
X102 a_102380_164960# a_23448_190688# VSS VSS nfet_05v0 ad=0.5808p pd=3.52u as=0.5808p ps=3.52u w=1.32u l=0.6u
X103 YP_OUT YN_OUT VDD VDD pfet_05v0 ad=0.8052p pd=4.54u as=0.8052p ps=4.54u w=1.83u l=0.5u
X104 a_83878_165043# a_75842_164929# a_82318_169443# VDD pfet_06v0 ad=1.3p pd=5.52u as=2.2p ps=10.88u w=5u l=1u
X105 a_99096_173860# a_99096_173860# VDD VDD pfet_06v0 ad=0.88p pd=4.88u as=0.88p ps=4.88u w=2u l=1u
X106 a_82762_194467# a_83430_191067# VSS VSS nfet_06v0 ad=0.65p pd=3.02u as=1.1p ps=5.88u w=2.5u l=1u
X107 a_79902_164973# a_75542_164929# VDD VDD pfet_06v0 ad=2.5p pd=10.5u as=4.4p ps=20.88u w=10u l=1u
X108 a_90558_190997# a_76234_190953# VSS VSS nfet_06v0 ad=1.25p pd=5.5u as=2.2p ps=10.88u w=5u l=1u
X109 a_46710_186803# a_38286_187303# VSS VSS nfet_06v0 ad=2.2p pd=10.88u as=1.3p ps=5.52u w=5u l=1u
X110 a_29446_128854# a_29246_128810# VSS VSS nfet_06v0 ad=1.25p pd=5.5u as=2.2p ps=10.88u w=5u l=1u
X111 a_103470_140870# a_103470_140870# a_105106_140870# VDD pfet_06v0 ad=4.4p pd=20.88u as=3.3p ps=10.66u w=10u l=1u
X112 a_36590_128854# a_29246_128810# VSS VSS nfet_06v0 ad=1.25p pd=5.5u as=2.2p ps=10.88u w=5u l=1u
X113 a_52318_187557# a_52318_187557# VSS VSS nfet_06v0 ad=0.44p pd=2.88u as=0.44p ps=2.88u w=1u l=1u
X114 a_52998_140914# a_51686_140870# VDD VDD pfet_06v0 ad=2.5p pd=10.5u as=4.4p ps=20.88u w=10u l=1u
X115 VSS VDD VSS VSS nfet_06v0 ad=7.92p pd=36.88u as=0 ps=0 w=18u l=2u
X116 a_88894_173593# a_75842_177061# a_92638_177177# VDD pfet_06v0 ad=4.4p pd=20.88u as=2.5p ps=10.5u w=10u l=1u
X117 a_57350_182333# a_52658_182289# a_57018_182333# VDD pfet_06v0 ad=2.5p pd=10.5u as=3.3p ps=10.66u w=10u l=1u
X118 a_96374_140870# a_96674_140870# a_108582_149572# VSS nfet_06v0 ad=0.44p pd=2.88u as=0.25p ps=1.5u w=1u l=1u
X119 a_82762_177107# a_75502_173593# a_83430_173707# VSS nfet_06v0 ad=1.1p pd=5.88u as=0.65p ps=3.02u w=2.5u l=1u
D1 VSS Y diode_nd2ps_06v0 pj=40u area=99.99999p
X120 a_112222_159680# a_96374_159564# VDD VDD pfet_06v0 ad=2.5p pd=10.5u as=4.4p ps=20.88u w=10u l=1u
X121 a_34950_186803# a_29586_182289# a_38738_182403# VDD pfet_06v0 ad=2.2p pd=10.88u as=1.3p ps=5.52u w=5u l=1u
X122 a_30598_135712# a_29286_135596# VDD VDD pfet_06v0 ad=2.5p pd=10.5u as=4.4p ps=20.88u w=10u l=1u
X123 a_60694_195467# a_52658_194421# a_59134_191067# VDD pfet_06v0 ad=1.3p pd=5.52u as=2.2p ps=10.88u w=5u l=1u
X124 a_89358_182289# a_89358_182289# a_90994_182289# VDD pfet_06v0 ad=4.4p pd=20.88u as=3.3p ps=10.66u w=10u l=1u
X125 a_54110_137602# a_57822_169399# cap_mim_2f0_m4m5_noshield c_width=25u c_length=8u
X126 a_98598_152822# a_100422_159680# VDD VDD pfet_06v0 ad=2.2p pd=10.88u as=2.2p ps=10.88u w=5u l=1u
X127 a_37174_173707# a_29246_173593# a_36506_177107# VSS nfet_06v0 ad=0.65p pd=3.02u as=1.1p ps=5.88u w=2.5u l=1u
X128 VDD VSS VDD VDD pfet_06v0 ad=7.92p pd=36.88u as=0 ps=0 w=18u l=2u
X129 a_29546_148656# a_29586_140870# a_44022_140914# VDD pfet_06v0 ad=4.4p pd=20.88u as=2.5p ps=10.5u w=10u l=1u
X130 a_83878_165043# a_88894_169897# a_83430_169943# VSS nfet_06v0 ad=1.1p pd=5.88u as=1.1p ps=5.88u w=2.5u l=1u
X131 a_81070_160764# a_81070_160764# a_82706_159564# VDD pfet_06v0 ad=4.4p pd=20.88u as=3.3p ps=10.66u w=10u l=1u
X132 a_106750_140914# a_96374_140870# VDD VDD pfet_06v0 ad=2.5p pd=10.5u as=4.4p ps=20.88u w=10u l=1u
X133 a_61358_169943# a_66174_164929# a_61810_165043# VDD pfet_06v0 ad=2.2p pd=10.88u as=2.2p ps=10.88u w=5u l=1u
X134 a_81646_165043# a_75502_170197# a_84542_169943# VSS nfet_06v0 ad=1.1p pd=5.88u as=0.65p ps=3.02u w=2.5u l=1u
X135 a_84994_195467# a_75842_194421# a_81206_191067# VDD pfet_06v0 ad=1.3p pd=5.52u as=2.2p ps=10.88u w=5u l=1u
X136 a_79614_149256# a_79614_149256# a_82122_148656# VSS nfet_06v0 ad=2.2p pd=10.88u as=1.65p ps=5.66u w=5u l=1u
X137 S3P a_53710_128810# VDD ppolyf_u r_width=16u r_length=4u
X138 a_103470_140870# a_96634_148656# a_103678_148772# VSS nfet_06v0 ad=2.2p pd=10.88u as=1.25p ps=5.5u w=5u l=1u
X139 a_29246_190953# a_29246_190953# VSS VSS nfet_06v0 ad=0.44p pd=2.88u as=0.44p ps=2.88u w=1u l=1u
X140 VDD VSS VDD VDD pfet_06v0 ad=4.29p pd=20.38u as=0 ps=0 w=9.75u l=2u
X141 a_89822_135712# a_73974_135596# VDD VDD pfet_06v0 ad=2.5p pd=10.5u as=4.4p ps=20.88u w=10u l=1u
X142 a_61358_191067# a_52318_190953# a_58462_194467# VSS nfet_06v0 ad=0.65p pd=3.02u as=1.1p ps=5.88u w=2.5u l=1u
X143 a_34750_186759# a_74848_145110# VDD VDD pfet_06v0 ad=0.44p pd=2.88u as=0.44p ps=2.88u w=1u l=1u
X144 VSS VDD VSS VSS nfet_06v0 ad=0.44p pd=2.88u as=0 ps=0 w=1u l=2u
X145 a_37174_169943# a_43102_164929# a_37622_165043# VDD pfet_06v0 ad=2.2p pd=10.88u as=2.2p ps=10.88u w=5u l=1u
X146 VSS a_60246_169943# a_58462_165043# VSS nfet_06v0 ad=1.1p pd=5.88u as=0.65p ps=3.02u w=2.5u l=1u
X147 a_60618_140914# a_60418_140870# VDD VDD pfet_06v0 ad=2.5p pd=10.5u as=4.4p ps=20.88u w=10u l=1u
X148 a_84350_159680# a_73974_159564# VDD VDD pfet_06v0 ad=2.5p pd=10.5u as=4.4p ps=20.88u w=10u l=1u
X149 a_60694_182403# a_65710_187257# a_60246_187303# VSS nfet_06v0 ad=1.1p pd=5.88u as=1.1p ps=5.88u w=2.5u l=1u
D2 Y VDD diode_pd2nw_06v0 pj=40u area=99.99999p
X150 VSS a_53050_169397# a_56990_169513# VSS nfet_06v0 ad=2.2p pd=10.88u as=1.25p ps=5.5u w=5u l=1u
X151 a_78498_190997# a_75842_194421# VSS VSS nfet_06v0 ad=0.25p pd=1.5u as=0.44p ps=2.88u w=1u l=1u
X152 a_74848_145110# a_74274_140870# a_76198_148272# VDD pfet_06v0 ad=4.4p pd=20.88u as=4.4p ps=20.88u w=10u l=1u
X153 a_34394_152822# a_36382_160764# a_30160_157284# VDD pfet_06v0 ad=1.76p pd=8.88u as=1.76p ps=8.88u w=4u l=1u
X154 a_69782_191067# a_61358_191067# VSS VSS nfet_06v0 ad=2.2p pd=10.88u as=1.3p ps=5.52u w=5u l=1u
X155 a_91402_190953# a_75502_190953# a_91602_190997# VSS nfet_06v0 ad=1.65p pd=5.66u as=1.25p ps=5.5u w=5u l=1u
X156 a_106078_175068# a_111626_184098# VDD VDD pfet_06v0 ad=1.32p pd=6.88u as=1.32p ps=6.88u w=3u l=1u
X157 VDD VSS VDD VDD pfet_06v0 ad=0.44p pd=2.88u as=0 ps=0 w=1u l=2u
X158 a_43102_164929# a_29246_170197# a_44302_169513# VSS nfet_06v0 ad=2.2p pd=10.88u as=1.25p ps=5.5u w=5u l=1u
X159 a_33946_194537# a_35862_190951# a_36506_194467# VDD pfet_06v0 ad=4.4p pd=20.88u as=2.6p ps=10.52u w=10u l=1u
X160 VSS a_37174_187303# a_36506_182403# VSS nfet_06v0 ad=1.1p pd=5.88u as=0.65p ps=3.02u w=2.5u l=1u
X161 a_80534_177177# a_75842_177061# a_80202_177177# VDD pfet_06v0 ad=2.5p pd=10.5u as=3.3p ps=10.66u w=10u l=1u
X162 a_34278_182333# a_29586_182289# a_33946_182333# VDD pfet_06v0 ad=2.5p pd=10.5u as=3.3p ps=10.66u w=10u l=1u
X163 a_29586_135596# a_29586_135596# VDD VDD pfet_06v0 ad=0.88p pd=4.88u as=0.88p ps=4.88u w=2u l=1u
X164 a_36506_177107# a_35862_173591# a_33946_177177# VDD pfet_06v0 ad=2.6p pd=10.52u as=4.4p ps=20.88u w=10u l=1u
X165 a_23448_70736# a_23448_70736# VDD VDD pfet_06v0 ad=0.52p pd=2.52u as=0.52p ps=2.52u w=2u l=1u
X166 a_30478_152822# a_29246_152778# VSS VSS nfet_06v0 ad=1.25p pd=5.5u as=2.2p ps=10.88u w=5u l=1u
X167 a_29286_177061# a_29586_177061# a_31210_173637# VSS nfet_06v0 ad=0.44p pd=2.88u as=0.25p ps=1.5u w=1u l=1u
X168 ZN_OUT a_102380_182320# VDD VDD pfet_05v0 ad=0.8052p pd=4.54u as=0.8052p ps=4.54u w=1.83u l=0.5u
X169 a_53050_190953# a_52318_190953# a_53250_190997# VSS nfet_06v0 ad=2.2p pd=10.88u as=1.25p ps=5.5u w=5u l=1u
X170 a_92966_186803# a_84542_187303# VSS VSS nfet_06v0 ad=1.3p pd=5.52u as=2.2p ps=10.88u w=5u l=1u
D3 VSS Y diode_nd2ps_06v0 pj=40u area=99.99999p
X171 a_75542_194421# a_75842_194421# a_78778_194537# VDD pfet_06v0 ad=4.4p pd=20.88u as=2.5p ps=10.5u w=10u l=1u
X172 VDD a_23448_190688# a_23448_190688# VDD pfet_06v0 ad=0.52p pd=2.52u as=0.52p ps=2.52u w=2u l=1u
X173 a_36062_186803# a_29586_182289# a_37622_182403# VDD pfet_06v0 ad=2.2p pd=10.88u as=1.3p ps=5.52u w=5u l=1u
X174 a_99134_175068# a_99306_190940# VDD VDD pfet_06v0 ad=1.32p pd=6.88u as=1.32p ps=6.88u w=3u l=1u
X175 a_52658_164929# a_52658_164929# VDD VDD pfet_06v0 ad=0.88p pd=4.88u as=0.88p ps=4.88u w=2u l=1u
X176 VSS a_46710_173707# a_110806_173624# VSS nfet_06v0 ad=0.44p pd=2.88u as=0.44p ps=2.88u w=1u l=1u
X177 VDD VSS VDD VDD pfet_06v0 ad=7.92p pd=36.88u as=0 ps=0 w=18u l=2u
D4 VSS S4N diode_nd2ps_06v0 pj=40u area=99.99999p
X178 a_96374_159564# a_96674_159564# a_108582_152822# VSS nfet_06v0 ad=0.44p pd=2.88u as=0.25p ps=1.5u w=1u l=1u
X179 a_33586_190997# a_29246_190953# a_33286_190997# VSS nfet_06v0 ad=1.65p pd=5.66u as=1.25p ps=5.5u w=5u l=1u
X180 a_59134_173707# a_35862_173591# a_56658_173637# VSS nfet_06v0 ad=1.3p pd=5.52u as=2.2p ps=10.88u w=5u l=1u
X181 a_38286_173707# a_29246_173593# a_35390_177107# VSS nfet_06v0 ad=0.65p pd=3.02u as=1.1p ps=5.88u w=2.5u l=1u
X182 a_30478_128854# a_29246_128810# VSS VSS nfet_06v0 ad=1.25p pd=5.5u as=2.2p ps=10.88u w=5u l=1u
X183 a_101360_168734# a_99096_168582# a_101060_168734# VSS nfet_06v0 ad=0.175p pd=1.2u as=0.175p ps=1.2u w=0.7u l=1u
D5 VSS S4N diode_nd2ps_06v0 pj=40u area=99.99999p
X184 VSS VDD VSS VSS nfet_06v0 ad=7.92p pd=36.88u as=0 ps=0 w=18u l=2u
X185 a_74234_152778# a_74274_159564# a_88710_159680# VDD pfet_06v0 ad=4.4p pd=20.88u as=2.5p ps=10.5u w=10u l=1u
X186 a_92966_186803# a_81206_186803# cap_mim_2f0_m4m5_noshield c_width=20u c_length=10u
X187 a_100246_184486# a_92966_173707# VSS VSS nfet_06v0 ad=0.33p pd=1.66u as=0.44p ps=2.88u w=1u l=1u
X188 a_83430_173707# a_75502_173593# a_82762_177107# VSS nfet_06v0 ad=0.65p pd=3.02u as=1.1p ps=5.88u w=2.5u l=1u
X189 a_83878_195467# a_75842_194421# a_82318_191067# VDD pfet_06v0 ad=1.3p pd=5.52u as=2.2p ps=10.88u w=5u l=1u
X190 a_65710_169897# a_65710_169897# a_68218_169397# VSS nfet_06v0 ad=2.2p pd=10.88u as=1.65p ps=5.66u w=5u l=1u
X191 VSS VDD VSS VSS nfet_06v0 ad=4.29p pd=20.38u as=0 ps=0 w=9.75u l=2u
X192 a_107550_148772# a_96334_148656# VSS VSS nfet_06v0 ad=1.25p pd=5.5u as=2.2p ps=10.88u w=5u l=1u
X193 a_30160_143310# a_45578_143760# VSS ppolyf_u_1k r_width=1u r_length=76.45u
X194 a_69782_173707# a_61810_178107# VDD VDD pfet_06v0 ad=4.4p pd=20.88u as=2.6p ps=10.52u w=10u l=1u
X195 a_69454_182333# a_52358_182289# VDD VDD pfet_06v0 ad=2.5p pd=10.5u as=4.4p ps=20.88u w=10u l=1u
D6 S3P VDD diode_pd2nw_06v0 pj=40u area=99.99999p
X196 a_56358_173637# a_53050_173593# VSS VSS nfet_06v0 ad=1.25p pd=5.5u as=2.2p ps=10.88u w=5u l=1u
X197 a_37622_182403# a_42638_187257# a_37174_187303# VSS nfet_06v0 ad=1.1p pd=5.88u as=1.1p ps=5.88u w=2.5u l=1u
X198 a_59578_182403# a_60246_187303# VSS VSS nfet_06v0 ad=0.65p pd=3.02u as=0.65p ps=3.02u w=2.5u l=1u
X199 a_51686_135596# a_51986_135596# a_69458_135712# VDD pfet_06v0 ad=4.4p pd=20.88u as=2.5p ps=10.5u w=10u l=1u
X200 a_92966_169443# a_81206_169443# cap_mim_2f0_m4m5_noshield c_width=20u c_length=10u
X201 a_82318_169443# a_34750_169399# a_79842_169513# VSS nfet_06v0 ad=1.3p pd=5.52u as=2.2p ps=10.88u w=5u l=1u
X202 a_52658_177061# a_52658_177061# VDD VDD pfet_06v0 ad=0.88p pd=4.88u as=0.88p ps=4.88u w=2u l=1u
X203 a_67810_194421# a_52658_194421# a_68010_194537# VDD pfet_06v0 ad=3.3p pd=10.66u as=2.5p ps=10.5u w=10u l=1u
X204 a_96374_135596# a_96674_135596# a_108582_128854# VSS nfet_06v0 ad=0.44p pd=2.88u as=0.25p ps=1.5u w=1u l=1u
X205 a_36506_165043# a_37174_169943# VSS VSS nfet_06v0 ad=0.65p pd=3.02u as=1.1p ps=5.88u w=2.5u l=1u
D7 Y VDD diode_pd2nw_06v0 pj=40u area=99.99999p
X206 a_79842_190997# a_75502_190953# a_79542_190997# VSS nfet_06v0 ad=1.65p pd=5.66u as=1.25p ps=5.5u w=5u l=1u
X207 a_84542_169943# a_75502_170197# a_81646_165043# VSS nfet_06v0 ad=0.65p pd=3.02u as=1.1p ps=5.88u w=2.5u l=1u
X208 VDD VSS VDD VDD pfet_06v0 ad=0.44p pd=2.88u as=0 ps=0 w=1u l=2u
X209 VSS VDD VSS VSS nfet_06v0 ad=4.29p pd=20.38u as=0 ps=0 w=9.75u l=2u
X210 a_68218_190953# a_52318_190953# a_68418_190997# VSS nfet_06v0 ad=1.65p pd=5.66u as=1.25p ps=5.5u w=5u l=1u
X211 a_96634_148656# a_96674_140870# a_111110_140914# VDD pfet_06v0 ad=4.4p pd=20.88u as=2.5p ps=10.5u w=10u l=1u
X212 a_31710_161570# a_32786_152778# VSS VSS nfet_06v0 ad=0.825p pd=3.16u as=1.1p ps=5.88u w=2.5u l=1u
X213 a_76398_161570# a_57822_190951# cap_mim_2f0_m4m5_noshield c_width=25u c_length=8u
X214 VDD VSS VDD VDD pfet_06v0 ad=4.29p pd=20.38u as=0 ps=0 w=9.75u l=2u
X215 a_23448_70736# a_23448_70736# VDD VDD pfet_06v0 ad=0.52p pd=2.52u as=0.52p ps=2.52u w=2u l=1u
X216 a_29978_190953# a_29246_190953# a_30178_190997# VSS nfet_06v0 ad=2.2p pd=10.88u as=1.25p ps=5.5u w=5u l=1u
X217 a_38018_159564# a_29586_159564# a_38218_159680# VDD pfet_06v0 ad=3.3p pd=10.66u as=2.5p ps=10.5u w=10u l=1u
X218 a_32242_128854# a_33334_135712# VDD VDD pfet_06v0 ad=2.2p pd=10.88u as=2.2p ps=10.88u w=5u l=1u
X219 VSS a_99306_190940# a_99134_175068# VSS nfet_06v0 ad=0.44p pd=2.88u as=0.44p ps=2.88u w=1u l=1u
D8 S2P VDD diode_pd2nw_06v0 pj=40u area=99.99999p
X220 VDD a_75542_164929# a_80534_164973# VDD pfet_06v0 ad=4.4p pd=20.88u as=2.5p ps=10.5u w=10u l=1u
X221 a_35862_169399# a_74848_133316# VDD VDD pfet_06v0 ad=0.44p pd=2.88u as=0.44p ps=2.88u w=1u l=1u
X222 a_37434_148656# a_29546_148656# a_37634_148772# VSS nfet_06v0 ad=1.65p pd=5.66u as=1.25p ps=5.5u w=5u l=1u
X223 a_54110_161570# a_55186_152778# VSS VSS nfet_06v0 ad=0.825p pd=3.16u as=1.1p ps=5.88u w=2.5u l=1u
X224 a_92966_191067# a_84542_191067# VSS VSS nfet_06v0 ad=2.2p pd=10.88u as=1.3p ps=5.52u w=5u l=1u
X225 a_112558_166742# a_110806_166742# a_111626_166626# VSS nfet_06v0 ad=0.25p pd=1.5u as=0.44p ps=2.88u w=1u l=1u
X226 a_57018_182333# a_52658_182289# a_56718_182333# VDD pfet_06v0 ad=3.3p pd=10.66u as=2.5p ps=10.5u w=10u l=1u
X227 a_55594_194537# a_52358_194421# VDD VDD pfet_06v0 ad=2.5p pd=10.5u as=4.4p ps=20.88u w=10u l=1u
X228 a_102002_184626# a_23448_70736# a_103402_184696# VSS nfet_06v0 ad=0.88p pd=4.88u as=0.5p ps=2.5u w=2u l=1u
X229 a_99134_184486# a_92966_191067# VSS VSS nfet_06v0 ad=0.33p pd=1.66u as=0.44p ps=2.88u w=1u l=1u
X230 a_54642_128854# a_55734_135712# VDD VDD pfet_06v0 ad=2.2p pd=10.88u as=2.2p ps=10.88u w=5u l=1u
X231 VSS VDD VSS VSS nfet_06v0 ad=4.29p pd=20.38u as=0 ps=0 w=9.75u l=2u
X232 a_31710_137602# a_32786_128810# VSS VSS nfet_06v0 ad=0.825p pd=3.16u as=1.1p ps=5.88u w=2.5u l=1u
X233 a_74274_140870# a_74274_140870# a_87214_149572# VSS nfet_06v0 ad=0.44p pd=2.88u as=0.25p ps=1.5u w=1u l=1u
X234 a_29546_148656# a_29546_148656# VSS VSS nfet_06v0 ad=0.44p pd=2.88u as=0.44p ps=2.88u w=1u l=1u
X235 a_52358_164929# a_52658_164929# a_54282_170313# VSS nfet_06v0 ad=0.44p pd=2.88u as=0.25p ps=1.5u w=1u l=1u
X236 a_42638_169897# a_42638_169897# a_45146_169397# VSS nfet_06v0 ad=2.2p pd=10.88u as=1.65p ps=5.66u w=5u l=1u
X237 a_76234_190953# a_75502_190953# a_76434_190997# VSS nfet_06v0 ad=2.2p pd=10.88u as=1.25p ps=5.5u w=5u l=1u
X238 a_31510_128854# a_33334_135712# VDD VDD pfet_06v0 ad=2.2p pd=10.88u as=2.2p ps=10.88u w=5u l=1u
X239 a_92638_177177# a_75542_177061# VDD VDD pfet_06v0 ad=2.5p pd=10.5u as=4.4p ps=20.88u w=10u l=1u
X240 a_108582_149572# a_96674_140870# VSS VSS nfet_06v0 ad=0.25p pd=1.5u as=0.44p ps=2.88u w=1u l=1u
X241 a_54110_137602# a_55186_128810# VSS VSS nfet_06v0 ad=0.825p pd=3.16u as=1.1p ps=5.88u w=2.5u l=1u
X242 VDD a_60694_165043# a_58022_169443# VDD pfet_06v0 ad=1.3p pd=5.52u as=1.3p ps=5.52u w=5u l=1u
X243 a_101482_152822# a_103470_160764# a_97248_157284# VDD pfet_06v0 ad=1.76p pd=8.88u as=1.76p ps=8.88u w=4u l=1u
X244 a_60246_169943# a_52318_170197# a_59578_165043# VSS nfet_06v0 ad=0.65p pd=3.02u as=1.1p ps=5.88u w=2.5u l=1u
D9 S3P VDD diode_pd2nw_06v0 pj=40u area=99.99999p
X245 a_37622_182403# a_29586_182289# a_36062_186803# VDD pfet_06v0 ad=1.3p pd=5.52u as=2.2p ps=10.88u w=5u l=1u
X246 a_74848_144210# a_90266_144660# VSS ppolyf_u_1k r_width=1u r_length=76.45u
X247 a_75842_164929# a_75842_164929# VDD VDD pfet_06v0 ad=0.88p pd=4.88u as=0.88p ps=4.88u w=2u l=1u
X248 a_44738_194421# a_29586_194421# a_44938_194537# VDD pfet_06v0 ad=3.3p pd=10.66u as=2.5p ps=10.5u w=10u l=1u
X249 a_96674_135596# a_96674_135596# VDD VDD pfet_06v0 ad=0.88p pd=4.88u as=0.88p ps=4.88u w=2u l=1u
D10 VSS S3P diode_nd2ps_06v0 pj=40u area=99.99999p
X250 a_80202_177177# a_38998_149572# a_81646_177107# VDD pfet_06v0 ad=4.4p pd=20.88u as=2.6p ps=10.52u w=10u l=1u
X251 VDD VSS VDD VDD pfet_06v0 ad=7.92p pd=36.88u as=0 ps=0 w=18u l=2u
X252 a_91194_164973# a_90994_164929# VDD VDD pfet_06v0 ad=2.5p pd=10.5u as=4.4p ps=20.88u w=10u l=1u
X253 a_57018_177177# a_35862_173591# a_59578_177107# VDD pfet_06v0 ad=4.4p pd=20.88u as=2.6p ps=10.52u w=10u l=1u
X254 a_58462_177107# a_60246_173707# VSS VSS nfet_06v0 ad=0.65p pd=3.02u as=1.1p ps=5.88u w=2.5u l=1u
X255 a_97248_144210# a_112666_144660# VSS ppolyf_u_1k r_width=1u r_length=76.45u
X256 a_57326_128810# a_51986_135596# a_62062_135712# VDD pfet_06v0 ad=4.4p pd=20.88u as=2.5p ps=10.5u w=10u l=1u
X257 VSS a_46710_191067# a_103078_190984# VSS nfet_06v0 ad=0.44p pd=2.88u as=0.25p ps=1.5u w=1u l=1u
X258 a_103678_148772# a_96334_148656# VSS VSS nfet_06v0 ad=1.25p pd=5.5u as=2.2p ps=10.88u w=5u l=1u
X259 a_35862_173591# a_52560_145110# VDD VDD pfet_06v0 ad=0.44p pd=2.88u as=0.44p ps=2.88u w=1u l=1u
X260 a_74434_148772# a_74234_148656# a_74134_148772# VSS nfet_06v0 ad=2.2p pd=10.88u as=1.25p ps=5.5u w=5u l=1u
X261 a_35390_165043# a_37174_169943# VSS VSS nfet_06v0 ad=0.65p pd=3.02u as=0.65p ps=3.02u w=2.5u l=1u
X262 a_75842_177061# a_75842_177061# VDD VDD pfet_06v0 ad=0.88p pd=4.88u as=0.88p ps=4.88u w=2u l=1u
X263 VDD a_61810_178107# a_69782_173707# VDD pfet_06v0 ad=2.6p pd=10.52u as=2.6p ps=10.52u w=10u l=1u
X264 a_35390_194467# a_29246_190953# a_38286_191067# VSS nfet_06v0 ad=1.1p pd=5.88u as=0.65p ps=3.02u w=2.5u l=1u
X265 a_34750_173591# a_97248_133316# VDD VDD pfet_06v0 ad=0.44p pd=2.88u as=0.44p ps=2.88u w=1u l=1u
X266 a_30160_144210# a_45578_143760# VSS ppolyf_u_1k r_width=1u r_length=76.45u
X267 VSS a_60246_187303# a_59578_182403# VSS nfet_06v0 ad=0.65p pd=3.02u as=0.65p ps=3.02u w=2.5u l=1u
X268 a_33946_164973# a_34750_169399# a_35390_165043# VDD pfet_06v0 ad=4.4p pd=20.88u as=2.6p ps=10.52u w=10u l=1u
D11 S2P VDD diode_pd2nw_06v0 pj=40u area=99.99999p
X269 VDD VSS VDD VDD pfet_06v0 ad=7.92p pd=36.88u as=0 ps=0 w=18u l=2u
X270 a_60246_191067# a_66174_195421# a_60694_195467# VDD pfet_06v0 ad=2.2p pd=10.88u as=2.2p ps=10.88u w=5u l=1u
X271 a_29246_173593# a_29586_177061# a_29486_177177# VDD pfet_06v0 ad=4.4p pd=20.88u as=2.5p ps=10.5u w=10u l=1u
X272 a_99134_167126# a_102146_190940# VDD VDD pfet_06v0 ad=1.32p pd=6.88u as=1.32p ps=6.88u w=3u l=1u
D12 VSS S2P diode_nd2ps_06v0 pj=40u area=99.99999p
X273 VDD VSS VDD VDD pfet_06v0 ad=4.29p pd=20.38u as=0 ps=0 w=9.75u l=2u
X274 VSS VDD VSS VSS nfet_06v0 ad=4.29p pd=20.38u as=0 ps=0 w=9.75u l=2u
X275 a_91602_190997# a_91402_190953# VSS VSS nfet_06v0 ad=1.25p pd=5.5u as=2.2p ps=10.88u w=5u l=1u
X276 a_44302_169513# a_29978_169397# VSS VSS nfet_06v0 ad=1.25p pd=5.5u as=2.2p ps=10.88u w=5u l=1u
D13 Z VDD diode_pd2nw_06v0 pj=40u area=99.99999p
X277 VDD a_23448_70736# a_23448_70736# VDD pfet_06v0 ad=0.52p pd=2.52u as=0.52p ps=2.52u w=2u l=1u
X278 a_96874_135712# a_96674_135596# a_96574_135712# VDD pfet_06v0 ad=4.4p pd=20.88u as=2.5p ps=10.5u w=10u l=1u
X279 a_52146_152822# a_51946_152778# a_51846_152822# VSS nfet_06v0 ad=2.2p pd=10.88u as=1.25p ps=5.5u w=5u l=1u
X280 a_69782_191067# a_58022_191067# cap_mim_2f0_m4m5_noshield c_width=20u c_length=10u
X281 a_31210_173637# a_29586_177061# VSS VSS nfet_06v0 ad=0.25p pd=1.5u as=0.44p ps=2.88u w=1u l=1u
X282 a_53250_190997# a_53050_190953# VSS VSS nfet_06v0 ad=1.25p pd=5.5u as=2.2p ps=10.88u w=5u l=1u
X283 a_32786_149156# a_29546_148656# a_32522_140914# VSS nfet_06v0 ad=1.1p pd=5.88u as=0.825p ps=3.16u w=2.5u l=1u
X284 a_23448_190688# a_23448_190688# VDD VDD pfet_06v0 ad=0.52p pd=2.52u as=0.88p ps=4.88u w=2u l=1u
X285 a_82318_173707# a_34750_173591# a_79842_173637# VSS nfet_06v0 ad=1.3p pd=5.52u as=2.2p ps=10.88u w=5u l=1u
X286 a_78778_194537# a_75542_194421# VDD VDD pfet_06v0 ad=2.5p pd=10.5u as=4.4p ps=20.88u w=10u l=1u
X287 a_34750_190951# a_52560_157284# VDD VDD pfet_06v0 ad=0.44p pd=2.88u as=0.44p ps=2.88u w=1u l=1u
X288 VDD a_60694_165043# a_59134_169443# VDD pfet_06v0 ad=2.2p pd=10.88u as=1.3p ps=5.52u w=5u l=1u
X289 a_30178_190997# a_29978_190953# VSS VSS nfet_06v0 ad=1.25p pd=5.5u as=2.2p ps=10.88u w=5u l=1u
X290 a_33918_190997# a_29246_190953# a_33586_190997# VSS nfet_06v0 ad=1.25p pd=5.5u as=1.65p ps=5.66u w=5u l=1u
X291 VSS a_84542_191067# a_92966_191067# VSS nfet_06v0 ad=1.3p pd=5.52u as=1.3p ps=5.52u w=5u l=1u
X292 a_53910_148272# a_55734_140914# VDD VDD pfet_06v0 ad=2.2p pd=10.88u as=2.2p ps=10.88u w=5u l=1u
X293 a_36506_182403# a_35862_186759# a_33946_182333# VDD pfet_06v0 ad=2.6p pd=10.52u as=4.4p ps=20.88u w=10u l=1u
X294 a_88894_169897# a_88894_169897# a_91402_169397# VSS nfet_06v0 ad=2.2p pd=10.88u as=1.65p ps=5.66u w=5u l=1u
X295 a_69782_173707# a_58022_173707# cap_mim_2f0_m4m5_noshield c_width=20u c_length=10u
X296 a_98798_161570# a_99874_152778# VSS VSS nfet_06v0 ad=0.825p pd=3.16u as=1.1p ps=5.88u w=2.5u l=1u
X297 a_74274_159564# a_74274_159564# a_87214_152822# VSS nfet_06v0 ad=0.44p pd=2.88u as=0.25p ps=1.5u w=1u l=1u
X298 a_29546_152778# a_29546_152778# VSS VSS nfet_06v0 ad=0.44p pd=2.88u as=0.44p ps=2.88u w=1u l=1u
X299 a_51646_148656# a_51946_148656# a_62862_148772# VSS nfet_06v0 ad=2.2p pd=10.88u as=1.25p ps=5.5u w=5u l=1u
X300 a_99296_185986# a_106078_184486# a_23448_70736# VSS nfet_06v0 ad=1.0912p pd=5.84u as=0.6448p ps=3u w=2.48u l=1u
X301 a_89358_182289# a_75502_187557# a_90558_186873# VSS nfet_06v0 ad=2.2p pd=10.88u as=1.25p ps=5.5u w=5u l=1u
X302 a_100422_159680# a_102014_152778# a_99874_152778# VSS nfet_06v0 ad=0.88p pd=4.88u as=0.88p ps=4.88u w=2u l=1u
X303 a_88894_169897# a_75842_164929# a_92638_164973# VDD pfet_06v0 ad=4.4p pd=20.88u as=2.5p ps=10.5u w=10u l=1u
X304 a_75542_164929# a_75842_164929# a_77466_170313# VSS nfet_06v0 ad=0.44p pd=2.88u as=0.25p ps=1.5u w=1u l=1u
X305 VSS a_83430_187303# a_81646_182403# VSS nfet_06v0 ad=1.1p pd=5.88u as=0.65p ps=3.02u w=2.5u l=1u
X306 a_105106_159564# a_96674_159564# a_105306_159680# VDD pfet_06v0 ad=3.3p pd=10.66u as=2.5p ps=10.5u w=10u l=1u
D14 VSS S3P diode_nd2ps_06v0 pj=40u area=99.99999p
X307 a_99330_128854# a_100422_135712# VDD VDD pfet_06v0 ad=2.2p pd=10.88u as=2.2p ps=10.88u w=5u l=1u
X308 XP_OUT XN_OUT VDD VDD pfet_05v0 ad=0.8052p pd=4.54u as=0.8052p ps=4.54u w=1.83u l=0.5u
X309 a_52146_128854# a_51946_128810# a_51846_128854# VSS nfet_06v0 ad=2.2p pd=10.88u as=1.25p ps=5.5u w=5u l=1u
X310 a_108582_152822# a_96674_159564# VSS VSS nfet_06v0 ad=0.25p pd=1.5u as=0.44p ps=2.88u w=1u l=1u
X311 a_33286_190997# a_29978_190953# VSS VSS nfet_06v0 ad=1.25p pd=5.5u as=2.2p ps=10.88u w=5u l=1u
X312 a_57018_177177# a_38998_149572# a_58462_177107# VDD pfet_06v0 ad=4.4p pd=20.88u as=2.6p ps=10.52u w=10u l=1u
X313 a_96834_148772# a_96634_148656# a_97566_148772# VSS nfet_06v0 ad=2.2p pd=10.88u as=1.25p ps=5.5u w=5u l=1u
X314 a_34750_186759# a_79082_149272# VSS VSS nfet_06v0 ad=0.44p pd=2.88u as=0.44p ps=2.88u w=1u l=1u
X315 VDD a_83878_165043# a_81206_169443# VDD pfet_06v0 ad=1.3p pd=5.52u as=1.3p ps=5.52u w=5u l=1u
X316 VDD a_60694_178107# a_58022_173707# VDD pfet_06v0 ad=2.2p pd=10.88u as=1.3p ps=5.52u w=5u l=1u
X317 a_104522_148656# a_96634_148656# a_104722_148772# VSS nfet_06v0 ad=1.65p pd=5.66u as=1.25p ps=5.5u w=5u l=1u
X318 a_47058_135712# a_29286_135596# VDD VDD pfet_06v0 ad=2.5p pd=10.5u as=4.4p ps=20.88u w=10u l=1u
X319 a_88710_159680# a_73974_159564# VDD VDD pfet_06v0 ad=2.5p pd=10.5u as=4.4p ps=20.88u w=10u l=1u
X320 a_77210_140914# a_23448_50576# a_74474_140914# VDD pfet_06v0 ad=0.22p pd=1.88u as=0.22p ps=1.88u w=0.5u l=1u
X321 a_57822_169399# a_52560_133316# VDD VDD pfet_06v0 ad=0.44p pd=2.88u as=0.44p ps=2.88u w=1u l=1u
X322 a_58022_169443# a_60694_165043# VDD VDD pfet_06v0 ad=1.3p pd=5.52u as=2.2p ps=10.88u w=5u l=1u
X323 a_52658_177061# a_52658_177061# a_55314_173637# VSS nfet_06v0 ad=0.44p pd=2.88u as=0.25p ps=1.5u w=1u l=1u
X324 a_29546_128810# a_29546_128810# VSS VSS nfet_06v0 ad=0.44p pd=2.88u as=0.44p ps=2.88u w=1u l=1u
X325 a_74274_135596# a_74274_135596# a_87214_128854# VSS nfet_06v0 ad=0.44p pd=2.88u as=0.25p ps=1.5u w=1u l=1u
X326 a_98798_137602# a_99874_128810# VSS VSS nfet_06v0 ad=0.825p pd=3.16u as=1.1p ps=5.88u w=2.5u l=1u
X327 VSS VDD VSS VSS nfet_06v0 ad=4.29p pd=20.38u as=0 ps=0 w=9.75u l=2u
X328 a_100422_135712# a_102014_128810# a_99874_128810# VSS nfet_06v0 ad=0.88p pd=4.88u as=0.88p ps=4.88u w=2u l=1u
X329 VSS a_37174_173707# a_36506_177107# VSS nfet_06v0 ad=1.1p pd=5.88u as=0.65p ps=3.02u w=2.5u l=1u
X330 a_69458_135712# a_51686_135596# VDD VDD pfet_06v0 ad=2.5p pd=10.5u as=4.4p ps=20.88u w=10u l=1u
X331 a_74848_145110# a_90266_144660# VSS ppolyf_u_1k r_width=1u r_length=76.45u
X332 a_74848_157734# a_90266_157284# VSS ppolyf_u_1k r_width=1u r_length=76.45u
X333 a_108582_128854# a_96674_135596# VSS VSS nfet_06v0 ad=0.25p pd=1.5u as=0.44p ps=2.88u w=1u l=1u
X334 VDD a_60694_195467# a_58022_191067# VDD pfet_06v0 ad=1.3p pd=5.52u as=1.3p ps=5.52u w=5u l=1u
X335 a_69782_186803# a_61810_182403# VDD VDD pfet_06v0 ad=4.4p pd=20.88u as=2.6p ps=10.52u w=10u l=1u
X336 a_79542_190997# a_76234_190953# VSS VSS nfet_06v0 ad=1.25p pd=5.5u as=2.2p ps=10.88u w=5u l=1u
X337 a_30160_157284# a_29586_159564# a_31510_152822# VDD pfet_06v0 ad=4.4p pd=20.88u as=4.4p ps=20.88u w=10u l=1u
D15 VSS S2P diode_nd2ps_06v0 pj=40u area=99.99999p
X338 a_96874_140914# a_96674_140870# a_97686_140914# VDD pfet_06v0 ad=4.4p pd=20.88u as=2.5p ps=10.5u w=10u l=1u
X339 VSS a_111626_184098# a_106078_175068# VSS nfet_06v0 ad=0.44p pd=2.88u as=0.44p ps=2.88u w=1u l=1u
X340 a_97248_145110# a_112666_144660# VSS ppolyf_u_1k r_width=1u r_length=76.45u
X341 a_97248_157734# a_112666_157284# VSS ppolyf_u_1k r_width=1u r_length=76.45u
X342 VDD a_84994_178107# a_92966_173707# VDD pfet_06v0 ad=2.6p pd=10.52u as=2.6p ps=10.52u w=10u l=1u
X343 a_68418_190997# a_68218_190953# VSS VSS nfet_06v0 ad=1.25p pd=5.5u as=2.2p ps=10.88u w=5u l=1u
X344 VSS VDD VSS VSS nfet_06v0 ad=0.44p pd=2.88u as=0 ps=0 w=1u l=2u
X345 a_74474_135712# a_74274_135596# a_75286_135712# VDD pfet_06v0 ad=4.4p pd=20.88u as=2.5p ps=10.5u w=10u l=1u
X346 a_32786_128810# a_36382_136796# a_33334_135712# VDD pfet_06v0 ad=1.76p pd=8.88u as=1.76p ps=8.88u w=4u l=1u
X347 S1P a_31310_152778# VDD ppolyf_u r_width=16u r_length=4u
X348 VSS a_83430_187303# a_82762_182403# VSS nfet_06v0 ad=0.65p pd=3.02u as=0.65p ps=3.02u w=2.5u l=1u
X349 a_74848_157284# a_90266_157284# VSS ppolyf_u_1k r_width=1u r_length=76.45u
X350 VDD a_37622_165043# a_34950_169443# VDD pfet_06v0 ad=2.2p pd=10.88u as=1.3p ps=5.52u w=5u l=1u
X351 VSS a_37174_169943# a_35390_165043# VSS nfet_06v0 ad=0.65p pd=3.02u as=0.65p ps=3.02u w=2.5u l=1u
X352 a_76398_137602# a_35862_169399# cap_mim_2f0_m4m5_noshield c_width=25u c_length=8u
X353 VSS a_69782_191067# a_99134_184486# VSS nfet_06v0 ad=0.44p pd=2.88u as=0.33p ps=1.66u w=1u l=1u
X354 a_56794_149272# a_51946_148656# a_54110_140914# VSS nfet_06v0 ad=1.1p pd=5.88u as=0.825p ps=3.16u w=2.5u l=1u
X355 a_52560_157284# a_51986_159564# a_53910_152822# VDD pfet_06v0 ad=4.4p pd=20.88u as=4.4p ps=20.88u w=10u l=1u
X356 a_38218_159680# a_38018_159564# VDD VDD pfet_06v0 ad=2.5p pd=10.5u as=4.4p ps=20.88u w=10u l=1u
X357 a_83430_191067# a_89358_195421# a_83878_195467# VDD pfet_06v0 ad=2.2p pd=10.88u as=2.2p ps=10.88u w=5u l=1u
X358 VDD VSS VDD VDD pfet_06v0 ad=7.92p pd=36.88u as=0 ps=0 w=18u l=2u
X359 a_92966_169443# a_84994_165043# VDD VDD pfet_06v0 ad=4.4p pd=20.88u as=2.6p ps=10.52u w=10u l=1u
X360 a_59578_182403# a_60246_187303# VSS VSS nfet_06v0 ad=0.65p pd=3.02u as=1.1p ps=5.88u w=2.5u l=1u
X361 a_35390_165043# a_34750_169399# a_33946_164973# VDD pfet_06v0 ad=2.6p pd=10.52u as=4.4p ps=20.88u w=10u l=1u
X362 a_38286_173707# a_43102_178061# a_38738_178107# VDD pfet_06v0 ad=2.2p pd=10.88u as=2.2p ps=10.88u w=5u l=1u
X363 YP_OUT YN_OUT VSS VSS nfet_05v0 ad=0.5808p pd=3.52u as=0.5808p ps=3.52u w=1.32u l=0.6u
D16 S4N VDD diode_pd2nw_06v0 pj=40u area=99.99999p
X364 a_80534_164973# a_75842_164929# a_80202_164973# VDD pfet_06v0 ad=2.5p pd=10.5u as=3.3p ps=10.66u w=10u l=1u
X365 a_76398_140914# a_77474_149156# VSS VSS nfet_06v0 ad=0.825p pd=3.16u as=1.1p ps=5.88u w=2.5u l=1u
X366 a_37634_148772# a_37434_148656# VSS VSS nfet_06v0 ad=1.25p pd=5.5u as=2.2p ps=10.88u w=5u l=1u
X367 a_58022_173707# a_52658_177061# a_61810_178107# VDD pfet_06v0 ad=2.2p pd=10.88u as=1.3p ps=5.52u w=5u l=1u
X368 a_35862_173591# a_53910_148272# cap_mim_2f0_m4m5_noshield c_width=25u c_length=8u
X369 a_56718_182333# a_52358_182289# VDD VDD pfet_06v0 ad=2.5p pd=10.5u as=4.4p ps=20.88u w=10u l=1u
X370 a_51686_140870# a_51986_140870# a_63894_149572# VSS nfet_06v0 ad=0.44p pd=2.88u as=0.25p ps=1.5u w=1u l=1u
X371 a_97248_157284# a_112666_157284# VSS ppolyf_u_1k r_width=1u r_length=76.45u
X372 VDD a_38738_165043# a_46710_169443# VDD pfet_06v0 ad=2.6p pd=10.52u as=2.6p ps=10.52u w=10u l=1u
X373 a_43102_178061# a_43102_178061# a_44738_177061# VDD pfet_06v0 ad=4.4p pd=20.88u as=3.3p ps=10.66u w=10u l=1u
X374 a_103402_184696# a_23448_70736# VSS VSS nfet_06v0 ad=0.5p pd=2.5u as=0.88p ps=4.88u w=2u l=1u
X375 a_77474_152778# a_81070_160764# a_78022_159680# VDD pfet_06v0 ad=1.76p pd=8.88u as=1.76p ps=8.88u w=4u l=1u
X376 VSS VDD VSS VSS nfet_06v0 ad=4.29p pd=20.38u as=0 ps=0 w=9.75u l=2u
X377 a_87214_149572# a_74274_140870# VSS VSS nfet_06v0 ad=0.25p pd=1.5u as=0.44p ps=2.88u w=1u l=1u
X378 a_54282_170313# a_52658_164929# VSS VSS nfet_06v0 ad=0.25p pd=1.5u as=0.44p ps=2.88u w=1u l=1u
X379 a_76434_190997# a_76234_190953# VSS VSS nfet_06v0 ad=1.25p pd=5.5u as=2.2p ps=10.88u w=5u l=1u
X380 VDD VSS VDD VDD pfet_06v0 ad=7.92p pd=36.88u as=0 ps=0 w=18u l=2u
X381 a_59578_177107# a_60246_173707# VSS VSS nfet_06v0 ad=0.65p pd=3.02u as=0.65p ps=3.02u w=2.5u l=1u
X382 a_34950_169443# a_37622_165043# VDD VDD pfet_06v0 ad=1.3p pd=5.52u as=2.2p ps=10.88u w=5u l=1u
X383 a_33586_169513# a_34750_169399# a_34950_169443# VSS nfet_06v0 ad=2.2p pd=10.88u as=1.3p ps=5.52u w=5u l=1u
X384 a_62062_140914# a_51686_140870# VDD VDD pfet_06v0 ad=2.5p pd=10.5u as=4.4p ps=20.88u w=10u l=1u
X385 a_100158_167170# a_100246_167126# a_23448_190688# VSS nfet_06v0 ad=1.0912p pd=5.84u as=0.6448p ps=3u w=2.48u l=1u
X386 a_59134_169443# a_60694_165043# VDD VDD pfet_06v0 ad=1.3p pd=5.52u as=1.3p ps=5.52u w=5u l=1u
X387 a_82706_135596# a_74274_135596# a_82906_135712# VDD pfet_06v0 ad=3.3p pd=10.66u as=2.5p ps=10.5u w=10u l=1u
X388 a_30160_157284# a_34926_152778# a_34394_152822# VSS nfet_06v0 ad=0.88p pd=4.88u as=0.88p ps=4.88u w=2u l=1u
X389 a_23448_131216# a_100246_175068# a_100158_175184# VSS nfet_06v0 ad=0.6448p pd=3u as=1.0912p ps=5.84u w=2.48u l=1u
X390 VDD VSS VDD VDD pfet_06v0 ad=7.92p pd=36.88u as=0 ps=0 w=18u l=2u
X391 a_29246_152778# a_29546_152778# a_40462_152822# VSS nfet_06v0 ad=2.2p pd=10.88u as=1.25p ps=5.5u w=5u l=1u
X392 a_36506_194467# a_29246_190953# a_37174_191067# VSS nfet_06v0 ad=1.1p pd=5.88u as=0.65p ps=3.02u w=2.5u l=1u
X393 VSS VDD VSS VSS nfet_06v0 ad=0.44p pd=2.88u as=0 ps=0 w=1u l=2u
X394 a_57822_190951# a_79082_152822# VSS VSS nfet_06v0 ad=0.44p pd=2.88u as=0.44p ps=2.88u w=1u l=1u
X395 a_46710_186803# a_34950_186803# cap_mim_2f0_m4m5_noshield c_width=20u c_length=10u
X396 VDD a_83878_178107# a_81206_173707# VDD pfet_06v0 ad=2.2p pd=10.88u as=1.3p ps=5.52u w=5u l=1u
X397 VDD a_60694_195467# a_59134_191067# VDD pfet_06v0 ad=2.2p pd=10.88u as=1.3p ps=5.52u w=5u l=1u
X398 a_79842_190997# a_34750_190951# a_82318_191067# VSS nfet_06v0 ad=2.2p pd=10.88u as=1.3p ps=5.52u w=5u l=1u
X399 a_79082_128854# a_81070_136796# a_74848_133316# VDD pfet_06v0 ad=1.76p pd=8.88u as=1.76p ps=8.88u w=4u l=1u
X400 a_35862_169399# a_74848_133316# VDD VDD pfet_06v0 ad=0.44p pd=2.88u as=0.44p ps=2.88u w=1u l=1u
X401 a_99874_149156# a_96634_148656# a_99610_140914# VSS nfet_06v0 ad=1.1p pd=5.88u as=0.825p ps=3.16u w=2.5u l=1u
X402 a_52560_157284# a_57326_152778# a_56794_152822# VSS nfet_06v0 ad=0.88p pd=4.88u as=0.88p ps=4.88u w=2u l=1u
X403 a_98798_161570# a_31310_128810# a_96874_159680# VDD pfet_06v0 ad=0.242p pd=1.98u as=0.242p ps=1.98u w=0.55u l=1u
X404 a_58462_177107# a_38998_149572# a_57018_177177# VDD pfet_06v0 ad=2.6p pd=10.52u as=4.4p ps=20.88u w=10u l=1u
X405 a_74434_152822# a_74234_152778# a_75166_152822# VSS nfet_06v0 ad=2.2p pd=10.88u as=1.25p ps=5.5u w=5u l=1u
X406 a_81206_169443# a_83878_165043# VDD VDD pfet_06v0 ad=1.3p pd=5.52u as=2.2p ps=10.88u w=5u l=1u
X407 VDD VSS VDD VDD pfet_06v0 ad=4.29p pd=20.38u as=0 ps=0 w=9.75u l=2u
X408 a_52358_182289# a_52658_182289# a_55594_182333# VDD pfet_06v0 ad=4.4p pd=20.88u as=2.5p ps=10.5u w=10u l=1u
X409 a_46710_169443# a_34950_169443# cap_mim_2f0_m4m5_noshield c_width=20u c_length=10u
X410 VSS VDD VSS VSS nfet_06v0 ad=7.92p pd=36.88u as=0 ps=0 w=18u l=2u
X411 a_102380_177524# a_23448_131216# VDD VDD pfet_05v0 ad=0.8052p pd=4.54u as=0.8052p ps=4.54u w=1.83u l=0.5u
X412 a_30160_133316# a_34926_128810# a_34394_128854# VSS nfet_06v0 ad=0.88p pd=4.88u as=0.88p ps=4.88u w=2u l=1u
X413 a_36062_191067# a_35862_190951# a_33586_190997# VSS nfet_06v0 ad=1.3p pd=5.52u as=2.2p ps=10.88u w=5u l=1u
X414 a_57018_182333# a_35862_186759# a_59578_182403# VDD pfet_06v0 ad=4.4p pd=20.88u as=2.6p ps=10.52u w=10u l=1u
X415 VSS a_46710_169443# a_110806_166742# VSS nfet_06v0 ad=0.44p pd=2.88u as=0.44p ps=2.88u w=1u l=1u
X416 a_80202_182333# a_57822_186759# a_81646_182403# VDD pfet_06v0 ad=4.4p pd=20.88u as=2.6p ps=10.52u w=10u l=1u
X417 a_56658_169513# a_52318_170197# a_56358_169513# VSS nfet_06v0 ad=1.65p pd=5.66u as=1.25p ps=5.5u w=5u l=1u
X418 a_29246_128810# a_29546_128810# a_40462_128854# VSS nfet_06v0 ad=2.2p pd=10.88u as=1.25p ps=5.5u w=5u l=1u
X419 a_75502_190953# a_75842_194421# a_75742_194537# VDD pfet_06v0 ad=4.4p pd=20.88u as=2.5p ps=10.5u w=10u l=1u
D17 X VDD diode_pd2nw_06v0 pj=40u area=99.99999p
X420 VDD a_83878_195467# a_81206_191067# VDD pfet_06v0 ad=1.3p pd=5.52u as=1.3p ps=5.52u w=5u l=1u
X421 a_35862_169399# a_79082_128854# VSS VSS nfet_06v0 ad=0.44p pd=2.88u as=0.44p ps=2.88u w=1u l=1u
X422 VSS a_38286_169943# a_46710_169443# VSS nfet_06v0 ad=1.3p pd=5.52u as=1.3p ps=5.52u w=5u l=1u
D18 S1P VDD diode_pd2nw_06v0 pj=40u area=99.99999p
X423 a_104234_184486# a_92966_169443# VSS VSS nfet_06v0 ad=0.33p pd=1.66u as=0.44p ps=2.88u w=1u l=1u
X424 a_58022_191067# a_60694_195467# VDD VDD pfet_06v0 ad=1.3p pd=5.52u as=2.2p ps=10.88u w=5u l=1u
X425 a_52560_133316# a_57326_128810# a_56794_128854# VSS nfet_06v0 ad=0.88p pd=4.88u as=0.88p ps=4.88u w=2u l=1u
X426 a_114146_135712# a_96374_135596# VDD VDD pfet_06v0 ad=2.5p pd=10.5u as=4.4p ps=20.88u w=10u l=1u
X427 a_76198_148272# a_23448_31424# a_74434_148772# VSS nfet_06v0 ad=3.3p pd=15.88u as=3.3p ps=15.88u w=7.5u l=1u
X428 a_29486_177177# a_29286_177061# VDD VDD pfet_06v0 ad=2.5p pd=10.5u as=4.4p ps=20.88u w=10u l=1u
X429 a_74434_128854# a_74234_128810# a_75166_128854# VSS nfet_06v0 ad=2.2p pd=10.88u as=1.25p ps=5.5u w=5u l=1u
X430 VDD a_61810_182403# a_69782_186803# VDD pfet_06v0 ad=2.6p pd=10.52u as=2.6p ps=10.52u w=10u l=1u
X431 a_74174_135712# a_73974_135596# VDD VDD pfet_06v0 ad=2.5p pd=10.5u as=4.4p ps=20.88u w=10u l=1u
X432 a_29786_140914# a_29586_140870# a_29486_140914# VDD pfet_06v0 ad=4.4p pd=20.88u as=2.5p ps=10.5u w=10u l=1u
X433 a_61810_178107# a_65710_173593# a_61358_173707# VSS nfet_06v0 ad=1.1p pd=5.88u as=1.1p ps=5.88u w=2.5u l=1u
X434 a_77210_161580# a_54442_128810# a_74474_159680# VDD pfet_06v0 ad=0.22p pd=1.88u as=0.22p ps=1.88u w=0.5u l=1u
X435 a_92966_173707# a_84994_178107# VDD VDD pfet_06v0 ad=2.6p pd=10.52u as=4.4p ps=20.88u w=10u l=1u
X436 a_98598_148272# a_53710_128810# a_96834_148772# VSS nfet_06v0 ad=3.3p pd=15.88u as=3.3p ps=15.88u w=7.5u l=1u
X437 a_82762_182403# a_83430_187303# VSS VSS nfet_06v0 ad=0.65p pd=3.02u as=1.1p ps=5.88u w=2.5u l=1u
X438 a_96574_135712# a_96374_135596# VDD VDD pfet_06v0 ad=2.5p pd=10.5u as=4.4p ps=20.88u w=10u l=1u
X439 a_38998_149572# a_30160_145110# VDD VDD pfet_06v0 ad=0.44p pd=2.88u as=0.44p ps=2.88u w=1u l=1u
X440 a_51846_152822# a_51646_152778# VSS VSS nfet_06v0 ad=1.25p pd=5.5u as=2.2p ps=10.88u w=5u l=1u
X441 a_99096_173860# a_99096_173860# a_101360_173976# VSS nfet_06v0 ad=0.308p pd=2.28u as=0.175p ps=1.2u w=0.7u l=1u
X442 a_29286_159564# a_29586_159564# a_47058_159680# VDD pfet_06v0 ad=4.4p pd=20.88u as=2.5p ps=10.5u w=10u l=1u
X443 a_51686_159564# a_51986_159564# a_63894_152822# VSS nfet_06v0 ad=0.44p pd=2.88u as=0.25p ps=1.5u w=1u l=1u
X444 a_102104_173976# a_99096_173860# VSS VSS nfet_06v0 ad=0.5456p pd=3.36u as=0.5456p ps=3.36u w=1.24u l=1u
X445 a_102002_175184# a_23448_131216# a_103402_175114# VSS nfet_06v0 ad=0.88p pd=4.88u as=0.5p ps=2.5u w=2u l=1u
X446 a_61810_178107# a_52658_177061# a_58022_173707# VDD pfet_06v0 ad=1.3p pd=5.52u as=2.2p ps=10.88u w=5u l=1u
X447 a_33946_194537# a_34750_190951# a_35390_194467# VDD pfet_06v0 ad=4.4p pd=20.88u as=2.6p ps=10.52u w=10u l=1u
X448 a_51946_128810# a_51986_135596# a_66422_135712# VDD pfet_06v0 ad=4.4p pd=20.88u as=2.5p ps=10.5u w=10u l=1u
X449 a_75166_148772# a_73934_148656# VSS VSS nfet_06v0 ad=1.25p pd=5.5u as=2.2p ps=10.88u w=5u l=1u
X450 VDD a_37622_195467# a_34950_191067# VDD pfet_06v0 ad=2.2p pd=10.88u as=1.3p ps=5.52u w=5u l=1u
X451 a_46710_169443# a_38738_165043# VDD VDD pfet_06v0 ad=2.6p pd=10.52u as=4.4p ps=20.88u w=10u l=1u
X452 a_99874_128810# a_103470_136796# a_100422_135712# VDD pfet_06v0 ad=1.76p pd=8.88u as=1.76p ps=8.88u w=4u l=1u
X453 a_87214_152822# a_74274_159564# VSS VSS nfet_06v0 ad=0.25p pd=1.5u as=0.44p ps=2.88u w=1u l=1u
X454 a_62862_148772# a_51646_148656# VSS VSS nfet_06v0 ad=1.25p pd=5.5u as=2.2p ps=10.88u w=5u l=1u
X455 a_90558_186873# a_76234_186757# VSS VSS nfet_06v0 ad=1.25p pd=5.5u as=2.2p ps=10.88u w=5u l=1u
X456 VSS VDD VSS VSS nfet_06v0 ad=7.92p pd=36.88u as=0 ps=0 w=18u l=2u
X457 a_92638_164973# a_75542_164929# VDD VDD pfet_06v0 ad=2.5p pd=10.5u as=4.4p ps=20.88u w=10u l=1u
X458 a_77466_170313# a_75842_164929# VSS VSS nfet_06v0 ad=0.25p pd=1.5u as=0.44p ps=2.88u w=1u l=1u
X459 a_58782_160764# a_58782_160764# a_60418_159564# VDD pfet_06v0 ad=4.4p pd=20.88u as=3.3p ps=10.66u w=10u l=1u
X460 a_29586_194421# a_29586_194421# a_32242_190997# VSS nfet_06v0 ad=0.44p pd=2.88u as=0.25p ps=1.5u w=1u l=1u
X461 a_83878_182403# a_88894_187257# a_83430_187303# VSS nfet_06v0 ad=1.1p pd=5.88u as=1.1p ps=5.88u w=2.5u l=1u
X462 a_105306_159680# a_105106_159564# VDD VDD pfet_06v0 ad=2.5p pd=10.5u as=4.4p ps=20.88u w=10u l=1u
X463 VSS a_46710_173707# a_115398_173624# VSS nfet_06v0 ad=0.44p pd=2.88u as=0.25p ps=1.5u w=1u l=1u
X464 a_51846_128854# a_51646_128810# VSS VSS nfet_06v0 ad=1.25p pd=5.5u as=2.2p ps=10.88u w=5u l=1u
X465 a_34926_152778# a_29586_159564# a_39662_159680# VDD pfet_06v0 ad=4.4p pd=20.88u as=2.5p ps=10.5u w=10u l=1u
X466 a_56658_190997# a_35862_190951# a_59134_191067# VSS nfet_06v0 ad=2.2p pd=10.88u as=1.3p ps=5.52u w=5u l=1u
X467 a_58462_194467# a_60246_191067# VSS VSS nfet_06v0 ad=0.65p pd=3.02u as=0.65p ps=3.02u w=2.5u l=1u
X468 a_97566_148772# a_96334_148656# VSS VSS nfet_06v0 ad=1.25p pd=5.5u as=2.2p ps=10.88u w=5u l=1u
X469 VSS a_60246_173707# a_59578_177107# VSS nfet_06v0 ad=0.65p pd=3.02u as=0.65p ps=3.02u w=2.5u l=1u
X470 a_51686_135596# a_51986_135596# a_63894_128854# VSS nfet_06v0 ad=0.44p pd=2.88u as=0.25p ps=1.5u w=1u l=1u
X471 a_55734_140914# a_51986_140870# a_54642_148072# VDD pfet_06v0 ad=4.4p pd=20.88u as=4.4p ps=20.88u w=10u l=1u
X472 a_82318_173707# a_83878_178107# VDD VDD pfet_06v0 ad=1.3p pd=5.52u as=2.2p ps=10.88u w=5u l=1u
X473 VDD VSS VDD VDD pfet_06v0 ad=0.44p pd=2.88u as=0 ps=0 w=1u l=2u
X474 a_104722_148772# a_104522_148656# VSS VSS nfet_06v0 ad=1.25p pd=5.5u as=2.2p ps=10.88u w=5u l=1u
X475 a_82318_169443# a_83878_165043# VDD VDD pfet_06v0 ad=1.3p pd=5.52u as=1.3p ps=5.52u w=5u l=1u
X476 a_30160_134666# a_45578_134216# VSS ppolyf_u_1k r_width=1u r_length=76.45u
D19 VSS S4P diode_nd2ps_06v0 pj=40u area=99.99999p
X477 a_55314_173637# a_52658_177061# VSS VSS nfet_06v0 ad=0.25p pd=1.5u as=0.44p ps=2.88u w=1u l=1u
X478 a_33334_135712# a_29586_135596# a_32242_128854# VDD pfet_06v0 ad=4.4p pd=20.88u as=4.4p ps=20.88u w=10u l=1u
X479 VDD a_60694_165043# a_59134_169443# VDD pfet_06v0 ad=1.3p pd=5.52u as=1.3p ps=5.52u w=5u l=1u
X480 VSS VDD VSS VSS nfet_06v0 ad=4.29p pd=20.38u as=0 ps=0 w=9.75u l=2u
X481 a_57018_182333# a_57822_186759# a_58462_182403# VDD pfet_06v0 ad=4.4p pd=20.88u as=2.6p ps=10.52u w=10u l=1u
X482 a_87214_128854# a_74274_135596# VSS VSS nfet_06v0 ad=0.25p pd=1.5u as=0.44p ps=2.88u w=1u l=1u
X483 VSS a_76234_190953# a_80174_190997# VSS nfet_06v0 ad=2.2p pd=10.88u as=1.25p ps=5.5u w=5u l=1u
X484 VDD a_37622_165043# a_36062_169443# VDD pfet_06v0 ad=1.3p pd=5.52u as=1.3p ps=5.52u w=5u l=1u
X485 a_34950_191067# a_37622_195467# VDD VDD pfet_06v0 ad=1.3p pd=5.52u as=2.2p ps=10.88u w=5u l=1u
D20 S1P VDD diode_pd2nw_06v0 pj=40u area=99.99999p
X486 a_58022_191067# a_57822_190951# a_56658_190997# VSS nfet_06v0 ad=1.3p pd=5.52u as=2.2p ps=10.88u w=5u l=1u
X487 a_100246_167126# a_114466_173580# VDD VDD pfet_06v0 ad=1.32p pd=6.88u as=1.32p ps=6.88u w=3u l=1u
X488 a_61358_187303# a_52318_187557# a_58462_182403# VSS nfet_06v0 ad=0.65p pd=3.02u as=1.1p ps=5.88u w=2.5u l=1u
X489 a_81206_173707# a_83878_178107# VDD VDD pfet_06v0 ad=1.3p pd=5.52u as=1.3p ps=5.52u w=5u l=1u
X490 a_75542_182289# a_75842_182289# a_78778_182333# VDD pfet_06v0 ad=4.4p pd=20.88u as=2.5p ps=10.5u w=10u l=1u
X491 a_59134_191067# a_60694_195467# VDD VDD pfet_06v0 ad=1.3p pd=5.52u as=1.3p ps=5.52u w=5u l=1u
D21 VSS S1P diode_nd2ps_06v0 pj=40u area=99.99999p
X492 a_97686_140914# a_96374_140870# VDD VDD pfet_06v0 ad=2.5p pd=10.5u as=4.4p ps=20.88u w=10u l=1u
X493 VDD VSS VDD VDD pfet_06v0 ad=4.29p pd=20.38u as=0 ps=0 w=9.75u l=2u
X494 a_97248_157284# a_102014_152778# a_101482_152822# VSS nfet_06v0 ad=0.88p pd=4.88u as=0.88p ps=4.88u w=2u l=1u
X495 a_33586_173637# a_34750_173591# a_34950_173707# VSS nfet_06v0 ad=2.2p pd=10.88u as=1.3p ps=5.52u w=5u l=1u
X496 a_56990_190997# a_52318_190953# a_56658_190997# VSS nfet_06v0 ad=1.25p pd=5.5u as=1.65p ps=5.66u w=5u l=1u
X497 a_54110_161570# a_23448_31424# a_52186_159680# VDD pfet_06v0 ad=0.242p pd=1.98u as=0.242p ps=1.98u w=0.55u l=1u
X498 a_75286_135712# a_73974_135596# VDD VDD pfet_06v0 ad=2.5p pd=10.5u as=4.4p ps=20.88u w=10u l=1u
X499 VDD VSS VDD VDD pfet_06v0 ad=7.92p pd=36.88u as=0 ps=0 w=18u l=2u
X500 a_51646_148656# a_51986_140870# a_67534_140914# VDD pfet_06v0 ad=4.4p pd=20.88u as=2.5p ps=10.5u w=10u l=1u
X501 a_42638_190953# a_29586_194421# a_46382_194537# VDD pfet_06v0 ad=4.4p pd=20.88u as=2.5p ps=10.5u w=10u l=1u
X502 a_29246_170197# a_29586_164929# a_29486_164973# VDD pfet_06v0 ad=4.4p pd=20.88u as=2.5p ps=10.5u w=10u l=1u
X503 a_113914_182402# a_92966_186803# a_106078_184486# VDD pfet_06v0 ad=0.75p pd=3.5u as=1.32p ps=6.88u w=3u l=1u
X504 a_104146_167170# a_104234_167126# a_23448_190688# VSS nfet_06v0 ad=1.0912p pd=5.84u as=0.6448p ps=3u w=2.48u l=1u
X505 VDD VSS VDD VDD pfet_06v0 ad=0.44p pd=2.88u as=0 ps=0 w=1u l=2u
X506 VSS a_83430_173707# a_81646_177107# VSS nfet_06v0 ad=1.1p pd=5.88u as=0.65p ps=3.02u w=2.5u l=1u
X507 a_81206_191067# a_83878_195467# VDD VDD pfet_06v0 ad=1.3p pd=5.52u as=2.2p ps=10.88u w=5u l=1u
X508 a_35862_186759# a_30160_157284# VDD VDD pfet_06v0 ad=0.44p pd=2.88u as=0.44p ps=2.88u w=1u l=1u
X509 VDD a_84994_182403# a_92966_186803# VDD pfet_06v0 ad=2.6p pd=10.52u as=2.6p ps=10.52u w=10u l=1u
X510 a_29246_128810# a_29586_135596# a_45134_135712# VDD pfet_06v0 ad=4.4p pd=20.88u as=2.5p ps=10.5u w=10u l=1u
X511 a_32786_149156# a_36382_140870# a_33334_140914# VDD pfet_06v0 ad=1.76p pd=8.88u as=1.76p ps=8.88u w=4u l=1u
X512 a_46710_169443# a_38286_169943# VSS VSS nfet_06v0 ad=1.3p pd=5.52u as=2.2p ps=10.88u w=5u l=1u
X513 a_84994_178107# a_88894_173593# a_84542_173707# VSS nfet_06v0 ad=1.1p pd=5.88u as=1.1p ps=5.88u w=2.5u l=1u
D22 S4P VDD diode_pd2nw_06v0 pj=40u area=99.99999p
X514 a_33586_186873# a_35862_186759# a_36062_186803# VSS nfet_06v0 ad=2.2p pd=10.88u as=1.3p ps=5.52u w=5u l=1u
X515 ZP_OUT ZN_OUT VSS VSS nfet_05v0 ad=0.5808p pd=3.52u as=0.5808p ps=3.52u w=1.32u l=0.6u
X516 a_63894_149572# a_51986_140870# VSS VSS nfet_06v0 ad=0.25p pd=1.5u as=0.44p ps=2.88u w=1u l=1u
X517 a_36506_165043# a_37174_169943# VSS VSS nfet_06v0 ad=0.65p pd=3.02u as=0.65p ps=3.02u w=2.5u l=1u
X518 a_91402_186757# a_75502_187557# a_91602_186873# VSS nfet_06v0 ad=1.65p pd=5.66u as=1.25p ps=5.5u w=5u l=1u
X519 a_97248_133316# a_102014_128810# a_101482_128854# VSS nfet_06v0 ad=0.88p pd=4.88u as=0.88p ps=4.88u w=2u l=1u
X520 VDD VSS VDD VDD pfet_06v0 ad=4.29p pd=20.38u as=0 ps=0 w=9.75u l=2u
X521 a_82906_140914# a_82706_140870# VDD VDD pfet_06v0 ad=2.5p pd=10.5u as=4.4p ps=20.88u w=10u l=1u
X522 a_79842_186873# a_57822_186759# a_81206_186803# VSS nfet_06v0 ad=2.2p pd=10.88u as=1.3p ps=5.52u w=5u l=1u
X523 a_67810_182289# a_52658_182289# a_68010_182333# VDD pfet_06v0 ad=3.3p pd=10.66u as=2.5p ps=10.5u w=10u l=1u
X524 a_53050_186757# a_52318_187557# a_53250_186873# VSS nfet_06v0 ad=2.2p pd=10.88u as=1.25p ps=5.5u w=5u l=1u
X525 a_34950_186803# a_34750_186759# a_33586_186873# VSS nfet_06v0 ad=1.3p pd=5.52u as=2.2p ps=10.88u w=5u l=1u
X526 a_53910_148272# a_31310_152778# a_52146_148772# VSS nfet_06v0 ad=3.3p pd=15.88u as=3.3p ps=15.88u w=7.5u l=1u
X527 VSS a_38286_173707# a_46710_173707# VSS nfet_06v0 ad=1.3p pd=5.52u as=1.3p ps=5.52u w=5u l=1u
X528 a_92966_191067# a_84994_195467# VDD VDD pfet_06v0 ad=4.4p pd=20.88u as=2.6p ps=10.52u w=10u l=1u
X529 a_35390_194467# a_34750_190951# a_33946_194537# VDD pfet_06v0 ad=2.6p pd=10.52u as=4.4p ps=20.88u w=10u l=1u
X530 VDD VSS VDD VDD pfet_06v0 ad=0.44p pd=2.88u as=0 ps=0 w=1u l=2u
X531 a_81646_165043# a_83430_169943# VSS VSS nfet_06v0 ad=0.65p pd=3.02u as=0.65p ps=3.02u w=2.5u l=1u
X532 a_32786_152778# a_29546_152778# a_32522_161580# VSS nfet_06v0 ad=1.1p pd=5.88u as=0.825p ps=3.16u w=2.5u l=1u
X533 a_33334_140914# a_34926_149256# a_32786_149156# VSS nfet_06v0 ad=0.88p pd=4.88u as=0.88p ps=4.88u w=2u l=1u
X534 a_40462_152822# a_29246_152778# VSS VSS nfet_06v0 ad=1.25p pd=5.5u as=2.2p ps=10.88u w=5u l=1u
X535 a_52560_158634# a_67978_158184# VSS ppolyf_u_1k r_width=1u r_length=76.45u
X536 VDD a_38738_195467# a_46710_191067# VDD pfet_06v0 ad=2.6p pd=10.52u as=2.6p ps=10.52u w=10u l=1u
X537 a_33586_186873# a_29246_187557# a_33286_186873# VSS nfet_06v0 ad=1.65p pd=5.66u as=1.25p ps=5.5u w=5u l=1u
X538 a_76398_140914# a_23448_31424# a_74474_140914# VDD pfet_06v0 ad=0.242p pd=1.98u as=0.242p ps=1.98u w=0.55u l=1u
X539 VSS a_83430_173707# a_82762_177107# VSS nfet_06v0 ad=0.65p pd=3.02u as=0.65p ps=3.02u w=2.5u l=1u
X540 a_57822_169399# a_52560_133316# VDD VDD pfet_06v0 ad=0.44p pd=2.88u as=0.44p ps=2.88u w=1u l=1u
X541 a_99046_175184# a_99134_175068# a_23448_131216# VSS nfet_06v0 ad=1.0912p pd=5.84u as=0.6448p ps=3u w=2.48u l=1u
X542 a_96374_159564# a_96674_159564# a_114146_159680# VDD pfet_06v0 ad=4.4p pd=20.88u as=2.5p ps=10.5u w=10u l=1u
X543 a_32242_152822# a_32042_152778# a_29746_152822# VSS nfet_06v0 ad=3.74p pd=17.88u as=3.74p ps=17.88u w=8.5u l=1u
X544 VDD a_23448_131216# a_23448_131216# VDD pfet_06v0 ad=0.52p pd=2.52u as=0.52p ps=2.52u w=2u l=1u
D23 VSS S1P diode_nd2ps_06v0 pj=40u area=99.99999p
X545 VDD VSS VDD VDD pfet_06v0 ad=4.29p pd=20.38u as=0 ps=0 w=9.75u l=2u
X546 VSS a_60246_191067# a_58462_194467# VSS nfet_06v0 ad=0.65p pd=3.02u as=0.65p ps=3.02u w=2.5u l=1u
X547 a_74474_159680# a_74274_159564# a_74174_159680# VDD pfet_06v0 ad=4.4p pd=20.88u as=2.5p ps=10.5u w=10u l=1u
X548 a_59578_177107# a_60246_173707# VSS VSS nfet_06v0 ad=0.65p pd=3.02u as=1.1p ps=5.88u w=2.5u l=1u
X549 a_75502_170197# a_75502_170197# VSS VSS nfet_06v0 ad=0.44p pd=2.88u as=0.44p ps=2.88u w=1u l=1u
X550 a_55594_182333# a_52358_182289# VDD VDD pfet_06v0 ad=2.5p pd=10.5u as=4.4p ps=20.88u w=10u l=1u
X551 a_55734_140914# a_57326_149256# a_55186_149156# VSS nfet_06v0 ad=0.88p pd=4.88u as=0.88p ps=4.88u w=2u l=1u
X552 VDD a_83878_165043# a_82318_169443# VDD pfet_06v0 ad=1.3p pd=5.52u as=1.3p ps=5.52u w=5u l=1u
X553 VSS a_69782_173707# a_100246_184486# VSS nfet_06v0 ad=0.44p pd=2.88u as=0.33p ps=1.66u w=1u l=1u
X554 VSS VDD VSS VSS nfet_06v0 ad=0.44p pd=2.88u as=0 ps=0 w=1u l=2u
X555 VDD a_60694_182403# a_58022_186803# VDD pfet_06v0 ad=2.2p pd=10.88u as=1.3p ps=5.52u w=5u l=1u
X556 a_79082_149272# a_81070_140870# a_74848_145110# VDD pfet_06v0 ad=1.76p pd=8.88u as=1.76p ps=8.88u w=4u l=1u
X557 a_30160_134666# a_34750_169399# VSS ppolyf_u_1k r_width=1u r_length=76.45u
X558 a_57822_186759# a_98598_148272# cap_mim_2f0_m4m5_noshield c_width=25u c_length=8u
X559 a_56358_169513# a_53050_169397# VSS VSS nfet_06v0 ad=1.25p pd=5.5u as=2.2p ps=10.88u w=5u l=1u
X560 VSS VDD VSS VSS nfet_06v0 ad=7.92p pd=36.88u as=0 ps=0 w=18u l=2u
X561 a_38738_195467# a_42638_190953# a_38286_191067# VSS nfet_06v0 ad=1.1p pd=5.88u as=1.1p ps=5.88u w=2.5u l=1u
X562 a_58462_182403# a_57822_186759# a_57018_182333# VDD pfet_06v0 ad=2.6p pd=10.52u as=4.4p ps=20.88u w=10u l=1u
X563 a_32786_128810# a_29546_128810# a_32522_137612# VSS nfet_06v0 ad=1.1p pd=5.88u as=0.825p ps=3.16u w=2.5u l=1u
X564 a_52560_157734# a_67978_158184# VSS ppolyf_u_1k r_width=1u r_length=76.45u
X565 a_40462_128854# a_29246_128810# VSS VSS nfet_06v0 ad=1.25p pd=5.5u as=2.2p ps=10.88u w=5u l=1u
X566 a_36062_169443# a_37622_165043# VDD VDD pfet_06v0 ad=1.3p pd=5.52u as=2.2p ps=10.88u w=5u l=1u
X567 a_75742_194537# a_75542_194421# VDD VDD pfet_06v0 ad=2.5p pd=10.5u as=4.4p ps=20.88u w=10u l=1u
X568 a_82318_191067# a_83878_195467# VDD VDD pfet_06v0 ad=1.3p pd=5.52u as=1.3p ps=5.52u w=5u l=1u
X569 a_102014_152778# a_96674_159564# a_106750_159680# VDD pfet_06v0 ad=4.4p pd=20.88u as=2.5p ps=10.5u w=10u l=1u
X570 a_66174_195421# a_66174_195421# a_67810_194421# VDD pfet_06v0 ad=4.4p pd=20.88u as=3.3p ps=10.66u w=10u l=1u
X571 a_32242_128854# a_32042_128810# a_29746_128854# VSS nfet_06v0 ad=3.74p pd=17.88u as=3.74p ps=17.88u w=8.5u l=1u
X572 a_79842_186873# a_75502_187557# a_79542_186873# VSS nfet_06v0 ad=1.65p pd=5.66u as=1.25p ps=5.5u w=5u l=1u
X573 VDD a_60694_195467# a_59134_191067# VDD pfet_06v0 ad=1.3p pd=5.52u as=1.3p ps=5.52u w=5u l=1u
X574 a_29486_140914# a_29286_140870# VDD VDD pfet_06v0 ad=2.5p pd=10.5u as=4.4p ps=20.88u w=10u l=1u
X575 a_80174_190997# a_75502_190953# a_79842_190997# VSS nfet_06v0 ad=1.25p pd=5.5u as=1.65p ps=5.66u w=5u l=1u
X576 a_57822_186759# a_97248_145110# VDD VDD pfet_06v0 ad=0.44p pd=2.88u as=0.44p ps=2.88u w=1u l=1u
X577 a_104234_167126# a_114466_166626# VDD VDD pfet_06v0 ad=1.32p pd=6.88u as=1.32p ps=6.88u w=3u l=1u
X578 a_44738_182289# a_29586_182289# a_44938_182333# VDD pfet_06v0 ad=3.3p pd=10.66u as=2.5p ps=10.5u w=10u l=1u
X579 VDD a_37622_195467# a_36062_191067# VDD pfet_06v0 ad=1.3p pd=5.52u as=1.3p ps=5.52u w=5u l=1u
X580 a_100422_135712# a_96674_135596# a_99330_128854# VDD pfet_06v0 ad=4.4p pd=20.88u as=4.4p ps=20.88u w=10u l=1u
X581 a_69782_169443# a_61358_169943# VSS VSS nfet_06v0 ad=2.2p pd=10.88u as=1.3p ps=5.52u w=5u l=1u
X582 a_68218_186757# a_52318_187557# a_68418_186873# VSS nfet_06v0 ad=1.65p pd=5.66u as=1.25p ps=5.5u w=5u l=1u
X583 a_29978_186757# a_29246_187557# a_30178_186873# VSS nfet_06v0 ad=2.2p pd=10.88u as=1.25p ps=5.5u w=5u l=1u
X584 a_56658_186873# a_57822_186759# a_58022_186803# VSS nfet_06v0 ad=2.2p pd=10.88u as=1.3p ps=5.52u w=5u l=1u
X585 a_114466_184098# a_46710_186803# VDD VDD pfet_06v0 ad=0.99p pd=3.66u as=1.32p ps=6.88u w=3u l=1u
X586 a_44022_135712# a_29286_135596# VDD VDD pfet_06v0 ad=2.5p pd=10.5u as=4.4p ps=20.88u w=10u l=1u
X587 a_52358_182289# a_52658_182289# a_54282_187673# VSS nfet_06v0 ad=0.44p pd=2.88u as=0.25p ps=1.5u w=1u l=1u
X588 a_23448_190688# a_104234_167126# a_104146_167170# VSS nfet_06v0 ad=0.6448p pd=3u as=1.0912p ps=5.84u w=2.48u l=1u
X589 a_98598_148272# a_100422_140914# VDD VDD pfet_06v0 ad=2.2p pd=10.88u as=2.2p ps=10.88u w=5u l=1u
X590 a_76198_152822# a_53710_128810# a_74434_152822# VSS nfet_06v0 ad=3.3p pd=15.88u as=3.3p ps=15.88u w=7.5u l=1u
X591 a_60418_159564# a_51986_159564# a_60618_159680# VDD pfet_06v0 ad=3.3p pd=10.66u as=2.5p ps=10.5u w=10u l=1u
X592 a_101360_173976# a_99096_173860# a_101060_173976# VSS nfet_06v0 ad=0.175p pd=1.2u as=0.175p ps=1.2u w=0.7u l=1u
X593 a_43102_164929# a_43102_164929# a_44738_164929# VDD pfet_06v0 ad=4.4p pd=20.88u as=3.3p ps=10.66u w=10u l=1u
X594 a_68010_177177# a_67810_177061# VDD VDD pfet_06v0 ad=2.5p pd=10.5u as=4.4p ps=20.88u w=10u l=1u
X595 a_63894_152822# a_51986_159564# VSS VSS nfet_06v0 ad=0.25p pd=1.5u as=0.44p ps=2.88u w=1u l=1u
X596 VDD VSS VDD VDD pfet_06v0 ad=0.44p pd=2.88u as=0 ps=0 w=1u l=2u
X597 a_92966_186803# a_84994_182403# VDD VDD pfet_06v0 ad=2.6p pd=10.52u as=4.4p ps=20.88u w=10u l=1u
X598 a_103402_175114# a_23448_131216# VSS VSS nfet_06v0 ad=0.5p pd=2.5u as=0.88p ps=4.88u w=2u l=1u
X599 a_89358_178061# a_75502_173593# a_90558_173637# VSS nfet_06v0 ad=2.2p pd=10.88u as=1.25p ps=5.5u w=5u l=1u
X600 a_66422_135712# a_51686_135596# VDD VDD pfet_06v0 ad=2.5p pd=10.5u as=4.4p ps=20.88u w=10u l=1u
X601 a_56794_152822# a_51946_152778# a_54110_161570# VSS nfet_06v0 ad=1.1p pd=5.88u as=0.825p ps=3.16u w=2.5u l=1u
X602 VSS a_37174_169943# a_36506_165043# VSS nfet_06v0 ad=0.65p pd=3.02u as=0.65p ps=3.02u w=2.5u l=1u
X603 a_58022_186803# a_52658_182289# a_61810_182403# VDD pfet_06v0 ad=2.2p pd=10.88u as=1.3p ps=5.52u w=5u l=1u
X604 a_98598_152822# a_31310_128810# a_96834_152822# VSS nfet_06v0 ad=3.3p pd=15.88u as=3.3p ps=15.88u w=7.5u l=1u
X605 VSS VDD VSS VSS nfet_06v0 ad=0.44p pd=2.88u as=0 ps=0 w=1u l=2u
X606 a_73974_140870# a_74274_140870# a_91746_140914# VDD pfet_06v0 ad=4.4p pd=20.88u as=2.5p ps=10.5u w=10u l=1u
X607 a_76398_161570# a_77474_152778# VSS VSS nfet_06v0 ad=0.825p pd=3.16u as=1.1p ps=5.88u w=2.5u l=1u
X608 a_32242_190997# a_29586_194421# VSS VSS nfet_06v0 ad=0.25p pd=1.5u as=0.44p ps=2.88u w=1u l=1u
X609 VSS VDD VSS VSS nfet_06v0 ad=7.92p pd=36.88u as=0 ps=0 w=18u l=2u
X610 a_115398_173624# a_69782_173707# a_114466_173580# VSS nfet_06v0 ad=0.25p pd=1.5u as=0.44p ps=2.88u w=1u l=1u
X611 a_76234_186757# a_75502_187557# a_76434_186873# VSS nfet_06v0 ad=2.2p pd=10.88u as=1.25p ps=5.5u w=5u l=1u
X612 a_51946_148656# a_51946_148656# VSS VSS nfet_06v0 ad=0.44p pd=2.88u as=0.44p ps=2.88u w=1u l=1u
X613 a_76198_128854# a_31310_152778# a_74434_128854# VSS nfet_06v0 ad=3.3p pd=15.88u as=3.3p ps=15.88u w=7.5u l=1u
X614 a_99874_149156# a_103470_140870# a_100422_140914# VDD pfet_06v0 ad=1.76p pd=8.88u as=1.76p ps=8.88u w=4u l=1u
X615 a_96334_128810# a_96674_135596# a_112222_135712# VDD pfet_06v0 ad=4.4p pd=20.88u as=2.5p ps=10.5u w=10u l=1u
X616 a_81206_191067# a_57822_190951# a_79842_190997# VSS nfet_06v0 ad=1.3p pd=5.52u as=2.2p ps=10.88u w=5u l=1u
X617 a_76930_128854# a_78022_135712# VDD VDD pfet_06v0 ad=2.2p pd=10.88u as=2.2p ps=10.88u w=5u l=1u
X618 a_39662_159680# a_29286_159564# VDD VDD pfet_06v0 ad=2.5p pd=10.5u as=4.4p ps=20.88u w=10u l=1u
X619 a_63894_128854# a_51986_135596# VSS VSS nfet_06v0 ad=0.25p pd=1.5u as=0.44p ps=2.88u w=1u l=1u
X620 a_56794_128854# a_51946_128810# a_54110_137602# VSS nfet_06v0 ad=1.1p pd=5.88u as=0.825p ps=3.16u w=2.5u l=1u
D24 VSS Z diode_nd2ps_06v0 pj=40u area=99.99999p
X621 a_46710_173707# a_38286_173707# VSS VSS nfet_06v0 ad=1.3p pd=5.52u as=2.2p ps=10.88u w=5u l=1u
X622 a_98598_128854# a_23448_31424# a_96834_128854# VSS nfet_06v0 ad=3.3p pd=15.88u as=3.3p ps=15.88u w=7.5u l=1u
X623 a_29286_194421# a_29586_194421# a_32522_194537# VDD pfet_06v0 ad=4.4p pd=20.88u as=2.5p ps=10.5u w=10u l=1u
X624 a_52318_190953# a_52318_190953# VSS VSS nfet_06v0 ad=0.44p pd=2.88u as=0.44p ps=2.88u w=1u l=1u
D25 VSS Z diode_nd2ps_06v0 pj=40u area=99.99999p
X625 a_76398_137602# a_77474_128810# VSS VSS nfet_06v0 ad=0.825p pd=3.16u as=1.1p ps=5.88u w=2.5u l=1u
X626 a_38738_165043# a_29586_164929# a_34950_169443# VDD pfet_06v0 ad=1.3p pd=5.52u as=2.2p ps=10.88u w=5u l=1u
X627 a_46710_191067# a_38738_195467# VDD VDD pfet_06v0 ad=2.6p pd=10.52u as=4.4p ps=20.88u w=10u l=1u
X628 a_52560_133316# a_67978_133316# VSS ppolyf_u_1k r_width=1u r_length=76.45u
X629 VSS a_83430_191067# a_81646_194467# VSS nfet_06v0 ad=0.65p pd=3.02u as=0.65p ps=3.02u w=2.5u l=1u
X630 a_82762_177107# a_83430_173707# VSS VSS nfet_06v0 ad=0.65p pd=3.02u as=1.1p ps=5.88u w=2.5u l=1u
X631 a_23448_131216# a_99134_175068# a_99046_175184# VSS nfet_06v0 ad=0.6448p pd=3u as=1.0912p ps=5.84u w=2.48u l=1u
X632 a_35390_182403# a_29246_187557# a_38286_187303# VSS nfet_06v0 ad=1.1p pd=5.88u as=0.65p ps=3.02u w=2.5u l=1u
X633 a_45134_140914# a_29286_140870# VDD VDD pfet_06v0 ad=2.5p pd=10.5u as=4.4p ps=20.88u w=10u l=1u
X634 a_78778_182333# a_75542_182289# VDD VDD pfet_06v0 ad=2.5p pd=10.5u as=4.4p ps=20.88u w=10u l=1u
X635 VDD a_83878_182403# a_81206_186803# VDD pfet_06v0 ad=2.2p pd=10.88u as=1.3p ps=5.52u w=5u l=1u
X636 a_31710_140914# a_31310_128810# a_29786_140914# VDD pfet_06v0 ad=0.242p pd=1.98u as=0.242p ps=1.98u w=0.55u l=1u
X637 a_99874_152778# a_96634_152778# a_99610_161580# VSS nfet_06v0 ad=1.1p pd=5.88u as=0.825p ps=3.16u w=2.5u l=1u
X638 a_44938_177177# a_44738_177061# VDD VDD pfet_06v0 ad=2.5p pd=10.5u as=4.4p ps=20.88u w=10u l=1u
X639 a_79614_128810# a_74274_135596# a_84350_135712# VDD pfet_06v0 ad=4.4p pd=20.88u as=2.5p ps=10.5u w=10u l=1u
X640 a_46382_194537# a_29286_194421# VDD VDD pfet_06v0 ad=2.5p pd=10.5u as=4.4p ps=20.88u w=10u l=1u
X641 a_67534_140914# a_51686_140870# VDD VDD pfet_06v0 ad=2.5p pd=10.5u as=4.4p ps=20.88u w=10u l=1u
X642 a_29586_159564# a_29586_159564# VDD VDD pfet_06v0 ad=0.88p pd=4.88u as=0.88p ps=4.88u w=2u l=1u
X643 a_102380_164960# a_23448_190688# VDD VDD pfet_05v0 ad=0.8052p pd=4.54u as=0.8052p ps=4.54u w=1.83u l=0.5u
X644 a_29486_164973# a_29286_164929# VDD VDD pfet_06v0 ad=2.5p pd=10.5u as=4.4p ps=20.88u w=10u l=1u
X645 VSS VDD VSS VSS nfet_06v0 ad=0.44p pd=2.88u as=0 ps=0 w=1u l=2u
X646 VDD VSS VDD VDD pfet_06v0 ad=7.92p pd=36.88u as=0 ps=0 w=18u l=2u
X647 a_75842_177061# a_75842_177061# a_78498_173637# VSS nfet_06v0 ad=0.44p pd=2.88u as=0.25p ps=1.5u w=1u l=1u
X648 VDD a_83878_195467# a_82318_191067# VDD pfet_06v0 ad=1.3p pd=5.52u as=1.3p ps=5.52u w=5u l=1u
X649 VSS VDD VSS VSS nfet_06v0 ad=4.29p pd=20.38u as=0 ps=0 w=9.75u l=2u
X650 a_34750_186759# a_74848_145110# VDD VDD pfet_06v0 ad=0.44p pd=2.88u as=0.44p ps=2.88u w=1u l=1u
X651 a_92966_169443# a_84542_169943# VSS VSS nfet_06v0 ad=2.2p pd=10.88u as=1.3p ps=5.52u w=5u l=1u
X652 a_38286_169943# a_43102_164929# a_38738_165043# VDD pfet_06v0 ad=2.2p pd=10.88u as=2.2p ps=10.88u w=5u l=1u
X653 a_53050_173593# a_52658_177061# a_53670_177177# VDD pfet_06v0 ad=4.4p pd=20.88u as=2.5p ps=10.5u w=10u l=1u
X654 a_91602_186873# a_91402_186757# VSS VSS nfet_06v0 ad=1.25p pd=5.5u as=2.2p ps=10.88u w=5u l=1u
X655 a_36062_191067# a_37622_195467# VDD VDD pfet_06v0 ad=1.3p pd=5.52u as=2.2p ps=10.88u w=5u l=1u
X656 a_75542_182289# a_75842_182289# a_77466_187673# VSS nfet_06v0 ad=0.44p pd=2.88u as=0.25p ps=1.5u w=1u l=1u
X657 a_99874_128810# a_96634_128810# a_99610_137612# VSS nfet_06v0 ad=1.1p pd=5.88u as=0.825p ps=3.16u w=2.5u l=1u
X658 a_102104_185738# VDD a_23448_70736# VSS nfet_06v0 ad=1.0912p pd=5.84u as=0.6448p ps=3u w=2.48u l=1u
X659 VSS a_60246_169943# a_59578_165043# VSS nfet_06v0 ad=1.1p pd=5.88u as=0.65p ps=3.02u w=2.5u l=1u
X660 a_59134_173707# a_52658_177061# a_60694_178107# VDD pfet_06v0 ad=2.2p pd=10.88u as=1.3p ps=5.52u w=5u l=1u
X661 a_53250_186873# a_53050_186757# VSS VSS nfet_06v0 ad=1.25p pd=5.5u as=2.2p ps=10.88u w=5u l=1u
X662 a_102104_168378# a_99096_168582# VSS VSS nfet_06v0 ad=0.5456p pd=3.36u as=0.5456p ps=3.36u w=1.24u l=1u
X663 a_61358_173707# a_52318_173593# a_58462_177107# VSS nfet_06v0 ad=0.65p pd=3.02u as=1.1p ps=5.88u w=2.5u l=1u
X664 a_30178_186873# a_29978_186757# VSS VSS nfet_06v0 ad=1.25p pd=5.5u as=2.2p ps=10.88u w=5u l=1u
X665 a_33918_186873# a_29246_187557# a_33586_186873# VSS nfet_06v0 ad=1.25p pd=5.5u as=1.65p ps=5.66u w=5u l=1u
X666 a_84542_173707# a_89358_178061# a_84994_178107# VDD pfet_06v0 ad=2.2p pd=10.88u as=2.2p ps=10.88u w=5u l=1u
X667 a_33946_194537# a_29586_194421# a_33646_194537# VDD pfet_06v0 ad=3.3p pd=10.66u as=2.5p ps=10.5u w=10u l=1u
X668 a_60246_187303# a_66174_182289# a_60694_182403# VDD pfet_06v0 ad=2.2p pd=10.88u as=2.2p ps=10.88u w=5u l=1u
X669 a_61810_182403# a_52658_182289# a_58022_186803# VDD pfet_06v0 ad=1.3p pd=5.52u as=2.2p ps=10.88u w=5u l=1u
X670 a_111110_135712# a_96374_135596# VDD VDD pfet_06v0 ad=2.5p pd=10.5u as=4.4p ps=20.88u w=10u l=1u
X671 a_51946_152778# a_51946_152778# VSS VSS nfet_06v0 ad=0.44p pd=2.88u as=0.44p ps=2.88u w=1u l=1u
X672 a_69782_173707# a_61358_173707# VSS VSS nfet_06v0 ad=2.2p pd=10.88u as=1.3p ps=5.52u w=5u l=1u
X673 a_103470_160764# a_103470_160764# a_105106_159564# VDD pfet_06v0 ad=4.4p pd=20.88u as=3.3p ps=10.66u w=10u l=1u
X674 a_33286_186873# a_29978_186757# VSS VSS nfet_06v0 ad=1.25p pd=5.5u as=2.2p ps=10.88u w=5u l=1u
X675 a_23448_131216# a_23448_131216# VDD VDD pfet_06v0 ad=0.52p pd=2.52u as=0.88p ps=4.88u w=2u l=1u
X676 a_53910_152822# a_23448_31424# a_52146_152822# VSS nfet_06v0 ad=3.3p pd=15.88u as=3.3p ps=15.88u w=7.5u l=1u
X677 a_52998_159680# a_51686_159564# VDD VDD pfet_06v0 ad=2.5p pd=10.5u as=4.4p ps=20.88u w=10u l=1u
X678 a_96834_152822# a_96634_152778# a_96534_152822# VSS nfet_06v0 ad=2.2p pd=10.88u as=1.25p ps=5.5u w=5u l=1u
X679 a_59834_152778# a_51946_152778# a_60034_152822# VSS nfet_06v0 ad=1.65p pd=5.66u as=1.25p ps=5.5u w=5u l=1u
X680 a_34926_152778# a_34926_152778# a_37434_152778# VSS nfet_06v0 ad=2.2p pd=10.88u as=1.65p ps=5.66u w=5u l=1u
X681 VSS VDD VSS VSS nfet_06v0 ad=0.44p pd=2.88u as=0 ps=0 w=1u l=2u
X682 S1N a_32042_152778# VDD ppolyf_u r_width=16u r_length=4u
X683 VDD VSS VDD VDD pfet_06v0 ad=0.44p pd=2.88u as=0 ps=0 w=1u l=2u
X684 a_82318_186803# a_83878_182403# VDD VDD pfet_06v0 ad=1.3p pd=5.52u as=2.2p ps=10.88u w=5u l=1u
X685 a_29586_140870# a_29586_140870# VDD VDD pfet_06v0 ad=0.88p pd=4.88u as=0.88p ps=4.88u w=2u l=1u
X686 a_104146_175184# a_99096_173860# VSS VSS nfet_06v0 ad=0.5456p pd=3.36u as=0.5456p ps=3.36u w=1.24u l=1u
X687 a_29546_152778# a_29586_159564# a_44022_159680# VDD pfet_06v0 ad=4.4p pd=20.88u as=2.5p ps=10.5u w=10u l=1u
X688 VSS a_46710_169443# a_115398_166742# VSS nfet_06v0 ad=0.44p pd=2.88u as=0.25p ps=1.5u w=1u l=1u
X689 VDD VSS VDD VDD pfet_06v0 ad=4.29p pd=20.38u as=0 ps=0 w=9.75u l=2u
X690 a_51946_128810# a_51946_128810# VSS VSS nfet_06v0 ad=0.44p pd=2.88u as=0.44p ps=2.88u w=1u l=1u
X691 a_57822_186759# a_97248_145110# VDD VDD pfet_06v0 ad=0.44p pd=2.88u as=0.44p ps=2.88u w=1u l=1u
X692 a_29586_164929# a_29586_164929# VDD VDD pfet_06v0 ad=0.88p pd=4.88u as=0.88p ps=4.88u w=2u l=1u
X693 a_32242_152822# a_33334_159680# VDD VDD pfet_06v0 ad=2.2p pd=10.88u as=2.2p ps=10.88u w=5u l=1u
X694 a_29978_173593# a_29586_177061# a_30598_177177# VDD pfet_06v0 ad=4.4p pd=20.88u as=2.5p ps=10.5u w=10u l=1u
X695 a_53910_128854# a_53710_128810# a_52146_128854# VSS nfet_06v0 ad=3.3p pd=15.88u as=3.3p ps=15.88u w=7.5u l=1u
X696 a_106750_159680# a_96374_159564# VDD VDD pfet_06v0 ad=2.5p pd=10.5u as=4.4p ps=20.88u w=10u l=1u
X697 a_81646_194467# a_83430_191067# VSS VSS nfet_06v0 ad=0.65p pd=3.02u as=1.1p ps=5.88u w=2.5u l=1u
X698 a_34926_128810# a_34926_128810# a_37434_128810# VSS nfet_06v0 ad=2.2p pd=10.88u as=1.65p ps=5.66u w=5u l=1u
X699 a_59834_128810# a_51946_128810# a_60034_128854# VSS nfet_06v0 ad=1.65p pd=5.66u as=1.25p ps=5.5u w=5u l=1u
X700 a_96834_128854# a_96634_128810# a_96534_128854# VSS nfet_06v0 ad=2.2p pd=10.88u as=1.25p ps=5.5u w=5u l=1u
X701 a_79542_186873# a_76234_186757# VSS VSS nfet_06v0 ad=1.25p pd=5.5u as=2.2p ps=10.88u w=5u l=1u
X702 a_34750_169399# a_30160_133316# VDD VDD pfet_06v0 ad=0.44p pd=2.88u as=0.44p ps=2.88u w=1u l=1u
X703 a_102002_167266# a_23448_190688# a_23448_190688# VSS nfet_06v0 ad=0.88p pd=4.88u as=0.52p ps=2.52u w=2u l=1u
X704 a_57822_190951# a_74848_157284# VDD VDD pfet_06v0 ad=0.44p pd=2.88u as=0.44p ps=2.88u w=1u l=1u
X705 a_81206_186803# a_83878_182403# VDD VDD pfet_06v0 ad=1.3p pd=5.52u as=1.3p ps=5.52u w=5u l=1u
X706 a_36382_140870# a_36382_140870# a_38018_140870# VDD pfet_06v0 ad=4.4p pd=20.88u as=3.3p ps=10.66u w=10u l=1u
X707 a_38738_195467# a_29586_194421# a_34950_191067# VDD pfet_06v0 ad=1.3p pd=5.52u as=2.2p ps=10.88u w=5u l=1u
X708 a_68418_186873# a_68218_186757# VSS VSS nfet_06v0 ad=1.25p pd=5.5u as=2.2p ps=10.88u w=5u l=1u
X709 VDD a_23448_190688# a_23448_190688# VDD pfet_06v0 ad=0.88p pd=4.88u as=0.52p ps=2.52u w=2u l=1u
X710 a_54642_152822# a_55734_159680# VDD VDD pfet_06v0 ad=2.2p pd=10.88u as=2.2p ps=10.88u w=5u l=1u
X711 a_23448_70736# a_100246_184486# a_100158_184530# VSS nfet_06v0 ad=0.6448p pd=3u as=1.0912p ps=5.84u w=2.48u l=1u
X712 a_54282_187673# a_52658_182289# VSS VSS nfet_06v0 ad=0.25p pd=1.5u as=0.44p ps=2.88u w=1u l=1u
X713 a_82318_169443# a_75842_164929# a_83878_165043# VDD pfet_06v0 ad=2.2p pd=10.88u as=1.3p ps=5.52u w=5u l=1u
X714 a_60618_159680# a_60418_159564# VDD VDD pfet_06v0 ad=2.5p pd=10.5u as=4.4p ps=20.88u w=10u l=1u
X715 a_31510_152822# a_33334_159680# VDD VDD pfet_06v0 ad=2.2p pd=10.88u as=2.2p ps=10.88u w=5u l=1u
X716 a_66174_195421# a_52318_190953# a_67374_190997# VSS nfet_06v0 ad=2.2p pd=10.88u as=1.25p ps=5.5u w=5u l=1u
X717 a_29586_177061# a_29586_177061# VDD VDD pfet_06v0 ad=0.88p pd=4.88u as=0.88p ps=4.88u w=2u l=1u
X718 a_76234_173593# a_75842_177061# a_76854_177177# VDD pfet_06v0 ad=4.4p pd=20.88u as=2.5p ps=10.5u w=10u l=1u
X719 VSS a_84542_169943# a_92966_169443# VSS nfet_06v0 ad=1.3p pd=5.52u as=1.3p ps=5.52u w=5u l=1u
X720 a_90558_173637# a_76234_173593# VSS VSS nfet_06v0 ad=1.25p pd=5.5u as=2.2p ps=10.88u w=5u l=1u
X721 VSS VDD VSS VSS nfet_06v0 ad=0.44p pd=2.88u as=0 ps=0 w=1u l=2u
X722 a_79082_149272# a_74234_148656# a_76398_140914# VSS nfet_06v0 ad=1.1p pd=5.88u as=0.825p ps=3.16u w=2.5u l=1u
X723 a_74848_157284# a_74274_159564# a_76198_152822# VDD pfet_06v0 ad=4.4p pd=20.88u as=4.4p ps=20.88u w=10u l=1u
X724 a_57822_190951# a_76198_152822# cap_mim_2f0_m4m5_noshield c_width=25u c_length=8u
X725 a_99096_168582# a_99096_168582# VDD VDD pfet_06v0 ad=0.88p pd=4.88u as=0.88p ps=4.88u w=2u l=1u
X726 VSS a_83430_169943# a_82762_165043# VSS nfet_06v0 ad=1.1p pd=5.88u as=0.65p ps=3.02u w=2.5u l=1u
X727 a_75502_187557# a_75842_182289# a_75742_182333# VDD pfet_06v0 ad=4.4p pd=20.88u as=2.5p ps=10.5u w=10u l=1u
X728 a_29746_148772# a_29546_148656# a_29446_148772# VSS nfet_06v0 ad=2.2p pd=10.88u as=1.25p ps=5.5u w=5u l=1u
X729 a_96674_159564# a_96674_159564# VDD VDD pfet_06v0 ad=0.88p pd=4.88u as=0.88p ps=4.88u w=2u l=1u
X730 a_91746_140914# a_73974_140870# VDD VDD pfet_06v0 ad=2.5p pd=10.5u as=4.4p ps=20.88u w=10u l=1u
X731 a_36382_140870# a_29546_148656# a_36590_148772# VSS nfet_06v0 ad=2.2p pd=10.88u as=1.25p ps=5.5u w=5u l=1u
X732 a_23448_70736# VDD a_102104_185738# VSS nfet_06v0 ad=0.6448p pd=3u as=1.0912p ps=5.84u w=2.48u l=1u
X733 a_76434_186873# a_76234_186757# VSS VSS nfet_06v0 ad=1.25p pd=5.5u as=2.2p ps=10.88u w=5u l=1u
X734 a_36506_182403# a_29246_187557# a_37174_187303# VSS nfet_06v0 ad=1.1p pd=5.88u as=0.65p ps=3.02u w=2.5u l=1u
X735 a_112222_135712# a_96374_135596# VDD VDD pfet_06v0 ad=2.5p pd=10.5u as=4.4p ps=20.88u w=10u l=1u
X736 a_54110_140914# a_35862_173591# cap_mim_2f0_m4m5_noshield c_width=25u c_length=8u
X737 a_80202_194537# a_75842_194421# a_79902_194537# VDD pfet_06v0 ad=3.3p pd=10.66u as=2.5p ps=10.5u w=10u l=1u
X738 a_60694_178107# a_52658_177061# a_59134_173707# VDD pfet_06v0 ad=1.3p pd=5.52u as=2.2p ps=10.88u w=5u l=1u
X739 VSS VDD VSS VSS nfet_06v0 ad=7.92p pd=36.88u as=0 ps=0 w=18u l=2u
X740 a_58782_140870# a_51946_148656# a_58990_148772# VSS nfet_06v0 ad=2.2p pd=10.88u as=1.25p ps=5.5u w=5u l=1u
X741 a_83430_187303# a_89358_182289# a_83878_182403# VDD pfet_06v0 ad=2.2p pd=10.88u as=2.2p ps=10.88u w=5u l=1u
X742 VDD VSS VDD VDD pfet_06v0 ad=7.92p pd=36.88u as=0 ps=0 w=18u l=2u
D26 S1N VDD diode_pd2nw_06v0 pj=40u area=99.99999p
X743 a_32522_194537# a_29286_194421# VDD VDD pfet_06v0 ad=2.5p pd=10.5u as=4.4p ps=20.88u w=10u l=1u
X744 a_81070_136796# a_81070_136796# a_82706_135596# VDD pfet_06v0 ad=4.4p pd=20.88u as=3.3p ps=10.66u w=10u l=1u
X745 a_92966_173707# a_84542_173707# VSS VSS nfet_06v0 ad=2.2p pd=10.88u as=1.3p ps=5.52u w=5u l=1u
X746 a_97248_145110# a_96674_140870# a_98598_148272# VDD pfet_06v0 ad=4.4p pd=20.88u as=4.4p ps=20.88u w=10u l=1u
X747 a_35862_190951# a_97248_157284# VDD VDD pfet_06v0 ad=0.44p pd=2.88u as=0.44p ps=2.88u w=1u l=1u
X748 VDD VSS VDD VDD pfet_06v0 ad=7.92p pd=36.88u as=0 ps=0 w=18u l=2u
X749 a_46710_169443# a_38738_165043# VDD VDD pfet_06v0 ad=4.4p pd=20.88u as=2.6p ps=10.52u w=10u l=1u
X750 a_84994_178107# a_75842_177061# a_81206_173707# VDD pfet_06v0 ad=1.3p pd=5.52u as=2.2p ps=10.88u w=5u l=1u
X751 a_58462_194467# a_52318_190953# a_61358_191067# VSS nfet_06v0 ad=1.1p pd=5.88u as=0.65p ps=3.02u w=2.5u l=1u
X752 a_30160_144210# a_45578_144660# VSS ppolyf_u_1k r_width=1u r_length=76.45u
X753 a_104146_167170# a_99096_168582# VSS VSS nfet_06v0 ad=0.5456p pd=3.36u as=0.5456p ps=3.36u w=1.24u l=1u
X754 a_29286_164929# a_29586_164929# a_31210_170313# VSS nfet_06v0 ad=0.44p pd=2.88u as=0.25p ps=1.5u w=1u l=1u
X755 a_29246_173593# a_29246_173593# VSS VSS nfet_06v0 ad=0.44p pd=2.88u as=0.44p ps=2.88u w=1u l=1u
X756 a_81646_165043# a_92966_169443# cap_mim_2f0_m4m5_noshield c_width=20u c_length=10u
X757 a_52318_173593# a_52658_177061# a_52558_177177# VDD pfet_06v0 ad=4.4p pd=20.88u as=2.5p ps=10.5u w=10u l=1u
X758 a_54922_137612# a_54442_128810# a_52186_135712# VDD pfet_06v0 ad=0.22p pd=1.88u as=0.22p ps=1.88u w=0.5u l=1u
X759 a_60034_152822# a_59834_152778# VSS VSS nfet_06v0 ad=1.25p pd=5.5u as=2.2p ps=10.88u w=5u l=1u
X760 a_84350_135712# a_73974_135596# VDD VDD pfet_06v0 ad=2.5p pd=10.5u as=4.4p ps=20.88u w=10u l=1u
X761 a_80202_164973# a_34750_169399# a_82762_165043# VDD pfet_06v0 ad=4.4p pd=20.88u as=2.6p ps=10.52u w=10u l=1u
X762 a_73934_152778# a_74234_152778# a_85150_152822# VSS nfet_06v0 ad=2.2p pd=10.88u as=1.25p ps=5.5u w=5u l=1u
X763 VDD a_52358_177061# a_57350_177177# VDD pfet_06v0 ad=4.4p pd=20.88u as=2.5p ps=10.5u w=10u l=1u
X764 a_102014_152778# a_102014_152778# a_104522_152778# VSS nfet_06v0 ad=2.2p pd=10.88u as=1.65p ps=5.66u w=5u l=1u
X765 a_78498_173637# a_75842_177061# VSS VSS nfet_06v0 ad=0.25p pd=1.5u as=0.44p ps=2.88u w=1u l=1u
X766 a_38998_149572# a_34394_149272# VSS VSS nfet_06v0 ad=0.44p pd=2.88u as=0.44p ps=2.88u w=1u l=1u
X767 VDD VSS VDD VDD pfet_06v0 ad=4.29p pd=20.38u as=0 ps=0 w=9.75u l=2u
X768 a_91402_173593# a_75502_173593# a_91602_173637# VSS nfet_06v0 ad=1.65p pd=5.66u as=1.25p ps=5.5u w=5u l=1u
X769 VSS a_69782_169443# a_104234_184486# VSS nfet_06v0 ad=0.44p pd=2.88u as=0.33p ps=1.66u w=1u l=1u
X770 a_33946_177177# a_35862_173591# a_36506_177107# VDD pfet_06v0 ad=4.4p pd=20.88u as=2.6p ps=10.52u w=10u l=1u
X771 a_23448_190688# a_23448_190688# a_102002_167266# VSS nfet_06v0 ad=0.52p pd=2.52u as=0.88p ps=4.88u w=2u l=1u
X772 a_96674_140870# a_96674_140870# VDD VDD pfet_06v0 ad=0.88p pd=4.88u as=0.88p ps=4.88u w=2u l=1u
X773 a_52186_140914# a_51986_140870# a_51886_140914# VDD pfet_06v0 ad=4.4p pd=20.88u as=2.5p ps=10.5u w=10u l=1u
X774 a_53670_177177# a_52358_177061# VDD VDD pfet_06v0 ad=2.5p pd=10.5u as=4.4p ps=20.88u w=10u l=1u
D27 VSS Y diode_nd2ps_06v0 pj=40u area=99.99999p
X775 a_61358_191067# a_66174_195421# a_61810_195467# VDD pfet_06v0 ad=2.2p pd=10.88u as=2.2p ps=10.88u w=5u l=1u
X776 a_96634_152778# a_96674_159564# a_111110_159680# VDD pfet_06v0 ad=4.4p pd=20.88u as=2.5p ps=10.5u w=10u l=1u
X777 a_23448_190688# a_23448_190688# VDD VDD pfet_06v0 ad=0.52p pd=2.52u as=0.52p ps=2.52u w=2u l=1u
X778 a_68010_164973# a_67810_164929# VDD VDD pfet_06v0 ad=2.5p pd=10.5u as=4.4p ps=20.88u w=10u l=1u
X779 a_77466_187673# a_75842_182289# VSS VSS nfet_06v0 ad=0.25p pd=1.5u as=0.44p ps=2.88u w=1u l=1u
X780 a_54642_148072# a_32042_152778# a_52146_148772# VSS nfet_06v0 ad=3.74p pd=17.88u as=3.74p ps=17.88u w=8.5u l=1u
X781 a_60034_128854# a_59834_128810# VSS VSS nfet_06v0 ad=1.25p pd=5.5u as=2.2p ps=10.88u w=5u l=1u
D28 VSS S4N diode_nd2ps_06v0 pj=40u area=99.99999p
X782 a_53050_173593# a_52318_173593# a_53250_173637# VSS nfet_06v0 ad=2.2p pd=10.88u as=1.25p ps=5.5u w=5u l=1u
X783 a_96674_140870# a_96674_140870# a_109614_149572# VSS nfet_06v0 ad=0.44p pd=2.88u as=0.25p ps=1.5u w=1u l=1u
X784 a_73934_128810# a_74234_128810# a_85150_128854# VSS nfet_06v0 ad=2.2p pd=10.88u as=1.25p ps=5.5u w=5u l=1u
X785 a_99330_152822# a_100422_159680# VDD VDD pfet_06v0 ad=2.2p pd=10.88u as=2.2p ps=10.88u w=5u l=1u
X786 a_90994_177061# a_75842_177061# a_91194_177177# VDD pfet_06v0 ad=3.3p pd=10.66u as=2.5p ps=10.5u w=10u l=1u
X787 a_76398_137602# a_31310_152778# a_74474_135712# VDD pfet_06v0 ad=0.242p pd=1.98u as=0.242p ps=1.98u w=0.55u l=1u
X788 a_102014_128810# a_102014_128810# a_104522_128810# VSS nfet_06v0 ad=2.2p pd=10.88u as=1.65p ps=5.66u w=5u l=1u
D29 S3N VDD diode_pd2nw_06v0 pj=40u area=99.99999p
X789 a_37174_191067# a_43102_195421# a_37622_195467# VDD pfet_06v0 ad=2.2p pd=10.88u as=2.2p ps=10.88u w=5u l=1u
X790 a_35390_177107# a_29246_173593# a_38286_173707# VSS nfet_06v0 ad=1.1p pd=5.88u as=0.65p ps=3.02u w=2.5u l=1u
X791 a_58462_182403# a_60246_187303# VSS VSS nfet_06v0 ad=0.65p pd=3.02u as=0.65p ps=3.02u w=2.5u l=1u
X792 a_34750_190951# a_52560_157284# VDD VDD pfet_06v0 ad=0.44p pd=2.88u as=0.44p ps=2.88u w=1u l=1u
D30 S1N VDD diode_pd2nw_06v0 pj=40u area=99.99999p
X793 a_33646_194537# a_29286_194421# VDD VDD pfet_06v0 ad=2.5p pd=10.5u as=4.4p ps=20.88u w=10u l=1u
X794 a_46710_191067# a_38286_191067# VSS VSS nfet_06v0 ad=2.2p pd=10.88u as=1.3p ps=5.52u w=5u l=1u
X795 a_74134_152822# a_73934_152778# VSS VSS nfet_06v0 ad=1.25p pd=5.5u as=2.2p ps=10.88u w=5u l=1u
X796 a_82318_191067# a_75842_194421# a_83878_195467# VDD pfet_06v0 ad=2.2p pd=10.88u as=1.3p ps=5.52u w=5u l=1u
X797 a_42638_187257# a_29586_182289# a_46382_182333# VDD pfet_06v0 ad=4.4p pd=20.88u as=2.5p ps=10.5u w=10u l=1u
X798 a_60694_195467# a_65710_190953# a_60246_191067# VSS nfet_06v0 ad=1.1p pd=5.88u as=1.1p ps=5.88u w=2.5u l=1u
X799 a_33586_173637# a_29246_173593# a_33286_173637# VSS nfet_06v0 ad=1.65p pd=5.66u as=1.25p ps=5.5u w=5u l=1u
X800 a_82762_165043# a_83430_169943# VSS VSS nfet_06v0 ad=0.65p pd=3.02u as=0.65p ps=3.02u w=2.5u l=1u
D31 VSS S1N diode_nd2ps_06v0 pj=40u area=99.99999p
D32 S3P VDD diode_pd2nw_06v0 pj=40u area=99.99999p
X801 a_74234_128810# a_74274_135596# a_88710_135712# VDD pfet_06v0 ad=4.4p pd=20.88u as=2.5p ps=10.5u w=10u l=1u
X802 a_29746_148772# a_29546_148656# a_30478_148772# VSS nfet_06v0 ad=2.2p pd=10.88u as=1.25p ps=5.5u w=5u l=1u
X803 a_83878_178107# a_75842_177061# a_82318_173707# VDD pfet_06v0 ad=1.3p pd=5.52u as=2.2p ps=10.88u w=5u l=1u
X804 a_23448_190688# a_106078_167126# a_99296_168626# VSS nfet_06v0 ad=0.6448p pd=3u as=1.0912p ps=5.84u w=2.48u l=1u
X805 a_34750_186759# a_74848_145110# VDD VDD pfet_06v0 ad=0.44p pd=2.88u as=0.44p ps=2.88u w=1u l=1u
X806 a_79842_169513# a_34750_169399# a_82318_169443# VSS nfet_06v0 ad=2.2p pd=10.88u as=1.3p ps=5.52u w=5u l=1u
X807 a_96534_152822# a_96334_152778# VSS VSS nfet_06v0 ad=1.25p pd=5.5u as=2.2p ps=10.88u w=5u l=1u
X808 a_85150_148772# a_73934_148656# VSS VSS nfet_06v0 ad=1.25p pd=5.5u as=2.2p ps=10.88u w=5u l=1u
D33 Y VDD diode_pd2nw_06v0 pj=40u area=99.99999p
X809 a_74134_128854# a_73934_128810# VSS VSS nfet_06v0 ad=1.25p pd=5.5u as=2.2p ps=10.88u w=5u l=1u
X810 a_36062_169443# a_35862_169399# a_33586_169513# VSS nfet_06v0 ad=1.3p pd=5.52u as=2.2p ps=10.88u w=5u l=1u
X811 VDD a_29286_177061# a_34278_177177# VDD pfet_06v0 ad=4.4p pd=20.88u as=2.5p ps=10.5u w=10u l=1u
X812 a_34750_173591# a_97248_133316# VDD VDD pfet_06v0 ad=0.44p pd=2.88u as=0.44p ps=2.88u w=1u l=1u
X813 a_79902_194537# a_75542_194421# VDD VDD pfet_06v0 ad=2.5p pd=10.5u as=4.4p ps=20.88u w=10u l=1u
X814 VSS a_76234_186757# a_80174_186873# VSS nfet_06v0 ad=2.2p pd=10.88u as=1.25p ps=5.5u w=5u l=1u
X815 a_78022_140914# a_74274_140870# a_76930_148072# VDD pfet_06v0 ad=4.4p pd=20.88u as=4.4p ps=20.88u w=10u l=1u
X816 a_32786_152778# a_36382_160764# a_33334_159680# VDD pfet_06v0 ad=1.76p pd=8.88u as=1.76p ps=8.88u w=4u l=1u
X817 a_115398_166742# a_69782_169443# a_114466_166626# VSS nfet_06v0 ad=0.25p pd=1.5u as=0.44p ps=2.88u w=1u l=1u
X818 VSS a_84542_173707# a_92966_173707# VSS nfet_06v0 ad=1.3p pd=5.52u as=1.3p ps=5.52u w=5u l=1u
X819 VSS VDD VSS VSS nfet_06v0 ad=4.29p pd=20.38u as=0 ps=0 w=9.75u l=2u
X820 a_81646_194467# a_75502_190953# a_84542_191067# VSS nfet_06v0 ad=1.1p pd=5.88u as=0.65p ps=3.02u w=2.5u l=1u
X821 a_79842_173637# a_75502_173593# a_79542_173637# VSS nfet_06v0 ad=1.65p pd=5.66u as=1.25p ps=5.5u w=5u l=1u
X822 a_110806_184214# a_46710_186803# VDD VDD pfet_06v0 ad=1.32p pd=6.88u as=1.32p ps=6.88u w=3u l=1u
X823 VSS VDD VSS VSS nfet_06v0 ad=7.92p pd=36.88u as=0 ps=0 w=18u l=2u
X824 a_30598_177177# a_29286_177061# VDD VDD pfet_06v0 ad=2.5p pd=10.5u as=4.4p ps=20.88u w=10u l=1u
X825 a_29786_140914# a_29586_140870# a_30598_140914# VDD pfet_06v0 ad=4.4p pd=20.88u as=2.5p ps=10.5u w=10u l=1u
X826 VDD VSS VDD VDD pfet_06v0 ad=0.44p pd=2.88u as=0 ps=0 w=1u l=2u
X827 a_81206_169443# a_75842_164929# a_84994_165043# VDD pfet_06v0 ad=2.2p pd=10.88u as=1.3p ps=5.52u w=5u l=1u
X828 a_96534_128854# a_96334_128810# VSS VSS nfet_06v0 ad=1.25p pd=5.5u as=2.2p ps=10.88u w=5u l=1u
X829 a_68218_173593# a_52318_173593# a_68418_173637# VSS nfet_06v0 ad=1.65p pd=5.66u as=1.25p ps=5.5u w=5u l=1u
X830 a_44938_164973# a_44738_164929# VDD VDD pfet_06v0 ad=2.5p pd=10.5u as=4.4p ps=20.88u w=10u l=1u
X831 a_30160_145110# a_45578_144660# VSS ppolyf_u_1k r_width=1u r_length=76.45u
X832 a_30160_157734# a_45578_157284# VSS ppolyf_u_1k r_width=1u r_length=76.45u
X833 a_23448_190688# a_23448_190688# VDD VDD pfet_06v0 ad=0.52p pd=2.52u as=0.52p ps=2.52u w=2u l=1u
X834 a_29978_173593# a_29246_173593# a_30178_173637# VSS nfet_06v0 ad=2.2p pd=10.88u as=1.25p ps=5.5u w=5u l=1u
X835 VSS a_61358_187303# a_69782_186803# VSS nfet_06v0 ad=1.3p pd=5.52u as=1.3p ps=5.52u w=5u l=1u
D34 VSS X diode_nd2ps_06v0 pj=40u area=99.99999p
X836 a_56990_186873# a_52318_187557# a_56658_186873# VSS nfet_06v0 ad=1.25p pd=5.5u as=1.65p ps=5.66u w=5u l=1u
X837 VSS VDD VSS VSS nfet_06v0 ad=0.44p pd=2.88u as=0 ps=0 w=1u l=2u
X838 VSS a_60246_191067# a_58462_194467# VSS nfet_06v0 ad=1.1p pd=5.88u as=0.65p ps=3.02u w=2.5u l=1u
X839 a_38018_135596# a_29586_135596# a_38218_135712# VDD pfet_06v0 ad=3.3p pd=10.66u as=2.5p ps=10.5u w=10u l=1u
X840 a_52186_140914# a_51986_140870# a_52998_140914# VDD pfet_06v0 ad=4.4p pd=20.88u as=2.5p ps=10.5u w=10u l=1u
X841 a_98486_190984# a_46710_191067# VDD VDD pfet_06v0 ad=1.32p pd=6.88u as=1.32p ps=6.88u w=3u l=1u
X842 a_81070_160764# a_74234_152778# a_81278_152822# VSS nfet_06v0 ad=2.2p pd=10.88u as=1.25p ps=5.5u w=5u l=1u
X843 VSS VDD VSS VSS nfet_06v0 ad=4.29p pd=20.38u as=0 ps=0 w=9.75u l=2u
X844 a_35862_186759# a_34394_152822# VSS VSS nfet_06v0 ad=0.44p pd=2.88u as=0.44p ps=2.88u w=1u l=1u
X845 a_82762_165043# a_34750_169399# a_80202_164973# VDD pfet_06v0 ad=2.6p pd=10.52u as=4.4p ps=20.88u w=10u l=1u
X846 a_53050_169397# a_52658_164929# a_53670_164973# VDD pfet_06v0 ad=4.4p pd=20.88u as=2.5p ps=10.5u w=10u l=1u
D35 S3N VDD diode_pd2nw_06v0 pj=40u area=99.99999p
X847 a_102002_167266# a_23448_190688# a_103402_167336# VSS nfet_06v0 ad=0.88p pd=4.88u as=0.5p ps=2.5u w=2u l=1u
X848 a_67374_190997# a_53050_190953# VSS VSS nfet_06v0 ad=1.25p pd=5.5u as=2.2p ps=10.88u w=5u l=1u
X849 a_30160_157284# a_45578_157284# VSS ppolyf_u_1k r_width=1u r_length=76.45u
X850 a_76854_177177# a_75542_177061# VDD VDD pfet_06v0 ad=2.5p pd=10.5u as=4.4p ps=20.88u w=10u l=1u
X851 a_99046_184530# a_99134_184486# a_23448_70736# VSS nfet_06v0 ad=1.0912p pd=5.84u as=0.6448p ps=3u w=2.48u l=1u
X852 a_37622_195467# a_42638_190953# a_37174_191067# VSS nfet_06v0 ad=1.1p pd=5.88u as=1.1p ps=5.88u w=2.5u l=1u
X853 a_73934_148656# a_74274_140870# a_89822_140914# VDD pfet_06v0 ad=4.4p pd=20.88u as=2.5p ps=10.5u w=10u l=1u
D36 VSS S3N diode_nd2ps_06v0 pj=40u area=99.99999p
X854 a_65710_173593# a_52658_177061# a_69454_177177# VDD pfet_06v0 ad=4.4p pd=20.88u as=2.5p ps=10.5u w=10u l=1u
X855 a_96674_159564# a_96674_159564# a_109614_152822# VSS nfet_06v0 ad=0.44p pd=2.88u as=0.25p ps=1.5u w=1u l=1u
X856 a_76234_173593# a_75502_173593# a_76434_173637# VSS nfet_06v0 ad=2.2p pd=10.88u as=1.25p ps=5.5u w=5u l=1u
X857 a_99610_140914# a_99874_149156# VSS VSS nfet_06v0 ad=0.825p pd=3.16u as=1.1p ps=5.88u w=2.5u l=1u
X858 a_61810_165043# a_65710_169897# a_61358_169943# VSS nfet_06v0 ad=1.1p pd=5.88u as=1.1p ps=5.88u w=2.5u l=1u
X859 a_59578_165043# a_52318_170197# a_60246_169943# VSS nfet_06v0 ad=1.1p pd=5.88u as=0.65p ps=3.02u w=2.5u l=1u
X860 a_75742_182333# a_75542_182289# VDD VDD pfet_06v0 ad=2.5p pd=10.5u as=4.4p ps=20.88u w=10u l=1u
X861 a_35862_169399# a_76198_128854# cap_mim_2f0_m4m5_noshield c_width=25u c_length=8u
X862 a_56794_128854# a_58782_136796# a_52560_133316# VDD pfet_06v0 ad=1.76p pd=8.88u as=1.76p ps=8.88u w=4u l=1u
X863 a_29446_148772# a_29246_148656# VSS VSS nfet_06v0 ad=1.25p pd=5.5u as=2.2p ps=10.88u w=5u l=1u
D37 VSS S1N diode_nd2ps_06v0 pj=40u area=99.99999p
D38 S3P VDD diode_pd2nw_06v0 pj=40u area=99.99999p
X864 a_92966_191067# a_84542_191067# VSS VSS nfet_06v0 ad=1.3p pd=5.52u as=2.2p ps=10.88u w=5u l=1u
X865 VDD VSS VDD VDD pfet_06v0 ad=0.44p pd=2.88u as=0 ps=0 w=1u l=2u
X866 a_81070_136796# a_74234_128810# a_81278_128854# VSS nfet_06v0 ad=2.2p pd=10.88u as=1.25p ps=5.5u w=5u l=1u
X867 a_36590_148772# a_29246_148656# VSS VSS nfet_06v0 ad=1.25p pd=5.5u as=2.2p ps=10.88u w=5u l=1u
X868 a_34750_169399# a_34394_128854# VSS VSS nfet_06v0 ad=0.44p pd=2.88u as=0.44p ps=2.88u w=1u l=1u
X869 a_86182_149572# a_74274_140870# VSS VSS nfet_06v0 ad=0.25p pd=1.5u as=0.44p ps=2.88u w=1u l=1u
X870 a_66174_182289# a_66174_182289# a_67810_182289# VDD pfet_06v0 ad=4.4p pd=20.88u as=3.3p ps=10.66u w=10u l=1u
X871 a_57822_186759# a_101482_149272# VSS VSS nfet_06v0 ad=0.44p pd=2.88u as=0.44p ps=2.88u w=1u l=1u
X872 VSS VDD VSS VSS nfet_06v0 ad=7.92p pd=36.88u as=0 ps=0 w=18u l=2u
X873 a_79082_152822# a_81070_160764# a_74848_157284# VDD pfet_06v0 ad=1.76p pd=8.88u as=1.76p ps=8.88u w=4u l=1u
X874 a_56658_169513# a_35862_169399# a_59134_169443# VSS nfet_06v0 ad=2.2p pd=10.88u as=1.3p ps=5.52u w=5u l=1u
X875 a_57822_190951# a_74848_157284# VDD VDD pfet_06v0 ad=0.44p pd=2.88u as=0.44p ps=2.88u w=1u l=1u
X876 a_75502_187557# a_75502_187557# VSS VSS nfet_06v0 ad=0.44p pd=2.88u as=0.44p ps=2.88u w=1u l=1u
D39 VSS S3P diode_nd2ps_06v0 pj=40u area=99.99999p
X877 a_59134_186803# a_52658_182289# a_60694_182403# VDD pfet_06v0 ad=2.2p pd=10.88u as=1.3p ps=5.52u w=5u l=1u
X878 VSS a_60246_187303# a_58462_182403# VSS nfet_06v0 ad=0.65p pd=3.02u as=0.65p ps=3.02u w=2.5u l=1u
X879 a_74274_135596# a_74274_135596# VDD VDD pfet_06v0 ad=0.88p pd=4.88u as=0.88p ps=4.88u w=2u l=1u
X880 a_31710_137602# a_31310_128810# a_29786_135712# VDD pfet_06v0 ad=0.242p pd=1.98u as=0.242p ps=1.98u w=0.55u l=1u
X881 a_96674_135596# a_96674_135596# a_109614_128854# VSS nfet_06v0 ad=0.44p pd=2.88u as=0.25p ps=1.5u w=1u l=1u
X882 VSS VDD VSS VSS nfet_06v0 ad=0.44p pd=2.88u as=0 ps=0 w=1u l=2u
X883 a_58022_169443# a_57822_169399# a_56658_169513# VSS nfet_06v0 ad=1.3p pd=5.52u as=2.2p ps=10.88u w=5u l=1u
X884 VSS a_37174_169943# a_35390_165043# VSS nfet_06v0 ad=1.1p pd=5.88u as=0.65p ps=3.02u w=2.5u l=1u
X885 a_100158_184530# a_99096_185942# VSS VSS nfet_06v0 ad=0.5456p pd=3.36u as=0.5456p ps=3.36u w=1.24u l=1u
X886 VSS VDD VSS VSS nfet_06v0 ad=4.29p pd=20.38u as=0 ps=0 w=9.75u l=2u
X887 a_31210_170313# a_29586_164929# VSS VSS nfet_06v0 ad=0.25p pd=1.5u as=0.44p ps=2.88u w=1u l=1u
X888 a_52558_177177# a_52358_177061# VDD VDD pfet_06v0 ad=2.5p pd=10.5u as=4.4p ps=20.88u w=10u l=1u
X889 a_74848_158634# a_90266_158184# VSS ppolyf_u_1k r_width=1u r_length=76.45u
X890 a_35862_169399# a_74848_133316# VDD VDD pfet_06v0 ad=0.44p pd=2.88u as=0.44p ps=2.88u w=1u l=1u
X891 a_36506_194467# a_37174_191067# VSS VSS nfet_06v0 ad=0.65p pd=3.02u as=1.1p ps=5.88u w=2.5u l=1u
X892 a_29978_169397# a_29586_164929# a_30598_164973# VDD pfet_06v0 ad=4.4p pd=20.88u as=2.5p ps=10.5u w=10u l=1u
D40 Z VDD diode_pd2nw_06v0 pj=40u area=99.99999p
X893 a_52560_143310# a_35862_173591# VSS ppolyf_u_1k r_width=1u r_length=76.45u
X894 a_84542_191067# a_75502_190953# a_81646_194467# VSS nfet_06v0 ad=0.65p pd=3.02u as=1.1p ps=5.88u w=2.5u l=1u
X895 a_78022_140914# a_79614_149256# a_77474_149156# VSS nfet_06v0 ad=0.88p pd=4.88u as=0.88p ps=4.88u w=2u l=1u
X896 a_31710_161570# a_35862_186759# cap_mim_2f0_m4m5_noshield c_width=25u c_length=8u
X897 a_97248_158634# a_112666_158184# VSS ppolyf_u_1k r_width=1u r_length=76.45u
X898 a_81646_165043# a_57822_169399# a_80202_164973# VDD pfet_06v0 ad=2.6p pd=10.52u as=4.4p ps=20.88u w=10u l=1u
X899 a_59578_165043# a_35862_169399# a_57018_164973# VDD pfet_06v0 ad=2.6p pd=10.52u as=4.4p ps=20.88u w=10u l=1u
X900 a_57350_177177# a_52658_177061# a_57018_177177# VDD pfet_06v0 ad=2.5p pd=10.5u as=3.3p ps=10.66u w=10u l=1u
X901 X a_23448_190688# VDD ppolyf_u r_width=16u r_length=4u
X902 VDD VSS VDD VDD pfet_06v0 ad=4.29p pd=20.38u as=0 ps=0 w=9.75u l=2u
X903 a_34950_169443# a_37622_165043# VDD VDD pfet_06v0 ad=1.3p pd=5.52u as=1.3p ps=5.52u w=5u l=1u
X904 a_35390_165043# a_37174_169943# VSS VSS nfet_06v0 ad=0.65p pd=3.02u as=1.1p ps=5.88u w=2.5u l=1u
X905 a_91602_173637# a_91402_173593# VSS VSS nfet_06v0 ad=1.25p pd=5.5u as=2.2p ps=10.88u w=5u l=1u
X906 a_36506_177107# a_29246_173593# a_37174_173707# VSS nfet_06v0 ad=1.1p pd=5.88u as=0.65p ps=3.02u w=2.5u l=1u
X907 a_96874_159680# a_96674_159564# a_97686_159680# VDD pfet_06v0 ad=4.4p pd=20.88u as=2.5p ps=10.5u w=10u l=1u
X908 a_74848_157734# a_90266_158184# VSS ppolyf_u_1k r_width=1u r_length=76.45u
D41 VSS S3N diode_nd2ps_06v0 pj=40u area=99.99999p
X909 a_80174_186873# a_75502_187557# a_79842_186873# VSS nfet_06v0 ad=1.25p pd=5.5u as=1.65p ps=5.66u w=5u l=1u
X910 a_46710_191067# a_38738_195467# VDD VDD pfet_06v0 ad=4.4p pd=20.88u as=2.6p ps=10.52u w=10u l=1u
X911 a_51886_140914# a_51686_140870# VDD VDD pfet_06v0 ad=2.5p pd=10.5u as=4.4p ps=20.88u w=10u l=1u
X912 a_89358_178061# a_89358_178061# a_90994_177061# VDD pfet_06v0 ad=4.4p pd=20.88u as=3.3p ps=10.66u w=10u l=1u
X913 VDD a_23448_190688# a_23448_190688# VDD pfet_06v0 ad=0.52p pd=2.52u as=0.52p ps=2.52u w=2u l=1u
X914 a_69782_186803# a_61358_187303# VSS VSS nfet_06v0 ad=1.3p pd=5.52u as=2.2p ps=10.88u w=5u l=1u
X915 a_29286_182289# a_29586_182289# a_32522_182333# VDD pfet_06v0 ad=4.4p pd=20.88u as=2.5p ps=10.5u w=10u l=1u
X916 a_52658_164929# a_52658_164929# a_55314_170313# VSS nfet_06v0 ad=0.44p pd=2.88u as=0.25p ps=1.5u w=1u l=1u
X917 a_79842_173637# a_34750_173591# a_82318_173707# VSS nfet_06v0 ad=2.2p pd=10.88u as=1.3p ps=5.52u w=5u l=1u
X918 a_99874_152778# a_103470_160764# a_100422_159680# VDD pfet_06v0 ad=1.76p pd=8.88u as=1.76p ps=8.88u w=4u l=1u
X919 a_69782_169443# a_61810_165043# VDD VDD pfet_06v0 ad=2.6p pd=10.52u as=4.4p ps=20.88u w=10u l=1u
X920 a_33946_182333# a_35862_186759# a_36506_182403# VDD pfet_06v0 ad=4.4p pd=20.88u as=2.6p ps=10.52u w=10u l=1u
X921 a_109614_149572# a_96674_140870# VSS VSS nfet_06v0 ad=0.25p pd=1.5u as=0.44p ps=2.88u w=1u l=1u
X922 a_76234_169397# a_75842_164929# a_76854_164973# VDD pfet_06v0 ad=4.4p pd=20.88u as=2.5p ps=10.5u w=10u l=1u
X923 a_53250_173637# a_53050_173593# VSS VSS nfet_06v0 ad=1.25p pd=5.5u as=2.2p ps=10.88u w=5u l=1u
X924 a_81206_191067# a_75842_194421# a_84994_195467# VDD pfet_06v0 ad=2.2p pd=10.88u as=1.3p ps=5.52u w=5u l=1u
X925 VDD a_69782_186803# a_114466_184098# VDD pfet_06v0 ad=1.32p pd=6.88u as=0.99p ps=3.66u w=3u l=1u
X926 a_97248_157734# a_112666_158184# VSS ppolyf_u_1k r_width=1u r_length=76.45u
X927 a_36062_173707# a_35862_173591# a_33586_173637# VSS nfet_06v0 ad=1.3p pd=5.52u as=2.2p ps=10.88u w=5u l=1u
X928 a_38998_149572# a_30160_145110# VDD VDD pfet_06v0 ad=0.44p pd=2.88u as=0.44p ps=2.88u w=1u l=1u
X929 a_33918_173637# a_29246_173593# a_33586_173637# VSS nfet_06v0 ad=1.25p pd=5.5u as=1.65p ps=5.66u w=5u l=1u
X930 a_30178_173637# a_29978_173593# VSS VSS nfet_06v0 ad=1.25p pd=5.5u as=2.2p ps=10.88u w=5u l=1u
D42 VSS S3P diode_nd2ps_06v0 pj=40u area=99.99999p
X931 a_80202_194537# a_34750_190951# a_82762_194467# VDD pfet_06v0 ad=4.4p pd=20.88u as=2.6p ps=10.52u w=10u l=1u
X932 a_89358_164929# a_75502_170197# a_90558_169513# VSS nfet_06v0 ad=2.2p pd=10.88u as=1.25p ps=5.5u w=5u l=1u
X933 VDD VSS VDD VDD pfet_06v0 ad=0.44p pd=2.88u as=0 ps=0 w=1u l=2u
X934 a_23448_70736# a_99134_184486# a_99046_184530# VSS nfet_06v0 ad=0.6448p pd=3u as=1.0912p ps=5.84u w=2.48u l=1u
X935 a_84994_165043# a_88894_169897# a_84542_169943# VSS nfet_06v0 ad=1.1p pd=5.88u as=1.1p ps=5.88u w=2.5u l=1u
X936 a_82762_165043# a_75502_170197# a_83430_169943# VSS nfet_06v0 ad=1.1p pd=5.88u as=0.65p ps=3.02u w=2.5u l=1u
X937 a_105106_135596# a_96674_135596# a_105306_135712# VDD pfet_06v0 ad=3.3p pd=10.66u as=2.5p ps=10.5u w=10u l=1u
X938 a_46382_182333# a_29286_182289# VDD VDD pfet_06v0 ad=2.5p pd=10.5u as=4.4p ps=20.88u w=10u l=1u
X939 VDD VSS VDD VDD pfet_06v0 ad=4.29p pd=20.38u as=0 ps=0 w=9.75u l=2u
X940 a_86182_152822# a_74274_159564# VSS VSS nfet_06v0 ad=0.25p pd=1.5u as=0.44p ps=2.88u w=1u l=1u
X941 a_33286_173637# a_29978_173593# VSS VSS nfet_06v0 ad=1.25p pd=5.5u as=2.2p ps=10.88u w=5u l=1u
X942 a_84542_169943# a_89358_164929# a_84994_165043# VDD pfet_06v0 ad=2.2p pd=10.88u as=2.2p ps=10.88u w=5u l=1u
X943 a_35862_190951# a_101482_152822# VSS VSS nfet_06v0 ad=0.44p pd=2.88u as=0.44p ps=2.88u w=1u l=1u
X944 VSS a_114466_184098# a_106078_167126# VSS nfet_06v0 ad=0.44p pd=2.88u as=0.44p ps=2.88u w=1u l=1u
X945 a_100246_175068# a_111626_173580# VDD VDD pfet_06v0 ad=1.32p pd=6.88u as=1.32p ps=6.88u w=3u l=1u
X946 a_88710_135712# a_73974_135596# VDD VDD pfet_06v0 ad=2.5p pd=10.5u as=4.4p ps=20.88u w=10u l=1u
X947 a_30478_148772# a_29246_148656# VSS VSS nfet_06v0 ad=1.25p pd=5.5u as=2.2p ps=10.88u w=5u l=1u
X948 a_79082_152822# a_74234_152778# a_76398_161570# VSS nfet_06v0 ad=1.1p pd=5.88u as=0.825p ps=3.16u w=2.5u l=1u
X949 a_35862_173591# a_52560_145110# VDD VDD pfet_06v0 ad=0.44p pd=2.88u as=0.44p ps=2.88u w=1u l=1u
X950 a_37174_169943# a_29246_170197# a_36506_165043# VSS nfet_06v0 ad=0.65p pd=3.02u as=1.1p ps=5.88u w=2.5u l=1u
X951 a_60246_191067# a_52318_190953# a_59578_194467# VSS nfet_06v0 ad=0.65p pd=3.02u as=1.1p ps=5.88u w=2.5u l=1u
X952 a_34750_173591# a_97248_133316# VDD VDD pfet_06v0 ad=0.44p pd=2.88u as=0.44p ps=2.88u w=1u l=1u
X953 a_62062_159680# a_51686_159564# VDD VDD pfet_06v0 ad=2.5p pd=10.5u as=4.4p ps=20.88u w=10u l=1u
X954 VDD a_75542_194421# a_80534_194537# VDD pfet_06v0 ad=4.4p pd=20.88u as=2.5p ps=10.5u w=10u l=1u
X955 VSS a_83430_187303# a_81646_182403# VSS nfet_06v0 ad=0.65p pd=3.02u as=0.65p ps=3.02u w=2.5u l=1u
X956 YN_OUT a_102380_177524# VDD VDD pfet_05v0 ad=0.8052p pd=4.54u as=0.8052p ps=4.54u w=1.83u l=0.5u
X957 a_60694_182403# a_52658_182289# a_59134_186803# VDD pfet_06v0 ad=1.3p pd=5.52u as=2.2p ps=10.88u w=5u l=1u
X958 a_45146_190953# a_29246_190953# a_45346_190997# VSS nfet_06v0 ad=1.65p pd=5.66u as=1.25p ps=5.5u w=5u l=1u
X959 a_34278_177177# a_29586_177061# a_33946_177177# VDD pfet_06v0 ad=2.5p pd=10.5u as=3.3p ps=10.66u w=10u l=1u
X960 a_86182_128854# a_74274_135596# VSS VSS nfet_06v0 ad=0.25p pd=1.5u as=0.44p ps=2.88u w=1u l=1u
X961 VDD a_60694_178107# a_58022_173707# VDD pfet_06v0 ad=1.3p pd=5.52u as=1.3p ps=5.52u w=5u l=1u
X962 a_34750_173591# a_101482_128854# VSS VSS nfet_06v0 ad=0.44p pd=2.88u as=0.44p ps=2.88u w=1u l=1u
X963 a_79542_173637# a_76234_173593# VSS VSS nfet_06v0 ad=1.25p pd=5.5u as=2.2p ps=10.88u w=5u l=1u
X964 a_30160_133316# a_29586_135596# a_31510_128854# VDD pfet_06v0 ad=4.4p pd=20.88u as=4.4p ps=20.88u w=10u l=1u
X965 a_79082_128854# a_74234_128810# a_76398_137602# VSS nfet_06v0 ad=1.1p pd=5.88u as=0.825p ps=3.16u w=2.5u l=1u
X966 a_52318_170197# a_52658_164929# a_52558_164973# VDD pfet_06v0 ad=4.4p pd=20.88u as=2.5p ps=10.5u w=10u l=1u
X967 a_30598_140914# a_29286_140870# VDD VDD pfet_06v0 ad=2.5p pd=10.5u as=4.4p ps=20.88u w=10u l=1u
D43 S4N VDD diode_pd2nw_06v0 pj=40u area=99.99999p
X968 a_68418_173637# a_68218_173593# VSS VSS nfet_06v0 ad=1.25p pd=5.5u as=2.2p ps=10.88u w=5u l=1u
X969 a_84994_182403# a_75842_182289# a_81206_186803# VDD pfet_06v0 ad=1.3p pd=5.52u as=2.2p ps=10.88u w=5u l=1u
D44 X VDD diode_pd2nw_06v0 pj=40u area=99.99999p
X970 a_35390_194467# a_37174_191067# VSS VSS nfet_06v0 ad=0.65p pd=3.02u as=0.65p ps=3.02u w=2.5u l=1u
X971 a_76398_140914# a_34750_186759# cap_mim_2f0_m4m5_noshield c_width=25u c_length=8u
X972 a_33946_182333# a_29586_182289# a_33646_182333# VDD pfet_06v0 ad=3.3p pd=10.66u as=2.5p ps=10.5u w=10u l=1u
X973 a_101060_186094# a_99096_185942# a_100760_186094# VSS nfet_06v0 ad=0.175p pd=1.2u as=0.175p ps=1.2u w=0.7u l=1u
X974 a_74848_133316# a_90266_133316# VSS ppolyf_u_1k r_width=1u r_length=76.45u
X975 a_58462_177107# a_60246_173707# VSS VSS nfet_06v0 ad=0.65p pd=3.02u as=0.65p ps=3.02u w=2.5u l=1u
X976 a_56658_173637# a_35862_173591# a_59134_173707# VSS nfet_06v0 ad=2.2p pd=10.88u as=1.3p ps=5.52u w=5u l=1u
X977 a_52560_133316# a_51986_135596# a_53910_128854# VDD pfet_06v0 ad=4.4p pd=20.88u as=4.4p ps=20.88u w=10u l=1u
X978 a_38218_135712# a_38018_135596# VDD VDD pfet_06v0 ad=2.5p pd=10.5u as=4.4p ps=20.88u w=10u l=1u
X979 VDD a_52358_164929# a_57350_164973# VDD pfet_06v0 ad=4.4p pd=20.88u as=2.5p ps=10.5u w=10u l=1u
X980 a_81278_152822# a_73934_152778# VSS VSS nfet_06v0 ad=1.25p pd=5.5u as=2.2p ps=10.88u w=5u l=1u
X981 a_53670_164973# a_52358_164929# VDD VDD pfet_06v0 ad=2.5p pd=10.5u as=4.4p ps=20.88u w=10u l=1u
X982 a_91194_194537# a_90994_194421# VDD VDD pfet_06v0 ad=2.5p pd=10.5u as=4.4p ps=20.88u w=10u l=1u
X983 a_97248_133316# a_112666_133316# VSS ppolyf_u_1k r_width=1u r_length=76.45u
X984 a_103402_167336# a_23448_190688# VSS VSS nfet_06v0 ad=0.5p pd=2.5u as=0.88p ps=4.88u w=2u l=1u
X985 a_29786_159680# a_29586_159564# a_29486_159680# VDD pfet_06v0 ad=4.4p pd=20.88u as=2.5p ps=10.5u w=10u l=1u
X986 a_89822_140914# a_73974_140870# VDD VDD pfet_06v0 ad=2.5p pd=10.5u as=4.4p ps=20.88u w=10u l=1u
X987 a_58022_173707# a_38998_149572# a_56658_173637# VSS nfet_06v0 ad=1.3p pd=5.52u as=2.2p ps=10.88u w=5u l=1u
X988 VDD a_37622_165043# a_34950_169443# VDD pfet_06v0 ad=1.3p pd=5.52u as=1.3p ps=5.52u w=5u l=1u
X989 VSS VDD VSS VSS nfet_06v0 ad=4.29p pd=20.38u as=0 ps=0 w=9.75u l=2u
X990 VSS a_111626_173580# a_100246_175068# VSS nfet_06v0 ad=0.44p pd=2.88u as=0.44p ps=2.88u w=1u l=1u
X991 S2N a_32042_128810# VDD ppolyf_u r_width=16u r_length=4u
X992 a_69454_177177# a_52358_177061# VDD VDD pfet_06v0 ad=2.5p pd=10.5u as=4.4p ps=20.88u w=10u l=1u
X993 a_109614_152822# a_96674_159564# VSS VSS nfet_06v0 ad=0.25p pd=1.5u as=0.44p ps=2.88u w=1u l=1u
X994 a_90994_164929# a_75842_164929# a_91194_164973# VDD pfet_06v0 ad=3.3p pd=10.66u as=2.5p ps=10.5u w=10u l=1u
X995 a_76434_173637# a_76234_173593# VSS VSS nfet_06v0 ad=1.25p pd=5.5u as=2.2p ps=10.88u w=5u l=1u
X996 a_100158_175184# a_100246_175068# a_23448_131216# VSS nfet_06v0 ad=1.0912p pd=5.84u as=0.6448p ps=3u w=2.48u l=1u
X997 a_81278_128854# a_73934_128810# VSS VSS nfet_06v0 ad=1.25p pd=5.5u as=2.2p ps=10.88u w=5u l=1u
X998 a_34950_191067# a_37622_195467# VDD VDD pfet_06v0 ad=1.3p pd=5.52u as=1.3p ps=5.52u w=5u l=1u
X999 a_34750_190951# a_52560_157284# VDD VDD pfet_06v0 ad=0.44p pd=2.88u as=0.44p ps=2.88u w=1u l=1u
X1000 a_56794_149272# a_58782_140870# a_52560_145110# VDD pfet_06v0 ad=1.76p pd=8.88u as=1.76p ps=8.88u w=4u l=1u
X1001 VSS VDD VSS VSS nfet_06v0 ad=7.92p pd=36.88u as=0 ps=0 w=18u l=2u
X1002 a_81206_169443# a_57822_169399# a_79842_169513# VSS nfet_06v0 ad=1.3p pd=5.52u as=2.2p ps=10.88u w=5u l=1u
X1003 a_59134_186803# a_35862_186759# a_56658_186873# VSS nfet_06v0 ad=1.3p pd=5.52u as=2.2p ps=10.88u w=5u l=1u
X1004 a_38286_169943# a_29246_170197# a_35390_165043# VSS nfet_06v0 ad=0.65p pd=3.02u as=1.1p ps=5.88u w=2.5u l=1u
X1005 a_82762_194467# a_34750_190951# a_80202_194537# VDD pfet_06v0 ad=2.6p pd=10.52u as=4.4p ps=20.88u w=10u l=1u
X1006 a_109614_128854# a_96674_135596# VSS VSS nfet_06v0 ad=0.25p pd=1.5u as=0.44p ps=2.88u w=1u l=1u
X1007 a_83430_169943# a_75502_170197# a_82762_165043# VSS nfet_06v0 ad=0.65p pd=3.02u as=1.1p ps=5.88u w=2.5u l=1u
X1008 VDD a_60694_178107# a_59134_173707# VDD pfet_06v0 ad=2.2p pd=10.88u as=1.3p ps=5.52u w=5u l=1u
X1009 a_59134_169443# a_60694_165043# VDD VDD pfet_06v0 ad=1.3p pd=5.52u as=2.2p ps=10.88u w=5u l=1u
D45 X VDD diode_pd2nw_06v0 pj=40u area=99.99999p
X1010 a_55734_159680# a_51986_159564# a_54642_152822# VDD pfet_06v0 ad=4.4p pd=20.88u as=4.4p ps=20.88u w=10u l=1u
X1011 VDD a_29286_164929# a_34278_164973# VDD pfet_06v0 ad=4.4p pd=20.88u as=2.5p ps=10.5u w=10u l=1u
X1012 a_57018_177177# a_52658_177061# a_56718_177177# VDD pfet_06v0 ad=3.3p pd=10.66u as=2.5p ps=10.5u w=10u l=1u
X1013 a_57326_152778# a_57326_152778# a_59834_152778# VSS nfet_06v0 ad=2.2p pd=10.88u as=1.65p ps=5.66u w=5u l=1u
X1014 a_83878_182403# a_75842_182289# a_82318_186803# VDD pfet_06v0 ad=1.3p pd=5.52u as=2.2p ps=10.88u w=5u l=1u
D46 S1P VDD diode_pd2nw_06v0 pj=40u area=99.99999p
X1015 a_81646_182403# a_83430_187303# VSS VSS nfet_06v0 ad=0.65p pd=3.02u as=1.1p ps=5.88u w=2.5u l=1u
X1016 a_104234_175068# a_111626_166626# VDD VDD pfet_06v0 ad=1.32p pd=6.88u as=1.32p ps=6.88u w=3u l=1u
X1017 VDD VSS VDD VDD pfet_06v0 ad=4.29p pd=20.38u as=0 ps=0 w=9.75u l=2u
X1018 VDD a_83878_178107# a_81206_173707# VDD pfet_06v0 ad=1.3p pd=5.52u as=1.3p ps=5.52u w=5u l=1u
X1019 a_82122_152778# a_74234_152778# a_82322_152822# VSS nfet_06v0 ad=1.65p pd=5.66u as=1.25p ps=5.5u w=5u l=1u
X1020 a_30598_164973# a_29286_164929# VDD VDD pfet_06v0 ad=2.5p pd=10.5u as=4.4p ps=20.88u w=10u l=1u
X1021 a_88894_190953# a_75842_194421# a_92638_194537# VDD pfet_06v0 ad=4.4p pd=20.88u as=2.5p ps=10.5u w=10u l=1u
X1022 a_111626_184098# a_92966_186803# VDD VDD pfet_06v0 ad=0.99p pd=3.66u as=1.32p ps=6.88u w=3u l=1u
X1023 a_58022_173707# a_60694_178107# VDD VDD pfet_06v0 ad=1.3p pd=5.52u as=2.2p ps=10.88u w=5u l=1u
X1024 a_58022_169443# a_60694_165043# VDD VDD pfet_06v0 ad=1.3p pd=5.52u as=1.3p ps=5.52u w=5u l=1u
X1025 VSS a_29978_190953# a_33918_190997# VSS nfet_06v0 ad=2.2p pd=10.88u as=1.25p ps=5.5u w=5u l=1u
X1026 a_80202_182333# a_75842_182289# a_79902_182333# VDD pfet_06v0 ad=3.3p pd=10.66u as=2.5p ps=10.5u w=10u l=1u
X1027 a_31710_137602# a_34750_169399# cap_mim_2f0_m4m5_noshield c_width=25u c_length=8u
X1028 a_97686_159680# a_96374_159564# VDD VDD pfet_06v0 ad=2.5p pd=10.5u as=4.4p ps=20.88u w=10u l=1u
X1029 a_57326_128810# a_57326_128810# a_59834_128810# VSS nfet_06v0 ad=2.2p pd=10.88u as=1.65p ps=5.66u w=5u l=1u
X1030 VDD a_37622_165043# a_36062_169443# VDD pfet_06v0 ad=2.2p pd=10.88u as=1.3p ps=5.52u w=5u l=1u
X1031 VSS VDD VSS VSS nfet_06v0 ad=7.92p pd=36.88u as=0 ps=0 w=18u l=2u
X1032 VSS a_37174_191067# a_35390_194467# VSS nfet_06v0 ad=0.65p pd=3.02u as=0.65p ps=3.02u w=2.5u l=1u
X1033 a_51686_140870# a_51986_140870# a_69458_140914# VDD pfet_06v0 ad=4.4p pd=20.88u as=2.5p ps=10.5u w=10u l=1u
X1034 a_32522_182333# a_29286_182289# VDD VDD pfet_06v0 ad=2.5p pd=10.5u as=4.4p ps=20.88u w=10u l=1u
X1035 a_55314_170313# a_52658_164929# VSS VSS nfet_06v0 ad=0.25p pd=1.5u as=0.44p ps=2.88u w=1u l=1u
X1036 VSS a_60246_173707# a_58462_177107# VSS nfet_06v0 ad=0.65p pd=3.02u as=0.65p ps=3.02u w=2.5u l=1u
X1037 VDD VSS VDD VDD pfet_06v0 ad=4.29p pd=20.38u as=0 ps=0 w=9.75u l=2u
X1038 VSS VDD VSS VSS nfet_06v0 ad=4.29p pd=20.38u as=0 ps=0 w=9.75u l=2u
X1039 a_82122_128810# a_74234_128810# a_82322_128854# VSS nfet_06v0 ad=1.65p pd=5.66u as=1.25p ps=5.5u w=5u l=1u
D47 S2N VDD diode_pd2nw_06v0 pj=40u area=99.99999p
X1040 a_51646_152778# a_51986_159564# a_67534_159680# VDD pfet_06v0 ad=4.4p pd=20.88u as=2.5p ps=10.5u w=10u l=1u
X1041 a_29286_135596# a_29586_135596# a_47058_135712# VDD pfet_06v0 ad=4.4p pd=20.88u as=2.5p ps=10.5u w=10u l=1u
X1042 a_76854_164973# a_75542_164929# VDD VDD pfet_06v0 ad=2.5p pd=10.5u as=4.4p ps=20.88u w=10u l=1u
X1043 a_33946_177177# a_34750_173591# a_35390_177107# VDD pfet_06v0 ad=4.4p pd=20.88u as=2.6p ps=10.52u w=10u l=1u
X1044 a_66174_182289# a_52318_187557# a_67374_186873# VSS nfet_06v0 ad=2.2p pd=10.88u as=1.25p ps=5.5u w=5u l=1u
X1045 a_65710_169897# a_52658_164929# a_69454_164973# VDD pfet_06v0 ad=4.4p pd=20.88u as=2.5p ps=10.5u w=10u l=1u
X1046 a_76930_152822# a_78022_159680# VDD VDD pfet_06v0 ad=2.2p pd=10.88u as=2.2p ps=10.88u w=5u l=1u
X1047 VDD a_37622_178107# a_34950_173707# VDD pfet_06v0 ad=2.2p pd=10.88u as=1.3p ps=5.52u w=5u l=1u
X1048 VDD a_23448_131216# a_23448_131216# VDD pfet_06v0 ad=0.88p pd=4.88u as=0.52p ps=2.52u w=2u l=1u
X1049 a_90558_169513# a_76234_169397# VSS VSS nfet_06v0 ad=1.25p pd=5.5u as=2.2p ps=10.88u w=5u l=1u
X1050 a_35862_169399# a_74848_133316# VDD VDD pfet_06v0 ad=0.44p pd=2.88u as=0.44p ps=2.88u w=1u l=1u
X1051 a_59578_194467# a_35862_190951# a_57018_194537# VDD pfet_06v0 ad=2.6p pd=10.52u as=4.4p ps=20.88u w=10u l=1u
X1052 a_81646_194467# a_57822_190951# a_80202_194537# VDD pfet_06v0 ad=2.6p pd=10.52u as=4.4p ps=20.88u w=10u l=1u
X1053 a_29586_177061# a_29586_177061# a_32242_173637# VSS nfet_06v0 ad=0.44p pd=2.88u as=0.25p ps=1.5u w=1u l=1u
X1054 a_58782_136796# a_58782_136796# a_60418_135596# VDD pfet_06v0 ad=4.4p pd=20.88u as=3.3p ps=10.66u w=10u l=1u
X1055 VDD a_83878_165043# a_82318_169443# VDD pfet_06v0 ad=2.2p pd=10.88u as=1.3p ps=5.52u w=5u l=1u
X1056 a_52358_194421# a_52658_194421# a_54282_190997# VSS nfet_06v0 ad=0.44p pd=2.88u as=0.25p ps=1.5u w=1u l=1u
X1057 a_105306_135712# a_105106_135596# VDD VDD pfet_06v0 ad=2.5p pd=10.5u as=4.4p ps=20.88u w=10u l=1u
X1058 a_82906_159680# a_82706_159564# VDD VDD pfet_06v0 ad=2.5p pd=10.5u as=4.4p ps=20.88u w=10u l=1u
X1059 VSS VDD VSS VSS nfet_06v0 ad=4.29p pd=20.38u as=0 ps=0 w=9.75u l=2u
X1060 a_34926_128810# a_29586_135596# a_39662_135712# VDD pfet_06v0 ad=4.4p pd=20.88u as=2.5p ps=10.5u w=10u l=1u
X1061 a_52146_148772# a_51946_148656# a_51846_148772# VSS nfet_06v0 ad=2.2p pd=10.88u as=1.25p ps=5.5u w=5u l=1u
X1062 VDD a_37622_195467# a_34950_191067# VDD pfet_06v0 ad=1.3p pd=5.52u as=1.3p ps=5.52u w=5u l=1u
X1063 a_29286_182289# a_29586_182289# a_31210_187673# VSS nfet_06v0 ad=0.44p pd=2.88u as=0.25p ps=1.5u w=1u l=1u
X1064 a_69782_191067# a_61810_195467# VDD VDD pfet_06v0 ad=2.6p pd=10.52u as=4.4p ps=20.88u w=10u l=1u
X1065 a_52560_133766# a_67978_133316# VSS ppolyf_u_1k r_width=1u r_length=76.45u
D48 S1P VDD diode_pd2nw_06v0 pj=40u area=99.99999p
X1066 VDD VSS VDD VDD pfet_06v0 ad=0.44p pd=2.88u as=0 ps=0 w=1u l=2u
X1067 a_58462_182403# a_52318_187557# a_61358_187303# VSS nfet_06v0 ad=1.1p pd=5.88u as=0.65p ps=3.02u w=2.5u l=1u
X1068 a_99610_161580# a_99874_152778# VSS VSS nfet_06v0 ad=0.825p pd=3.16u as=1.1p ps=5.88u w=2.5u l=1u
X1069 a_80534_194537# a_75842_194421# a_80202_194537# VDD pfet_06v0 ad=2.5p pd=10.5u as=3.3p ps=10.66u w=10u l=1u
X1070 VDD VSS VDD VDD pfet_06v0 ad=4.29p pd=20.38u as=0 ps=0 w=9.75u l=2u
X1071 a_58462_165043# a_60246_169943# VSS VSS nfet_06v0 ad=0.65p pd=3.02u as=1.1p ps=5.88u w=2.5u l=1u
X1072 VSS a_76234_173593# a_80174_173637# VSS nfet_06v0 ad=2.2p pd=10.88u as=1.25p ps=5.5u w=5u l=1u
X1073 a_34950_173707# a_37622_178107# VDD VDD pfet_06v0 ad=1.3p pd=5.52u as=2.2p ps=10.88u w=5u l=1u
D49 VSS S1P diode_nd2ps_06v0 pj=40u area=99.99999p
X1074 a_45346_190997# a_45146_190953# VSS VSS nfet_06v0 ad=1.25p pd=5.5u as=2.2p ps=10.88u w=5u l=1u
X1075 a_59134_173707# a_60694_178107# VDD VDD pfet_06v0 ad=1.3p pd=5.52u as=1.3p ps=5.52u w=5u l=1u
X1076 VSS VDD VSS VSS nfet_06v0 ad=4.29p pd=20.38u as=0 ps=0 w=9.75u l=2u
X1077 a_52558_164973# a_52358_164929# VDD VDD pfet_06v0 ad=2.5p pd=10.5u as=4.4p ps=20.88u w=10u l=1u
X1078 a_56990_173637# a_52318_173593# a_56658_173637# VSS nfet_06v0 ad=1.25p pd=5.5u as=1.65p ps=5.66u w=5u l=1u
X1079 a_83878_195467# a_88894_190953# a_83430_191067# VSS nfet_06v0 ad=1.1p pd=5.88u as=1.1p ps=5.88u w=2.5u l=1u
X1080 a_99610_137612# a_99874_128810# VSS VSS nfet_06v0 ad=0.825p pd=3.16u as=1.1p ps=5.88u w=2.5u l=1u
X1081 a_52560_158634# a_34750_190951# VSS ppolyf_u_1k r_width=1u r_length=76.45u
X1082 a_104146_175184# a_104234_175068# a_23448_131216# VSS nfet_06v0 ad=1.0912p pd=5.84u as=0.6448p ps=3u w=2.48u l=1u
X1083 a_33646_182333# a_29286_182289# VDD VDD pfet_06v0 ad=2.5p pd=10.5u as=4.4p ps=20.88u w=10u l=1u
X1084 a_100760_186094# a_99096_185942# VSS VSS nfet_06v0 ad=0.175p pd=1.2u as=0.308p ps=2.28u w=0.7u l=1u
X1085 VDD VSS VDD VDD pfet_06v0 ad=7.92p pd=36.88u as=0 ps=0 w=18u l=2u
D50 S2N VDD diode_pd2nw_06v0 pj=40u area=99.99999p
X1086 a_81206_173707# a_38998_149572# a_79842_173637# VSS nfet_06v0 ad=1.3p pd=5.52u as=2.2p ps=10.88u w=5u l=1u
X1087 a_81206_173707# a_83878_178107# VDD VDD pfet_06v0 ad=1.3p pd=5.52u as=2.2p ps=10.88u w=5u l=1u
X1088 a_57350_164973# a_52658_164929# a_57018_164973# VDD pfet_06v0 ad=2.5p pd=10.5u as=3.3p ps=10.66u w=10u l=1u
X1089 a_59134_191067# a_60694_195467# VDD VDD pfet_06v0 ad=1.3p pd=5.52u as=2.2p ps=10.88u w=5u l=1u
X1090 VSS VDD VSS VSS nfet_06v0 ad=0.44p pd=2.88u as=0 ps=0 w=1u l=2u
X1091 a_57326_149256# a_51986_140870# a_62062_140914# VDD pfet_06v0 ad=4.4p pd=20.88u as=2.5p ps=10.5u w=10u l=1u
D51 VSS S2N diode_nd2ps_06v0 pj=40u area=99.99999p
X1092 a_89358_164929# a_89358_164929# a_90994_164929# VDD pfet_06v0 ad=4.4p pd=20.88u as=3.3p ps=10.66u w=10u l=1u
X1093 XP_OUT XN_OUT VSS VSS nfet_05v0 ad=0.5808p pd=3.52u as=0.5808p ps=3.52u w=1.32u l=0.6u
X1094 a_74848_145110# a_79614_149256# a_79082_149272# VSS nfet_06v0 ad=0.88p pd=4.88u as=0.88p ps=4.88u w=2u l=1u
X1095 a_91402_169397# a_75502_170197# a_91602_169513# VSS nfet_06v0 ad=1.65p pd=5.66u as=1.25p ps=5.5u w=5u l=1u
X1096 a_29486_159680# a_29286_159564# VDD VDD pfet_06v0 ad=2.5p pd=10.5u as=4.4p ps=20.88u w=10u l=1u
X1097 a_36062_169443# a_37622_165043# VDD VDD pfet_06v0 ad=1.3p pd=5.52u as=1.3p ps=5.52u w=5u l=1u
X1098 VSS a_83430_173707# a_81646_177107# VSS nfet_06v0 ad=0.65p pd=3.02u as=0.65p ps=3.02u w=2.5u l=1u
X1099 a_82318_186803# a_34750_186759# a_79842_186873# VSS nfet_06v0 ad=1.3p pd=5.52u as=2.2p ps=10.88u w=5u l=1u
X1100 a_54922_140914# a_32042_152778# a_52186_140914# VDD pfet_06v0 ad=0.22p pd=1.88u as=0.22p ps=1.88u w=0.5u l=1u
X1101 a_79902_182333# a_75542_182289# VDD VDD pfet_06v0 ad=2.5p pd=10.5u as=4.4p ps=20.88u w=10u l=1u
X1102 a_58022_191067# a_60694_195467# VDD VDD pfet_06v0 ad=1.3p pd=5.52u as=1.3p ps=5.52u w=5u l=1u
X1103 a_99610_137612# a_23448_50576# a_96874_135712# VDD pfet_06v0 ad=0.22p pd=1.88u as=0.22p ps=1.88u w=0.5u l=1u
X1104 a_38998_149572# a_30160_145110# VDD VDD pfet_06v0 ad=0.44p pd=2.88u as=0.44p ps=2.88u w=1u l=1u
X1105 a_74234_148656# a_74234_148656# VSS VSS nfet_06v0 ad=0.44p pd=2.88u as=0.44p ps=2.88u w=1u l=1u
X1106 a_53050_169397# a_52318_170197# a_53250_169513# VSS nfet_06v0 ad=2.2p pd=10.88u as=1.25p ps=5.5u w=5u l=1u
X1107 a_35390_177107# a_46710_173707# cap_mim_2f0_m4m5_noshield c_width=20u c_length=10u
X1108 a_76198_128854# a_78022_135712# VDD VDD pfet_06v0 ad=2.2p pd=10.88u as=2.2p ps=10.88u w=5u l=1u
X1109 a_92966_173707# a_84994_178107# VDD VDD pfet_06v0 ad=4.4p pd=20.88u as=2.6p ps=10.52u w=10u l=1u
X1110 VDD a_37622_195467# a_36062_191067# VDD pfet_06v0 ad=2.2p pd=10.88u as=1.3p ps=5.52u w=5u l=1u
X1111 a_35390_177107# a_34750_173591# a_33946_177177# VDD pfet_06v0 ad=2.6p pd=10.52u as=4.4p ps=20.88u w=10u l=1u
X1112 a_76930_148072# a_23448_50576# a_74434_148772# VSS nfet_06v0 ad=3.74p pd=17.88u as=3.74p ps=17.88u w=8.5u l=1u
X1113 a_32242_148072# a_33334_140914# VDD VDD pfet_06v0 ad=2.2p pd=10.88u as=2.2p ps=10.88u w=5u l=1u
X1114 a_75542_194421# a_75842_194421# a_77466_190997# VSS nfet_06v0 ad=0.44p pd=2.88u as=0.25p ps=1.5u w=1u l=1u
X1115 a_23448_131216# a_23448_131216# VDD VDD pfet_06v0 ad=0.52p pd=2.52u as=0.52p ps=2.52u w=2u l=1u
D52 VSS S1P diode_nd2ps_06v0 pj=40u area=99.99999p
X1116 VSS VDD VSS VSS nfet_06v0 ad=7.92p pd=36.88u as=0 ps=0 w=18u l=2u
X1117 VDD a_38738_178107# a_46710_173707# VDD pfet_06v0 ad=2.6p pd=10.52u as=2.6p ps=10.52u w=10u l=1u
X1118 a_96874_140914# a_96674_140870# a_96574_140914# VDD pfet_06v0 ad=4.4p pd=20.88u as=2.5p ps=10.5u w=10u l=1u
X1119 a_33586_169513# a_29246_170197# a_33286_169513# VSS nfet_06v0 ad=1.65p pd=5.66u as=1.25p ps=5.5u w=5u l=1u
X1120 a_96374_135596# a_96674_135596# a_114146_135712# VDD pfet_06v0 ad=4.4p pd=20.88u as=2.5p ps=10.5u w=10u l=1u
X1121 a_73974_159564# a_74274_159564# a_91746_159680# VDD pfet_06v0 ad=4.4p pd=20.88u as=2.5p ps=10.5u w=10u l=1u
X1122 a_99330_148072# a_54442_128810# a_96834_148772# VSS nfet_06v0 ad=3.74p pd=17.88u as=3.74p ps=17.88u w=8.5u l=1u
X1123 a_74474_135712# a_74274_135596# a_74174_135712# VDD pfet_06v0 ad=4.4p pd=20.88u as=2.5p ps=10.5u w=10u l=1u
X1124 a_54642_148072# a_55734_140914# VDD VDD pfet_06v0 ad=2.2p pd=10.88u as=2.2p ps=10.88u w=5u l=1u
X1125 a_81646_182403# a_75502_187557# a_84542_187303# VSS nfet_06v0 ad=1.1p pd=5.88u as=0.65p ps=3.02u w=2.5u l=1u
X1126 VSS a_37174_169943# a_36506_165043# VSS nfet_06v0 ad=1.1p pd=5.88u as=0.65p ps=3.02u w=2.5u l=1u
X1127 VDD a_110806_184214# a_111626_184098# VDD pfet_06v0 ad=1.32p pd=6.88u as=0.99p ps=3.66u w=3u l=1u
X1128 a_61358_187303# a_66174_182289# a_61810_182403# VDD pfet_06v0 ad=2.2p pd=10.88u as=2.2p ps=10.88u w=5u l=1u
X1129 VDD a_83878_195467# a_82318_191067# VDD pfet_06v0 ad=2.2p pd=10.88u as=1.3p ps=5.52u w=5u l=1u
X1130 a_34278_164973# a_29586_164929# a_33946_164973# VDD pfet_06v0 ad=2.5p pd=10.5u as=3.3p ps=10.66u w=10u l=1u
X1131 a_56718_177177# a_52358_177061# VDD VDD pfet_06v0 ad=2.5p pd=10.5u as=4.4p ps=20.88u w=10u l=1u
X1132 a_35862_186759# a_30160_157284# VDD VDD pfet_06v0 ad=0.44p pd=2.88u as=0.44p ps=2.88u w=1u l=1u
X1133 a_38738_178107# a_42638_173593# a_38286_173707# VSS nfet_06v0 ad=1.1p pd=5.88u as=1.1p ps=5.88u w=2.5u l=1u
X1134 a_31510_148272# a_33334_140914# VDD VDD pfet_06v0 ad=2.2p pd=10.88u as=2.2p ps=10.88u w=5u l=1u
X1135 VDD VSS VDD VDD pfet_06v0 ad=4.29p pd=20.38u as=0 ps=0 w=9.75u l=2u
X1136 a_52560_133766# a_67978_134216# VSS ppolyf_u_1k r_width=1u r_length=76.45u
X1137 a_102146_190940# a_46710_191067# VDD VDD pfet_06v0 ad=0.99p pd=3.66u as=1.32p ps=6.88u w=3u l=1u
X1138 XN_OUT a_102380_164960# VDD VDD pfet_05v0 ad=0.8052p pd=4.54u as=0.8052p ps=4.54u w=1.83u l=0.5u
X1139 a_82318_173707# a_83878_178107# VDD VDD pfet_06v0 ad=1.3p pd=5.52u as=1.3p ps=5.52u w=5u l=1u
X1140 a_29246_148656# a_29546_148656# a_40462_148772# VSS nfet_06v0 ad=2.2p pd=10.88u as=1.25p ps=5.5u w=5u l=1u
X1141 a_82322_152822# a_82122_152778# VSS VSS nfet_06v0 ad=1.25p pd=5.5u as=2.2p ps=10.88u w=5u l=1u
X1142 a_102014_128810# a_96674_135596# a_106750_135712# VDD pfet_06v0 ad=4.4p pd=20.88u as=2.5p ps=10.5u w=10u l=1u
X1143 a_92638_194537# a_75542_194421# VDD VDD pfet_06v0 ad=2.5p pd=10.5u as=4.4p ps=20.88u w=10u l=1u
X1144 a_79842_169513# a_75502_170197# a_79542_169513# VSS nfet_06v0 ad=1.65p pd=5.66u as=1.25p ps=5.5u w=5u l=1u
D53 VSS S2N diode_nd2ps_06v0 pj=40u area=99.99999p
X1145 VSS a_60246_187303# a_58462_182403# VSS nfet_06v0 ad=1.1p pd=5.88u as=0.65p ps=3.02u w=2.5u l=1u
X1146 a_37174_187303# a_43102_182289# a_37622_182403# VDD pfet_06v0 ad=2.2p pd=10.88u as=2.2p ps=10.88u w=5u l=1u
X1147 a_47058_140914# a_29286_140870# VDD VDD pfet_06v0 ad=2.5p pd=10.5u as=4.4p ps=20.88u w=10u l=1u
X1148 VDD a_60694_178107# a_59134_173707# VDD pfet_06v0 ad=1.3p pd=5.52u as=1.3p ps=5.52u w=5u l=1u
X1149 a_80174_173637# a_75502_173593# a_79842_173637# VSS nfet_06v0 ad=1.25p pd=5.5u as=1.65p ps=5.66u w=5u l=1u
X1150 VDD a_60694_182403# a_58022_186803# VDD pfet_06v0 ad=1.3p pd=5.52u as=1.3p ps=5.52u w=5u l=1u
X1151 a_64926_149572# a_51986_140870# VSS VSS nfet_06v0 ad=0.25p pd=1.5u as=0.44p ps=2.88u w=1u l=1u
X1152 a_58462_177107# a_69782_173707# cap_mim_2f0_m4m5_noshield c_width=20u c_length=10u
X1153 a_74434_148772# a_74234_148656# a_75166_148772# VSS nfet_06v0 ad=2.2p pd=10.88u as=1.25p ps=5.5u w=5u l=1u
X1154 a_45134_159680# a_29286_159564# VDD VDD pfet_06v0 ad=2.5p pd=10.5u as=4.4p ps=20.88u w=10u l=1u
X1155 VDD a_37622_178107# a_36062_173707# VDD pfet_06v0 ad=1.3p pd=5.52u as=1.3p ps=5.52u w=5u l=1u
X1156 a_68218_169397# a_52318_170197# a_68418_169513# VSS nfet_06v0 ad=1.65p pd=5.66u as=1.25p ps=5.5u w=5u l=1u
X1157 a_34750_169399# a_30160_133316# VDD VDD pfet_06v0 ad=0.44p pd=2.88u as=0.44p ps=2.88u w=1u l=1u
X1158 VDD a_69782_191067# a_101594_192396# VDD pfet_06v0 ad=1.32p pd=6.88u as=0.75p ps=3.5u w=3u l=1u
X1159 a_29978_169397# a_29246_170197# a_30178_169513# VSS nfet_06v0 ad=2.2p pd=10.88u as=1.25p ps=5.5u w=5u l=1u
X1160 a_23448_131216# a_104234_175068# a_104146_175184# VSS nfet_06v0 ad=0.6448p pd=3u as=1.0912p ps=5.84u w=2.48u l=1u
X1161 a_69458_140914# a_51686_140870# VDD VDD pfet_06v0 ad=2.5p pd=10.5u as=4.4p ps=20.88u w=10u l=1u
X1162 a_61810_182403# a_65710_187257# a_61358_187303# VSS nfet_06v0 ad=1.1p pd=5.88u as=1.1p ps=5.88u w=2.5u l=1u
X1163 VDD VSS VDD VDD pfet_06v0 ad=7.92p pd=36.88u as=0 ps=0 w=18u l=2u
X1164 a_82322_128854# a_82122_128810# VSS VSS nfet_06v0 ad=1.25p pd=5.5u as=2.2p ps=10.88u w=5u l=1u
X1165 a_60418_135596# a_51986_135596# a_60618_135712# VDD pfet_06v0 ad=3.3p pd=10.66u as=2.5p ps=10.5u w=10u l=1u
X1166 a_67534_159680# a_51686_159564# VDD VDD pfet_06v0 ad=2.5p pd=10.5u as=4.4p ps=20.88u w=10u l=1u
X1167 a_36506_194467# a_37174_191067# VSS VSS nfet_06v0 ad=0.65p pd=3.02u as=0.65p ps=3.02u w=2.5u l=1u
X1168 a_33586_190997# a_35862_190951# a_36062_191067# VSS nfet_06v0 ad=2.2p pd=10.88u as=1.3p ps=5.52u w=5u l=1u
X1169 a_67374_186873# a_53050_186757# VSS VSS nfet_06v0 ad=1.25p pd=5.5u as=2.2p ps=10.88u w=5u l=1u
X1170 a_69454_164973# a_52358_164929# VDD VDD pfet_06v0 ad=2.5p pd=10.5u as=4.4p ps=20.88u w=10u l=1u
X1171 a_23448_131216# a_23448_131216# VDD VDD pfet_06v0 ad=0.52p pd=2.52u as=0.52p ps=2.52u w=2u l=1u
X1172 a_52358_177061# a_52658_177061# a_55594_177177# VDD pfet_06v0 ad=4.4p pd=20.88u as=2.5p ps=10.5u w=10u l=1u
X1173 a_74474_140914# a_74274_140870# a_75286_140914# VDD pfet_06v0 ad=4.4p pd=20.88u as=2.5p ps=10.5u w=10u l=1u
X1174 a_57822_169399# a_52560_133316# VDD VDD pfet_06v0 ad=0.44p pd=2.88u as=0.44p ps=2.88u w=1u l=1u
X1175 a_59578_165043# a_60246_169943# VSS VSS nfet_06v0 ad=0.65p pd=3.02u as=0.65p ps=3.02u w=2.5u l=1u
X1176 a_79842_190997# a_57822_190951# a_81206_191067# VSS nfet_06v0 ad=2.2p pd=10.88u as=1.3p ps=5.52u w=5u l=1u
X1177 a_35390_182403# a_46710_186803# cap_mim_2f0_m4m5_noshield c_width=20u c_length=10u
D54 VSS Z diode_nd2ps_06v0 pj=40u area=99.99999p
X1178 a_52146_152822# a_51946_152778# a_52878_152822# VSS nfet_06v0 ad=2.2p pd=10.88u as=1.25p ps=5.5u w=5u l=1u
X1179 a_74234_152778# a_74234_152778# VSS VSS nfet_06v0 ad=0.44p pd=2.88u as=0.44p ps=2.88u w=1u l=1u
X1180 a_32242_173637# a_29586_177061# VSS VSS nfet_06v0 ad=0.25p pd=1.5u as=0.44p ps=2.88u w=1u l=1u
X1181 VDD VSS VDD VDD pfet_06v0 ad=7.92p pd=36.88u as=0 ps=0 w=18u l=2u
X1182 a_76234_169397# a_75502_170197# a_76434_169513# VSS nfet_06v0 ad=2.2p pd=10.88u as=1.25p ps=5.5u w=5u l=1u
X1183 a_46710_169443# a_38286_169943# VSS VSS nfet_06v0 ad=2.2p pd=10.88u as=1.3p ps=5.52u w=5u l=1u
X1184 a_81646_177107# a_83430_173707# VSS VSS nfet_06v0 ad=0.65p pd=3.02u as=1.1p ps=5.88u w=2.5u l=1u
X1185 a_54282_190997# a_52658_194421# VSS VSS nfet_06v0 ad=0.25p pd=1.5u as=0.44p ps=2.88u w=1u l=1u
X1186 a_33946_182333# a_34750_186759# a_35390_182403# VDD pfet_06v0 ad=4.4p pd=20.88u as=2.6p ps=10.52u w=10u l=1u
X1187 a_52658_182289# a_52658_182289# VDD VDD pfet_06v0 ad=0.88p pd=4.88u as=0.88p ps=4.88u w=2u l=1u
X1188 a_39662_135712# a_29286_135596# VDD VDD pfet_06v0 ad=2.5p pd=10.5u as=4.4p ps=20.88u w=10u l=1u
X1189 a_29246_190953# a_29586_194421# a_29486_194537# VDD pfet_06v0 ad=4.4p pd=20.88u as=2.5p ps=10.5u w=10u l=1u
X1190 a_34950_191067# a_34750_190951# a_33586_190997# VSS nfet_06v0 ad=1.3p pd=5.52u as=2.2p ps=10.88u w=5u l=1u
X1191 a_92966_191067# a_81206_191067# cap_mim_2f0_m4m5_noshield c_width=20u c_length=10u
X1192 a_51846_148772# a_51646_148656# VSS VSS nfet_06v0 ad=1.25p pd=5.5u as=2.2p ps=10.88u w=5u l=1u
X1193 a_34394_149272# a_29546_148656# a_31710_140914# VSS nfet_06v0 ad=1.1p pd=5.88u as=0.825p ps=3.16u w=2.5u l=1u
X1194 a_31210_187673# a_29586_182289# VSS VSS nfet_06v0 ad=0.25p pd=1.5u as=0.44p ps=2.88u w=1u l=1u
X1195 a_34950_169443# a_29586_164929# a_38738_165043# VDD pfet_06v0 ad=2.2p pd=10.88u as=1.3p ps=5.52u w=5u l=1u
X1196 a_75842_164929# a_75842_164929# a_78498_170313# VSS nfet_06v0 ad=0.44p pd=2.88u as=0.25p ps=1.5u w=1u l=1u
X1197 YN_OUT a_102380_177524# VSS VSS nfet_05v0 ad=0.5808p pd=3.52u as=0.5808p ps=3.52u w=1.32u l=0.6u
X1198 a_36062_191067# a_37622_195467# VDD VDD pfet_06v0 ad=1.3p pd=5.52u as=1.3p ps=5.52u w=5u l=1u
X1199 VSS a_53050_190953# a_56990_190997# VSS nfet_06v0 ad=2.2p pd=10.88u as=1.25p ps=5.5u w=5u l=1u
X1200 VSS a_111626_166626# a_104234_175068# VSS nfet_06v0 ad=0.44p pd=2.88u as=0.44p ps=2.88u w=1u l=1u
X1201 a_81646_194467# a_83430_191067# VSS VSS nfet_06v0 ad=0.65p pd=3.02u as=0.65p ps=3.02u w=2.5u l=1u
X1202 a_43102_195421# a_29246_190953# a_44302_190997# VSS nfet_06v0 ad=2.2p pd=10.88u as=1.25p ps=5.5u w=5u l=1u
X1203 a_52318_173593# a_52318_173593# VSS VSS nfet_06v0 ad=0.44p pd=2.88u as=0.44p ps=2.88u w=1u l=1u
X1204 a_52146_128854# a_51946_128810# a_52878_128854# VSS nfet_06v0 ad=2.2p pd=10.88u as=1.25p ps=5.5u w=5u l=1u
X1205 a_92966_173707# a_81206_173707# cap_mim_2f0_m4m5_noshield c_width=20u c_length=10u
X1206 a_29286_140870# a_29586_140870# a_41494_149572# VSS nfet_06v0 ad=0.44p pd=2.88u as=0.25p ps=1.5u w=1u l=1u
X1207 VDD a_69782_186803# a_113914_182402# VDD pfet_06v0 ad=1.32p pd=6.88u as=0.75p ps=3.5u w=3u l=1u
X1208 a_74234_128810# a_74234_128810# VSS VSS nfet_06v0 ad=0.44p pd=2.88u as=0.44p ps=2.88u w=1u l=1u
X1209 a_35390_194467# a_46710_191067# cap_mim_2f0_m4m5_noshield c_width=20u c_length=10u
X1210 a_54922_161580# a_23448_50576# a_52186_159680# VDD pfet_06v0 ad=0.22p pd=1.88u as=0.22p ps=1.88u w=0.5u l=1u
X1211 a_46710_173707# a_38738_178107# VDD VDD pfet_06v0 ad=2.6p pd=10.52u as=4.4p ps=20.88u w=10u l=1u
X1212 VDD VSS VDD VDD pfet_06v0 ad=0.44p pd=2.88u as=0 ps=0 w=1u l=2u
X1213 VSS VDD VSS VSS nfet_06v0 ad=7.92p pd=36.88u as=0 ps=0 w=18u l=2u
X1214 a_52658_194421# a_52658_194421# VDD VDD pfet_06v0 ad=0.88p pd=4.88u as=0.88p ps=4.88u w=2u l=1u
X1215 a_57018_164973# a_52658_164929# a_56718_164973# VDD pfet_06v0 ad=3.3p pd=10.66u as=2.5p ps=10.5u w=10u l=1u
X1216 a_36506_182403# a_37174_187303# VSS VSS nfet_06v0 ad=0.65p pd=3.02u as=1.1p ps=5.88u w=2.5u l=1u
X1217 a_102002_175184# a_23448_131216# a_23448_131216# VSS nfet_06v0 ad=0.88p pd=4.88u as=0.52p ps=2.52u w=2u l=1u
X1218 VDD a_60694_182403# a_59134_186803# VDD pfet_06v0 ad=2.2p pd=10.88u as=1.3p ps=5.52u w=5u l=1u
X1219 a_84542_187303# a_75502_187557# a_81646_182403# VSS nfet_06v0 ad=0.65p pd=3.02u as=1.1p ps=5.88u w=2.5u l=1u
X1220 a_82706_140870# a_74274_140870# a_82906_140914# VDD pfet_06v0 ad=3.3p pd=10.66u as=2.5p ps=10.5u w=10u l=1u
X1221 a_99330_148072# a_100422_140914# VDD VDD pfet_06v0 ad=2.2p pd=10.88u as=2.2p ps=10.88u w=5u l=1u
X1222 a_52658_182289# a_52658_182289# a_55314_187673# VSS nfet_06v0 ad=0.44p pd=2.88u as=0.25p ps=1.5u w=1u l=1u
X1223 VDD VSS VDD VDD pfet_06v0 ad=7.92p pd=36.88u as=0 ps=0 w=18u l=2u
X1224 a_58462_182403# a_69782_186803# cap_mim_2f0_m4m5_noshield c_width=20u c_length=10u
X1225 VDD a_83878_178107# a_82318_173707# VDD pfet_06v0 ad=1.3p pd=5.52u as=1.3p ps=5.52u w=5u l=1u
X1226 a_64926_152822# a_51986_159564# VSS VSS nfet_06v0 ad=0.25p pd=1.5u as=0.44p ps=2.88u w=1u l=1u
X1227 VDD a_83878_182403# a_81206_186803# VDD pfet_06v0 ad=1.3p pd=5.52u as=1.3p ps=5.52u w=5u l=1u
X1228 VSS a_92966_186803# a_112558_184214# VSS nfet_06v0 ad=0.44p pd=2.88u as=0.25p ps=1.5u w=1u l=1u
X1229 a_65710_190953# a_65710_190953# a_68218_190953# VSS nfet_06v0 ad=2.2p pd=10.88u as=1.65p ps=5.66u w=5u l=1u
X1230 VDD a_75542_182289# a_80534_182333# VDD pfet_06v0 ad=4.4p pd=20.88u as=2.5p ps=10.5u w=10u l=1u
X1231 a_58022_186803# a_60694_182403# VDD VDD pfet_06v0 ad=1.3p pd=5.52u as=2.2p ps=10.88u w=5u l=1u
X1232 a_76398_161570# a_53710_128810# a_74474_159680# VDD pfet_06v0 ad=0.242p pd=1.98u as=0.242p ps=1.98u w=0.55u l=1u
X1233 a_91602_169513# a_91402_169397# VSS VSS nfet_06v0 ad=1.25p pd=5.5u as=2.2p ps=10.88u w=5u l=1u
X1234 a_36062_173707# a_37622_178107# VDD VDD pfet_06v0 ad=1.3p pd=5.52u as=2.2p ps=10.88u w=5u l=1u
X1235 a_74848_143310# a_34750_186759# VSS ppolyf_u_1k r_width=1u r_length=76.45u
X1236 a_58990_152822# a_51646_152778# VSS VSS nfet_06v0 ad=1.25p pd=5.5u as=2.2p ps=10.88u w=5u l=1u
X1237 a_36382_160764# a_36382_160764# a_38018_159564# VDD pfet_06v0 ad=4.4p pd=20.88u as=3.3p ps=10.66u w=10u l=1u
X1238 a_58462_177107# a_52318_173593# a_61358_173707# VSS nfet_06v0 ad=1.1p pd=5.88u as=0.65p ps=3.02u w=2.5u l=1u
X1239 a_56658_190997# a_57822_190951# a_58022_191067# VSS nfet_06v0 ad=2.2p pd=10.88u as=1.3p ps=5.52u w=5u l=1u
X1240 a_84994_182403# a_88894_187257# a_84542_187303# VSS nfet_06v0 ad=1.1p pd=5.88u as=1.1p ps=5.88u w=2.5u l=1u
X1241 a_58462_194467# a_69782_191067# cap_mim_2f0_m4m5_noshield c_width=20u c_length=10u
X1242 a_53250_169513# a_53050_169397# VSS VSS nfet_06v0 ad=1.25p pd=5.5u as=2.2p ps=10.88u w=5u l=1u
X1243 a_64926_128854# a_51986_135596# VSS VSS nfet_06v0 ad=0.25p pd=1.5u as=0.44p ps=2.88u w=1u l=1u
X1244 a_92966_169443# a_84542_169943# VSS VSS nfet_06v0 ad=1.3p pd=5.52u as=2.2p ps=10.88u w=5u l=1u
X1245 a_97248_143310# a_57822_186759# VSS ppolyf_u_1k r_width=1u r_length=76.45u
X1246 a_114146_140914# a_96374_140870# VDD VDD pfet_06v0 ad=2.5p pd=10.5u as=4.4p ps=20.88u w=10u l=1u
X1247 a_74174_140914# a_73974_140870# VDD VDD pfet_06v0 ad=2.5p pd=10.5u as=4.4p ps=20.88u w=10u l=1u
X1248 a_33918_169513# a_29246_170197# a_33586_169513# VSS nfet_06v0 ad=1.25p pd=5.5u as=1.65p ps=5.66u w=5u l=1u
X1249 a_30178_169513# a_29978_169397# VSS VSS nfet_06v0 ad=1.25p pd=5.5u as=2.2p ps=10.88u w=5u l=1u
X1250 a_75542_177061# a_75842_177061# a_78778_177177# VDD pfet_06v0 ad=4.4p pd=20.88u as=2.5p ps=10.5u w=10u l=1u
X1251 VSS a_37174_191067# a_36506_194467# VSS nfet_06v0 ad=0.65p pd=3.02u as=0.65p ps=3.02u w=2.5u l=1u
X1252 a_36062_169443# a_29586_164929# a_37622_165043# VDD pfet_06v0 ad=2.2p pd=10.88u as=1.3p ps=5.52u w=5u l=1u
X1253 a_113914_175036# a_92966_173707# a_100246_184486# VDD pfet_06v0 ad=0.75p pd=3.5u as=1.32p ps=6.88u w=3u l=1u
X1254 a_60246_187303# a_52318_187557# a_59578_182403# VSS nfet_06v0 ad=0.65p pd=3.02u as=1.1p ps=5.88u w=2.5u l=1u
X1255 VDD a_23448_131216# a_23448_131216# VDD pfet_06v0 ad=0.52p pd=2.52u as=0.52p ps=2.52u w=2u l=1u
X1256 a_58990_128854# a_51646_128810# VSS VSS nfet_06v0 ad=1.25p pd=5.5u as=2.2p ps=10.88u w=5u l=1u
X1257 a_77466_190997# a_75842_194421# VSS VSS nfet_06v0 ad=0.25p pd=1.5u as=0.44p ps=2.88u w=1u l=1u
X1258 VDD a_37622_182403# a_34950_186803# VDD pfet_06v0 ad=2.2p pd=10.88u as=1.3p ps=5.52u w=5u l=1u
X1259 VSS a_60246_169943# a_59578_165043# VSS nfet_06v0 ad=0.65p pd=3.02u as=0.65p ps=3.02u w=2.5u l=1u
X1260 a_75842_182289# a_75842_182289# VDD VDD pfet_06v0 ad=0.88p pd=4.88u as=0.88p ps=4.88u w=2u l=1u
X1261 a_96574_140914# a_96374_140870# VDD VDD pfet_06v0 ad=2.5p pd=10.5u as=4.4p ps=20.88u w=10u l=1u
X1262 VDD VSS VDD VDD pfet_06v0 ad=7.92p pd=36.88u as=0 ps=0 w=18u l=2u
X1263 a_33286_169513# a_29978_169397# VSS VSS nfet_06v0 ad=1.25p pd=5.5u as=2.2p ps=10.88u w=5u l=1u
X1264 a_92966_186803# a_84994_182403# VDD VDD pfet_06v0 ad=4.4p pd=20.88u as=2.6p ps=10.52u w=10u l=1u
X1265 a_35390_182403# a_34750_186759# a_33946_182333# VDD pfet_06v0 ad=2.6p pd=10.52u as=4.4p ps=20.88u w=10u l=1u
X1266 a_103470_136796# a_103470_136796# a_105106_135596# VDD pfet_06v0 ad=4.4p pd=20.88u as=3.3p ps=10.66u w=10u l=1u
X1267 a_38286_191067# a_43102_195421# a_38738_195467# VDD pfet_06v0 ad=2.2p pd=10.88u as=2.2p ps=10.88u w=5u l=1u
X1268 a_35862_190951# a_97248_157284# VDD VDD pfet_06v0 ad=0.44p pd=2.88u as=0.44p ps=2.88u w=1u l=1u
D55 VSS S4P diode_nd2ps_06v0 pj=40u area=99.99999p
X1269 a_52998_135712# a_51686_135596# VDD VDD pfet_06v0 ad=2.5p pd=10.5u as=4.4p ps=20.88u w=10u l=1u
X1270 a_91746_159680# a_73974_159564# VDD VDD pfet_06v0 ad=2.5p pd=10.5u as=4.4p ps=20.88u w=10u l=1u
X1271 VSS VDD VSS VSS nfet_06v0 ad=4.29p pd=20.38u as=0 ps=0 w=9.75u l=2u
X1272 a_91194_182333# a_90994_182289# VDD VDD pfet_06v0 ad=2.5p pd=10.5u as=4.4p ps=20.88u w=10u l=1u
X1273 a_43102_195421# a_43102_195421# a_44738_194421# VDD pfet_06v0 ad=4.4p pd=20.88u as=3.3p ps=10.66u w=10u l=1u
X1274 VDD a_38738_182403# a_46710_186803# VDD pfet_06v0 ad=2.6p pd=10.52u as=2.6p ps=10.52u w=10u l=1u
D56 VSS S4P diode_nd2ps_06v0 pj=40u area=99.99999p
X1275 a_51946_148656# a_51986_140870# a_66422_140914# VDD pfet_06v0 ad=4.4p pd=20.88u as=2.5p ps=10.5u w=10u l=1u
X1276 a_29286_159564# a_29586_159564# a_41494_152822# VSS nfet_06v0 ad=0.44p pd=2.88u as=0.25p ps=1.5u w=1u l=1u
X1277 VDD VSS VDD VDD pfet_06v0 ad=4.29p pd=20.38u as=0 ps=0 w=9.75u l=2u
X1278 a_29546_128810# a_29586_135596# a_44022_135712# VDD pfet_06v0 ad=4.4p pd=20.88u as=2.5p ps=10.5u w=10u l=1u
X1279 a_45146_186757# a_29246_187557# a_45346_186873# VSS nfet_06v0 ad=1.65p pd=5.66u as=1.25p ps=5.5u w=5u l=1u
X1280 a_75842_194421# a_75842_194421# VDD VDD pfet_06v0 ad=0.88p pd=4.88u as=0.88p ps=4.88u w=2u l=1u
X1281 a_35390_182403# a_37174_187303# VSS VSS nfet_06v0 ad=0.65p pd=3.02u as=0.65p ps=3.02u w=2.5u l=1u
X1282 a_67810_177061# a_52658_177061# a_68010_177177# VDD pfet_06v0 ad=3.3p pd=10.66u as=2.5p ps=10.5u w=10u l=1u
X1283 a_42638_190953# a_42638_190953# a_45146_190953# VSS nfet_06v0 ad=2.2p pd=10.88u as=1.65p ps=5.66u w=5u l=1u
X1284 a_34950_186803# a_37622_182403# VDD VDD pfet_06v0 ad=1.3p pd=5.52u as=2.2p ps=10.88u w=5u l=1u
X1285 a_40462_148772# a_29246_148656# VSS VSS nfet_06v0 ad=1.25p pd=5.5u as=2.2p ps=10.88u w=5u l=1u
X1286 a_33586_186873# a_34750_186759# a_34950_186803# VSS nfet_06v0 ad=2.2p pd=10.88u as=1.3p ps=5.52u w=5u l=1u
X1287 a_106750_135712# a_96374_135596# VDD VDD pfet_06v0 ad=2.5p pd=10.5u as=4.4p ps=20.88u w=10u l=1u
X1288 a_97248_157284# a_96674_159564# a_98598_152822# VDD pfet_06v0 ad=4.4p pd=20.88u as=4.4p ps=20.88u w=10u l=1u
X1289 a_34950_191067# a_29586_194421# a_38738_195467# VDD pfet_06v0 ad=2.2p pd=10.88u as=1.3p ps=5.52u w=5u l=1u
X1290 a_69782_186803# a_58022_186803# cap_mim_2f0_m4m5_noshield c_width=20u c_length=10u
X1291 a_101482_149272# a_96634_148656# a_98798_140914# VSS nfet_06v0 ad=1.1p pd=5.88u as=0.825p ps=3.16u w=2.5u l=1u
X1292 a_79542_169513# a_76234_169397# VSS VSS nfet_06v0 ad=1.25p pd=5.5u as=2.2p ps=10.88u w=5u l=1u
X1293 a_96334_152778# a_96634_152778# a_107550_152822# VSS nfet_06v0 ad=2.2p pd=10.88u as=1.25p ps=5.5u w=5u l=1u
X1294 a_46710_173707# a_38286_173707# VSS VSS nfet_06v0 ad=2.2p pd=10.88u as=1.3p ps=5.52u w=5u l=1u
X1295 a_23448_131216# a_23448_131216# a_102002_175184# VSS nfet_06v0 ad=0.52p pd=2.52u as=0.88p ps=4.88u w=2u l=1u
X1296 a_100158_184530# a_100246_184486# a_23448_70736# VSS nfet_06v0 ad=1.0912p pd=5.84u as=0.6448p ps=3u w=2.48u l=1u
X1297 a_59134_186803# a_60694_182403# VDD VDD pfet_06v0 ad=1.3p pd=5.52u as=1.3p ps=5.52u w=5u l=1u
X1298 a_68418_169513# a_68218_169397# VSS VSS nfet_06v0 ad=1.25p pd=5.5u as=2.2p ps=10.88u w=5u l=1u
X1299 a_29286_135596# a_29586_135596# a_41494_128854# VSS nfet_06v0 ad=0.44p pd=2.88u as=0.25p ps=1.5u w=1u l=1u
X1300 a_33334_140914# a_29586_140870# a_32242_148072# VDD pfet_06v0 ad=4.4p pd=20.88u as=4.4p ps=20.88u w=10u l=1u
X1301 VSS a_83430_169943# a_81646_165043# VSS nfet_06v0 ad=1.1p pd=5.88u as=0.65p ps=3.02u w=2.5u l=1u
X1302 a_38738_178107# a_29586_177061# a_34950_173707# VDD pfet_06v0 ad=1.3p pd=5.52u as=2.2p ps=10.88u w=5u l=1u
X1303 a_69782_169443# a_58022_169443# cap_mim_2f0_m4m5_noshield c_width=20u c_length=10u
X1304 a_101594_192396# a_92966_191067# a_99134_184486# VDD pfet_06v0 ad=0.75p pd=3.5u as=1.32p ps=6.88u w=3u l=1u
X1305 VSS VDD VSS VSS nfet_06v0 ad=7.92p pd=36.88u as=0 ps=0 w=18u l=2u
X1306 a_99046_184530# a_99096_185942# VSS VSS nfet_06v0 ad=0.5456p pd=3.36u as=0.5456p ps=3.36u w=1.24u l=1u
X1307 a_60618_135712# a_60418_135596# VDD VDD pfet_06v0 ad=2.5p pd=10.5u as=4.4p ps=20.88u w=10u l=1u
D57 S4P VDD diode_pd2nw_06v0 pj=40u area=99.99999p
X1308 a_66174_178061# a_52318_173593# a_67374_173637# VSS nfet_06v0 ad=2.2p pd=10.88u as=1.25p ps=5.5u w=5u l=1u
X1309 a_56794_152822# a_58782_160764# a_52560_157284# VDD pfet_06v0 ad=1.76p pd=8.88u as=1.76p ps=8.88u w=4u l=1u
X1310 a_96334_128810# a_96634_128810# a_107550_128854# VSS nfet_06v0 ad=2.2p pd=10.88u as=1.25p ps=5.5u w=5u l=1u
X1311 a_81206_186803# a_83878_182403# VDD VDD pfet_06v0 ad=1.3p pd=5.52u as=2.2p ps=10.88u w=5u l=1u
X1312 a_98798_161570# a_35862_190951# cap_mim_2f0_m4m5_noshield c_width=25u c_length=8u
D58 S4P VDD diode_pd2nw_06v0 pj=40u area=99.99999p
X1313 a_74848_133316# a_74274_135596# a_76198_128854# VDD pfet_06v0 ad=4.4p pd=20.88u as=4.4p ps=20.88u w=10u l=1u
X1314 a_51986_135596# a_51986_135596# VDD VDD pfet_06v0 ad=0.88p pd=4.88u as=0.88p ps=4.88u w=2u l=1u
X1315 VSS VDD VSS VSS nfet_06v0 ad=4.29p pd=20.38u as=0 ps=0 w=9.75u l=2u
X1316 a_55594_177177# a_52358_177061# VDD VDD pfet_06v0 ad=2.5p pd=10.5u as=4.4p ps=20.88u w=10u l=1u
X1317 a_81646_177107# a_75502_173593# a_84542_173707# VSS nfet_06v0 ad=1.1p pd=5.88u as=0.65p ps=3.02u w=2.5u l=1u
X1318 a_75286_140914# a_73974_140870# VDD VDD pfet_06v0 ad=2.5p pd=10.5u as=4.4p ps=20.88u w=10u l=1u
X1319 a_29246_170197# a_29246_170197# VSS VSS nfet_06v0 ad=0.44p pd=2.88u as=0.44p ps=2.88u w=1u l=1u
X1320 a_52878_152822# a_51646_152778# VSS VSS nfet_06v0 ad=1.25p pd=5.5u as=2.2p ps=10.88u w=5u l=1u
X1321 a_52186_159680# a_51986_159564# a_51886_159680# VDD pfet_06v0 ad=4.4p pd=20.88u as=2.5p ps=10.5u w=10u l=1u
X1322 VSS a_60246_191067# a_59578_194467# VSS nfet_06v0 ad=1.1p pd=5.88u as=0.65p ps=3.02u w=2.5u l=1u
X1323 a_32522_140914# a_32786_149156# VSS VSS nfet_06v0 ad=0.825p pd=3.16u as=1.1p ps=5.88u w=2.5u l=1u
X1324 a_74274_159564# a_74274_159564# VDD VDD pfet_06v0 ad=0.88p pd=4.88u as=0.88p ps=4.88u w=2u l=1u
X1325 a_31710_161570# a_31310_152778# a_29786_159680# VDD pfet_06v0 ad=0.242p pd=1.98u as=0.242p ps=1.98u w=0.55u l=1u
X1326 a_76434_169513# a_76234_169397# VSS VSS nfet_06v0 ad=1.25p pd=5.5u as=2.2p ps=10.88u w=5u l=1u
X1327 a_88894_187257# a_75842_182289# a_92638_182333# VDD pfet_06v0 ad=4.4p pd=20.88u as=2.5p ps=10.5u w=10u l=1u
X1328 VSS a_38286_187303# a_46710_186803# VSS nfet_06v0 ad=1.3p pd=5.52u as=1.3p ps=5.52u w=5u l=1u
X1329 a_29246_148656# a_29586_140870# a_45134_140914# VDD pfet_06v0 ad=4.4p pd=20.88u as=2.5p ps=10.5u w=10u l=1u
X1330 ZP_OUT ZN_OUT VDD VDD pfet_05v0 ad=0.8052p pd=4.54u as=0.8052p ps=4.54u w=1.83u l=0.5u
X1331 a_29486_194537# a_29286_194421# VDD VDD pfet_06v0 ad=2.5p pd=10.5u as=4.4p ps=20.88u w=10u l=1u
D59 S1N VDD diode_pd2nw_06v0 pj=40u area=99.99999p
X1332 VSS a_60246_173707# a_58462_177107# VSS nfet_06v0 ad=1.1p pd=5.88u as=0.65p ps=3.02u w=2.5u l=1u
X1333 a_57822_186759# a_97248_145110# VDD VDD pfet_06v0 ad=0.44p pd=2.88u as=0.44p ps=2.88u w=1u l=1u
X1334 a_114466_173580# a_46710_173707# VDD VDD pfet_06v0 ad=0.99p pd=3.66u as=1.32p ps=6.88u w=3u l=1u
X1335 a_54922_140914# a_55186_149156# VSS VSS nfet_06v0 ad=0.825p pd=3.16u as=1.1p ps=5.88u w=2.5u l=1u
X1336 a_78498_170313# a_75842_164929# VSS VSS nfet_06v0 ad=0.25p pd=1.5u as=0.44p ps=2.88u w=1u l=1u
X1337 VDD VSS VDD VDD pfet_06v0 ad=7.92p pd=36.88u as=0 ps=0 w=18u l=2u
X1338 a_37622_165043# a_29586_164929# a_36062_169443# VDD pfet_06v0 ad=1.3p pd=5.52u as=2.2p ps=10.88u w=5u l=1u
X1339 VSS a_83430_169943# a_82762_165043# VSS nfet_06v0 ad=0.65p pd=3.02u as=0.65p ps=3.02u w=2.5u l=1u
X1340 a_44738_177061# a_29586_177061# a_44938_177177# VDD pfet_06v0 ad=3.3p pd=10.66u as=2.5p ps=10.5u w=10u l=1u
X1341 a_44302_190997# a_29978_190953# VSS VSS nfet_06v0 ad=1.25p pd=5.5u as=2.2p ps=10.88u w=5u l=1u
X1342 ZN_OUT a_102380_182320# VSS VSS nfet_05v0 ad=0.5808p pd=3.52u as=0.5808p ps=3.52u w=1.32u l=0.6u
X1343 a_41494_149572# a_29586_140870# VSS VSS nfet_06v0 ad=0.25p pd=1.5u as=0.44p ps=2.88u w=1u l=1u
X1344 a_52878_128854# a_51646_128810# VSS VSS nfet_06v0 ad=1.25p pd=5.5u as=2.2p ps=10.88u w=5u l=1u
X1345 a_35862_186759# a_31510_152822# cap_mim_2f0_m4m5_noshield c_width=25u c_length=8u
X1346 a_59578_165043# a_60246_169943# VSS VSS nfet_06v0 ad=0.65p pd=3.02u as=1.1p ps=5.88u w=2.5u l=1u
X1347 a_57822_190951# a_74848_157284# VDD VDD pfet_06v0 ad=0.44p pd=2.88u as=0.44p ps=2.88u w=1u l=1u
X1348 a_113914_164930# a_92966_169443# a_104234_184486# VDD pfet_06v0 ad=0.75p pd=3.5u as=1.32p ps=6.88u w=3u l=1u
X1349 a_36062_191067# a_29586_194421# a_37622_195467# VDD pfet_06v0 ad=2.2p pd=10.88u as=1.3p ps=5.52u w=5u l=1u
X1350 a_52560_143310# a_67978_143760# VSS ppolyf_u_1k r_width=1u r_length=76.45u
X1351 a_56718_164973# a_52358_164929# VDD VDD pfet_06v0 ad=2.5p pd=10.5u as=4.4p ps=20.88u w=10u l=1u
X1352 a_75502_190953# a_75502_190953# VSS VSS nfet_06v0 ad=0.44p pd=2.88u as=0.44p ps=2.88u w=1u l=1u
X1353 a_102380_177524# a_23448_131216# VSS VSS nfet_05v0 ad=0.5808p pd=3.52u as=0.5808p ps=3.52u w=1.32u l=0.6u
X1354 a_46710_186803# a_38738_182403# VDD VDD pfet_06v0 ad=2.6p pd=10.52u as=4.4p ps=20.88u w=10u l=1u
X1355 a_31510_148272# a_31310_128810# a_29746_148772# VSS nfet_06v0 ad=3.3p pd=15.88u as=3.3p ps=15.88u w=7.5u l=1u
X1356 a_92966_173707# a_84542_173707# VSS VSS nfet_06v0 ad=1.3p pd=5.52u as=2.2p ps=10.88u w=5u l=1u
X1357 a_88894_190953# a_88894_190953# a_91402_190953# VSS nfet_06v0 ad=2.2p pd=10.88u as=1.65p ps=5.66u w=5u l=1u
X1358 a_33334_159680# a_34926_152778# a_32786_152778# VSS nfet_06v0 ad=0.88p pd=4.88u as=0.88p ps=4.88u w=2u l=1u
X1359 a_55314_187673# a_52658_182289# VSS VSS nfet_06v0 ad=0.25p pd=1.5u as=0.44p ps=2.88u w=1u l=1u
X1360 VSS a_37174_187303# a_35390_182403# VSS nfet_06v0 ad=0.65p pd=3.02u as=0.65p ps=3.02u w=2.5u l=1u
X1361 a_78022_159680# a_74274_159564# a_76930_152822# VDD pfet_06v0 ad=4.4p pd=20.88u as=4.4p ps=20.88u w=10u l=1u
X1362 a_99296_185986# a_99096_185942# VSS VSS nfet_06v0 ad=0.5456p pd=3.36u as=0.5456p ps=3.36u w=1.24u l=1u
D60 VSS S4N diode_nd2ps_06v0 pj=40u area=99.99999p
X1363 a_79614_152778# a_79614_152778# a_82122_152778# VSS nfet_06v0 ad=2.2p pd=10.88u as=1.65p ps=5.66u w=5u l=1u
X1364 a_60246_173707# a_66174_178061# a_60694_178107# VDD pfet_06v0 ad=2.2p pd=10.88u as=2.2p ps=10.88u w=5u l=1u
X1365 a_112558_184214# a_110806_184214# a_111626_184098# VSS nfet_06v0 ad=0.25p pd=1.5u as=0.44p ps=2.88u w=1u l=1u
X1366 a_103470_160764# a_96634_152778# a_103678_152822# VSS nfet_06v0 ad=2.2p pd=10.88u as=1.25p ps=5.5u w=5u l=1u
X1367 a_30160_158634# a_45578_158184# VSS ppolyf_u_1k r_width=1u r_length=76.45u
D61 VSS X diode_nd2ps_06v0 pj=40u area=99.99999p
X1368 a_82318_186803# a_83878_182403# VDD VDD pfet_06v0 ad=1.3p pd=5.52u as=1.3p ps=5.52u w=5u l=1u
X1369 VSS a_29978_186757# a_33918_186873# VSS nfet_06v0 ad=2.2p pd=10.88u as=1.25p ps=5.5u w=5u l=1u
X1370 a_34750_169399# a_30160_133316# VDD VDD pfet_06v0 ad=0.44p pd=2.88u as=0.44p ps=2.88u w=1u l=1u
X1371 a_55734_159680# a_57326_152778# a_55186_152778# VSS nfet_06v0 ad=0.88p pd=4.88u as=0.88p ps=4.88u w=2u l=1u
X1372 a_29786_159680# a_29586_159564# a_30598_159680# VDD pfet_06v0 ad=4.4p pd=20.88u as=2.5p ps=10.5u w=10u l=1u
X1373 a_74274_140870# a_74274_140870# VDD VDD pfet_06v0 ad=0.88p pd=4.88u as=0.88p ps=4.88u w=2u l=1u
X1374 a_80534_182333# a_75842_182289# a_80202_182333# VDD pfet_06v0 ad=2.5p pd=10.5u as=3.3p ps=10.66u w=10u l=1u
X1375 VDD a_60694_182403# a_59134_186803# VDD pfet_06v0 ad=1.3p pd=5.52u as=1.3p ps=5.52u w=5u l=1u
X1376 VSS a_102146_190940# a_99134_167126# VSS nfet_06v0 ad=0.44p pd=2.88u as=0.44p ps=2.88u w=1u l=1u
X1377 a_96634_128810# a_96674_135596# a_111110_135712# VDD pfet_06v0 ad=4.4p pd=20.88u as=2.5p ps=10.5u w=10u l=1u
X1378 a_102104_173976# VDD a_23448_131216# VSS nfet_06v0 ad=1.0912p pd=5.84u as=0.6448p ps=3u w=2.48u l=1u
X1379 VDD a_37622_182403# a_36062_186803# VDD pfet_06v0 ad=1.3p pd=5.52u as=1.3p ps=5.52u w=5u l=1u
D62 S3N VDD diode_pd2nw_06v0 pj=40u area=99.99999p
X1380 a_33334_135712# a_34926_128810# a_32786_128810# VSS nfet_06v0 ad=0.88p pd=4.88u as=0.88p ps=4.88u w=2u l=1u
X1381 a_52186_159680# a_51986_159564# a_52998_159680# VDD pfet_06v0 ad=4.4p pd=20.88u as=2.5p ps=10.5u w=10u l=1u
X1382 a_30160_157734# a_45578_158184# VSS ppolyf_u_1k r_width=1u r_length=76.45u
X1383 VDD VSS VDD VDD pfet_06v0 ad=4.29p pd=20.38u as=0 ps=0 w=9.75u l=2u
D63 S1N VDD diode_pd2nw_06v0 pj=40u area=99.99999p
X1384 a_52358_164929# a_52658_164929# a_55594_164973# VDD pfet_06v0 ad=4.4p pd=20.88u as=2.5p ps=10.5u w=10u l=1u
X1385 a_79614_128810# a_79614_128810# a_82122_128810# VSS nfet_06v0 ad=2.2p pd=10.88u as=1.65p ps=5.66u w=5u l=1u
X1386 a_103470_136796# a_96634_128810# a_103678_128854# VSS nfet_06v0 ad=2.2p pd=10.88u as=1.25p ps=5.5u w=5u l=1u
X1387 VSS VDD VSS VSS nfet_06v0 ad=7.92p pd=36.88u as=0 ps=0 w=18u l=2u
X1388 a_78778_177177# a_75542_177061# VDD VDD pfet_06v0 ad=2.5p pd=10.5u as=4.4p ps=20.88u w=10u l=1u
X1389 a_36506_177107# a_37174_173707# VSS VSS nfet_06v0 ad=0.65p pd=3.02u as=1.1p ps=5.88u w=2.5u l=1u
X1390 a_55734_135712# a_57326_128810# a_55186_128810# VSS nfet_06v0 ad=0.88p pd=4.88u as=0.88p ps=4.88u w=2u l=1u
X1391 a_100422_140914# a_96674_140870# a_99330_148072# VDD pfet_06v0 ad=4.4p pd=20.88u as=4.4p ps=20.88u w=10u l=1u
X1392 a_35862_190951# a_97248_157284# VDD VDD pfet_06v0 ad=0.44p pd=2.88u as=0.44p ps=2.88u w=1u l=1u
X1393 VSS VDD VSS VSS nfet_06v0 ad=7.92p pd=36.88u as=0 ps=0 w=18u l=2u
D64 VSS S1N diode_nd2ps_06v0 pj=40u area=99.99999p
X1394 a_73934_152778# a_74274_159564# a_89822_159680# VDD pfet_06v0 ad=4.4p pd=20.88u as=2.5p ps=10.5u w=10u l=1u
X1395 a_36506_165043# a_35862_169399# a_33946_164973# VDD pfet_06v0 ad=2.6p pd=10.52u as=4.4p ps=20.88u w=10u l=1u
X1396 a_82318_173707# a_75842_177061# a_83878_178107# VDD pfet_06v0 ad=2.2p pd=10.88u as=1.3p ps=5.52u w=5u l=1u
X1397 a_60694_178107# a_65710_173593# a_60246_173707# VSS nfet_06v0 ad=1.1p pd=5.88u as=1.1p ps=5.88u w=2.5u l=1u
X1398 VSS a_83430_191067# a_82762_194467# VSS nfet_06v0 ad=1.1p pd=5.88u as=0.65p ps=3.02u w=2.5u l=1u
X1399 a_99296_168626# a_106078_167126# a_23448_190688# VSS nfet_06v0 ad=1.0912p pd=5.84u as=0.6448p ps=3u w=2.48u l=1u
X1400 a_84542_173707# a_75502_173593# a_81646_177107# VSS nfet_06v0 ad=0.65p pd=3.02u as=1.1p ps=5.88u w=2.5u l=1u
X1401 a_53910_128854# a_55734_135712# VDD VDD pfet_06v0 ad=2.2p pd=10.88u as=2.2p ps=10.88u w=5u l=1u
X1402 a_44022_140914# a_29286_140870# VDD VDD pfet_06v0 ad=2.5p pd=10.5u as=4.4p ps=20.88u w=10u l=1u
X1403 a_23448_131216# a_106078_175068# a_99296_173976# VSS nfet_06v0 ad=0.6448p pd=3u as=1.0912p ps=5.84u w=2.48u l=1u
X1404 a_104146_184530# a_104234_184486# a_23448_70736# VSS nfet_06v0 ad=1.0912p pd=5.84u as=0.6448p ps=3u w=2.48u l=1u
X1405 a_46710_191067# a_34950_191067# cap_mim_2f0_m4m5_noshield c_width=20u c_length=10u
X1406 a_46710_186803# a_38286_187303# VSS VSS nfet_06v0 ad=1.3p pd=5.52u as=2.2p ps=10.88u w=5u l=1u
X1407 a_46710_173707# a_34950_173707# cap_mim_2f0_m4m5_noshield c_width=20u c_length=10u
X1408 a_66422_140914# a_51686_140870# VDD VDD pfet_06v0 ad=2.5p pd=10.5u as=4.4p ps=20.88u w=10u l=1u
X1409 a_41494_152822# a_29586_159564# VSS VSS nfet_06v0 ad=0.25p pd=1.5u as=0.44p ps=2.88u w=1u l=1u
X1410 VDD VSS VDD VDD pfet_06v0 ad=0.44p pd=2.88u as=0 ps=0 w=1u l=2u
X1411 a_82762_165043# a_83430_169943# VSS VSS nfet_06v0 ad=0.65p pd=3.02u as=1.1p ps=5.88u w=2.5u l=1u
X1412 VSS a_76234_169397# a_80174_169513# VSS nfet_06v0 ad=2.2p pd=10.88u as=1.25p ps=5.5u w=5u l=1u
X1413 a_34394_152822# a_29546_152778# a_31710_161570# VSS nfet_06v0 ad=1.1p pd=5.88u as=0.825p ps=3.16u w=2.5u l=1u
X1414 a_45346_186873# a_45146_186757# VSS VSS nfet_06v0 ad=1.25p pd=5.5u as=2.2p ps=10.88u w=5u l=1u
X1415 a_114466_166626# a_46710_169443# VDD VDD pfet_06v0 ad=0.99p pd=3.66u as=1.32p ps=6.88u w=3u l=1u
X1416 a_96334_148656# a_96674_140870# a_112222_140914# VDD pfet_06v0 ad=4.4p pd=20.88u as=2.5p ps=10.5u w=10u l=1u
X1417 a_74848_133766# a_90266_133316# VSS ppolyf_u_1k r_width=1u r_length=76.45u
D65 VSS X diode_nd2ps_06v0 pj=40u area=99.99999p
X1418 VSS a_46710_191067# a_98486_190984# VSS nfet_06v0 ad=0.44p pd=2.88u as=0.44p ps=2.88u w=1u l=1u
X1419 a_69782_169443# a_61810_165043# VDD VDD pfet_06v0 ad=4.4p pd=20.88u as=2.6p ps=10.52u w=10u l=1u
X1420 a_107550_152822# a_96334_152778# VSS VSS nfet_06v0 ad=1.25p pd=5.5u as=2.2p ps=10.88u w=5u l=1u
X1421 a_37622_195467# a_29586_194421# a_36062_191067# VDD pfet_06v0 ad=1.3p pd=5.52u as=2.2p ps=10.88u w=5u l=1u
X1422 a_96834_148772# a_96634_148656# a_96534_148772# VSS nfet_06v0 ad=2.2p pd=10.88u as=1.25p ps=5.5u w=5u l=1u
X1423 a_59834_148656# a_51946_148656# a_60034_148772# VSS nfet_06v0 ad=1.65p pd=5.66u as=1.25p ps=5.5u w=5u l=1u
X1424 a_34926_149256# a_34926_149256# a_37434_148656# VSS nfet_06v0 ad=2.2p pd=10.88u as=1.65p ps=5.66u w=5u l=1u
X1425 VDD VSS VDD VDD pfet_06v0 ad=0.44p pd=2.88u as=0 ps=0 w=1u l=2u
X1426 a_56990_169513# a_52318_170197# a_56658_169513# VSS nfet_06v0 ad=1.25p pd=5.5u as=1.65p ps=5.66u w=5u l=1u
X1427 a_41494_128854# a_29586_135596# VSS VSS nfet_06v0 ad=0.25p pd=1.5u as=0.44p ps=2.88u w=1u l=1u
X1428 a_52560_144210# a_67978_143760# VSS ppolyf_u_1k r_width=1u r_length=76.45u
D66 S3N VDD diode_pd2nw_06v0 pj=40u area=99.99999p
X1429 a_97248_133766# a_112666_133316# VSS ppolyf_u_1k r_width=1u r_length=76.45u
X1430 a_34394_128854# a_29546_128810# a_31710_137602# VSS nfet_06v0 ad=1.1p pd=5.88u as=0.825p ps=3.16u w=2.5u l=1u
X1431 a_60246_173707# a_52318_173593# a_59578_177107# VSS nfet_06v0 ad=0.65p pd=3.02u as=1.1p ps=5.88u w=2.5u l=1u
X1432 VSS VDD VSS VSS nfet_06v0 ad=4.29p pd=20.38u as=0 ps=0 w=9.75u l=2u
X1433 a_83430_173707# a_89358_178061# a_83878_178107# VDD pfet_06v0 ad=2.2p pd=10.88u as=2.2p ps=10.88u w=5u l=1u
D67 VSS S3N diode_nd2ps_06v0 pj=40u area=99.99999p
X1434 a_74848_158634# a_57822_190951# VSS ppolyf_u_1k r_width=1u r_length=76.45u
X1435 a_67374_173637# a_53050_173593# VSS VSS nfet_06v0 ad=1.25p pd=5.5u as=2.2p ps=10.88u w=5u l=1u
X1436 a_107550_128854# a_96334_128810# VSS VSS nfet_06v0 ad=1.25p pd=5.5u as=2.2p ps=10.88u w=5u l=1u
X1437 a_37622_178107# a_42638_173593# a_37174_173707# VSS nfet_06v0 ad=1.1p pd=5.88u as=1.1p ps=5.88u w=2.5u l=1u
X1438 a_30160_133316# a_45578_133316# VSS ppolyf_u_1k r_width=1u r_length=76.45u
X1439 VDD a_83878_182403# a_82318_186803# VDD pfet_06v0 ad=1.3p pd=5.52u as=1.3p ps=5.52u w=5u l=1u
D68 VSS S1N diode_nd2ps_06v0 pj=40u area=99.99999p
X1440 a_98798_137602# a_34750_173591# cap_mim_2f0_m4m5_noshield c_width=25u c_length=8u
X1441 a_34750_186759# a_76198_148272# cap_mim_2f0_m4m5_noshield c_width=25u c_length=8u
X1442 a_56658_190997# a_52318_190953# a_56358_190997# VSS nfet_06v0 ad=1.65p pd=5.66u as=1.25p ps=5.5u w=5u l=1u
X1443 a_79614_149256# a_74274_140870# a_84350_140914# VDD pfet_06v0 ad=4.4p pd=20.88u as=2.5p ps=10.5u w=10u l=1u
X1444 a_97248_158634# a_35862_190951# VSS ppolyf_u_1k r_width=1u r_length=76.45u
X1445 a_51886_159680# a_51686_159564# VDD VDD pfet_06v0 ad=2.5p pd=10.5u as=4.4p ps=20.88u w=10u l=1u
X1446 a_23448_131216# VDD a_102104_173976# VSS nfet_06v0 ad=0.6448p pd=3u as=1.0912p ps=5.84u w=2.48u l=1u
X1447 a_36062_186803# a_37622_182403# VDD VDD pfet_06v0 ad=1.3p pd=5.52u as=2.2p ps=10.88u w=5u l=1u
X1448 a_61358_169943# a_52318_170197# a_58462_165043# VSS nfet_06v0 ad=0.65p pd=3.02u as=1.1p ps=5.88u w=2.5u l=1u
X1449 a_55186_149156# a_51946_148656# a_54922_140914# VSS nfet_06v0 ad=1.1p pd=5.88u as=0.825p ps=3.16u w=2.5u l=1u
X1450 a_75542_164929# a_75842_164929# a_78778_164973# VDD pfet_06v0 ad=4.4p pd=20.88u as=2.5p ps=10.5u w=10u l=1u
X1451 a_92638_182333# a_75542_182289# VDD VDD pfet_06v0 ad=2.5p pd=10.5u as=4.4p ps=20.88u w=10u l=1u
X1452 VDD VSS VDD VDD pfet_06v0 ad=4.29p pd=20.38u as=0 ps=0 w=9.75u l=2u
X1453 a_37434_152778# a_29546_152778# a_37634_152822# VSS nfet_06v0 ad=1.65p pd=5.66u as=1.25p ps=5.5u w=5u l=1u
X1454 a_35390_177107# a_37174_173707# VSS VSS nfet_06v0 ad=0.65p pd=3.02u as=0.65p ps=3.02u w=2.5u l=1u
X1455 VDD VSS VDD VDD pfet_06v0 ad=7.92p pd=36.88u as=0 ps=0 w=18u l=2u
X1456 a_101060_168734# a_99096_168582# a_100760_168734# VSS nfet_06v0 ad=0.175p pd=1.2u as=0.175p ps=1.2u w=0.7u l=1u
X1457 a_69782_186803# a_61358_187303# VSS VSS nfet_06v0 ad=2.2p pd=10.88u as=1.3p ps=5.52u w=5u l=1u
X1458 a_100422_140914# a_102014_149256# a_99874_149156# VSS nfet_06v0 ad=0.88p pd=4.88u as=0.88p ps=4.88u w=2u l=1u
X1459 VSS VDD VSS VSS nfet_06v0 ad=4.29p pd=20.38u as=0 ps=0 w=9.75u l=2u
X1460 a_82762_194467# a_83430_191067# VSS VSS nfet_06v0 ad=0.65p pd=3.02u as=0.65p ps=3.02u w=2.5u l=1u
X1461 a_99610_140914# a_54442_128810# a_96874_140914# VDD pfet_06v0 ad=0.22p pd=1.88u as=0.22p ps=1.88u w=0.5u l=1u
X1462 a_34750_169399# a_31510_128854# cap_mim_2f0_m4m5_noshield c_width=25u c_length=8u
X1463 a_23448_70736# a_104234_184486# a_104146_184530# VSS nfet_06v0 ad=0.6448p pd=3u as=1.0912p ps=5.84u w=2.48u l=1u
X1464 a_68010_194537# a_67810_194421# VDD VDD pfet_06v0 ad=2.5p pd=10.5u as=4.4p ps=20.88u w=10u l=1u
X1465 a_37434_128810# a_29546_128810# a_37634_128854# VSS nfet_06v0 ad=1.65p pd=5.66u as=1.25p ps=5.5u w=5u l=1u
X1466 VSS VDD VSS VSS nfet_06v0 ad=4.29p pd=20.38u as=0 ps=0 w=9.75u l=2u
X1467 VDD VSS VDD VDD pfet_06v0 ad=0.44p pd=2.88u as=0 ps=0 w=1u l=2u
X1468 VDD VSS VDD VDD pfet_06v0 ad=4.29p pd=20.38u as=0 ps=0 w=9.75u l=2u
X1469 a_102380_182320# a_23448_70736# VSS VSS nfet_05v0 ad=0.5808p pd=3.52u as=0.5808p ps=3.52u w=1.32u l=0.6u
X1470 a_80202_164973# a_57822_169399# a_81646_165043# VDD pfet_06v0 ad=4.4p pd=20.88u as=2.6p ps=10.52u w=10u l=1u
X1471 a_67810_164929# a_52658_164929# a_68010_164973# VDD pfet_06v0 ad=3.3p pd=10.66u as=2.5p ps=10.5u w=10u l=1u
X1472 a_57018_164973# a_35862_169399# a_59578_165043# VDD pfet_06v0 ad=4.4p pd=20.88u as=2.6p ps=10.52u w=10u l=1u
X1473 a_111110_140914# a_96374_140870# VDD VDD pfet_06v0 ad=2.5p pd=10.5u as=4.4p ps=20.88u w=10u l=1u
X1474 a_76930_148072# a_78022_140914# VDD VDD pfet_06v0 ad=2.2p pd=10.88u as=2.2p ps=10.88u w=5u l=1u
X1475 a_75502_173593# a_75842_177061# a_75742_177177# VDD pfet_06v0 ad=4.4p pd=20.88u as=2.5p ps=10.5u w=10u l=1u
D69 VSS S3N diode_nd2ps_06v0 pj=40u area=99.99999p
X1476 VDD a_69782_191067# a_102146_190940# VDD pfet_06v0 ad=1.32p pd=6.88u as=0.99p ps=3.66u w=3u l=1u
X1477 a_29246_187557# a_29586_182289# a_29486_182333# VDD pfet_06v0 ad=4.4p pd=20.88u as=2.5p ps=10.5u w=10u l=1u
X1478 a_103678_152822# a_96334_152778# VSS VSS nfet_06v0 ad=1.25p pd=5.5u as=2.2p ps=10.88u w=5u l=1u
X1479 a_96874_135712# a_96674_135596# a_97686_135712# VDD pfet_06v0 ad=4.4p pd=20.88u as=2.5p ps=10.5u w=10u l=1u
X1480 VDD a_61810_165043# a_69782_169443# VDD pfet_06v0 ad=2.6p pd=10.52u as=2.6p ps=10.52u w=10u l=1u
X1481 a_80174_169513# a_75502_170197# a_79842_169513# VSS nfet_06v0 ad=1.25p pd=5.5u as=1.65p ps=5.66u w=5u l=1u
X1482 a_74848_133766# a_90266_134216# VSS ppolyf_u_1k r_width=1u r_length=76.45u
X1483 a_55186_128810# a_58782_136796# a_55734_135712# VDD pfet_06v0 ad=1.76p pd=8.88u as=1.76p ps=8.88u w=4u l=1u
X1484 a_31510_152822# a_31310_152778# a_29746_152822# VSS nfet_06v0 ad=3.3p pd=15.88u as=3.3p ps=15.88u w=7.5u l=1u
X1485 a_46710_173707# a_38738_178107# VDD VDD pfet_06v0 ad=4.4p pd=20.88u as=2.6p ps=10.52u w=10u l=1u
X1486 VSS a_61358_191067# a_69782_191067# VSS nfet_06v0 ad=1.3p pd=5.52u as=1.3p ps=5.52u w=5u l=1u
X1487 a_30598_159680# a_29286_159564# VDD VDD pfet_06v0 ad=2.5p pd=10.5u as=4.4p ps=20.88u w=10u l=1u
X1488 a_74434_152822# a_74234_152778# a_74134_152822# VSS nfet_06v0 ad=2.2p pd=10.88u as=1.25p ps=5.5u w=5u l=1u
X1489 a_36506_182403# a_37174_187303# VSS VSS nfet_06v0 ad=0.65p pd=3.02u as=0.65p ps=3.02u w=2.5u l=1u
X1490 VDD VSS VDD VDD pfet_06v0 ad=4.29p pd=20.38u as=0 ps=0 w=9.75u l=2u
X1491 a_101482_152822# a_96634_152778# a_98798_161570# VSS nfet_06v0 ad=1.1p pd=5.88u as=0.825p ps=3.16u w=2.5u l=1u
X1492 a_57822_190951# a_74848_157284# VDD VDD pfet_06v0 ad=0.44p pd=2.88u as=0.44p ps=2.88u w=1u l=1u
X1493 a_38738_182403# a_29586_182289# a_34950_186803# VDD pfet_06v0 ad=1.3p pd=5.52u as=2.2p ps=10.88u w=5u l=1u
X1494 a_81206_173707# a_75842_177061# a_84994_178107# VDD pfet_06v0 ad=2.2p pd=10.88u as=1.3p ps=5.52u w=5u l=1u
X1495 a_97248_133766# a_112666_134216# VSS ppolyf_u_1k r_width=1u r_length=76.45u
X1496 a_60034_148772# a_59834_148656# VSS VSS nfet_06v0 ad=1.25p pd=5.5u as=2.2p ps=10.88u w=5u l=1u
X1497 a_55594_164973# a_52358_164929# VDD VDD pfet_06v0 ad=2.5p pd=10.5u as=4.4p ps=20.88u w=10u l=1u
X1498 a_73934_148656# a_74234_148656# a_85150_148772# VSS nfet_06v0 ad=2.2p pd=10.88u as=1.25p ps=5.5u w=5u l=1u
X1499 a_103678_128854# a_96334_128810# VSS VSS nfet_06v0 ad=1.25p pd=5.5u as=2.2p ps=10.88u w=5u l=1u
X1500 a_102014_149256# a_102014_149256# a_104522_148656# VSS nfet_06v0 ad=2.2p pd=10.88u as=1.65p ps=5.66u w=5u l=1u
X1501 a_80202_177177# a_34750_173591# a_82762_177107# VDD pfet_06v0 ad=4.4p pd=20.88u as=2.6p ps=10.52u w=10u l=1u
X1502 a_75842_182289# a_75842_182289# a_78498_187673# VSS nfet_06v0 ad=0.44p pd=2.88u as=0.25p ps=1.5u w=1u l=1u
X1503 a_31510_128854# a_31310_128810# a_29746_128854# VSS nfet_06v0 ad=3.3p pd=15.88u as=3.3p ps=15.88u w=7.5u l=1u
X1504 a_74434_128854# a_74234_128810# a_74134_128854# VSS nfet_06v0 ad=2.2p pd=10.88u as=1.25p ps=5.5u w=5u l=1u
X1505 a_89822_159680# a_73974_159564# VDD VDD pfet_06v0 ad=2.5p pd=10.5u as=4.4p ps=20.88u w=10u l=1u
X1506 a_44938_194537# a_44738_194421# VDD VDD pfet_06v0 ad=2.5p pd=10.5u as=4.4p ps=20.88u w=10u l=1u
X1507 a_59578_194467# a_52318_190953# a_60246_191067# VSS nfet_06v0 ad=1.1p pd=5.88u as=0.65p ps=3.02u w=2.5u l=1u
X1508 a_101482_128854# a_96634_128810# a_98798_137602# VSS nfet_06v0 ad=1.1p pd=5.88u as=0.825p ps=3.16u w=2.5u l=1u
X1509 VDD VSS VDD VDD pfet_06v0 ad=7.92p pd=36.88u as=0 ps=0 w=18u l=2u
X1510 a_81646_182403# a_83430_187303# VSS VSS nfet_06v0 ad=0.65p pd=3.02u as=0.65p ps=3.02u w=2.5u l=1u
X1511 VSS a_37174_173707# a_35390_177107# VSS nfet_06v0 ad=0.65p pd=3.02u as=0.65p ps=3.02u w=2.5u l=1u
X1512 a_44738_164929# a_29586_164929# a_44938_164973# VDD pfet_06v0 ad=3.3p pd=10.66u as=2.5p ps=10.5u w=10u l=1u
X1513 a_92966_186803# a_84542_187303# VSS VSS nfet_06v0 ad=2.2p pd=10.88u as=1.3p ps=5.52u w=5u l=1u
X1514 a_62062_135712# a_51686_135596# VDD VDD pfet_06v0 ad=2.5p pd=10.5u as=4.4p ps=20.88u w=10u l=1u
X1515 a_99096_185942# a_99096_185942# a_101360_186094# VSS nfet_06v0 ad=0.308p pd=2.28u as=0.175p ps=1.2u w=0.7u l=1u
X1516 a_53050_190953# a_52658_194421# a_53670_194537# VDD pfet_06v0 ad=4.4p pd=20.88u as=2.5p ps=10.5u w=10u l=1u
X1517 a_103078_190984# a_69782_191067# a_102146_190940# VSS nfet_06v0 ad=0.25p pd=1.5u as=0.44p ps=2.88u w=1u l=1u
X1518 a_32522_161580# a_32786_152778# VSS VSS nfet_06v0 ad=0.825p pd=3.16u as=1.1p ps=5.88u w=2.5u l=1u
X1519 VSS a_53050_186757# a_56990_186873# VSS nfet_06v0 ad=2.2p pd=10.88u as=1.25p ps=5.5u w=5u l=1u
X1520 a_51646_152778# a_51946_152778# a_62862_152822# VSS nfet_06v0 ad=2.2p pd=10.88u as=1.25p ps=5.5u w=5u l=1u
X1521 a_30160_145110# a_34926_149256# a_34394_149272# VSS nfet_06v0 ad=0.88p pd=4.88u as=0.88p ps=4.88u w=2u l=1u
X1522 VSS a_46710_186803# a_110806_184214# VSS nfet_06v0 ad=0.44p pd=2.88u as=0.44p ps=2.88u w=1u l=1u
X1523 a_45146_173593# a_29246_173593# a_45346_173637# VSS nfet_06v0 ad=1.65p pd=5.66u as=1.25p ps=5.5u w=5u l=1u
X1524 a_43102_182289# a_29246_187557# a_44302_186873# VSS nfet_06v0 ad=2.2p pd=10.88u as=1.25p ps=5.5u w=5u l=1u
X1525 a_57018_164973# a_57822_169399# a_58462_165043# VDD pfet_06v0 ad=4.4p pd=20.88u as=2.6p ps=10.52u w=10u l=1u
X1526 a_74134_148772# a_73934_148656# VSS VSS nfet_06v0 ad=1.25p pd=5.5u as=2.2p ps=10.88u w=5u l=1u
X1527 a_96834_152822# a_96634_152778# a_97566_152822# VSS nfet_06v0 ad=2.2p pd=10.88u as=1.25p ps=5.5u w=5u l=1u
X1528 VSS a_37174_191067# a_35390_194467# VSS nfet_06v0 ad=1.1p pd=5.88u as=0.65p ps=3.02u w=2.5u l=1u
X1529 a_106078_184486# a_92966_186803# VSS VSS nfet_06v0 ad=0.33p pd=1.66u as=0.44p ps=2.88u w=1u l=1u
X1530 a_104522_152778# a_96634_152778# a_104722_152822# VSS nfet_06v0 ad=1.65p pd=5.66u as=1.25p ps=5.5u w=5u l=1u
X1531 a_54922_161580# a_55186_152778# VSS VSS nfet_06v0 ad=0.825p pd=3.16u as=1.1p ps=5.88u w=2.5u l=1u
X1532 a_36506_194467# a_35862_190951# a_33946_194537# VDD pfet_06v0 ad=2.6p pd=10.52u as=4.4p ps=20.88u w=10u l=1u
X1533 a_112222_140914# a_96374_140870# VDD VDD pfet_06v0 ad=2.5p pd=10.5u as=4.4p ps=20.88u w=10u l=1u
X1534 a_29286_194421# a_29586_194421# a_31210_190997# VSS nfet_06v0 ad=0.44p pd=2.88u as=0.25p ps=1.5u w=1u l=1u
X1535 a_52560_145110# a_57326_149256# a_56794_149272# VSS nfet_06v0 ad=0.88p pd=4.88u as=0.88p ps=4.88u w=2u l=1u
X1536 VSS a_114466_173580# a_100246_167126# VSS nfet_06v0 ad=0.44p pd=2.88u as=0.44p ps=2.88u w=1u l=1u
X1537 S4P a_23448_31424# VDD ppolyf_u r_width=16u r_length=4u
X1538 S2P a_31310_128810# VDD ppolyf_u r_width=16u r_length=4u
X1539 a_32522_137612# a_32786_128810# VSS VSS nfet_06v0 ad=0.825p pd=3.16u as=1.1p ps=5.88u w=2.5u l=1u
X1540 a_96534_148772# a_96334_148656# VSS VSS nfet_06v0 ad=1.25p pd=5.5u as=2.2p ps=10.88u w=5u l=1u
X1541 VDD a_23448_70736# a_23448_70736# VDD pfet_06v0 ad=0.52p pd=2.52u as=0.52p ps=2.52u w=2u l=1u
X1542 a_84542_191067# a_89358_195421# a_84994_195467# VDD pfet_06v0 ad=2.2p pd=10.88u as=2.2p ps=10.88u w=5u l=1u
X1543 a_51646_128810# a_51946_128810# a_62862_128854# VSS nfet_06v0 ad=2.2p pd=10.88u as=1.25p ps=5.5u w=5u l=1u
D70 VSS Y diode_nd2ps_06v0 pj=40u area=99.99999p
X1544 a_81070_140870# a_81070_140870# a_82706_140870# VDD pfet_06v0 ad=4.4p pd=20.88u as=3.3p ps=10.66u w=10u l=1u
X1545 VSS VDD VSS VSS nfet_06v0 ad=7.92p pd=36.88u as=0 ps=0 w=18u l=2u
X1546 a_42638_173593# a_29586_177061# a_46382_177177# VDD pfet_06v0 ad=4.4p pd=20.88u as=2.5p ps=10.5u w=10u l=1u
X1547 VDD VSS VDD VDD pfet_06v0 ad=7.92p pd=36.88u as=0 ps=0 w=18u l=2u
X1548 VDD VSS VDD VDD pfet_06v0 ad=0.44p pd=2.88u as=0 ps=0 w=1u l=2u
X1549 a_96834_128854# a_96634_128810# a_97566_128854# VSS nfet_06v0 ad=2.2p pd=10.88u as=1.25p ps=5.5u w=5u l=1u
X1550 a_73974_140870# a_74274_140870# a_86182_149572# VSS nfet_06v0 ad=0.44p pd=2.88u as=0.25p ps=1.5u w=1u l=1u
X1551 a_104522_128810# a_96634_128810# a_104722_128854# VSS nfet_06v0 ad=1.65p pd=5.66u as=1.25p ps=5.5u w=5u l=1u
X1552 a_38738_165043# a_42638_169897# a_38286_169943# VSS nfet_06v0 ad=1.1p pd=5.88u as=1.1p ps=5.88u w=2.5u l=1u
X1553 a_54922_137612# a_55186_128810# VSS VSS nfet_06v0 ad=0.825p pd=3.16u as=1.1p ps=5.88u w=2.5u l=1u
X1554 a_99610_161580# a_32042_128810# a_96874_159680# VDD pfet_06v0 ad=0.22p pd=1.88u as=0.22p ps=1.88u w=0.5u l=1u
X1555 VDD a_84994_165043# a_92966_169443# VDD pfet_06v0 ad=2.6p pd=10.52u as=2.6p ps=10.52u w=10u l=1u
X1556 a_35390_194467# a_37174_191067# VSS VSS nfet_06v0 ad=0.65p pd=3.02u as=1.1p ps=5.88u w=2.5u l=1u
X1557 a_43102_182289# a_43102_182289# a_44738_182289# VDD pfet_06v0 ad=4.4p pd=20.88u as=3.3p ps=10.66u w=10u l=1u
X1558 a_29786_135712# a_29586_135596# a_29486_135712# VDD pfet_06v0 ad=4.4p pd=20.88u as=2.5p ps=10.5u w=10u l=1u
X1559 a_76198_152822# a_78022_159680# VDD VDD pfet_06v0 ad=2.2p pd=10.88u as=2.2p ps=10.88u w=5u l=1u
X1560 a_65710_187257# a_65710_187257# a_68218_186757# VSS nfet_06v0 ad=2.2p pd=10.88u as=1.65p ps=5.66u w=5u l=1u
X1561 VSS VDD VSS VSS nfet_06v0 ad=4.29p pd=20.38u as=0 ps=0 w=9.75u l=2u
X1562 VDD VSS VDD VDD pfet_06v0 ad=7.92p pd=36.88u as=0 ps=0 w=18u l=2u
X1563 a_33586_169513# a_35862_169399# a_36062_169443# VSS nfet_06v0 ad=2.2p pd=10.88u as=1.3p ps=5.52u w=5u l=1u
X1564 a_110806_173624# a_46710_173707# VDD VDD pfet_06v0 ad=1.32p pd=6.88u as=1.32p ps=6.88u w=3u l=1u
X1565 a_69782_191067# a_61358_191067# VSS VSS nfet_06v0 ad=1.3p pd=5.52u as=2.2p ps=10.88u w=5u l=1u
X1566 a_35862_173591# a_52560_145110# VDD VDD pfet_06v0 ad=0.44p pd=2.88u as=0.44p ps=2.88u w=1u l=1u
X1567 a_69782_191067# a_61810_195467# VDD VDD pfet_06v0 ad=4.4p pd=20.88u as=2.6p ps=10.52u w=10u l=1u
X1568 a_56358_190997# a_53050_190953# VSS VSS nfet_06v0 ad=1.25p pd=5.5u as=2.2p ps=10.88u w=5u l=1u
X1569 VSS a_37174_187303# a_36506_182403# VSS nfet_06v0 ad=0.65p pd=3.02u as=0.65p ps=3.02u w=2.5u l=1u
X1570 a_79842_169513# a_57822_169399# a_81206_169443# VSS nfet_06v0 ad=2.2p pd=10.88u as=1.3p ps=5.52u w=5u l=1u
X1571 a_84350_140914# a_73974_140870# VDD VDD pfet_06v0 ad=2.5p pd=10.5u as=4.4p ps=20.88u w=10u l=1u
X1572 a_34750_173591# a_97248_133316# VDD VDD pfet_06v0 ad=0.44p pd=2.88u as=0.44p ps=2.88u w=1u l=1u
X1573 VDD VSS VDD VDD pfet_06v0 ad=7.92p pd=36.88u as=0 ps=0 w=18u l=2u
X1574 a_51686_159564# a_51986_159564# a_69458_159680# VDD pfet_06v0 ad=4.4p pd=20.88u as=2.5p ps=10.5u w=10u l=1u
X1575 a_32522_137612# a_32042_128810# a_29786_135712# VDD pfet_06v0 ad=0.22p pd=1.88u as=0.22p ps=1.88u w=0.5u l=1u
X1576 a_78778_164973# a_75542_164929# VDD VDD pfet_06v0 ad=2.5p pd=10.5u as=4.4p ps=20.88u w=10u l=1u
X1577 a_35390_165043# a_29246_170197# a_38286_169943# VSS nfet_06v0 ad=1.1p pd=5.88u as=0.65p ps=3.02u w=2.5u l=1u
X1578 a_34950_173707# a_37622_178107# VDD VDD pfet_06v0 ad=1.3p pd=5.52u as=1.3p ps=5.52u w=5u l=1u
X1579 a_29978_190953# a_29586_194421# a_30598_194537# VDD pfet_06v0 ad=4.4p pd=20.88u as=2.5p ps=10.5u w=10u l=1u
X1580 a_81070_140870# a_74234_148656# a_81278_148772# VSS nfet_06v0 ad=2.2p pd=10.88u as=1.25p ps=5.5u w=5u l=1u
X1581 a_37634_152822# a_37434_152778# VSS VSS nfet_06v0 ad=1.25p pd=5.5u as=2.2p ps=10.88u w=5u l=1u
X1582 a_100760_168734# a_99096_168582# VSS VSS nfet_06v0 ad=0.175p pd=1.2u as=0.308p ps=2.28u w=0.7u l=1u
X1583 a_34950_169443# a_34750_169399# a_33586_169513# VSS nfet_06v0 ad=1.3p pd=5.52u as=2.2p ps=10.88u w=5u l=1u
X1584 a_102002_184626# a_23448_70736# a_23448_70736# VSS nfet_06v0 ad=0.88p pd=4.88u as=0.52p ps=2.52u w=2u l=1u
X1585 a_82762_177107# a_34750_173591# a_80202_177177# VDD pfet_06v0 ad=2.6p pd=10.52u as=4.4p ps=20.88u w=10u l=1u
X1586 a_82762_194467# a_75502_190953# a_83430_191067# VSS nfet_06v0 ad=1.1p pd=5.88u as=0.65p ps=3.02u w=2.5u l=1u
X1587 VSS VDD VSS VSS nfet_06v0 ad=4.29p pd=20.38u as=0 ps=0 w=9.75u l=2u
D71 Y VDD diode_pd2nw_06v0 pj=40u area=99.99999p
X1588 VSS VDD VSS VSS nfet_06v0 ad=7.92p pd=36.88u as=0 ps=0 w=18u l=2u
D72 X VDD diode_pd2nw_06v0 pj=40u area=99.99999p
X1589 VDD VSS VDD VDD pfet_06v0 ad=4.29p pd=20.38u as=0 ps=0 w=9.75u l=2u
X1590 VSS VDD VSS VSS nfet_06v0 ad=7.92p pd=36.88u as=0 ps=0 w=18u l=2u
X1591 a_99306_190940# a_92966_191067# VDD VDD pfet_06v0 ad=0.99p pd=3.66u as=1.32p ps=6.88u w=3u l=1u
X1592 a_82318_186803# a_75842_182289# a_83878_182403# VDD pfet_06v0 ad=2.2p pd=10.88u as=1.3p ps=5.52u w=5u l=1u
X1593 a_37174_191067# a_29246_190953# a_36506_194467# VSS nfet_06v0 ad=0.65p pd=3.02u as=1.1p ps=5.88u w=2.5u l=1u
X1594 a_52560_134666# a_67978_134216# VSS ppolyf_u_1k r_width=1u r_length=76.45u
X1595 a_32242_148072# a_32042_128810# a_29746_148772# VSS nfet_06v0 ad=3.74p pd=17.88u as=3.74p ps=17.88u w=8.5u l=1u
X1596 a_37634_128854# a_37434_128810# VSS VSS nfet_06v0 ad=1.25p pd=5.5u as=2.2p ps=10.88u w=5u l=1u
X1597 a_76234_190953# a_75842_194421# a_76854_194537# VDD pfet_06v0 ad=4.4p pd=20.88u as=2.5p ps=10.5u w=10u l=1u
X1598 a_55734_135712# a_51986_135596# a_54642_128854# VDD pfet_06v0 ad=4.4p pd=20.88u as=4.4p ps=20.88u w=10u l=1u
X1599 a_34750_190951# a_53910_152822# cap_mim_2f0_m4m5_noshield c_width=25u c_length=8u
X1600 VDD VSS VDD VDD pfet_06v0 ad=4.29p pd=20.38u as=0 ps=0 w=9.75u l=2u
X1601 VSS a_84542_187303# a_92966_186803# VSS nfet_06v0 ad=1.3p pd=5.52u as=1.3p ps=5.52u w=5u l=1u
X1602 VDD a_60694_165043# a_58022_169443# VDD pfet_06v0 ad=2.2p pd=10.88u as=1.3p ps=5.52u w=5u l=1u
D73 S2P VDD diode_pd2nw_06v0 pj=40u area=99.99999p
X1603 VSS VDD VSS VSS nfet_06v0 ad=4.29p pd=20.38u as=0 ps=0 w=9.75u l=2u
X1604 a_35862_186759# a_30160_157284# VDD VDD pfet_06v0 ad=0.44p pd=2.88u as=0.44p ps=2.88u w=1u l=1u
X1605 a_58462_165043# a_57822_169399# a_57018_164973# VDD pfet_06v0 ad=2.6p pd=10.52u as=4.4p ps=20.88u w=10u l=1u
X1606 a_29586_164929# a_29586_164929# a_32242_170313# VSS nfet_06v0 ad=0.44p pd=2.88u as=0.25p ps=1.5u w=1u l=1u
X1607 a_75742_177177# a_75542_177061# VDD VDD pfet_06v0 ad=2.5p pd=10.5u as=4.4p ps=20.88u w=10u l=1u
X1608 a_74234_148656# a_74274_140870# a_88710_140914# VDD pfet_06v0 ad=4.4p pd=20.88u as=2.5p ps=10.5u w=10u l=1u
X1609 VSS a_29978_173593# a_33918_173637# VSS nfet_06v0 ad=2.2p pd=10.88u as=1.25p ps=5.5u w=5u l=1u
X1610 a_42638_187257# a_42638_187257# a_45146_186757# VSS nfet_06v0 ad=2.2p pd=10.88u as=1.65p ps=5.66u w=5u l=1u
X1611 a_29486_182333# a_29286_182289# VDD VDD pfet_06v0 ad=2.5p pd=10.5u as=4.4p ps=20.88u w=10u l=1u
X1612 a_31710_140914# a_38998_149572# cap_mim_2f0_m4m5_noshield c_width=25u c_length=8u
X1613 a_102380_182320# a_23448_70736# VDD VDD pfet_05v0 ad=0.8052p pd=4.54u as=0.8052p ps=4.54u w=1.83u l=0.5u
X1614 a_66174_178061# a_66174_178061# a_67810_177061# VDD pfet_06v0 ad=4.4p pd=20.88u as=3.3p ps=10.66u w=10u l=1u
D74 S2N VDD diode_pd2nw_06v0 pj=40u area=99.99999p
X1615 a_97686_135712# a_96374_135596# VDD VDD pfet_06v0 ad=2.5p pd=10.5u as=4.4p ps=20.88u w=10u l=1u
X1616 a_97248_145110# a_102014_149256# a_101482_149272# VSS nfet_06v0 ad=0.88p pd=4.88u as=0.88p ps=4.88u w=2u l=1u
X1617 a_60246_169943# a_66174_164929# a_60694_165043# VDD pfet_06v0 ad=2.2p pd=10.88u as=2.2p ps=10.88u w=5u l=1u
X1618 a_29246_187557# a_29246_187557# VSS VSS nfet_06v0 ad=0.44p pd=2.88u as=0.44p ps=2.88u w=1u l=1u
X1619 VDD VSS VDD VDD pfet_06v0 ad=4.29p pd=20.38u as=0 ps=0 w=9.75u l=2u
X1620 a_38286_187303# a_43102_182289# a_38738_182403# VDD pfet_06v0 ad=2.2p pd=10.88u as=2.2p ps=10.88u w=5u l=1u
X1621 a_73974_159564# a_74274_159564# a_86182_152822# VSS nfet_06v0 ad=0.44p pd=2.88u as=0.25p ps=1.5u w=1u l=1u
X1622 a_34750_190951# a_52560_157284# VDD VDD pfet_06v0 ad=0.44p pd=2.88u as=0.44p ps=2.88u w=1u l=1u
X1623 a_51646_128810# a_51986_135596# a_67534_135712# VDD pfet_06v0 ad=4.4p pd=20.88u as=2.5p ps=10.5u w=10u l=1u
X1624 a_55186_149156# a_58782_140870# a_55734_140914# VDD pfet_06v0 ad=1.76p pd=8.88u as=1.76p ps=8.88u w=4u l=1u
X1625 a_56658_169513# a_57822_169399# a_58022_169443# VSS nfet_06v0 ad=2.2p pd=10.88u as=1.3p ps=5.52u w=5u l=1u
X1626 VSS VDD VSS VSS nfet_06v0 ad=7.92p pd=36.88u as=0 ps=0 w=18u l=2u
X1627 a_46710_186803# a_38738_182403# VDD VDD pfet_06v0 ad=4.4p pd=20.88u as=2.6p ps=10.52u w=10u l=1u
X1628 a_57018_194537# a_35862_190951# a_59578_194467# VDD pfet_06v0 ad=4.4p pd=20.88u as=2.6p ps=10.52u w=10u l=1u
X1629 a_80202_194537# a_57822_190951# a_81646_194467# VDD pfet_06v0 ad=4.4p pd=20.88u as=2.6p ps=10.52u w=10u l=1u
X1630 VSS a_60246_187303# a_59578_182403# VSS nfet_06v0 ad=1.1p pd=5.88u as=0.65p ps=3.02u w=2.5u l=1u
X1631 a_96634_148656# a_96634_148656# VSS VSS nfet_06v0 ad=0.44p pd=2.88u as=0.44p ps=2.88u w=1u l=1u
X1632 VSS VDD VSS VSS nfet_06v0 ad=7.92p pd=36.88u as=0 ps=0 w=18u l=2u
X1633 a_66174_164929# a_52318_170197# a_67374_169513# VSS nfet_06v0 ad=2.2p pd=10.88u as=1.25p ps=5.5u w=5u l=1u
X1634 a_104146_184530# a_99096_185942# VSS VSS nfet_06v0 ad=0.5456p pd=3.36u as=0.5456p ps=3.36u w=1.24u l=1u
X1635 a_57326_152778# a_51986_159564# a_62062_159680# VDD pfet_06v0 ad=4.4p pd=20.88u as=2.5p ps=10.5u w=10u l=1u
X1636 a_92966_169443# a_84994_165043# VDD VDD pfet_06v0 ad=2.6p pd=10.52u as=4.4p ps=20.88u w=10u l=1u
X1637 a_98598_128854# a_100422_135712# VDD VDD pfet_06v0 ad=2.2p pd=10.88u as=2.2p ps=10.88u w=5u l=1u
X1638 a_52318_190953# a_52658_194421# a_52558_194537# VDD pfet_06v0 ad=4.4p pd=20.88u as=2.5p ps=10.5u w=10u l=1u
X1639 a_78498_187673# a_75842_182289# VSS VSS nfet_06v0 ad=0.25p pd=1.5u as=0.44p ps=2.88u w=1u l=1u
X1640 a_81646_177107# a_38998_149572# a_80202_177177# VDD pfet_06v0 ad=2.6p pd=10.52u as=4.4p ps=20.88u w=10u l=1u
X1641 a_59578_177107# a_35862_173591# a_57018_177177# VDD pfet_06v0 ad=2.6p pd=10.52u as=4.4p ps=20.88u w=10u l=1u
X1642 a_52358_177061# a_52658_177061# a_54282_173637# VSS nfet_06v0 ad=0.44p pd=2.88u as=0.25p ps=1.5u w=1u l=1u
X1643 a_82906_135712# a_82706_135596# VDD VDD pfet_06v0 ad=2.5p pd=10.5u as=4.4p ps=20.88u w=10u l=1u
X1644 a_38018_140870# a_29586_140870# a_38218_140914# VDD pfet_06v0 ad=3.3p pd=10.66u as=2.5p ps=10.5u w=10u l=1u
X1645 a_58022_169443# a_52658_164929# a_61810_165043# VDD pfet_06v0 ad=2.2p pd=10.88u as=1.3p ps=5.52u w=5u l=1u
X1646 VSS VDD VSS VSS nfet_06v0 ad=0.44p pd=2.88u as=0 ps=0 w=1u l=2u
X1647 a_73974_135596# a_74274_135596# a_86182_128854# VSS nfet_06v0 ad=0.44p pd=2.88u as=0.25p ps=1.5u w=1u l=1u
X1648 VDD a_61810_195467# a_69782_191067# VDD pfet_06v0 ad=2.6p pd=10.52u as=2.6p ps=10.52u w=10u l=1u
X1649 a_80202_182333# a_34750_186759# a_82762_182403# VDD pfet_06v0 ad=4.4p pd=20.88u as=2.6p ps=10.52u w=10u l=1u
X1650 VDD a_52358_194421# a_57350_194537# VDD pfet_06v0 ad=4.4p pd=20.88u as=2.5p ps=10.5u w=10u l=1u
X1651 a_110806_166742# a_46710_169443# VDD VDD pfet_06v0 ad=1.32p pd=6.88u as=1.32p ps=6.88u w=3u l=1u
X1652 VDD a_37622_178107# a_34950_173707# VDD pfet_06v0 ad=1.3p pd=5.52u as=1.3p ps=5.52u w=5u l=1u
X1653 a_69782_173707# a_61810_178107# VDD VDD pfet_06v0 ad=2.6p pd=10.52u as=4.4p ps=20.88u w=10u l=1u
X1654 a_38286_191067# a_29246_190953# a_35390_194467# VSS nfet_06v0 ad=0.65p pd=3.02u as=1.1p ps=5.88u w=2.5u l=1u
X1655 a_59134_191067# a_35862_190951# a_56658_190997# VSS nfet_06v0 ad=1.3p pd=5.52u as=2.2p ps=10.88u w=5u l=1u
X1656 a_75166_152822# a_73934_152778# VSS VSS nfet_06v0 ad=1.25p pd=5.5u as=2.2p ps=10.88u w=5u l=1u
X1657 a_23448_70736# a_23448_70736# a_102002_184626# VSS nfet_06v0 ad=0.52p pd=2.52u as=0.88p ps=4.88u w=2u l=1u
X1658 a_101360_186094# a_99096_185942# a_101060_186094# VSS nfet_06v0 ad=0.175p pd=1.2u as=0.175p ps=1.2u w=0.7u l=1u
X1659 a_55186_152778# a_51946_152778# a_54922_161580# VSS nfet_06v0 ad=1.1p pd=5.88u as=0.825p ps=3.16u w=2.5u l=1u
D75 S2P VDD diode_pd2nw_06v0 pj=40u area=99.99999p
X1660 a_53670_194537# a_52358_194421# VDD VDD pfet_06v0 ad=2.5p pd=10.5u as=4.4p ps=20.88u w=10u l=1u
X1661 a_62862_152822# a_51646_152778# VSS VSS nfet_06v0 ad=1.25p pd=5.5u as=2.2p ps=10.88u w=5u l=1u
X1662 a_83430_191067# a_75502_190953# a_82762_194467# VSS nfet_06v0 ad=0.65p pd=3.02u as=1.1p ps=5.88u w=2.5u l=1u
X1663 VDD a_69782_173707# a_114466_173580# VDD pfet_06v0 ad=1.32p pd=6.88u as=0.99p ps=3.66u w=3u l=1u
X1664 a_45346_173637# a_45146_173593# VSS VSS nfet_06v0 ad=1.25p pd=5.5u as=2.2p ps=10.88u w=5u l=1u
X1665 VSS a_92966_191067# a_100238_190984# VSS nfet_06v0 ad=0.44p pd=2.88u as=0.25p ps=1.5u w=1u l=1u
X1666 a_44302_186873# a_29978_186757# VSS VSS nfet_06v0 ad=1.25p pd=5.5u as=2.2p ps=10.88u w=5u l=1u
X1667 a_98798_140914# a_53710_128810# a_96874_140914# VDD pfet_06v0 ad=0.242p pd=1.98u as=0.242p ps=1.98u w=0.55u l=1u
X1668 a_29286_177061# a_29586_177061# a_32522_177177# VDD pfet_06v0 ad=4.4p pd=20.88u as=2.5p ps=10.5u w=10u l=1u
X1669 a_36506_177107# a_37174_173707# VSS VSS nfet_06v0 ad=0.65p pd=3.02u as=0.65p ps=3.02u w=2.5u l=1u
D76 VSS S2P diode_nd2ps_06v0 pj=40u area=99.99999p
X1670 a_54642_152822# a_23448_50576# a_52146_152822# VSS nfet_06v0 ad=3.74p pd=17.88u as=3.74p ps=17.88u w=8.5u l=1u
X1671 a_96874_159680# a_96674_159564# a_96574_159680# VDD pfet_06v0 ad=4.4p pd=20.88u as=2.5p ps=10.5u w=10u l=1u
X1672 a_33586_173637# a_35862_173591# a_36062_173707# VSS nfet_06v0 ad=2.2p pd=10.88u as=1.3p ps=5.52u w=5u l=1u
X1673 a_97566_152822# a_96334_152778# VSS VSS nfet_06v0 ad=1.25p pd=5.5u as=2.2p ps=10.88u w=5u l=1u
X1674 a_90994_194421# a_75842_194421# a_91194_194537# VDD pfet_06v0 ad=3.3p pd=10.66u as=2.5p ps=10.5u w=10u l=1u
X1675 a_77210_140914# a_77474_149156# VSS VSS nfet_06v0 ad=0.825p pd=3.16u as=1.1p ps=5.88u w=2.5u l=1u
X1676 a_104722_152822# a_104522_152778# VSS VSS nfet_06v0 ad=1.25p pd=5.5u as=2.2p ps=10.88u w=5u l=1u
X1677 a_31210_190997# a_29586_194421# VSS VSS nfet_06v0 ad=0.25p pd=1.5u as=0.44p ps=2.88u w=1u l=1u
X1678 a_34394_128854# a_36382_136796# a_30160_133316# VDD pfet_06v0 ad=1.76p pd=8.88u as=1.76p ps=8.88u w=4u l=1u
D77 S2N VDD diode_pd2nw_06v0 pj=40u area=99.99999p
X1679 a_29586_182289# a_29586_182289# VDD VDD pfet_06v0 ad=0.88p pd=4.88u as=0.88p ps=4.88u w=2u l=1u
X1680 a_79842_173637# a_38998_149572# a_81206_173707# VSS nfet_06v0 ad=2.2p pd=10.88u as=1.3p ps=5.52u w=5u l=1u
X1681 a_83878_178107# a_88894_173593# a_83430_173707# VSS nfet_06v0 ad=1.1p pd=5.88u as=1.1p ps=5.88u w=2.5u l=1u
X1682 a_106078_167126# a_114466_184098# VDD VDD pfet_06v0 ad=1.32p pd=6.88u as=1.32p ps=6.88u w=3u l=1u
X1683 a_52560_134666# a_57822_169399# VSS ppolyf_u_1k r_width=1u r_length=76.45u
X1684 a_75166_128854# a_73934_128810# VSS VSS nfet_06v0 ad=1.25p pd=5.5u as=2.2p ps=10.88u w=5u l=1u
X1685 VDD a_83878_165043# a_81206_169443# VDD pfet_06v0 ad=2.2p pd=10.88u as=1.3p ps=5.52u w=5u l=1u
X1686 a_23448_70736# a_23448_70736# VDD VDD pfet_06v0 ad=0.52p pd=2.52u as=0.88p ps=4.88u w=2u l=1u
X1687 a_55186_128810# a_51946_128810# a_54922_137612# VSS nfet_06v0 ad=1.1p pd=5.88u as=0.825p ps=3.16u w=2.5u l=1u
X1688 a_62862_128854# a_51646_128810# VSS VSS nfet_06v0 ad=1.25p pd=5.5u as=2.2p ps=10.88u w=5u l=1u
D78 Z VDD diode_pd2nw_06v0 pj=40u area=99.99999p
X1689 a_75502_170197# a_75842_164929# a_75742_164973# VDD pfet_06v0 ad=4.4p pd=20.88u as=2.5p ps=10.5u w=10u l=1u
X1690 a_88894_187257# a_88894_187257# a_91402_186757# VSS nfet_06v0 ad=2.2p pd=10.88u as=1.65p ps=5.66u w=5u l=1u
D79 VSS S2N diode_nd2ps_06v0 pj=40u area=99.99999p
X1691 a_34950_173707# a_34750_173591# a_33586_173637# VSS nfet_06v0 ad=1.3p pd=5.52u as=2.2p ps=10.88u w=5u l=1u
X1692 a_59134_173707# a_60694_178107# VDD VDD pfet_06v0 ad=1.3p pd=5.52u as=2.2p ps=10.88u w=5u l=1u
X1693 a_74848_143310# a_90266_143760# VSS ppolyf_u_1k r_width=1u r_length=76.45u
D80 Z VDD diode_pd2nw_06v0 pj=40u area=99.99999p
X1694 a_54642_128854# a_54442_128810# a_52146_128854# VSS nfet_06v0 ad=3.74p pd=17.88u as=3.74p ps=17.88u w=8.5u l=1u
X1695 a_36506_165043# a_29246_170197# a_37174_169943# VSS nfet_06v0 ad=1.1p pd=5.88u as=0.65p ps=3.02u w=2.5u l=1u
X1696 a_46382_177177# a_29286_177061# VDD VDD pfet_06v0 ad=2.5p pd=10.5u as=4.4p ps=20.88u w=10u l=1u
X1697 VSS VDD VSS VSS nfet_06v0 ad=0.44p pd=2.88u as=0 ps=0 w=1u l=2u
X1698 a_99046_175184# a_99096_173860# VSS VSS nfet_06v0 ad=0.5456p pd=3.36u as=0.5456p ps=3.36u w=1.24u l=1u
X1699 a_97566_128854# a_96334_128810# VSS VSS nfet_06v0 ad=1.25p pd=5.5u as=2.2p ps=10.88u w=5u l=1u
X1700 a_104722_128854# a_104522_128810# VSS VSS nfet_06v0 ad=1.25p pd=5.5u as=2.2p ps=10.88u w=5u l=1u
X1701 a_81646_177107# a_83430_173707# VSS VSS nfet_06v0 ad=0.65p pd=3.02u as=0.65p ps=3.02u w=2.5u l=1u
X1702 a_23448_70736# a_106078_184486# a_99296_185986# VSS nfet_06v0 ad=0.6448p pd=3u as=1.0912p ps=5.84u w=2.48u l=1u
X1703 a_57018_194537# a_57822_190951# a_58462_194467# VDD pfet_06v0 ad=4.4p pd=20.88u as=2.6p ps=10.52u w=10u l=1u
X1704 a_79842_186873# a_34750_186759# a_82318_186803# VSS nfet_06v0 ad=2.2p pd=10.88u as=1.3p ps=5.52u w=5u l=1u
X1705 a_47058_159680# a_29286_159564# VDD VDD pfet_06v0 ad=2.5p pd=10.5u as=4.4p ps=20.88u w=10u l=1u
X1706 VDD a_60694_195467# a_58022_191067# VDD pfet_06v0 ad=2.2p pd=10.88u as=1.3p ps=5.52u w=5u l=1u
X1707 a_83430_169943# a_89358_164929# a_83878_165043# VDD pfet_06v0 ad=2.2p pd=10.88u as=2.2p ps=10.88u w=5u l=1u
X1708 a_29586_194421# a_29586_194421# VDD VDD pfet_06v0 ad=0.88p pd=4.88u as=0.88p ps=4.88u w=2u l=1u
X1709 a_29486_135712# a_29286_135596# VDD VDD pfet_06v0 ad=2.5p pd=10.5u as=4.4p ps=20.88u w=10u l=1u
X1710 VSS VDD VSS VSS nfet_06v0 ad=0.44p pd=2.88u as=0 ps=0 w=1u l=2u
X1711 a_97248_143310# a_112666_143760# VSS ppolyf_u_1k r_width=1u r_length=76.45u
X1712 a_52658_194421# a_52658_194421# a_55314_190997# VSS nfet_06v0 ad=0.44p pd=2.88u as=0.25p ps=1.5u w=1u l=1u
X1713 a_36062_186803# a_35862_186759# a_33586_186873# VSS nfet_06v0 ad=1.3p pd=5.52u as=2.2p ps=10.88u w=5u l=1u
X1714 a_58022_173707# a_60694_178107# VDD VDD pfet_06v0 ad=1.3p pd=5.52u as=1.3p ps=5.52u w=5u l=1u
X1715 VDD a_29286_194421# a_34278_194537# VDD pfet_06v0 ad=4.4p pd=20.88u as=2.5p ps=10.5u w=10u l=1u
X1716 a_99096_185942# a_99096_185942# VDD VDD pfet_06v0 ad=0.88p pd=4.88u as=0.88p ps=4.88u w=2u l=1u
X1717 a_102104_168378# VDD a_23448_190688# VSS nfet_06v0 ad=1.0912p pd=5.84u as=0.6448p ps=3u w=2.48u l=1u
X1718 a_96634_152778# a_96634_152778# VSS VSS nfet_06v0 ad=0.44p pd=2.88u as=0.44p ps=2.88u w=1u l=1u
X1719 a_69458_159680# a_51686_159564# VDD VDD pfet_06v0 ad=2.5p pd=10.5u as=4.4p ps=20.88u w=10u l=1u
X1720 VSS a_83430_187303# a_82762_182403# VSS nfet_06v0 ad=1.1p pd=5.88u as=0.65p ps=3.02u w=2.5u l=1u
X1721 a_78022_159680# a_79614_152778# a_77474_152778# VSS nfet_06v0 ad=0.88p pd=4.88u as=0.88p ps=4.88u w=2u l=1u
X1722 a_30598_194537# a_29286_194421# VDD VDD pfet_06v0 ad=2.5p pd=10.5u as=4.4p ps=20.88u w=10u l=1u
X1723 a_30160_143310# a_38998_149572# VSS ppolyf_u_1k r_width=1u r_length=76.45u
X1724 VDD a_37622_178107# a_36062_173707# VDD pfet_06v0 ad=2.2p pd=10.88u as=1.3p ps=5.52u w=5u l=1u
X1725 a_81278_148772# a_73934_148656# VSS VSS nfet_06v0 ad=1.25p pd=5.5u as=2.2p ps=10.88u w=5u l=1u
X1726 a_81206_186803# a_75842_182289# a_84994_182403# VDD pfet_06v0 ad=2.2p pd=10.88u as=1.3p ps=5.52u w=5u l=1u
X1727 a_75542_177061# a_75842_177061# a_77466_173637# VSS nfet_06v0 ad=0.44p pd=2.88u as=0.25p ps=1.5u w=1u l=1u
X1728 a_33946_177177# a_29586_177061# a_33646_177177# VDD pfet_06v0 ad=3.3p pd=10.66u as=2.5p ps=10.5u w=10u l=1u
X1729 VDD a_84994_195467# a_92966_191067# VDD pfet_06v0 ad=2.6p pd=10.52u as=2.6p ps=10.52u w=10u l=1u
X1730 a_74474_159680# a_74274_159564# a_75286_159680# VDD pfet_06v0 ad=4.4p pd=20.88u as=2.5p ps=10.5u w=10u l=1u
D81 VSS S2P diode_nd2ps_06v0 pj=40u area=99.99999p
X1731 a_61810_165043# a_52658_164929# a_58022_169443# VDD pfet_06v0 ad=1.3p pd=5.52u as=2.2p ps=10.88u w=5u l=1u
X1732 a_73974_135596# a_74274_135596# a_91746_135712# VDD pfet_06v0 ad=4.4p pd=20.88u as=2.5p ps=10.5u w=10u l=1u
X1733 a_96634_128810# a_96634_128810# VSS VSS nfet_06v0 ad=0.44p pd=2.88u as=0.44p ps=2.88u w=1u l=1u
X1734 a_78022_135712# a_79614_128810# a_77474_128810# VSS nfet_06v0 ad=0.88p pd=4.88u as=0.88p ps=4.88u w=2u l=1u
X1735 VDD VSS VDD VDD pfet_06v0 ad=4.29p pd=20.38u as=0 ps=0 w=9.75u l=2u
X1736 a_82762_182403# a_34750_186759# a_80202_182333# VDD pfet_06v0 ad=2.6p pd=10.52u as=4.4p ps=20.88u w=10u l=1u
X1737 VSS VDD VSS VSS nfet_06v0 ad=7.92p pd=36.88u as=0 ps=0 w=18u l=2u
X1738 VSS VDD VSS VSS nfet_06v0 ad=0.44p pd=2.88u as=0 ps=0 w=1u l=2u
X1739 a_56658_173637# a_38998_149572# a_58022_173707# VSS nfet_06v0 ad=2.2p pd=10.88u as=1.3p ps=5.52u w=5u l=1u
X1740 a_76854_194537# a_75542_194421# VDD VDD pfet_06v0 ad=2.5p pd=10.5u as=4.4p ps=20.88u w=10u l=1u
X1741 VDD a_83878_178107# a_82318_173707# VDD pfet_06v0 ad=2.2p pd=10.88u as=1.3p ps=5.52u w=5u l=1u
X1742 a_58022_191067# a_52658_194421# a_61810_195467# VDD pfet_06v0 ad=2.2p pd=10.88u as=1.3p ps=5.52u w=5u l=1u
X1743 a_58462_194467# a_60246_191067# VSS VSS nfet_06v0 ad=0.65p pd=3.02u as=1.1p ps=5.88u w=2.5u l=1u
D82 VSS S2N diode_nd2ps_06v0 pj=40u area=99.99999p
X1744 a_65710_190953# a_52658_194421# a_69454_194537# VDD pfet_06v0 ad=4.4p pd=20.88u as=2.5p ps=10.5u w=10u l=1u
X1745 a_82318_169443# a_83878_165043# VDD VDD pfet_06v0 ad=1.3p pd=5.52u as=2.2p ps=10.88u w=5u l=1u
X1746 a_105106_140870# a_96674_140870# a_105306_140914# VDD pfet_06v0 ad=3.3p pd=10.66u as=2.5p ps=10.5u w=10u l=1u
X1747 a_57822_169399# a_53910_128854# cap_mim_2f0_m4m5_noshield c_width=25u c_length=8u
X1748 VSS VDD VSS VSS nfet_06v0 ad=0.44p pd=2.88u as=0 ps=0 w=1u l=2u
X1749 a_32242_170313# a_29586_164929# VSS VSS nfet_06v0 ad=0.25p pd=1.5u as=0.44p ps=2.88u w=1u l=1u
X1750 a_99296_173976# a_99096_173860# VSS VSS nfet_06v0 ad=0.5456p pd=3.36u as=0.5456p ps=3.36u w=1.24u l=1u
X1751 VSS a_37174_173707# a_36506_177107# VSS nfet_06v0 ad=0.65p pd=3.02u as=0.65p ps=3.02u w=2.5u l=1u
X1752 a_88710_140914# a_73974_140870# VDD VDD pfet_06v0 ad=2.5p pd=10.5u as=4.4p ps=20.88u w=10u l=1u
D83 S4N VDD diode_pd2nw_06v0 pj=40u area=99.99999p
X1753 VDD a_69782_169443# a_114466_166626# VDD pfet_06v0 ad=1.32p pd=6.88u as=0.99p ps=3.66u w=3u l=1u
X1754 a_56658_186873# a_35862_186759# a_59134_186803# VSS nfet_06v0 ad=2.2p pd=10.88u as=1.3p ps=5.52u w=5u l=1u
X1755 a_54110_140914# a_31310_152778# a_52186_140914# VDD pfet_06v0 ad=0.242p pd=1.98u as=0.242p ps=1.98u w=0.55u l=1u
X1756 a_58462_165043# a_60246_169943# VSS VSS nfet_06v0 ad=0.65p pd=3.02u as=0.65p ps=3.02u w=2.5u l=1u
X1757 a_45134_135712# a_29286_135596# VDD VDD pfet_06v0 ad=2.5p pd=10.5u as=4.4p ps=20.88u w=10u l=1u
D84 S4N VDD diode_pd2nw_06v0 pj=40u area=99.99999p
X1758 a_38998_149572# a_30160_145110# VDD VDD pfet_06v0 ad=0.44p pd=2.88u as=0.44p ps=2.88u w=1u l=1u
X1759 a_81206_169443# a_83878_165043# VDD VDD pfet_06v0 ad=1.3p pd=5.52u as=1.3p ps=5.52u w=5u l=1u
X1760 VDD VSS VDD VDD pfet_06v0 ad=0.44p pd=2.88u as=0 ps=0 w=1u l=2u
X1761 a_42638_169897# a_29586_164929# a_46382_164973# VDD pfet_06v0 ad=4.4p pd=20.88u as=2.5p ps=10.5u w=10u l=1u
X1762 a_57326_149256# a_57326_149256# a_59834_148656# VSS nfet_06v0 ad=2.2p pd=10.88u as=1.65p ps=5.66u w=5u l=1u
X1763 a_82706_159564# a_74274_159564# a_82906_159680# VDD pfet_06v0 ad=3.3p pd=10.66u as=2.5p ps=10.5u w=10u l=1u
X1764 a_51986_159564# a_51986_159564# VDD VDD pfet_06v0 ad=0.88p pd=4.88u as=0.88p ps=4.88u w=2u l=1u
D85 VSS Z diode_nd2ps_06v0 pj=40u area=99.99999p
X1765 VSS VDD VSS VSS nfet_06v0 ad=0.44p pd=2.88u as=0 ps=0 w=1u l=2u
X1766 a_52318_170197# a_52318_170197# VSS VSS nfet_06v0 ad=0.44p pd=2.88u as=0.44p ps=2.88u w=1u l=1u
X1767 a_67534_135712# a_51686_135596# VDD VDD pfet_06v0 ad=2.5p pd=10.5u as=4.4p ps=20.88u w=10u l=1u
X1768 a_23448_190688# a_100246_167126# a_100158_167170# VSS nfet_06v0 ad=0.6448p pd=3u as=1.0912p ps=5.84u w=2.48u l=1u
X1769 a_68010_182333# a_67810_182289# VDD VDD pfet_06v0 ad=2.5p pd=10.5u as=4.4p ps=20.88u w=10u l=1u
X1770 a_58022_186803# a_57822_186759# a_56658_186873# VSS nfet_06v0 ad=1.3p pd=5.52u as=2.2p ps=10.88u w=5u l=1u
X1771 a_82122_148656# a_74234_148656# a_82322_148772# VSS nfet_06v0 ad=1.65p pd=5.66u as=1.25p ps=5.5u w=5u l=1u
X1772 a_30160_145110# a_29586_140870# a_31510_148272# VDD pfet_06v0 ad=4.4p pd=20.88u as=4.4p ps=20.88u w=10u l=1u
X1773 VDD a_83878_195467# a_81206_191067# VDD pfet_06v0 ad=2.2p pd=10.88u as=1.3p ps=5.52u w=5u l=1u
X1774 a_101482_128854# a_103470_136796# a_97248_133316# VDD pfet_06v0 ad=1.76p pd=8.88u as=1.76p ps=8.88u w=4u l=1u
X1775 VSS a_114466_166626# a_104234_167126# VSS nfet_06v0 ad=0.44p pd=2.88u as=0.44p ps=2.88u w=1u l=1u
X1776 a_74848_144210# a_90266_143760# VSS ppolyf_u_1k r_width=1u r_length=76.45u
X1777 VSS VDD VSS VSS nfet_06v0 ad=7.92p pd=36.88u as=0 ps=0 w=18u l=2u
X1778 a_67374_169513# a_53050_169397# VSS VSS nfet_06v0 ad=1.25p pd=5.5u as=2.2p ps=10.88u w=5u l=1u
X1779 a_58462_194467# a_57822_190951# a_57018_194537# VDD pfet_06v0 ad=2.6p pd=10.52u as=4.4p ps=20.88u w=10u l=1u
X1780 VSS VDD VSS VSS nfet_06v0 ad=7.92p pd=36.88u as=0 ps=0 w=18u l=2u
X1781 a_52558_194537# a_52358_194421# VDD VDD pfet_06v0 ad=2.5p pd=10.5u as=4.4p ps=20.88u w=10u l=1u
X1782 VDD VSS VDD VDD pfet_06v0 ad=0.44p pd=2.88u as=0 ps=0 w=1u l=2u
X1783 VSS VDD VSS VSS nfet_06v0 ad=0.44p pd=2.88u as=0 ps=0 w=1u l=2u
X1784 a_111626_173580# a_92966_173707# VDD VDD pfet_06v0 ad=0.99p pd=3.66u as=1.32p ps=6.88u w=3u l=1u
X1785 a_82318_191067# a_34750_190951# a_79842_190997# VSS nfet_06v0 ad=1.3p pd=5.52u as=2.2p ps=10.88u w=5u l=1u
X1786 a_54282_173637# a_52658_177061# VSS VSS nfet_06v0 ad=0.25p pd=1.5u as=0.44p ps=2.88u w=1u l=1u
X1787 a_52560_145110# a_51986_140870# a_53910_148272# VDD pfet_06v0 ad=4.4p pd=20.88u as=4.4p ps=20.88u w=10u l=1u
X1788 a_38218_140914# a_38018_140870# VDD VDD pfet_06v0 ad=2.5p pd=10.5u as=4.4p ps=20.88u w=10u l=1u
X1789 a_56658_186873# a_52318_187557# a_56358_186873# VSS nfet_06v0 ad=1.65p pd=5.66u as=1.25p ps=5.5u w=5u l=1u
X1790 a_97248_144210# a_112666_143760# VSS ppolyf_u_1k r_width=1u r_length=76.45u
X1791 a_35862_190951# a_98598_152822# cap_mim_2f0_m4m5_noshield c_width=25u c_length=8u
X1792 VSS VDD VSS VSS nfet_06v0 ad=0.44p pd=2.88u as=0 ps=0 w=1u l=2u
X1793 a_23448_190688# VDD a_102104_168378# VSS nfet_06v0 ad=0.6448p pd=3u as=1.0912p ps=5.84u w=2.48u l=1u
X1794 a_57350_194537# a_52658_194421# a_57018_194537# VDD pfet_06v0 ad=2.5p pd=10.5u as=3.3p ps=10.66u w=10u l=1u
X1795 a_82762_182403# a_83430_187303# VSS VSS nfet_06v0 ad=0.65p pd=3.02u as=0.65p ps=3.02u w=2.5u l=1u
X1796 a_59578_182403# a_35862_186759# a_57018_182333# VDD pfet_06v0 ad=2.6p pd=10.52u as=4.4p ps=20.88u w=10u l=1u
X1797 a_81646_182403# a_57822_186759# a_80202_182333# VDD pfet_06v0 ad=2.6p pd=10.52u as=4.4p ps=20.88u w=10u l=1u
X1798 a_114146_159680# a_96374_159564# VDD VDD pfet_06v0 ad=2.5p pd=10.5u as=4.4p ps=20.88u w=10u l=1u
X1799 VSS a_53050_173593# a_56990_173637# VSS nfet_06v0 ad=2.2p pd=10.88u as=1.25p ps=5.5u w=5u l=1u
X1800 a_80202_177177# a_75842_177061# a_79902_177177# VDD pfet_06v0 ad=3.3p pd=10.66u as=2.5p ps=10.5u w=10u l=1u
X1801 a_36062_173707# a_37622_178107# VDD VDD pfet_06v0 ad=1.3p pd=5.52u as=1.3p ps=5.52u w=5u l=1u
X1802 a_34950_186803# a_37622_182403# VDD VDD pfet_06v0 ad=1.3p pd=5.52u as=1.3p ps=5.52u w=5u l=1u
X1803 a_74174_159680# a_73974_159564# VDD VDD pfet_06v0 ad=2.5p pd=10.5u as=4.4p ps=20.88u w=10u l=1u
X1804 a_43102_178061# a_29246_173593# a_44302_173637# VSS nfet_06v0 ad=2.2p pd=10.88u as=1.25p ps=5.5u w=5u l=1u
X1805 a_89358_195421# a_89358_195421# a_90994_194421# VDD pfet_06v0 ad=4.4p pd=20.88u as=3.3p ps=10.66u w=10u l=1u
X1806 a_77474_149156# a_74234_148656# a_77210_140914# VSS nfet_06v0 ad=1.1p pd=5.88u as=0.825p ps=3.16u w=2.5u l=1u
X1807 a_61810_195467# a_65710_190953# a_61358_191067# VSS nfet_06v0 ad=1.1p pd=5.88u as=1.1p ps=5.88u w=2.5u l=1u
X1808 a_100238_190984# a_98486_190984# a_99306_190940# VSS nfet_06v0 ad=0.25p pd=1.5u as=0.44p ps=2.88u w=1u l=1u
X1809 VSS a_46710_186803# a_115398_184214# VSS nfet_06v0 ad=0.44p pd=2.88u as=0.25p ps=1.5u w=1u l=1u
X1810 a_92966_191067# a_84994_195467# VDD VDD pfet_06v0 ad=2.6p pd=10.52u as=4.4p ps=20.88u w=10u l=1u
X1811 a_69782_186803# a_61810_182403# VDD VDD pfet_06v0 ad=2.6p pd=10.52u as=4.4p ps=20.88u w=10u l=1u
X1812 VDD VSS VDD VDD pfet_06v0 ad=7.92p pd=36.88u as=0 ps=0 w=18u l=2u
X1813 a_32522_177177# a_29286_177061# VDD VDD pfet_06v0 ad=2.5p pd=10.5u as=4.4p ps=20.88u w=10u l=1u
X1814 a_96574_159680# a_96374_159564# VDD VDD pfet_06v0 ad=2.5p pd=10.5u as=4.4p ps=20.88u w=10u l=1u
X1815 a_60694_165043# a_65710_169897# a_60246_169943# VSS nfet_06v0 ad=1.1p pd=5.88u as=1.1p ps=5.88u w=2.5u l=1u
X1816 VSS VDD VSS VSS nfet_06v0 ad=4.29p pd=20.38u as=0 ps=0 w=9.75u l=2u
X1817 VSS VDD VSS VSS nfet_06v0 ad=0.44p pd=2.88u as=0 ps=0 w=1u l=2u
X1818 VSS a_37174_191067# a_36506_194467# VSS nfet_06v0 ad=1.1p pd=5.88u as=0.65p ps=3.02u w=2.5u l=1u
X1819 VDD VSS VDD VDD pfet_06v0 ad=7.92p pd=36.88u as=0 ps=0 w=18u l=2u
X1820 a_51986_140870# a_51986_140870# VDD VDD pfet_06v0 ad=0.88p pd=4.88u as=0.88p ps=4.88u w=2u l=1u
X1821 VSS a_60246_173707# a_59578_177107# VSS nfet_06v0 ad=1.1p pd=5.88u as=0.65p ps=3.02u w=2.5u l=1u
X1822 VSS VDD VSS VSS nfet_06v0 ad=7.92p pd=36.88u as=0 ps=0 w=18u l=2u
X1823 a_51946_152778# a_51986_159564# a_66422_159680# VDD pfet_06v0 ad=4.4p pd=20.88u as=2.5p ps=10.5u w=10u l=1u
X1824 a_61810_195467# a_52658_194421# a_58022_191067# VDD pfet_06v0 ad=1.3p pd=5.52u as=2.2p ps=10.88u w=5u l=1u
X1825 a_35862_186759# a_30160_157284# VDD VDD pfet_06v0 ad=0.44p pd=2.88u as=0.44p ps=2.88u w=1u l=1u
X1826 a_81646_177107# a_92966_173707# cap_mim_2f0_m4m5_noshield c_width=20u c_length=10u
X1827 a_44938_182333# a_44738_182289# VDD VDD pfet_06v0 ad=2.5p pd=10.5u as=4.4p ps=20.88u w=10u l=1u
X1828 a_34394_149272# a_36382_140870# a_30160_145110# VDD pfet_06v0 ad=1.76p pd=8.88u as=1.76p ps=8.88u w=4u l=1u
X1829 a_75742_164973# a_75542_164929# VDD VDD pfet_06v0 ad=2.5p pd=10.5u as=4.4p ps=20.88u w=10u l=1u
X1830 a_66174_164929# a_66174_164929# a_67810_164929# VDD pfet_06v0 ad=4.4p pd=20.88u as=3.3p ps=10.66u w=10u l=1u
X1831 a_57822_169399# a_52560_133316# VDD VDD pfet_06v0 ad=0.44p pd=2.88u as=0.44p ps=2.88u w=1u l=1u
X1832 a_65710_173593# a_65710_173593# a_68218_173593# VSS nfet_06v0 ad=2.2p pd=10.88u as=1.65p ps=5.66u w=5u l=1u
X1833 a_101060_173976# a_99096_173860# a_100760_173976# VSS nfet_06v0 ad=0.175p pd=1.2u as=0.175p ps=1.2u w=0.7u l=1u
X1834 VSS VDD VSS VSS nfet_06v0 ad=0.44p pd=2.88u as=0 ps=0 w=1u l=2u
X1835 a_82318_191067# a_83878_195467# VDD VDD pfet_06v0 ad=1.3p pd=5.52u as=2.2p ps=10.88u w=5u l=1u
X1836 a_53050_186757# a_52658_182289# a_53670_182333# VDD pfet_06v0 ad=4.4p pd=20.88u as=2.5p ps=10.5u w=10u l=1u
X1837 VSS a_60246_169943# a_58462_165043# VSS nfet_06v0 ad=0.65p pd=3.02u as=0.65p ps=3.02u w=2.5u l=1u
X1838 VDD VSS VDD VDD pfet_06v0 ad=0.44p pd=2.88u as=0 ps=0 w=1u l=2u
X1839 a_36382_136796# a_36382_136796# a_38018_135596# VDD pfet_06v0 ad=4.4p pd=20.88u as=3.3p ps=10.66u w=10u l=1u
X1840 a_33334_159680# a_29586_159564# a_32242_152822# VDD pfet_06v0 ad=4.4p pd=20.88u as=4.4p ps=20.88u w=10u l=1u
X1841 a_55314_190997# a_52658_194421# VSS VSS nfet_06v0 ad=0.25p pd=1.5u as=0.44p ps=2.88u w=1u l=1u
X1842 a_61358_173707# a_66174_178061# a_61810_178107# VDD pfet_06v0 ad=2.2p pd=10.88u as=2.2p ps=10.88u w=5u l=1u
X1843 a_34278_194537# a_29586_194421# a_33946_194537# VDD pfet_06v0 ad=2.5p pd=10.5u as=3.3p ps=10.66u w=10u l=1u
X1844 a_53910_152822# a_55734_159680# VDD VDD pfet_06v0 ad=2.2p pd=10.88u as=2.2p ps=10.88u w=5u l=1u
X1845 a_59578_182403# a_52318_187557# a_60246_187303# VSS nfet_06v0 ad=1.1p pd=5.88u as=0.65p ps=3.02u w=2.5u l=1u
D86 VSS S4P diode_nd2ps_06v0 pj=40u area=99.99999p
X1846 a_81206_191067# a_83878_195467# VDD VDD pfet_06v0 ad=1.3p pd=5.52u as=1.3p ps=5.52u w=5u l=1u
X1847 VSS a_92966_173707# a_112558_173624# VSS nfet_06v0 ad=0.44p pd=2.88u as=0.25p ps=1.5u w=1u l=1u
X1848 a_59578_194467# a_60246_191067# VSS VSS nfet_06v0 ad=0.65p pd=3.02u as=0.65p ps=3.02u w=2.5u l=1u
X1849 a_29586_140870# a_29586_140870# a_42526_149572# VSS nfet_06v0 ad=0.44p pd=2.88u as=0.25p ps=1.5u w=1u l=1u
X1850 a_77466_173637# a_75842_177061# VSS VSS nfet_06v0 ad=0.25p pd=1.5u as=0.44p ps=2.88u w=1u l=1u
X1851 a_37174_173707# a_43102_178061# a_37622_178107# VDD pfet_06v0 ad=2.2p pd=10.88u as=2.2p ps=10.88u w=5u l=1u
X1852 a_37622_165043# a_42638_169897# a_37174_169943# VSS nfet_06v0 ad=1.1p pd=5.88u as=1.1p ps=5.88u w=2.5u l=1u
X1853 a_33646_177177# a_29286_177061# VDD VDD pfet_06v0 ad=2.5p pd=10.5u as=4.4p ps=20.88u w=10u l=1u
X1854 a_75286_159680# a_73974_159564# VDD VDD pfet_06v0 ad=2.5p pd=10.5u as=4.4p ps=20.88u w=10u l=1u
X1855 VDD VSS VDD VDD pfet_06v0 ad=0.44p pd=2.88u as=0 ps=0 w=1u l=2u
X1856 a_91746_135712# a_73974_135596# VDD VDD pfet_06v0 ad=2.5p pd=10.5u as=4.4p ps=20.88u w=10u l=1u
X1857 a_29286_140870# a_29586_140870# a_47058_140914# VDD pfet_06v0 ad=4.4p pd=20.88u as=2.5p ps=10.5u w=10u l=1u
X1858 a_111626_166626# a_92966_169443# VDD VDD pfet_06v0 ad=0.99p pd=3.66u as=1.32p ps=6.88u w=3u l=1u
X1859 a_51986_140870# a_51986_140870# a_64926_149572# VSS nfet_06v0 ad=0.44p pd=2.88u as=0.25p ps=1.5u w=1u l=1u
X1860 a_29246_152778# a_29586_159564# a_45134_159680# VDD pfet_06v0 ad=4.4p pd=20.88u as=2.5p ps=10.5u w=10u l=1u
X1861 VSS a_37174_187303# a_35390_182403# VSS nfet_06v0 ad=1.1p pd=5.88u as=0.65p ps=3.02u w=2.5u l=1u
X1862 a_84994_195467# a_88894_190953# a_84542_191067# VSS nfet_06v0 ad=1.1p pd=5.88u as=1.1p ps=5.88u w=2.5u l=1u
X1863 VDD a_37622_182403# a_34950_186803# VDD pfet_06v0 ad=1.3p pd=5.52u as=1.3p ps=5.52u w=5u l=1u
X1864 a_29286_164929# a_29586_164929# a_32522_164973# VDD pfet_06v0 ad=4.4p pd=20.88u as=2.5p ps=10.5u w=10u l=1u
X1865 a_100158_175184# a_99096_173860# VSS VSS nfet_06v0 ad=0.5456p pd=3.36u as=0.5456p ps=3.36u w=1.24u l=1u
X1866 VSS VDD VSS VSS nfet_06v0 ad=0.44p pd=2.88u as=0 ps=0 w=1u l=2u
X1867 a_45146_169397# a_29246_170197# a_45346_169513# VSS nfet_06v0 ad=1.65p pd=5.66u as=1.25p ps=5.5u w=5u l=1u
X1868 a_69454_194537# a_52358_194421# VDD VDD pfet_06v0 ad=2.5p pd=10.5u as=4.4p ps=20.88u w=10u l=1u
X1869 a_105306_140914# a_105106_140870# VDD VDD pfet_06v0 ad=2.5p pd=10.5u as=4.4p ps=20.88u w=10u l=1u
X1870 a_58782_140870# a_58782_140870# a_60418_140870# VDD pfet_06v0 ad=4.4p pd=20.88u as=3.3p ps=10.66u w=10u l=1u
X1871 a_42638_173593# a_42638_173593# a_45146_173593# VSS nfet_06v0 ad=2.2p pd=10.88u as=1.65p ps=5.66u w=5u l=1u
X1872 a_52560_144210# a_67978_144660# VSS ppolyf_u_1k r_width=1u r_length=76.45u
X1873 a_34926_149256# a_29586_140870# a_39662_140914# VDD pfet_06v0 ad=4.4p pd=20.88u as=2.5p ps=10.5u w=10u l=1u
X1874 a_79902_177177# a_75542_177061# VDD VDD pfet_06v0 ad=2.5p pd=10.5u as=4.4p ps=20.88u w=10u l=1u
X1875 a_29978_186757# a_29586_182289# a_30598_182333# VDD pfet_06v0 ad=4.4p pd=20.88u as=2.5p ps=10.5u w=10u l=1u
X1876 a_34950_173707# a_29586_177061# a_38738_178107# VDD pfet_06v0 ad=2.2p pd=10.88u as=1.3p ps=5.52u w=5u l=1u
X1877 a_97248_133316# a_96674_135596# a_98598_128854# VDD pfet_06v0 ad=4.4p pd=20.88u as=4.4p ps=20.88u w=10u l=1u
X1878 a_38738_182403# a_42638_187257# a_38286_187303# VSS nfet_06v0 ad=1.1p pd=5.88u as=1.1p ps=5.88u w=2.5u l=1u
X1879 a_81646_182403# a_92966_186803# cap_mim_2f0_m4m5_noshield c_width=20u c_length=10u
D87 S4P VDD diode_pd2nw_06v0 pj=40u area=99.99999p
X1880 VSS a_83430_173707# a_82762_177107# VSS nfet_06v0 ad=1.1p pd=5.88u as=0.65p ps=3.02u w=2.5u l=1u
X1881 a_81206_186803# a_57822_186759# a_79842_186873# VSS nfet_06v0 ad=1.3p pd=5.52u as=2.2p ps=10.88u w=5u l=1u
X1882 VSS a_69782_186803# a_106078_184486# VSS nfet_06v0 ad=0.44p pd=2.88u as=0.33p ps=1.66u w=1u l=1u
X1883 a_77474_128810# a_81070_136796# a_78022_135712# VDD pfet_06v0 ad=1.76p pd=8.88u as=1.76p ps=8.88u w=4u l=1u
X1884 a_35390_182403# a_37174_187303# VSS VSS nfet_06v0 ad=0.65p pd=3.02u as=1.1p ps=5.88u w=2.5u l=1u
X1885 a_46382_164973# a_29286_164929# VDD VDD pfet_06v0 ad=2.5p pd=10.5u as=4.4p ps=20.88u w=10u l=1u
X1886 a_30160_133766# a_45578_133316# VSS ppolyf_u_1k r_width=1u r_length=76.45u
X1887 VSS a_61358_169943# a_69782_169443# VSS nfet_06v0 ad=1.3p pd=5.52u as=1.3p ps=5.52u w=5u l=1u
X1888 a_77210_161580# a_77474_152778# VSS VSS nfet_06v0 ad=0.825p pd=3.16u as=1.1p ps=5.88u w=2.5u l=1u
X1889 a_99046_167170# a_99096_168582# VSS VSS nfet_06v0 ad=0.5456p pd=3.36u as=0.5456p ps=3.36u w=1.24u l=1u
X1890 VDD a_110806_173624# a_111626_173580# VDD pfet_06v0 ad=1.32p pd=6.88u as=0.99p ps=3.66u w=3u l=1u
X1891 a_82322_148772# a_82122_148656# VSS VSS nfet_06v0 ad=1.25p pd=5.5u as=2.2p ps=10.88u w=5u l=1u
X1892 a_59134_186803# a_60694_182403# VDD VDD pfet_06v0 ad=1.3p pd=5.52u as=2.2p ps=10.88u w=5u l=1u
X1893 a_76234_186757# a_75842_182289# a_76854_182333# VDD pfet_06v0 ad=4.4p pd=20.88u as=2.5p ps=10.5u w=10u l=1u
X1894 VSS VDD VSS VSS nfet_06v0 ad=7.92p pd=36.88u as=0 ps=0 w=18u l=2u
X1895 VSS a_83430_169943# a_81646_165043# VSS nfet_06v0 ad=0.65p pd=3.02u as=0.65p ps=3.02u w=2.5u l=1u
X1896 a_81646_194467# a_92966_191067# cap_mim_2f0_m4m5_noshield c_width=20u c_length=10u
X1897 a_57018_194537# a_52658_194421# a_56718_194537# VDD pfet_06v0 ad=3.3p pd=10.66u as=2.5p ps=10.5u w=10u l=1u
X1898 VDD VSS VDD VDD pfet_06v0 ad=4.29p pd=20.38u as=0 ps=0 w=9.75u l=2u
X1899 VSS VDD VSS VSS nfet_06v0 ad=7.92p pd=36.88u as=0 ps=0 w=18u l=2u
X1900 a_99046_167170# a_99134_167126# a_23448_190688# VSS nfet_06v0 ad=1.0912p pd=5.84u as=0.6448p ps=3u w=2.48u l=1u
X1901 a_101482_149272# a_103470_140870# a_97248_145110# VDD pfet_06v0 ad=1.76p pd=8.88u as=1.76p ps=8.88u w=4u l=1u
X1902 a_52186_135712# a_51986_135596# a_51886_135712# VDD pfet_06v0 ad=4.4p pd=20.88u as=2.5p ps=10.5u w=10u l=1u
X1903 a_77210_137612# a_77474_128810# VSS VSS nfet_06v0 ad=0.825p pd=3.16u as=1.1p ps=5.88u w=2.5u l=1u
X1904 VSS VDD VSS VSS nfet_06v0 ad=7.92p pd=36.88u as=0 ps=0 w=18u l=2u
X1905 a_30160_158634# a_35862_186759# VSS ppolyf_u_1k r_width=1u r_length=76.45u
X1906 a_56358_186873# a_53050_186757# VSS VSS nfet_06v0 ad=1.25p pd=5.5u as=2.2p ps=10.88u w=5u l=1u
X1907 a_82762_182403# a_75502_187557# a_83430_187303# VSS nfet_06v0 ad=1.1p pd=5.88u as=0.65p ps=3.02u w=2.5u l=1u
X1908 VDD VSS VDD VDD pfet_06v0 ad=4.29p pd=20.38u as=0 ps=0 w=9.75u l=2u
X1909 VDD VSS VDD VDD pfet_06v0 ad=0.44p pd=2.88u as=0 ps=0 w=1u l=2u
X1910 a_98798_137602# a_23448_31424# a_96874_135712# VDD pfet_06v0 ad=0.242p pd=1.98u as=0.242p ps=1.98u w=0.55u l=1u
X1911 a_34750_173591# a_98598_128854# cap_mim_2f0_m4m5_noshield c_width=25u c_length=8u
X1912 a_58022_186803# a_60694_182403# VDD VDD pfet_06v0 ad=1.3p pd=5.52u as=1.3p ps=5.52u w=5u l=1u
X1913 a_84542_187303# a_89358_182289# a_84994_182403# VDD pfet_06v0 ad=2.2p pd=10.88u as=2.2p ps=10.88u w=5u l=1u
X1914 a_29586_159564# a_29586_159564# a_42526_152822# VSS nfet_06v0 ad=0.44p pd=2.88u as=0.25p ps=1.5u w=1u l=1u
X1915 a_37174_187303# a_29246_187557# a_36506_182403# VSS nfet_06v0 ad=0.65p pd=3.02u as=1.1p ps=5.88u w=2.5u l=1u
X1916 a_74848_157284# a_79614_152778# a_79082_152822# VSS nfet_06v0 ad=0.88p pd=4.88u as=0.88p ps=4.88u w=2u l=1u
X1917 a_33946_164973# a_29586_164929# a_33646_164973# VDD pfet_06v0 ad=3.3p pd=10.66u as=2.5p ps=10.5u w=10u l=1u
X1918 VDD a_37622_182403# a_36062_186803# VDD pfet_06v0 ad=2.2p pd=10.88u as=1.3p ps=5.52u w=5u l=1u
X1919 VDD VSS VDD VDD pfet_06v0 ad=7.92p pd=36.88u as=0 ps=0 w=18u l=2u
X1920 VSS a_60246_191067# a_59578_194467# VSS nfet_06v0 ad=0.65p pd=3.02u as=0.65p ps=3.02u w=2.5u l=1u
X1921 a_59134_169443# a_52658_164929# a_60694_165043# VDD pfet_06v0 ad=2.2p pd=10.88u as=1.3p ps=5.52u w=5u l=1u
X1922 XN_OUT a_102380_164960# VSS VSS nfet_05v0 ad=0.5808p pd=3.52u as=0.5808p ps=3.52u w=1.32u l=0.6u
X1923 a_44302_173637# a_29978_173593# VSS VSS nfet_06v0 ad=1.25p pd=5.5u as=2.2p ps=10.88u w=5u l=1u
X1924 a_100422_159680# a_96674_159564# a_99330_152822# VDD pfet_06v0 ad=4.4p pd=20.88u as=4.4p ps=20.88u w=10u l=1u
X1925 a_29746_152822# a_29546_152778# a_29446_152822# VSS nfet_06v0 ad=2.2p pd=10.88u as=1.25p ps=5.5u w=5u l=1u
X1926 Z a_23448_70736# VDD ppolyf_u r_width=16u r_length=4u
X1927 a_115398_184214# a_69782_186803# a_114466_184098# VSS nfet_06v0 ad=0.25p pd=1.5u as=0.44p ps=2.88u w=1u l=1u
X1928 a_52146_148772# a_51946_148656# a_52878_148772# VSS nfet_06v0 ad=2.2p pd=10.88u as=1.25p ps=5.5u w=5u l=1u
X1929 a_36382_160764# a_29546_152778# a_36590_152822# VSS nfet_06v0 ad=2.2p pd=10.88u as=1.25p ps=5.5u w=5u l=1u
X1930 a_51986_159564# a_51986_159564# a_64926_152822# VSS nfet_06v0 ad=0.44p pd=2.88u as=0.25p ps=1.5u w=1u l=1u
X1931 a_29586_182289# a_29586_182289# a_32242_187673# VSS nfet_06v0 ad=0.44p pd=2.88u as=0.25p ps=1.5u w=1u l=1u
X1932 a_44022_159680# a_29286_159564# VDD VDD pfet_06v0 ad=2.5p pd=10.5u as=4.4p ps=20.88u w=10u l=1u
X1933 a_32522_140914# a_32042_128810# a_29786_140914# VDD pfet_06v0 ad=0.22p pd=1.88u as=0.22p ps=1.88u w=0.5u l=1u
X1934 a_36062_173707# a_29586_177061# a_37622_178107# VDD pfet_06v0 ad=2.2p pd=10.88u as=1.3p ps=5.52u w=5u l=1u
X1935 a_75502_173593# a_75502_173593# VSS VSS nfet_06v0 ad=0.44p pd=2.88u as=0.44p ps=2.88u w=1u l=1u
X1936 VDD a_98486_190984# a_99306_190940# VDD pfet_06v0 ad=1.32p pd=6.88u as=0.99p ps=3.66u w=3u l=1u
X1937 a_100158_167170# a_99096_168582# VSS VSS nfet_06v0 ad=0.5456p pd=3.36u as=0.5456p ps=3.36u w=1.24u l=1u
X1938 a_77210_137612# a_32042_152778# a_74474_135712# VDD pfet_06v0 ad=0.22p pd=1.88u as=0.22p ps=1.88u w=0.5u l=1u
X1939 a_29586_135596# a_29586_135596# a_42526_128854# VSS nfet_06v0 ad=0.44p pd=2.88u as=0.25p ps=1.5u w=1u l=1u
X1940 a_52318_187557# a_52658_182289# a_52558_182333# VDD pfet_06v0 ad=4.4p pd=20.88u as=2.5p ps=10.5u w=10u l=1u
X1941 a_74848_133316# a_79614_128810# a_79082_128854# VSS nfet_06v0 ad=0.88p pd=4.88u as=0.88p ps=4.88u w=2u l=1u
X1942 a_35862_173591# a_56794_149272# VSS VSS nfet_06v0 ad=0.44p pd=2.88u as=0.44p ps=2.88u w=1u l=1u
X1943 a_58782_160764# a_51946_152778# a_58990_152822# VSS nfet_06v0 ad=2.2p pd=10.88u as=1.25p ps=5.5u w=5u l=1u
X1944 a_88894_173593# a_88894_173593# a_91402_173593# VSS nfet_06v0 ad=2.2p pd=10.88u as=1.65p ps=5.66u w=5u l=1u
X1945 a_66422_159680# a_51686_159564# VDD VDD pfet_06v0 ad=2.5p pd=10.5u as=4.4p ps=20.88u w=10u l=1u
X1946 a_89358_195421# a_75502_190953# a_90558_190997# VSS nfet_06v0 ad=2.2p pd=10.88u as=1.25p ps=5.5u w=5u l=1u
X1947 a_55186_152778# a_58782_160764# a_55734_159680# VDD pfet_06v0 ad=1.76p pd=8.88u as=1.76p ps=8.88u w=4u l=1u
X1948 a_74848_134666# a_90266_134216# VSS ppolyf_u_1k r_width=1u r_length=76.45u
X1949 VSS VDD VSS VSS nfet_06v0 ad=7.92p pd=36.88u as=0 ps=0 w=18u l=2u
X1950 a_29746_128854# a_29546_128810# a_29446_128854# VSS nfet_06v0 ad=2.2p pd=10.88u as=1.25p ps=5.5u w=5u l=1u
X1951 VDD a_83878_182403# a_82318_186803# VDD pfet_06v0 ad=2.2p pd=10.88u as=1.3p ps=5.52u w=5u l=1u
X1952 a_34750_186759# a_74848_145110# VDD VDD pfet_06v0 ad=0.44p pd=2.88u as=0.44p ps=2.88u w=1u l=1u
X1953 a_36382_136796# a_29546_128810# a_36590_128854# VSS nfet_06v0 ad=2.2p pd=10.88u as=1.25p ps=5.5u w=5u l=1u
X1954 a_99296_168626# a_99096_168582# VSS VSS nfet_06v0 ad=0.5456p pd=3.36u as=0.5456p ps=3.36u w=1.24u l=1u
X1955 a_33586_190997# a_34750_190951# a_34950_191067# VSS nfet_06v0 ad=2.2p pd=10.88u as=1.3p ps=5.52u w=5u l=1u
X1956 a_78022_135712# a_74274_135596# a_76930_128854# VDD pfet_06v0 ad=4.4p pd=20.88u as=4.4p ps=20.88u w=10u l=1u
X1957 a_51986_135596# a_51986_135596# a_64926_128854# VSS nfet_06v0 ad=0.44p pd=2.88u as=0.25p ps=1.5u w=1u l=1u
X1958 VDD a_52358_182289# a_57350_182333# VDD pfet_06v0 ad=4.4p pd=20.88u as=2.5p ps=10.5u w=10u l=1u
X1959 a_96374_140870# a_96674_140870# a_114146_140914# VDD pfet_06v0 ad=4.4p pd=20.88u as=2.5p ps=10.5u w=10u l=1u
X1960 a_74474_140914# a_74274_140870# a_74174_140914# VDD pfet_06v0 ad=4.4p pd=20.88u as=2.5p ps=10.5u w=10u l=1u
X1961 VSS a_29978_169397# a_33918_169513# VSS nfet_06v0 ad=2.2p pd=10.88u as=1.25p ps=5.5u w=5u l=1u
X1962 a_52560_145110# a_67978_144660# VSS ppolyf_u_1k r_width=1u r_length=76.45u
X1963 a_96334_152778# a_96674_159564# a_112222_159680# VDD pfet_06v0 ad=4.4p pd=20.88u as=2.5p ps=10.5u w=10u l=1u
X1964 a_52560_157734# a_67978_157284# VSS ppolyf_u_1k r_width=1u r_length=76.45u
X1965 a_100760_173976# a_99096_173860# VSS VSS nfet_06v0 ad=0.175p pd=1.2u as=0.308p ps=2.28u w=0.7u l=1u
X1966 VSS a_83430_191067# a_81646_194467# VSS nfet_06v0 ad=1.1p pd=5.88u as=0.65p ps=3.02u w=2.5u l=1u
X1967 a_29786_135712# a_29586_135596# a_30598_135712# VDD pfet_06v0 ad=4.4p pd=20.88u as=2.5p ps=10.5u w=10u l=1u
X1968 a_97248_134666# a_112666_134216# VSS ppolyf_u_1k r_width=1u r_length=76.45u
X1969 a_54110_161570# a_34750_190951# cap_mim_2f0_m4m5_noshield c_width=25u c_length=8u
X1970 VDD a_69782_173707# a_113914_175036# VDD pfet_06v0 ad=1.32p pd=6.88u as=0.75p ps=3.5u w=3u l=1u
X1971 a_82762_177107# a_83430_173707# VSS VSS nfet_06v0 ad=0.65p pd=3.02u as=0.65p ps=3.02u w=2.5u l=1u
X1972 a_53670_182333# a_52358_182289# VDD VDD pfet_06v0 ad=2.5p pd=10.5u as=4.4p ps=20.88u w=10u l=1u
X1973 a_58782_136796# a_51946_128810# a_58990_128854# VSS nfet_06v0 ad=2.2p pd=10.88u as=1.25p ps=5.5u w=5u l=1u
X1974 a_69782_169443# a_61358_169943# VSS VSS nfet_06v0 ad=1.3p pd=5.52u as=2.2p ps=10.88u w=5u l=1u
X1975 a_102014_149256# a_96674_140870# a_106750_140914# VDD pfet_06v0 ad=4.4p pd=20.88u as=2.5p ps=10.5u w=10u l=1u
X1976 a_52186_135712# a_51986_135596# a_52998_135712# VDD pfet_06v0 ad=4.4p pd=20.88u as=2.5p ps=10.5u w=10u l=1u
X1977 a_30160_133766# a_45578_134216# VSS ppolyf_u_1k r_width=1u r_length=76.45u
X1978 a_31710_140914# a_32786_149156# VSS VSS nfet_06v0 ad=0.825p pd=3.16u as=1.1p ps=5.88u w=2.5u l=1u
.ends
