* NGSPICE file created from B26_A.ext - technology: gf180mcuD

.subckt B26_A S1N S1P S2N S2P S3N S3P S4N S4P VDD VSS X XN_IN XN_OUT XP_IN XP_OUT
+ Y YN_IN YN_OUT YP_IN YP_OUT Z ZN_IN ZN_OUT ZP_IN ZP_OUT
X0 a_52560_157284# a_67978_157284# VSS ppolyf_u_1k r_width=1u r_length=76.45u
X1 a_60034_140838# a_59834_140794# VSS VSS nfet_06v0 ad=1.25p pd=5.5u as=2.2p ps=10.88u w=5u l=1u
X2 a_99296_173976# a_106078_175068# a_23448_131216# VSS nfet_06v0 ad=1.0912p pd=5.84u as=0.6448p ps=3u w=2.48u l=1u
X3 a_112558_173624# a_110806_173624# a_111626_173580# VSS nfet_06v0 ad=0.25p pd=1.5u as=0.44p ps=2.88u w=1u l=1u
X4 a_73934_140794# a_74234_140794# a_85150_140838# VSS nfet_06v0 ad=2.2p pd=10.88u as=1.25p ps=5.5u w=5u l=1u
X5 a_99096_182484# a_99096_182484# VDD VDD pfet_06v0 ad=0.88p pd=4.88u as=0.88p ps=4.88u w=2u l=1u
X6 a_73934_128810# a_74274_135596# a_89822_135712# VDD pfet_06v0 ad=4.4p pd=20.88u as=2.5p ps=10.5u w=10u l=1u
X7 a_91602_182373# a_91402_182329# VSS VSS nfet_06v0 ad=1.25p pd=5.5u as=2.2p ps=10.88u w=5u l=1u
X8 a_36506_185843# a_29246_182329# a_37174_182443# VSS nfet_06v0 ad=1.1p pd=5.88u as=0.65p ps=3.02u w=2.5u l=1u
X9 VSS VDD VSS VSS nfet_06v0 ad=7.92p pd=36.88u as=1.23306n ps=6.04388m w=18u l=2u
X10 a_102014_140794# a_102014_140794# a_104522_140794# VSS nfet_06v0 ad=2.2p pd=10.88u as=1.65p ps=5.66u w=5u l=1u
X11 VSS a_38286_191067# a_46710_191067# VSS nfet_06v0 ad=1.3p pd=5.52u as=1.3p ps=5.52u w=5u l=1u
X12 VDD a_60694_186843# a_59134_182443# VDD pfet_06v0 ad=2.2p pd=10.88u as=1.3p ps=5.52u w=5u l=1u
X13 a_38998_140838# a_30160_145300# VDD VDD pfet_06v0 ad=0.44p pd=2.88u as=0.44p ps=2.88u w=1u l=1u
X14 a_79614_152778# a_74274_159564# a_84350_159680# VDD pfet_06v0 ad=4.4p pd=20.88u as=2.5p ps=10.5u w=10u l=1u
X15 a_79842_182373# a_34750_182327# a_82318_182443# VSS nfet_06v0 ad=2.2p pd=10.88u as=1.3p ps=5.52u w=5u l=1u
X16 a_31710_149586# a_38998_140838# cap_mim_2f0_m4m5_noshield c_width=25u c_length=8u
X17 VDD VSS VDD VDD pfet_06v0 ad=4.29p pd=20.38u as=1.86749n ps=8.9035m w=9.75u l=2u
X18 a_31210_165013# a_29586_168437# VSS VSS nfet_06v0 ad=0.25p pd=1.5u as=0.44p ps=2.88u w=1u l=1u
X19 VSS a_61358_173707# a_69782_173707# VSS nfet_06v0 ad=1.3p pd=5.52u as=1.3p ps=5.52u w=5u l=1u
X20 a_53250_182373# a_53050_182329# VSS VSS nfet_06v0 ad=1.25p pd=5.5u as=2.2p ps=10.88u w=5u l=1u
X21 a_96634_140794# a_96674_147580# a_111110_147696# VDD pfet_06v0 ad=4.4p pd=20.88u as=2.5p ps=10.5u w=10u l=1u
X22 S4N a_23448_50576# VDD ppolyf_u r_width=16u r_length=4u
X23 a_75842_194421# a_75842_194421# a_78498_190997# VSS nfet_06v0 ad=0.44p pd=2.88u as=0.25p ps=1.5u w=1u l=1u
X24 a_36062_182443# a_35862_182327# a_33586_182373# VSS nfet_06v0 ad=1.3p pd=5.52u as=2.2p ps=10.88u w=5u l=1u
X25 a_99096_165124# a_99096_165124# a_101360_165240# VSS nfet_06v0 ad=0.308p pd=2.28u as=0.175p ps=1.2u w=0.7u l=1u
X26 VSS a_83430_191067# a_82762_194467# VSS nfet_06v0 ad=0.65p pd=3.02u as=0.65p ps=3.02u w=2.5u l=1u
X27 a_30178_182373# a_29978_182329# VSS VSS nfet_06v0 ad=1.25p pd=5.5u as=2.2p ps=10.88u w=5u l=1u
X28 a_33918_182373# a_29246_182329# a_33586_182373# VSS nfet_06v0 ad=1.25p pd=5.5u as=1.65p ps=5.66u w=5u l=1u
X29 a_54110_137602# a_31310_152778# a_52186_135712# VDD pfet_06v0 ad=0.242p pd=1.98u as=0.242p ps=1.98u w=0.55u l=1u
X30 VDD a_75542_177061# a_80534_177177# VDD pfet_06v0 ad=4.4p pd=20.88u as=2.5p ps=10.5u w=10u l=1u
D0 VSS X diode_nd2ps_06v0 pj=40u area=99.99999p
X31 a_75502_182329# a_75842_185797# a_75742_185913# VDD pfet_06v0 ad=4.4p pd=20.88u as=2.5p ps=10.5u w=10u l=1u
X32 VDD a_83878_186843# a_81206_182443# VDD pfet_06v0 ad=1.3p pd=5.52u as=1.3p ps=5.52u w=5u l=1u
X33 VSS a_60246_165083# a_59578_168483# VSS nfet_06v0 ad=1.1p pd=5.88u as=0.65p ps=3.02u w=2.5u l=1u
X34 VSS VDD VSS VSS nfet_06v0 ad=4.29p pd=20.38u as=0 ps=0 w=9.75u l=2u
X35 a_59578_194467# a_60246_191067# VSS VSS nfet_06v0 ad=0.65p pd=3.02u as=1.1p ps=5.88u w=2.5u l=1u
X36 a_102104_165240# a_99096_165124# VSS VSS nfet_06v0 ad=0.5456p pd=3.36u as=0.5456p ps=3.36u w=1.24u l=1u
X37 a_34750_164967# a_30160_133316# VDD VDD pfet_06v0 ad=0.44p pd=2.88u as=0.44p ps=2.88u w=1u l=1u
X38 a_29746_152822# a_29546_152778# a_30478_152822# VSS nfet_06v0 ad=2.2p pd=10.88u as=1.25p ps=5.5u w=5u l=1u
X39 a_58022_182443# a_60694_186843# VDD VDD pfet_06v0 ad=1.3p pd=5.52u as=2.2p ps=10.88u w=5u l=1u
X40 a_33286_182373# a_29978_182329# VSS VSS nfet_06v0 ad=1.25p pd=5.5u as=2.2p ps=10.88u w=5u l=1u
X41 a_29486_168553# a_29286_168437# VDD VDD pfet_06v0 ad=2.5p pd=10.5u as=4.4p ps=20.88u w=10u l=1u
X42 a_74134_140838# a_73934_140794# VSS VSS nfet_06v0 ad=1.25p pd=5.5u as=2.2p ps=10.88u w=5u l=1u
X43 a_77474_152778# a_74234_152778# a_77210_161580# VSS nfet_06v0 ad=1.1p pd=5.88u as=0.825p ps=3.16u w=2.5u l=1u
X44 a_23448_190688# a_23448_190688# VDD VDD pfet_06v0 ad=0.52p pd=2.52u as=0.88p ps=4.88u w=2u l=1u
X45 a_37622_178107# a_29586_177061# a_36062_173707# VDD pfet_06v0 ad=1.3p pd=5.52u as=2.2p ps=10.88u w=5u l=1u
X46 a_53910_140838# a_55734_147696# VDD VDD pfet_06v0 ad=2.2p pd=10.88u as=2.2p ps=10.88u w=5u l=1u
X47 a_85150_152822# a_73934_152778# VSS VSS nfet_06v0 ad=1.25p pd=5.5u as=2.2p ps=10.88u w=5u l=1u
X48 a_34750_190951# a_56794_152822# VSS VSS nfet_06v0 ad=0.44p pd=2.88u as=0.44p ps=2.88u w=1u l=1u
X49 a_59578_177107# a_52318_173593# a_60246_173707# VSS nfet_06v0 ad=1.1p pd=5.88u as=0.65p ps=3.02u w=2.5u l=1u
X50 a_59134_191067# a_52658_194421# a_60694_195467# VDD pfet_06v0 ad=2.2p pd=10.88u as=1.3p ps=5.52u w=5u l=1u
X51 a_52658_168437# a_52658_168437# a_55314_165013# VSS nfet_06v0 ad=0.44p pd=2.88u as=0.25p ps=1.5u w=1u l=1u
X52 a_76930_152822# a_23448_50576# a_74434_152822# VSS nfet_06v0 ad=3.74p pd=17.88u as=3.74p ps=17.88u w=8.5u l=1u
X53 a_104146_166448# a_99096_165124# VSS VSS nfet_06v0 ad=0.5456p pd=3.36u as=0.5456p ps=3.36u w=1.24u l=1u
X54 a_96534_140838# a_96334_140794# VSS VSS nfet_06v0 ad=1.25p pd=5.5u as=2.2p ps=10.88u w=5u l=1u
X55 VSS VDD VSS VSS nfet_06v0 ad=4.29p pd=20.38u as=0 ps=0 w=9.75u l=2u
X56 a_111110_159680# a_96374_159564# VDD VDD pfet_06v0 ad=2.5p pd=10.5u as=4.4p ps=20.88u w=10u l=1u
X57 a_29746_128854# a_29546_128810# a_30478_128854# VSS nfet_06v0 ad=2.2p pd=10.88u as=1.25p ps=5.5u w=5u l=1u
X58 a_35862_190951# a_97248_157284# VDD VDD pfet_06v0 ad=0.44p pd=2.88u as=0.44p ps=2.88u w=1u l=1u
X59 a_36062_165083# a_29586_168437# a_37622_169483# VDD pfet_06v0 ad=2.2p pd=10.88u as=1.3p ps=5.52u w=5u l=1u
X60 a_74848_134666# a_35862_164967# VSS ppolyf_u_1k r_width=1u r_length=76.45u
X61 a_77474_128810# a_74234_128810# a_77210_137612# VSS nfet_06v0 ad=1.1p pd=5.88u as=0.825p ps=3.16u w=2.5u l=1u
X62 a_33946_185913# a_34750_182327# a_35390_185843# VDD pfet_06v0 ad=4.4p pd=20.88u as=2.6p ps=10.52u w=10u l=1u
X63 a_99330_152822# a_32042_128810# a_96834_152822# VSS nfet_06v0 ad=3.74p pd=17.88u as=3.74p ps=17.88u w=8.5u l=1u
X64 a_32522_161580# a_32042_152778# a_29786_159680# VDD pfet_06v0 ad=0.22p pd=1.88u as=0.22p ps=1.88u w=0.5u l=1u
X65 a_57822_164967# a_56794_128854# VSS VSS nfet_06v0 ad=0.44p pd=2.88u as=0.44p ps=2.88u w=1u l=1u
X66 a_85150_128854# a_73934_128810# VSS VSS nfet_06v0 ad=1.25p pd=5.5u as=2.2p ps=10.88u w=5u l=1u
X67 a_79542_182373# a_76234_182329# VSS VSS nfet_06v0 ad=1.25p pd=5.5u as=2.2p ps=10.88u w=5u l=1u
X68 VDD a_37622_186843# a_34950_182443# VDD pfet_06v0 ad=2.2p pd=10.88u as=1.3p ps=5.52u w=5u l=1u
X69 a_91194_177177# a_90994_177061# VDD VDD pfet_06v0 ad=2.5p pd=10.5u as=4.4p ps=20.88u w=10u l=1u
X70 a_56718_194537# a_52358_194421# VDD VDD pfet_06v0 ad=2.5p pd=10.5u as=4.4p ps=20.88u w=10u l=1u
X71 a_23448_190688# a_104234_166332# a_104146_166448# VSS nfet_06v0 ad=0.6448p pd=3u as=1.0912p ps=5.84u w=2.48u l=1u
X72 a_56658_173637# a_52318_173593# a_56358_173637# VSS nfet_06v0 ad=1.65p pd=5.66u as=1.25p ps=5.5u w=5u l=1u
X73 VSS a_37174_173707# a_35390_177107# VSS nfet_06v0 ad=1.1p pd=5.88u as=0.65p ps=3.02u w=2.5u l=1u
X74 a_76930_128854# a_43160_205808# a_74434_128854# VSS nfet_06v0 ad=3.74p pd=17.88u as=3.74p ps=17.88u w=8.5u l=1u
X75 a_68418_182373# a_68218_182329# VSS VSS nfet_06v0 ad=1.25p pd=5.5u as=2.2p ps=10.88u w=5u l=1u
X76 a_51886_135712# a_51686_135596# VDD VDD pfet_06v0 ad=2.5p pd=10.5u as=4.4p ps=20.88u w=10u l=1u
X77 a_97248_134666# a_34750_173591# VSS ppolyf_u_1k r_width=1u r_length=76.45u
X78 a_56658_182373# a_35862_182327# a_59134_182443# VSS nfet_06v0 ad=2.2p pd=10.88u as=1.3p ps=5.52u w=5u l=1u
X79 VSS VDD VSS VSS nfet_06v0 ad=4.29p pd=20.38u as=0 ps=0 w=9.75u l=2u
X80 a_58462_185843# a_60246_182443# VSS VSS nfet_06v0 ad=0.65p pd=3.02u as=0.65p ps=3.02u w=2.5u l=1u
X81 a_99330_128854# a_43160_205808# a_96834_128854# VSS nfet_06v0 ad=3.74p pd=17.88u as=3.74p ps=17.88u w=8.5u l=1u
X82 a_42526_152822# a_29586_159564# VSS VSS nfet_06v0 ad=0.25p pd=1.5u as=0.44p ps=2.88u w=1u l=1u
X83 a_81070_148780# a_74234_140794# a_81278_140838# VSS nfet_06v0 ad=2.2p pd=10.88u as=1.25p ps=5.5u w=5u l=1u
X84 a_38998_140838# a_34394_140838# VSS VSS nfet_06v0 ad=0.44p pd=2.88u as=0.44p ps=2.88u w=1u l=1u
X85 a_34950_182443# a_37622_186843# VDD VDD pfet_06v0 ad=1.3p pd=5.52u as=2.2p ps=10.88u w=5u l=1u
X86 a_58022_182443# a_57822_182327# a_56658_182373# VSS nfet_06v0 ad=1.3p pd=5.52u as=2.2p ps=10.88u w=5u l=1u
X87 a_104234_166332# a_114466_164956# VDD VDD pfet_06v0 ad=1.32p pd=6.88u as=1.32p ps=6.88u w=3u l=1u
X88 VDD VSS VDD VDD pfet_06v0 ad=4.29p pd=20.38u as=0 ps=0 w=9.75u l=2u
X89 a_29446_152822# a_29246_152778# VSS VSS nfet_06v0 ad=1.25p pd=5.5u as=2.2p ps=10.88u w=5u l=1u
X90 VSS a_111626_182316# a_106078_175068# VSS nfet_06v0 ad=0.44p pd=2.88u as=0.44p ps=2.88u w=1u l=1u
X91 a_35390_177107# a_37174_173707# VSS VSS nfet_06v0 ad=0.65p pd=3.02u as=1.1p ps=5.88u w=2.5u l=1u
X92 Y a_23448_131216# VDD ppolyf_u r_width=16u r_length=4u
X93 a_36590_152822# a_29246_152778# VSS VSS nfet_06v0 ad=1.25p pd=5.5u as=2.2p ps=10.88u w=5u l=1u
X94 a_46710_191067# a_38286_191067# VSS VSS nfet_06v0 ad=1.3p pd=5.52u as=2.2p ps=10.88u w=5u l=1u
X95 a_59134_182443# a_60694_186843# VDD VDD pfet_06v0 ad=1.3p pd=5.52u as=1.3p ps=5.52u w=5u l=1u
X96 a_76434_182373# a_76234_182329# VSS VSS nfet_06v0 ad=1.25p pd=5.5u as=2.2p ps=10.88u w=5u l=1u
X97 a_96674_147580# a_96674_147580# a_109614_140838# VSS nfet_06v0 ad=0.44p pd=2.88u as=0.25p ps=1.5u w=1u l=1u
X98 a_69782_173707# a_61358_173707# VSS VSS nfet_06v0 ad=1.3p pd=5.52u as=2.2p ps=10.88u w=5u l=1u
X99 a_52358_194421# a_52658_194421# a_55594_194537# VDD pfet_06v0 ad=4.4p pd=20.88u as=2.5p ps=10.5u w=10u l=1u
X100 a_42526_128854# a_29586_135596# VSS VSS nfet_06v0 ad=0.25p pd=1.5u as=0.44p ps=2.88u w=1u l=1u
X101 S3N a_32042_152778# VDD ppolyf_u r_width=16u r_length=4u
X102 YP_OUT YN_OUT VDD VDD pfet_05v0 ad=0.8052p pd=4.54u as=0.8052p ps=4.54u w=1.83u l=0.5u
X103 VSS a_83430_165083# a_82762_168483# VSS nfet_06v0 ad=1.1p pd=5.88u as=0.65p ps=3.02u w=2.5u l=1u
X104 a_99096_173860# a_99096_173860# VDD VDD pfet_06v0 ad=0.88p pd=4.88u as=0.88p ps=4.88u w=2u l=1u
X105 a_82762_194467# a_83430_191067# VSS VSS nfet_06v0 ad=0.65p pd=3.02u as=1.1p ps=5.88u w=2.5u l=1u
X106 a_42638_182329# a_29586_185797# a_46382_185913# VDD pfet_06v0 ad=4.4p pd=20.88u as=2.5p ps=10.5u w=10u l=1u
X107 a_90558_190997# a_76234_190953# VSS VSS nfet_06v0 ad=1.25p pd=5.5u as=2.2p ps=10.88u w=5u l=1u
X108 a_81206_182443# a_83878_186843# VDD VDD pfet_06v0 ad=1.3p pd=5.52u as=2.2p ps=10.88u w=5u l=1u
X109 a_29446_128854# a_29246_128810# VSS VSS nfet_06v0 ad=1.25p pd=5.5u as=2.2p ps=10.88u w=5u l=1u
X110 a_36590_128854# a_29246_128810# VSS VSS nfet_06v0 ad=1.25p pd=5.5u as=2.2p ps=10.88u w=5u l=1u
X111 a_81646_168483# a_92966_165083# cap_mim_2f0_m4m5_noshield c_width=20u c_length=10u
X112 VSS VDD VSS VSS nfet_06v0 ad=7.92p pd=36.88u as=0 ps=0 w=18u l=2u
X113 a_102002_166448# a_23448_190688# a_23448_190688# VSS nfet_06v0 ad=0.88p pd=4.88u as=0.52p ps=2.52u w=2u l=1u
X114 a_88894_173593# a_75842_177061# a_92638_177177# VDD pfet_06v0 ad=4.4p pd=20.88u as=2.5p ps=10.5u w=10u l=1u
X115 a_82762_177107# a_75502_173593# a_83430_173707# VSS nfet_06v0 ad=1.1p pd=5.88u as=0.65p ps=3.02u w=2.5u l=1u
D1 VSS Y diode_nd2ps_06v0 pj=40u area=99.99999p
X116 a_112222_159680# a_96374_159564# VDD VDD pfet_06v0 ad=2.5p pd=10.5u as=4.4p ps=20.88u w=10u l=1u
X117 a_30598_135712# a_29286_135596# VDD VDD pfet_06v0 ad=2.5p pd=10.5u as=4.4p ps=20.88u w=10u l=1u
X118 a_60694_195467# a_52658_194421# a_59134_191067# VDD pfet_06v0 ad=1.3p pd=5.52u as=2.2p ps=10.88u w=5u l=1u
X119 a_54110_137602# a_57822_164967# cap_mim_2f0_m4m5_noshield c_width=25u c_length=8u
X120 a_98598_152822# a_100422_159680# VDD VDD pfet_06v0 ad=2.2p pd=10.88u as=2.2p ps=10.88u w=5u l=1u
X121 a_37174_173707# a_29246_173593# a_36506_177107# VSS nfet_06v0 ad=0.65p pd=3.02u as=1.1p ps=5.88u w=2.5u l=1u
X122 a_81070_160764# a_81070_160764# a_82706_159564# VDD pfet_06v0 ad=4.4p pd=20.88u as=3.3p ps=10.66u w=10u l=1u
X123 a_37622_169483# a_29586_168437# a_36062_165083# VDD pfet_06v0 ad=1.3p pd=5.52u as=2.2p ps=10.88u w=5u l=1u
X124 a_84994_195467# a_75842_194421# a_81206_191067# VDD pfet_06v0 ad=1.3p pd=5.52u as=2.2p ps=10.88u w=5u l=1u
X125 a_92966_182443# a_84994_186843# VDD VDD pfet_06v0 ad=4.4p pd=20.88u as=2.6p ps=10.52u w=10u l=1u
X126 a_35390_185843# a_34750_182327# a_33946_185913# VDD pfet_06v0 ad=2.6p pd=10.52u as=4.4p ps=20.88u w=10u l=1u
X127 S3P a_31310_152778# VDD ppolyf_u r_width=16u r_length=4u
X128 a_61810_169483# a_65710_164969# a_61358_165083# VSS nfet_06v0 ad=1.1p pd=5.88u as=1.1p ps=5.88u w=2.5u l=1u
X129 a_29246_190953# a_29246_190953# VSS VSS nfet_06v0 ad=0.44p pd=2.88u as=0.44p ps=2.88u w=1u l=1u
X130 VDD VSS VDD VDD pfet_06v0 ad=4.29p pd=20.38u as=0 ps=0 w=9.75u l=2u
X131 a_89822_135712# a_73974_135596# VDD VDD pfet_06v0 ad=2.5p pd=10.5u as=4.4p ps=20.88u w=10u l=1u
X132 a_61358_191067# a_52318_190953# a_58462_194467# VSS nfet_06v0 ad=0.65p pd=3.02u as=1.1p ps=5.88u w=2.5u l=1u
X133 VDD a_38738_186843# a_46710_182443# VDD pfet_06v0 ad=2.6p pd=10.52u as=2.6p ps=10.52u w=10u l=1u
X134 a_96874_147696# a_96674_147580# a_97686_147696# VDD pfet_06v0 ad=4.4p pd=20.88u as=2.5p ps=10.5u w=10u l=1u
X135 a_55186_140794# a_58782_148780# a_55734_147696# VDD pfet_06v0 ad=1.76p pd=8.88u as=1.76p ps=8.88u w=4u l=1u
X136 a_84350_159680# a_73974_159564# VDD VDD pfet_06v0 ad=2.5p pd=10.5u as=4.4p ps=20.88u w=10u l=1u
X137 VSS a_60246_182443# a_58462_185843# VSS nfet_06v0 ad=0.65p pd=3.02u as=0.65p ps=3.02u w=2.5u l=1u
D2 Y VDD diode_pd2nw_06v0 pj=40u area=99.99999p
X138 a_78498_190997# a_75842_194421# VSS VSS nfet_06v0 ad=0.25p pd=1.5u as=0.44p ps=2.88u w=1u l=1u
X139 a_34394_152822# a_36382_160764# a_30160_157284# VDD pfet_06v0 ad=1.76p pd=8.88u as=1.76p ps=8.88u w=4u l=1u
X140 a_69782_191067# a_61358_191067# VSS VSS nfet_06v0 ad=2.2p pd=10.88u as=1.3p ps=5.52u w=5u l=1u
X141 a_101360_165240# a_99096_165124# a_101060_165240# VSS nfet_06v0 ad=0.175p pd=1.2u as=0.175p ps=1.2u w=0.7u l=1u
X142 a_91402_190953# a_75502_190953# a_91602_190997# VSS nfet_06v0 ad=1.65p pd=5.66u as=1.25p ps=5.5u w=5u l=1u
X143 VDD VSS VDD VDD pfet_06v0 ad=0.44p pd=2.88u as=0 ps=0 w=1u l=2u
X144 a_33946_194537# a_35862_190951# a_36506_194467# VDD pfet_06v0 ad=4.4p pd=20.88u as=2.6p ps=10.52u w=10u l=1u
X145 a_80534_177177# a_75842_177061# a_80202_177177# VDD pfet_06v0 ad=2.5p pd=10.5u as=3.3p ps=10.66u w=10u l=1u
X146 a_75742_185913# a_75542_185797# VDD VDD pfet_06v0 ad=2.5p pd=10.5u as=4.4p ps=20.88u w=10u l=1u
X147 a_29586_135596# a_29586_135596# VDD VDD pfet_06v0 ad=0.88p pd=4.88u as=0.88p ps=4.88u w=2u l=1u
X148 a_82318_182443# a_83878_186843# VDD VDD pfet_06v0 ad=1.3p pd=5.52u as=1.3p ps=5.52u w=5u l=1u
X149 a_29586_185797# a_29586_185797# a_32242_182373# VSS nfet_06v0 ad=0.44p pd=2.88u as=0.25p ps=1.5u w=1u l=1u
X150 a_36506_177107# a_35862_173591# a_33946_177177# VDD pfet_06v0 ad=2.6p pd=10.52u as=4.4p ps=20.88u w=10u l=1u
X151 a_66174_186797# a_66174_186797# a_67810_185797# VDD pfet_06v0 ad=4.4p pd=20.88u as=3.3p ps=10.66u w=10u l=1u
X152 VSS a_46710_165083# a_115398_165000# VSS nfet_06v0 ad=0.44p pd=2.88u as=0.25p ps=1.5u w=1u l=1u
X153 a_30478_152822# a_29246_152778# VSS VSS nfet_06v0 ad=1.25p pd=5.5u as=2.2p ps=10.88u w=5u l=1u
X154 a_29286_177061# a_29586_177061# a_31210_173637# VSS nfet_06v0 ad=0.44p pd=2.88u as=0.25p ps=1.5u w=1u l=1u
X155 a_53050_190953# a_52318_190953# a_53250_190997# VSS nfet_06v0 ad=2.2p pd=10.88u as=1.25p ps=5.5u w=5u l=1u
X156 VDD a_60694_186843# a_59134_182443# VDD pfet_06v0 ad=1.3p pd=5.52u as=1.3p ps=5.52u w=5u l=1u
D3 VSS Y diode_nd2ps_06v0 pj=40u area=99.99999p
X157 a_75542_194421# a_75842_194421# a_78778_194537# VDD pfet_06v0 ad=4.4p pd=20.88u as=2.5p ps=10.5u w=10u l=1u
X158 VDD a_37622_186843# a_36062_182443# VDD pfet_06v0 ad=1.3p pd=5.52u as=1.3p ps=5.52u w=5u l=1u
X159 a_86182_140838# a_74274_147580# VSS VSS nfet_06v0 ad=0.25p pd=1.5u as=0.44p ps=2.88u w=1u l=1u
X160 a_99134_175068# a_99306_190940# VDD VDD pfet_06v0 ad=1.32p pd=6.88u as=1.32p ps=6.88u w=3u l=1u
X161 a_57822_182327# a_101482_140838# VSS VSS nfet_06v0 ad=0.44p pd=2.88u as=0.44p ps=2.88u w=1u l=1u
X162 a_100158_183808# a_99096_182484# VSS VSS nfet_06v0 ad=0.5456p pd=3.36u as=0.5456p ps=3.36u w=1.24u l=1u
X163 a_55314_165013# a_52658_168437# VSS VSS nfet_06v0 ad=0.25p pd=1.5u as=0.44p ps=2.88u w=1u l=1u
X164 a_79082_140838# a_74234_140794# a_76398_149586# VSS nfet_06v0 ad=1.1p pd=5.88u as=0.825p ps=3.16u w=2.5u l=1u
X165 a_74848_145750# a_90266_145300# VSS ppolyf_u_1k r_width=1u r_length=76.45u
X166 a_82762_168483# a_83430_165083# VSS VSS nfet_06v0 ad=0.65p pd=3.02u as=0.65p ps=3.02u w=2.5u l=1u
X167 VSS a_46710_173707# a_110806_173624# VSS nfet_06v0 ad=0.44p pd=2.88u as=0.44p ps=2.88u w=1u l=1u
X168 VDD VSS VDD VDD pfet_06v0 ad=7.92p pd=36.88u as=0 ps=0 w=18u l=2u
D4 VSS S4N diode_nd2ps_06v0 pj=40u area=99.99999p
X169 VSS a_76234_182329# a_80174_182373# VSS nfet_06v0 ad=2.2p pd=10.88u as=1.25p ps=5.5u w=5u l=1u
X170 a_62062_147696# a_51686_147580# VDD VDD pfet_06v0 ad=2.5p pd=10.5u as=4.4p ps=20.88u w=10u l=1u
X171 a_68010_168553# a_67810_168437# VDD VDD pfet_06v0 ad=2.5p pd=10.5u as=4.4p ps=20.88u w=10u l=1u
X172 a_96374_159564# a_96674_159564# a_108582_152822# VSS nfet_06v0 ad=0.44p pd=2.88u as=0.25p ps=1.5u w=1u l=1u
X173 a_33586_190997# a_29246_190953# a_33286_190997# VSS nfet_06v0 ad=1.65p pd=5.66u as=1.25p ps=5.5u w=5u l=1u
X174 a_59134_173707# a_35862_173591# a_56658_173637# VSS nfet_06v0 ad=1.3p pd=5.52u as=2.2p ps=10.88u w=5u l=1u
X175 a_38286_173707# a_29246_173593# a_35390_177107# VSS nfet_06v0 ad=0.65p pd=3.02u as=1.1p ps=5.88u w=2.5u l=1u
X176 a_30478_128854# a_29246_128810# VSS VSS nfet_06v0 ad=1.25p pd=5.5u as=2.2p ps=10.88u w=5u l=1u
X177 VDD VSS VDD VDD pfet_06v0 ad=0.44p pd=2.88u as=0 ps=0 w=1u l=2u
D5 VSS S4N diode_nd2ps_06v0 pj=40u area=99.99999p
X178 VSS VDD VSS VSS nfet_06v0 ad=7.92p pd=36.88u as=0 ps=0 w=18u l=2u
X179 a_74234_152778# a_74274_159564# a_88710_159680# VDD pfet_06v0 ad=4.4p pd=20.88u as=2.5p ps=10.5u w=10u l=1u
X180 a_23448_190688# a_23448_190688# a_102002_166448# VSS nfet_06v0 ad=0.52p pd=2.52u as=0.88p ps=4.88u w=2u l=1u
X181 a_97248_145750# a_112666_145300# VSS ppolyf_u_1k r_width=1u r_length=76.45u
X182 a_100246_183692# a_92966_173707# VSS VSS nfet_06v0 ad=0.33p pd=1.66u as=0.44p ps=2.88u w=1u l=1u
X183 a_83430_173707# a_75502_173593# a_82762_177107# VSS nfet_06v0 ad=0.65p pd=3.02u as=1.1p ps=5.88u w=2.5u l=1u
X184 a_83878_195467# a_75842_194421# a_82318_191067# VDD pfet_06v0 ad=1.3p pd=5.52u as=2.2p ps=10.88u w=5u l=1u
X185 a_23448_70736# a_100246_183692# a_100158_183808# VSS nfet_06v0 ad=0.6448p pd=3u as=1.0912p ps=5.84u w=2.48u l=1u
X186 VDD VSS VDD VDD pfet_06v0 ad=4.29p pd=20.38u as=0 ps=0 w=9.75u l=2u
X187 a_69782_173707# a_61810_178107# VDD VDD pfet_06v0 ad=4.4p pd=20.88u as=2.6p ps=10.52u w=10u l=1u
X188 a_56990_182373# a_52318_182329# a_56658_182373# VSS nfet_06v0 ad=1.25p pd=5.5u as=1.65p ps=5.66u w=5u l=1u
D6 S3P VDD diode_pd2nw_06v0 pj=40u area=99.99999p
X189 a_56358_173637# a_53050_173593# VSS VSS nfet_06v0 ad=1.25p pd=5.5u as=2.2p ps=10.88u w=5u l=1u
X190 a_51686_135596# a_51986_135596# a_69458_135712# VDD pfet_06v0 ad=4.4p pd=20.88u as=2.5p ps=10.5u w=10u l=1u
X191 a_52658_177061# a_52658_177061# VDD VDD pfet_06v0 ad=0.88p pd=4.88u as=0.88p ps=4.88u w=2u l=1u
X192 a_67810_194421# a_52658_194421# a_68010_194537# VDD pfet_06v0 ad=3.3p pd=10.66u as=2.5p ps=10.5u w=10u l=1u
X193 a_96374_135596# a_96674_135596# a_108582_128854# VSS nfet_06v0 ad=0.44p pd=2.88u as=0.25p ps=1.5u w=1u l=1u
X194 a_30160_145300# a_45578_145300# VSS ppolyf_u_1k r_width=1u r_length=76.45u
X195 a_81206_182443# a_57822_182327# a_79842_182373# VSS nfet_06v0 ad=1.3p pd=5.52u as=2.2p ps=10.88u w=5u l=1u
D7 Y VDD diode_pd2nw_06v0 pj=40u area=99.99999p
X196 a_79842_190997# a_75502_190953# a_79542_190997# VSS nfet_06v0 ad=1.65p pd=5.66u as=1.25p ps=5.5u w=5u l=1u
X197 a_84994_169483# a_88894_164969# a_84542_165083# VSS nfet_06v0 ad=1.1p pd=5.88u as=1.1p ps=5.88u w=2.5u l=1u
X198 VDD VSS VDD VDD pfet_06v0 ad=0.44p pd=2.88u as=0 ps=0 w=1u l=2u
X199 a_99046_183808# a_99096_182484# VSS VSS nfet_06v0 ad=0.5456p pd=3.36u as=0.5456p ps=3.36u w=1.24u l=1u
X200 VSS a_61358_165083# a_69782_165083# VSS nfet_06v0 ad=1.3p pd=5.52u as=1.3p ps=5.52u w=5u l=1u
X201 a_68218_190953# a_52318_190953# a_68418_190997# VSS nfet_06v0 ad=1.65p pd=5.66u as=1.25p ps=5.5u w=5u l=1u
X202 a_29286_185797# a_29586_185797# a_32522_185913# VDD pfet_06v0 ad=4.4p pd=20.88u as=2.5p ps=10.5u w=10u l=1u
X203 a_81278_140838# a_73934_140794# VSS VSS nfet_06v0 ad=1.25p pd=5.5u as=2.2p ps=10.88u w=5u l=1u
X204 VDD VSS VDD VDD pfet_06v0 ad=4.29p pd=20.38u as=0 ps=0 w=9.75u l=2u
X205 a_31710_161570# a_32786_152778# VSS VSS nfet_06v0 ad=0.825p pd=3.16u as=1.1p ps=5.88u w=2.5u l=1u
X206 a_76398_161570# a_57822_190951# cap_mim_2f0_m4m5_noshield c_width=25u c_length=8u
X207 a_29978_190953# a_29246_190953# a_30178_190997# VSS nfet_06v0 ad=2.2p pd=10.88u as=1.25p ps=5.5u w=5u l=1u
X208 a_38018_159564# a_29586_159564# a_38218_159680# VDD pfet_06v0 ad=3.3p pd=10.66u as=2.5p ps=10.5u w=10u l=1u
X209 VSS VDD VSS VSS nfet_06v0 ad=0.44p pd=2.88u as=0 ps=0 w=1u l=2u
X210 a_46710_182443# a_38738_186843# VDD VDD pfet_06v0 ad=2.6p pd=10.52u as=4.4p ps=20.88u w=10u l=1u
X211 VSS a_83430_182443# a_81646_185843# VSS nfet_06v0 ad=0.65p pd=3.02u as=0.65p ps=3.02u w=2.5u l=1u
X212 a_32242_128854# a_33334_135712# VDD VDD pfet_06v0 ad=2.2p pd=10.88u as=2.2p ps=10.88u w=5u l=1u
X213 a_29786_147696# a_29586_147580# a_29486_147696# VDD pfet_06v0 ad=4.4p pd=20.88u as=2.5p ps=10.5u w=10u l=1u
X214 VSS a_99306_190940# a_99134_175068# VSS nfet_06v0 ad=0.44p pd=2.88u as=0.44p ps=2.88u w=1u l=1u
D8 S2P VDD diode_pd2nw_06v0 pj=40u area=99.99999p
X215 a_35862_164967# a_74848_133316# VDD VDD pfet_06v0 ad=0.44p pd=2.88u as=0.44p ps=2.88u w=1u l=1u
X216 a_54110_161570# a_55186_152778# VSS VSS nfet_06v0 ad=0.825p pd=3.16u as=1.1p ps=5.88u w=2.5u l=1u
X217 a_92966_191067# a_84542_191067# VSS VSS nfet_06v0 ad=2.2p pd=10.88u as=1.3p ps=5.52u w=5u l=1u
X218 a_109614_140838# a_96674_147580# VSS VSS nfet_06v0 ad=0.25p pd=1.5u as=0.44p ps=2.88u w=1u l=1u
X219 a_57822_182327# a_97248_145300# VDD VDD pfet_06v0 ad=0.44p pd=2.88u as=0.44p ps=2.88u w=1u l=1u
X220 a_55594_194537# a_52358_194421# VDD VDD pfet_06v0 ad=2.5p pd=10.5u as=4.4p ps=20.88u w=10u l=1u
X221 a_99134_183692# a_92966_191067# VSS VSS nfet_06v0 ad=0.33p pd=1.66u as=0.44p ps=2.88u w=1u l=1u
X222 a_54642_128854# a_55734_135712# VDD VDD pfet_06v0 ad=2.2p pd=10.88u as=2.2p ps=10.88u w=5u l=1u
X223 a_32522_149596# a_32042_128810# a_29786_147696# VDD pfet_06v0 ad=0.22p pd=1.88u as=0.22p ps=1.88u w=0.5u l=1u
X224 a_59578_168483# a_52318_164969# a_60246_165083# VSS nfet_06v0 ad=1.1p pd=5.88u as=0.65p ps=3.02u w=2.5u l=1u
X225 a_44938_168553# a_44738_168437# VDD VDD pfet_06v0 ad=2.5p pd=10.5u as=4.4p ps=20.88u w=10u l=1u
X226 a_31710_137602# a_32786_128810# VSS VSS nfet_06v0 ad=0.825p pd=3.16u as=1.1p ps=5.88u w=2.5u l=1u
X227 a_46382_185913# a_29286_185797# VDD VDD pfet_06v0 ad=2.5p pd=10.5u as=4.4p ps=20.88u w=10u l=1u
X228 a_76234_190953# a_75502_190953# a_76434_190997# VSS nfet_06v0 ad=2.2p pd=10.88u as=1.25p ps=5.5u w=5u l=1u
X229 VDD a_83878_186843# a_82318_182443# VDD pfet_06v0 ad=1.3p pd=5.52u as=1.3p ps=5.52u w=5u l=1u
X230 a_31510_128854# a_33334_135712# VDD VDD pfet_06v0 ad=2.2p pd=10.88u as=2.2p ps=10.88u w=5u l=1u
X231 a_92638_177177# a_75542_177061# VDD VDD pfet_06v0 ad=2.5p pd=10.5u as=4.4p ps=20.88u w=10u l=1u
X232 a_53050_164969# a_52658_168437# a_53670_168553# VDD pfet_06v0 ad=4.4p pd=20.88u as=2.5p ps=10.5u w=10u l=1u
X233 a_54110_137602# a_55186_128810# VSS VSS nfet_06v0 ad=0.825p pd=3.16u as=1.1p ps=5.88u w=2.5u l=1u
X234 a_101482_152822# a_103470_160764# a_97248_157284# VDD pfet_06v0 ad=1.76p pd=8.88u as=1.76p ps=8.88u w=4u l=1u
X235 a_36062_182443# a_37622_186843# VDD VDD pfet_06v0 ad=1.3p pd=5.52u as=2.2p ps=10.88u w=5u l=1u
D9 S3P VDD diode_pd2nw_06v0 pj=40u area=99.99999p
X236 VSS a_69782_165083# a_104234_183692# VSS nfet_06v0 ad=0.44p pd=2.88u as=0.33p ps=1.66u w=1u l=1u
X237 a_44738_194421# a_29586_194421# a_44938_194537# VDD pfet_06v0 ad=3.3p pd=10.66u as=2.5p ps=10.5u w=10u l=1u
X238 a_96674_135596# a_96674_135596# VDD VDD pfet_06v0 ad=0.88p pd=4.88u as=0.88p ps=4.88u w=2u l=1u
X239 a_38738_186843# a_42638_182329# a_38286_182443# VSS nfet_06v0 ad=1.1p pd=5.88u as=1.1p ps=5.88u w=2.5u l=1u
X240 a_55734_147696# a_51986_147580# a_54642_140838# VDD pfet_06v0 ad=4.4p pd=20.88u as=4.4p ps=20.88u w=10u l=1u
X241 VSS a_37174_165083# a_35390_168483# VSS nfet_06v0 ad=1.1p pd=5.88u as=0.65p ps=3.02u w=2.5u l=1u
X242 a_57326_140794# a_57326_140794# a_59834_140794# VSS nfet_06v0 ad=2.2p pd=10.88u as=1.65p ps=5.66u w=5u l=1u
X243 a_36506_168483# a_35862_164967# a_33946_168553# VDD pfet_06v0 ad=2.6p pd=10.52u as=4.4p ps=20.88u w=10u l=1u
D10 VSS S3P diode_nd2ps_06v0 pj=40u area=99.99999p
X244 a_74848_145750# a_90266_146200# VSS ppolyf_u_1k r_width=1u r_length=76.45u
X245 a_80202_177177# a_38998_140838# a_81646_177107# VDD pfet_06v0 ad=4.4p pd=20.88u as=2.6p ps=10.52u w=10u l=1u
X246 VDD VSS VDD VDD pfet_06v0 ad=7.92p pd=36.88u as=0 ps=0 w=18u l=2u
X247 a_57018_177177# a_35862_173591# a_59578_177107# VDD pfet_06v0 ad=4.4p pd=20.88u as=2.6p ps=10.52u w=10u l=1u
X248 a_58462_177107# a_60246_173707# VSS VSS nfet_06v0 ad=0.65p pd=3.02u as=1.1p ps=5.88u w=2.5u l=1u
X249 a_57326_128810# a_51986_135596# a_62062_135712# VDD pfet_06v0 ad=4.4p pd=20.88u as=2.5p ps=10.5u w=10u l=1u
X250 a_99296_182600# a_99096_182484# VSS VSS nfet_06v0 ad=0.5456p pd=3.36u as=0.5456p ps=3.36u w=1.24u l=1u
X251 VSS a_46710_191067# a_103078_190984# VSS nfet_06v0 ad=0.44p pd=2.88u as=0.25p ps=1.5u w=1u l=1u
X252 a_82122_140794# a_74234_140794# a_82322_140838# VSS nfet_06v0 ad=1.65p pd=5.66u as=1.25p ps=5.5u w=5u l=1u
X253 a_84542_165083# a_89358_169437# a_84994_169483# VDD pfet_06v0 ad=2.2p pd=10.88u as=2.2p ps=10.88u w=5u l=1u
X254 a_33946_185913# a_29586_185797# a_33646_185913# VDD pfet_06v0 ad=3.3p pd=10.66u as=2.5p ps=10.5u w=10u l=1u
X255 a_113914_183772# a_92966_182443# a_106078_183692# VDD pfet_06v0 ad=0.75p pd=3.5u as=1.32p ps=6.88u w=3u l=1u
X256 a_80174_182373# a_75502_182329# a_79842_182373# VSS nfet_06v0 ad=1.25p pd=5.5u as=1.65p ps=5.66u w=5u l=1u
X257 a_97248_145750# a_112666_146200# VSS ppolyf_u_1k r_width=1u r_length=76.45u
X258 a_75842_177061# a_75842_177061# VDD VDD pfet_06v0 ad=0.88p pd=4.88u as=0.88p ps=4.88u w=2u l=1u
X259 VDD a_61810_178107# a_69782_173707# VDD pfet_06v0 ad=2.6p pd=10.52u as=2.6p ps=10.52u w=10u l=1u
X260 a_35390_194467# a_29246_190953# a_38286_191067# VSS nfet_06v0 ad=1.1p pd=5.88u as=0.65p ps=3.02u w=2.5u l=1u
X261 a_34750_173591# a_97248_133316# VDD VDD pfet_06v0 ad=0.44p pd=2.88u as=0.44p ps=2.88u w=1u l=1u
X262 a_97686_147696# a_96374_147580# VDD VDD pfet_06v0 ad=2.5p pd=10.5u as=4.4p ps=20.88u w=10u l=1u
D11 S2P VDD diode_pd2nw_06v0 pj=40u area=99.99999p
X263 VDD VSS VDD VDD pfet_06v0 ad=7.92p pd=36.88u as=0 ps=0 w=18u l=2u
X264 a_60246_191067# a_66174_195421# a_60694_195467# VDD pfet_06v0 ad=2.2p pd=10.88u as=2.2p ps=10.88u w=5u l=1u
X265 a_35390_168483# a_37174_165083# VSS VSS nfet_06v0 ad=0.65p pd=3.02u as=1.1p ps=5.88u w=2.5u l=1u
X266 a_29246_173593# a_29586_177061# a_29486_177177# VDD pfet_06v0 ad=4.4p pd=20.88u as=2.5p ps=10.5u w=10u l=1u
X267 a_99134_166332# a_102146_190940# VDD VDD pfet_06v0 ad=1.32p pd=6.88u as=1.32p ps=6.88u w=3u l=1u
X268 VDD VSS VDD VDD pfet_06v0 ad=0.44p pd=2.88u as=0 ps=0 w=1u l=2u
D12 VSS S2P diode_nd2ps_06v0 pj=40u area=99.99999p
X269 a_51646_140794# a_51986_147580# a_67534_147696# VDD pfet_06v0 ad=4.4p pd=20.88u as=2.5p ps=10.5u w=10u l=1u
X270 VSS VDD VSS VSS nfet_06v0 ad=4.29p pd=20.38u as=0 ps=0 w=9.75u l=2u
X271 a_89358_169437# a_75502_164969# a_90558_165013# VSS nfet_06v0 ad=2.2p pd=10.88u as=1.25p ps=5.5u w=5u l=1u
X272 a_69782_165083# a_61358_165083# VSS VSS nfet_06v0 ad=1.3p pd=5.52u as=2.2p ps=10.88u w=5u l=1u
X273 a_91602_190997# a_91402_190953# VSS VSS nfet_06v0 ad=1.25p pd=5.5u as=2.2p ps=10.88u w=5u l=1u
X274 a_69782_165083# a_61810_169483# VDD VDD pfet_06v0 ad=4.4p pd=20.88u as=2.6p ps=10.52u w=10u l=1u
X275 a_23448_190688# a_106078_166332# a_99296_165240# VSS nfet_06v0 ad=0.6448p pd=3u as=1.0912p ps=5.84u w=2.48u l=1u
D13 Z VDD diode_pd2nw_06v0 pj=40u area=99.99999p
X276 VSS VDD VSS VSS nfet_06v0 ad=0.44p pd=2.88u as=0 ps=0 w=1u l=2u
X277 a_32242_182373# a_29586_185797# VSS VSS nfet_06v0 ad=0.25p pd=1.5u as=0.44p ps=2.88u w=1u l=1u
X278 a_96874_135712# a_96674_135596# a_96574_135712# VDD pfet_06v0 ad=4.4p pd=20.88u as=2.5p ps=10.5u w=10u l=1u
X279 a_98598_140838# a_100422_147696# VDD VDD pfet_06v0 ad=2.2p pd=10.88u as=2.2p ps=10.88u w=5u l=1u
X280 a_29978_164969# a_29586_168437# a_30598_168553# VDD pfet_06v0 ad=4.4p pd=20.88u as=2.5p ps=10.5u w=10u l=1u
X281 a_52146_152822# a_51946_152778# a_51846_152822# VSS nfet_06v0 ad=2.2p pd=10.88u as=1.25p ps=5.5u w=5u l=1u
X282 a_115398_165000# a_69782_165083# a_114466_164956# VSS nfet_06v0 ad=0.25p pd=1.5u as=0.44p ps=2.88u w=1u l=1u
X283 a_81646_185843# a_83430_182443# VSS VSS nfet_06v0 ad=0.65p pd=3.02u as=1.1p ps=5.88u w=2.5u l=1u
X284 a_69782_191067# a_58022_191067# cap_mim_2f0_m4m5_noshield c_width=20u c_length=10u
X285 a_31210_173637# a_29586_177061# VSS VSS nfet_06v0 ad=0.25p pd=1.5u as=0.44p ps=2.88u w=1u l=1u
X286 a_53250_190997# a_53050_190953# VSS VSS nfet_06v0 ad=1.25p pd=5.5u as=2.2p ps=10.88u w=5u l=1u
X287 a_82906_147696# a_82706_147580# VDD VDD pfet_06v0 ad=2.5p pd=10.5u as=4.4p ps=20.88u w=10u l=1u
X288 a_82318_173707# a_34750_173591# a_79842_173637# VSS nfet_06v0 ad=1.3p pd=5.52u as=2.2p ps=10.88u w=5u l=1u
X289 a_78778_194537# a_75542_194421# VDD VDD pfet_06v0 ad=2.5p pd=10.5u as=4.4p ps=20.88u w=10u l=1u
X290 a_34750_190951# a_52560_157284# VDD VDD pfet_06v0 ad=0.44p pd=2.88u as=0.44p ps=2.88u w=1u l=1u
X291 a_30178_190997# a_29978_190953# VSS VSS nfet_06v0 ad=1.25p pd=5.5u as=2.2p ps=10.88u w=5u l=1u
X292 a_33918_190997# a_29246_190953# a_33586_190997# VSS nfet_06v0 ad=1.25p pd=5.5u as=1.65p ps=5.66u w=5u l=1u
X293 VSS a_84542_191067# a_92966_191067# VSS nfet_06v0 ad=1.3p pd=5.52u as=1.3p ps=5.52u w=5u l=1u
X294 a_82762_168483# a_75502_164969# a_83430_165083# VSS nfet_06v0 ad=1.1p pd=5.88u as=0.65p ps=3.02u w=2.5u l=1u
X295 a_38738_186843# a_29586_185797# a_34950_182443# VDD pfet_06v0 ad=1.3p pd=5.52u as=2.2p ps=10.88u w=5u l=1u
X296 XN_OUT a_102380_168788# VDD VDD pfet_05v0 ad=0.8052p pd=4.54u as=0.8052p ps=4.54u w=1.83u l=0.5u
X297 a_69782_173707# a_58022_173707# cap_mim_2f0_m4m5_noshield c_width=20u c_length=10u
X298 a_98798_161570# a_99874_152778# VSS VSS nfet_06v0 ad=0.825p pd=3.16u as=1.1p ps=5.88u w=2.5u l=1u
X299 a_74274_159564# a_74274_159564# a_87214_152822# VSS nfet_06v0 ad=0.44p pd=2.88u as=0.25p ps=1.5u w=1u l=1u
X300 a_29546_152778# a_29546_152778# VSS VSS nfet_06v0 ad=0.44p pd=2.88u as=0.44p ps=2.88u w=1u l=1u
X301 a_100422_159680# a_102014_152778# a_99874_152778# VSS nfet_06v0 ad=0.88p pd=4.88u as=0.88p ps=4.88u w=2u l=1u
X302 a_105106_159564# a_96674_159564# a_105306_159680# VDD pfet_06v0 ad=3.3p pd=10.66u as=2.5p ps=10.5u w=10u l=1u
D14 VSS S3P diode_nd2ps_06v0 pj=40u area=99.99999p
X303 a_52318_182329# a_52318_182329# VSS VSS nfet_06v0 ad=0.44p pd=2.88u as=0.44p ps=2.88u w=1u l=1u
X304 a_37174_165083# a_29246_164969# a_36506_168483# VSS nfet_06v0 ad=0.65p pd=3.02u as=1.1p ps=5.88u w=2.5u l=1u
X305 a_99610_149596# a_99874_140794# VSS VSS nfet_06v0 ad=0.825p pd=3.16u as=1.1p ps=5.88u w=2.5u l=1u
X306 a_99330_128854# a_100422_135712# VDD VDD pfet_06v0 ad=2.2p pd=10.88u as=2.2p ps=10.88u w=5u l=1u
X307 a_52146_128854# a_51946_128810# a_51846_128854# VSS nfet_06v0 ad=2.2p pd=10.88u as=1.25p ps=5.5u w=5u l=1u
X308 a_108582_152822# a_96674_159564# VSS VSS nfet_06v0 ad=0.25p pd=1.5u as=0.44p ps=2.88u w=1u l=1u
X309 a_33286_190997# a_29978_190953# VSS VSS nfet_06v0 ad=1.25p pd=5.5u as=2.2p ps=10.88u w=5u l=1u
X310 a_57018_177177# a_38998_140838# a_58462_177107# VDD pfet_06v0 ad=4.4p pd=20.88u as=2.6p ps=10.52u w=10u l=1u
X311 a_76234_164969# a_75842_168437# a_76854_168553# VDD pfet_06v0 ad=4.4p pd=20.88u as=2.5p ps=10.5u w=10u l=1u
X312 VDD a_60694_178107# a_58022_173707# VDD pfet_06v0 ad=2.2p pd=10.88u as=1.3p ps=5.52u w=5u l=1u
X313 a_47058_135712# a_29286_135596# VDD VDD pfet_06v0 ad=2.5p pd=10.5u as=4.4p ps=20.88u w=10u l=1u
X314 a_88710_159680# a_73974_159564# VDD VDD pfet_06v0 ad=2.5p pd=10.5u as=4.4p ps=20.88u w=10u l=1u
X315 a_57822_164967# a_52560_133316# VDD VDD pfet_06v0 ad=0.44p pd=2.88u as=0.44p ps=2.88u w=1u l=1u
X316 a_52658_177061# a_52658_177061# a_55314_173637# VSS nfet_06v0 ad=0.44p pd=2.88u as=0.25p ps=1.5u w=1u l=1u
X317 a_29546_128810# a_29546_128810# VSS VSS nfet_06v0 ad=0.44p pd=2.88u as=0.44p ps=2.88u w=1u l=1u
X318 a_74274_135596# a_74274_135596# a_87214_128854# VSS nfet_06v0 ad=0.44p pd=2.88u as=0.25p ps=1.5u w=1u l=1u
X319 a_98798_137602# a_99874_128810# VSS VSS nfet_06v0 ad=0.825p pd=3.16u as=1.1p ps=5.88u w=2.5u l=1u
X320 VSS VDD VSS VSS nfet_06v0 ad=4.29p pd=20.38u as=0 ps=0 w=9.75u l=2u
X321 a_100422_135712# a_102014_128810# a_99874_128810# VSS nfet_06v0 ad=0.88p pd=4.88u as=0.88p ps=4.88u w=2u l=1u
X322 a_34394_140838# a_36382_148780# a_30160_145300# VDD pfet_06v0 ad=1.76p pd=8.88u as=1.76p ps=8.88u w=4u l=1u
X323 VSS a_37174_173707# a_36506_177107# VSS nfet_06v0 ad=1.1p pd=5.88u as=0.65p ps=3.02u w=2.5u l=1u
X324 a_99046_183808# a_99134_183692# a_23448_70736# VSS nfet_06v0 ad=1.0912p pd=5.84u as=0.6448p ps=3u w=2.48u l=1u
X325 a_69458_135712# a_51686_135596# VDD VDD pfet_06v0 ad=2.5p pd=10.5u as=4.4p ps=20.88u w=10u l=1u
X326 a_74848_157734# a_90266_157284# VSS ppolyf_u_1k r_width=1u r_length=76.45u
X327 a_80202_185913# a_75842_185797# a_79902_185913# VDD pfet_06v0 ad=3.3p pd=10.66u as=2.5p ps=10.5u w=10u l=1u
X328 a_108582_128854# a_96674_135596# VSS VSS nfet_06v0 ad=0.25p pd=1.5u as=0.44p ps=2.88u w=1u l=1u
X329 VDD a_60694_195467# a_58022_191067# VDD pfet_06v0 ad=1.3p pd=5.52u as=1.3p ps=5.52u w=5u l=1u
X330 VSS VDD VSS VSS nfet_06v0 ad=0.44p pd=2.88u as=0 ps=0 w=1u l=2u
X331 VDD VSS VDD VDD pfet_06v0 ad=7.92p pd=36.88u as=0 ps=0 w=18u l=2u
X332 a_75842_168437# a_75842_168437# a_78498_165013# VSS nfet_06v0 ad=0.44p pd=2.88u as=0.25p ps=1.5u w=1u l=1u
X333 a_79542_190997# a_76234_190953# VSS VSS nfet_06v0 ad=1.25p pd=5.5u as=2.2p ps=10.88u w=5u l=1u
X334 a_30160_157284# a_29586_159564# a_31510_152822# VDD pfet_06v0 ad=4.4p pd=20.88u as=4.4p ps=20.88u w=10u l=1u
D15 VSS S2P diode_nd2ps_06v0 pj=40u area=99.99999p
X335 a_114466_182316# a_46710_182443# VDD VDD pfet_06v0 ad=0.99p pd=3.66u as=1.32p ps=6.88u w=3u l=1u
X336 a_97248_157734# a_112666_157284# VSS ppolyf_u_1k r_width=1u r_length=76.45u
X337 VDD a_84994_178107# a_92966_173707# VDD pfet_06v0 ad=2.6p pd=10.52u as=2.6p ps=10.52u w=10u l=1u
X338 a_101060_182600# a_99096_182484# a_100760_182600# VSS nfet_06v0 ad=0.175p pd=1.2u as=0.175p ps=1.2u w=0.7u l=1u
X339 a_68418_190997# a_68218_190953# VSS VSS nfet_06v0 ad=1.25p pd=5.5u as=2.2p ps=10.88u w=5u l=1u
X340 a_32522_185913# a_29286_185797# VDD VDD pfet_06v0 ad=2.5p pd=10.5u as=4.4p ps=20.88u w=10u l=1u
X341 a_74474_135712# a_74274_135596# a_75286_135712# VDD pfet_06v0 ad=4.4p pd=20.88u as=2.5p ps=10.5u w=10u l=1u
X342 a_32786_128810# a_36382_136796# a_33334_135712# VDD pfet_06v0 ad=1.76p pd=8.88u as=1.76p ps=8.88u w=4u l=1u
X343 S1P a_63208_205808# VDD ppolyf_u r_width=16u r_length=4u
X344 a_74848_157284# a_90266_157284# VSS ppolyf_u_1k r_width=1u r_length=76.45u
X345 a_76398_137602# a_35862_164967# cap_mim_2f0_m4m5_noshield c_width=25u c_length=8u
X346 VSS a_69782_191067# a_99134_183692# VSS nfet_06v0 ad=0.44p pd=2.88u as=0.33p ps=1.66u w=1u l=1u
X347 a_58462_185843# a_52318_182329# a_61358_182443# VSS nfet_06v0 ad=1.1p pd=5.88u as=0.65p ps=3.02u w=2.5u l=1u
X348 a_52560_157284# a_51986_159564# a_53910_152822# VDD pfet_06v0 ad=4.4p pd=20.88u as=4.4p ps=20.88u w=10u l=1u
X349 a_38218_159680# a_38018_159564# VDD VDD pfet_06v0 ad=2.5p pd=10.5u as=4.4p ps=20.88u w=10u l=1u
X350 a_83430_191067# a_89358_195421# a_83878_195467# VDD pfet_06v0 ad=2.2p pd=10.88u as=2.2p ps=10.88u w=5u l=1u
X351 a_29486_147696# a_29286_147580# VDD VDD pfet_06v0 ad=2.5p pd=10.5u as=4.4p ps=20.88u w=10u l=1u
X352 VDD VSS VDD VDD pfet_06v0 ad=7.92p pd=36.88u as=0 ps=0 w=18u l=2u
X353 a_80202_168553# a_57822_164967# a_81646_168483# VDD pfet_06v0 ad=4.4p pd=20.88u as=2.6p ps=10.52u w=10u l=1u
X354 a_57018_168553# a_35862_164967# a_59578_168483# VDD pfet_06v0 ad=4.4p pd=20.88u as=2.6p ps=10.52u w=10u l=1u
X355 a_38286_173707# a_43102_178061# a_38738_178107# VDD pfet_06v0 ad=2.2p pd=10.88u as=2.2p ps=10.88u w=5u l=1u
X356 YP_OUT YN_OUT VSS VSS nfet_05v0 ad=0.5808p pd=3.52u as=0.5808p ps=3.52u w=1.32u l=0.6u
D16 S4N VDD diode_pd2nw_06v0 pj=40u area=99.99999p
X357 a_52318_164969# a_52658_168437# a_52558_168553# VDD pfet_06v0 ad=4.4p pd=20.88u as=2.5p ps=10.5u w=10u l=1u
X358 a_58022_173707# a_52658_177061# a_61810_178107# VDD pfet_06v0 ad=2.2p pd=10.88u as=1.3p ps=5.52u w=5u l=1u
X359 a_97248_157284# a_112666_157284# VSS ppolyf_u_1k r_width=1u r_length=76.45u
X360 a_43102_178061# a_43102_178061# a_44738_177061# VDD pfet_06v0 ad=4.4p pd=20.88u as=3.3p ps=10.66u w=10u l=1u
X361 a_52560_146650# a_67978_146200# VSS ppolyf_u_1k r_width=1u r_length=76.45u
X362 VDD a_61810_169483# a_69782_165083# VDD pfet_06v0 ad=2.6p pd=10.52u as=2.6p ps=10.52u w=10u l=1u
X363 a_77474_152778# a_81070_160764# a_78022_159680# VDD pfet_06v0 ad=1.76p pd=8.88u as=1.76p ps=8.88u w=4u l=1u
X364 VDD a_52358_168437# a_57350_168553# VDD pfet_06v0 ad=4.4p pd=20.88u as=2.5p ps=10.5u w=10u l=1u
X365 a_76434_190997# a_76234_190953# VSS VSS nfet_06v0 ad=1.25p pd=5.5u as=2.2p ps=10.88u w=5u l=1u
X366 VDD VSS VDD VDD pfet_06v0 ad=7.92p pd=36.88u as=0 ps=0 w=18u l=2u
X367 a_59578_177107# a_60246_173707# VSS VSS nfet_06v0 ad=0.65p pd=3.02u as=0.65p ps=3.02u w=2.5u l=1u
X368 VDD VSS VDD VDD pfet_06v0 ad=4.29p pd=20.38u as=0 ps=0 w=9.75u l=2u
X369 a_59134_165083# a_35862_164967# a_56658_165013# VSS nfet_06v0 ad=1.3p pd=5.52u as=2.2p ps=10.88u w=5u l=1u
X370 a_38286_165083# a_29246_164969# a_35390_168483# VSS nfet_06v0 ad=0.65p pd=3.02u as=1.1p ps=5.88u w=2.5u l=1u
X371 a_53670_168553# a_52358_168437# VDD VDD pfet_06v0 ad=2.5p pd=10.5u as=4.4p ps=20.88u w=10u l=1u
X372 a_61358_182443# a_66174_186797# a_61810_186843# VDD pfet_06v0 ad=2.2p pd=10.88u as=2.2p ps=10.88u w=5u l=1u
X373 a_73974_147580# a_74274_147580# a_91746_147696# VDD pfet_06v0 ad=4.4p pd=20.88u as=2.5p ps=10.5u w=10u l=1u
X374 a_83430_165083# a_75502_164969# a_82762_168483# VSS nfet_06v0 ad=0.65p pd=3.02u as=1.1p ps=5.88u w=2.5u l=1u
X375 a_82706_135596# a_74274_135596# a_82906_135712# VDD pfet_06v0 ad=3.3p pd=10.66u as=2.5p ps=10.5u w=10u l=1u
X376 a_30160_157284# a_34926_152778# a_34394_152822# VSS nfet_06v0 ad=0.88p pd=4.88u as=0.88p ps=4.88u w=2u l=1u
X377 a_23448_131216# a_100246_175068# a_100158_175184# VSS nfet_06v0 ad=0.6448p pd=3u as=1.0912p ps=5.84u w=2.48u l=1u
X378 a_29246_152778# a_29546_152778# a_40462_152822# VSS nfet_06v0 ad=2.2p pd=10.88u as=1.25p ps=5.5u w=5u l=1u
X379 a_36506_194467# a_29246_190953# a_37174_191067# VSS nfet_06v0 ad=1.1p pd=5.88u as=0.65p ps=3.02u w=2.5u l=1u
X380 a_57822_190951# a_79082_152822# VSS VSS nfet_06v0 ad=0.44p pd=2.88u as=0.44p ps=2.88u w=1u l=1u
X381 a_90994_168437# a_75842_168437# a_91194_168553# VDD pfet_06v0 ad=3.3p pd=10.66u as=2.5p ps=10.5u w=10u l=1u
X382 VSS VDD VSS VSS nfet_06v0 ad=4.29p pd=20.38u as=0 ps=0 w=9.75u l=2u
X383 VDD a_83878_178107# a_81206_173707# VDD pfet_06v0 ad=2.2p pd=10.88u as=1.3p ps=5.52u w=5u l=1u
X384 VDD a_60694_195467# a_59134_191067# VDD pfet_06v0 ad=2.2p pd=10.88u as=1.3p ps=5.52u w=5u l=1u
X385 a_79842_190997# a_34750_190951# a_82318_191067# VSS nfet_06v0 ad=2.2p pd=10.88u as=1.3p ps=5.52u w=5u l=1u
X386 a_79082_128854# a_81070_136796# a_74848_133316# VDD pfet_06v0 ad=1.76p pd=8.88u as=1.76p ps=8.88u w=4u l=1u
X387 a_35862_164967# a_74848_133316# VDD VDD pfet_06v0 ad=0.44p pd=2.88u as=0.44p ps=2.88u w=1u l=1u
X388 a_52560_157284# a_57326_152778# a_56794_152822# VSS nfet_06v0 ad=0.88p pd=4.88u as=0.88p ps=4.88u w=2u l=1u
X389 a_98798_161570# a_31310_128810# a_96874_159680# VDD pfet_06v0 ad=0.242p pd=1.98u as=0.242p ps=1.98u w=0.55u l=1u
X390 a_58462_177107# a_38998_140838# a_57018_177177# VDD pfet_06v0 ad=2.6p pd=10.52u as=4.4p ps=20.88u w=10u l=1u
X391 a_37174_182443# a_43102_186797# a_37622_186843# VDD pfet_06v0 ad=2.2p pd=10.88u as=2.2p ps=10.88u w=5u l=1u
X392 a_74434_152822# a_74234_152778# a_75166_152822# VSS nfet_06v0 ad=2.2p pd=10.88u as=1.25p ps=5.5u w=5u l=1u
X393 VDD VSS VDD VDD pfet_06v0 ad=4.29p pd=20.38u as=0 ps=0 w=9.75u l=2u
X394 a_82322_140838# a_82122_140794# VSS VSS nfet_06v0 ad=1.25p pd=5.5u as=2.2p ps=10.88u w=5u l=1u
X395 a_33646_185913# a_29286_185797# VDD VDD pfet_06v0 ad=2.5p pd=10.5u as=4.4p ps=20.88u w=10u l=1u
X396 a_46710_182443# a_38286_182443# VSS VSS nfet_06v0 ad=2.2p pd=10.88u as=1.3p ps=5.52u w=5u l=1u
X397 VSS VDD VSS VSS nfet_06v0 ad=7.92p pd=36.88u as=0 ps=0 w=18u l=2u
X398 a_102380_177524# a_23448_131216# VDD VDD pfet_05v0 ad=0.8052p pd=4.54u as=0.8052p ps=4.54u w=1.83u l=0.5u
X399 a_82318_182443# a_75842_185797# a_83878_186843# VDD pfet_06v0 ad=2.2p pd=10.88u as=1.3p ps=5.52u w=5u l=1u
X400 a_30160_133316# a_34926_128810# a_34394_128854# VSS nfet_06v0 ad=0.88p pd=4.88u as=0.88p ps=4.88u w=2u l=1u
X401 a_36062_191067# a_35862_190951# a_33586_190997# VSS nfet_06v0 ad=1.3p pd=5.52u as=2.2p ps=10.88u w=5u l=1u
X402 a_29246_128810# a_29546_128810# a_40462_128854# VSS nfet_06v0 ad=2.2p pd=10.88u as=1.25p ps=5.5u w=5u l=1u
X403 a_45134_147696# a_29286_147580# VDD VDD pfet_06v0 ad=2.5p pd=10.5u as=4.4p ps=20.88u w=10u l=1u
X404 a_75502_190953# a_75842_194421# a_75742_194537# VDD pfet_06v0 ad=4.4p pd=20.88u as=2.5p ps=10.5u w=10u l=1u
D17 X VDD diode_pd2nw_06v0 pj=40u area=99.99999p
X405 VDD a_83878_195467# a_81206_191067# VDD pfet_06v0 ad=1.3p pd=5.52u as=1.3p ps=5.52u w=5u l=1u
X406 a_35862_164967# a_79082_128854# VSS VSS nfet_06v0 ad=0.44p pd=2.88u as=0.44p ps=2.88u w=1u l=1u
X407 a_23448_70736# a_99134_183692# a_99046_183808# VSS nfet_06v0 ad=0.6448p pd=3u as=1.0912p ps=5.84u w=2.48u l=1u
X408 a_57018_168553# a_57822_164967# a_58462_168483# VDD pfet_06v0 ad=4.4p pd=20.88u as=2.6p ps=10.52u w=10u l=1u
D18 S1P VDD diode_pd2nw_06v0 pj=40u area=99.99999p
X409 a_58022_191067# a_60694_195467# VDD VDD pfet_06v0 ad=1.3p pd=5.52u as=2.2p ps=10.88u w=5u l=1u
X410 a_52560_133316# a_57326_128810# a_56794_128854# VSS nfet_06v0 ad=0.88p pd=4.88u as=0.88p ps=4.88u w=2u l=1u
X411 VDD a_60694_169483# a_58022_165083# VDD pfet_06v0 ad=2.2p pd=10.88u as=1.3p ps=5.52u w=5u l=1u
X412 a_114146_135712# a_96374_135596# VDD VDD pfet_06v0 ad=2.5p pd=10.5u as=4.4p ps=20.88u w=10u l=1u
X413 a_29486_177177# a_29286_177061# VDD VDD pfet_06v0 ad=2.5p pd=10.5u as=4.4p ps=20.88u w=10u l=1u
X414 a_74434_128854# a_74234_128810# a_75166_128854# VSS nfet_06v0 ad=2.2p pd=10.88u as=1.25p ps=5.5u w=5u l=1u
X415 a_66174_186797# a_52318_182329# a_67374_182373# VSS nfet_06v0 ad=2.2p pd=10.88u as=1.25p ps=5.5u w=5u l=1u
X416 a_74174_135712# a_73974_135596# VDD VDD pfet_06v0 ad=2.5p pd=10.5u as=4.4p ps=20.88u w=10u l=1u
X417 VDD VSS VDD VDD pfet_06v0 ad=7.92p pd=36.88u as=0 ps=0 w=18u l=2u
X418 a_61810_178107# a_65710_173593# a_61358_173707# VSS nfet_06v0 ad=1.1p pd=5.88u as=1.1p ps=5.88u w=2.5u l=1u
X419 a_67534_147696# a_51686_147580# VDD VDD pfet_06v0 ad=2.5p pd=10.5u as=4.4p ps=20.88u w=10u l=1u
X420 a_77210_161580# a_23448_50576# a_74474_159680# VDD pfet_06v0 ad=0.22p pd=1.88u as=0.22p ps=1.88u w=0.5u l=1u
X421 a_90558_165013# a_76234_164969# VSS VSS nfet_06v0 ad=1.25p pd=5.5u as=2.2p ps=10.88u w=5u l=1u
X422 VDD a_29286_168437# a_34278_168553# VDD pfet_06v0 ad=4.4p pd=20.88u as=2.5p ps=10.5u w=10u l=1u
X423 VDD a_23448_190688# a_23448_190688# VDD pfet_06v0 ad=0.88p pd=4.88u as=0.52p ps=2.52u w=2u l=1u
X424 a_79902_185913# a_75542_185797# VDD VDD pfet_06v0 ad=2.5p pd=10.5u as=4.4p ps=20.88u w=10u l=1u
X425 a_92966_173707# a_84994_178107# VDD VDD pfet_06v0 ad=2.6p pd=10.52u as=4.4p ps=20.88u w=10u l=1u
X426 a_101482_140838# a_103470_148780# a_97248_145300# VDD pfet_06v0 ad=1.76p pd=8.88u as=1.76p ps=8.88u w=4u l=1u
X427 a_81646_185843# a_75502_182329# a_84542_182443# VSS nfet_06v0 ad=1.1p pd=5.88u as=0.65p ps=3.02u w=2.5u l=1u
X428 a_30598_168553# a_29286_168437# VDD VDD pfet_06v0 ad=2.5p pd=10.5u as=4.4p ps=20.88u w=10u l=1u
X429 a_96574_135712# a_96374_135596# VDD VDD pfet_06v0 ad=2.5p pd=10.5u as=4.4p ps=20.88u w=10u l=1u
X430 a_98798_149586# a_57822_182327# cap_mim_2f0_m4m5_noshield c_width=25u c_length=8u
X431 a_51846_152822# a_51646_152778# VSS VSS nfet_06v0 ad=1.25p pd=5.5u as=2.2p ps=10.88u w=5u l=1u
X432 a_99096_173860# a_99096_173860# a_101360_173976# VSS nfet_06v0 ad=0.308p pd=2.28u as=0.175p ps=1.2u w=0.7u l=1u
X433 a_52146_140838# a_51946_140794# a_52878_140838# VSS nfet_06v0 ad=2.2p pd=10.88u as=1.25p ps=5.5u w=5u l=1u
X434 a_29286_159564# a_29586_159564# a_47058_159680# VDD pfet_06v0 ad=4.4p pd=20.88u as=2.5p ps=10.5u w=10u l=1u
X435 a_74234_140794# a_74234_140794# VSS VSS nfet_06v0 ad=0.44p pd=2.88u as=0.44p ps=2.88u w=1u l=1u
X436 a_51686_159564# a_51986_159564# a_63894_152822# VSS nfet_06v0 ad=0.44p pd=2.88u as=0.25p ps=1.5u w=1u l=1u
X437 VDD VSS VDD VDD pfet_06v0 ad=7.92p pd=36.88u as=0 ps=0 w=18u l=2u
X438 VSS VDD VSS VSS nfet_06v0 ad=4.29p pd=20.38u as=0 ps=0 w=9.75u l=2u
X439 a_102104_173976# a_99096_173860# VSS VSS nfet_06v0 ad=0.5456p pd=3.36u as=0.5456p ps=3.36u w=1.24u l=1u
X440 a_102002_175184# a_23448_131216# a_103402_175114# VSS nfet_06v0 ad=0.88p pd=4.88u as=0.5p ps=2.5u w=2u l=1u
X441 a_61810_178107# a_52658_177061# a_58022_173707# VDD pfet_06v0 ad=1.3p pd=5.52u as=2.2p ps=10.88u w=5u l=1u
X442 a_33946_194537# a_34750_190951# a_35390_194467# VDD pfet_06v0 ad=4.4p pd=20.88u as=2.6p ps=10.52u w=10u l=1u
X443 a_51946_128810# a_51986_135596# a_66422_135712# VDD pfet_06v0 ad=4.4p pd=20.88u as=2.5p ps=10.5u w=10u l=1u
X444 VDD a_84994_169483# a_92966_165083# VDD pfet_06v0 ad=2.6p pd=10.52u as=2.6p ps=10.52u w=10u l=1u
X445 VDD a_37622_195467# a_34950_191067# VDD pfet_06v0 ad=2.2p pd=10.88u as=1.3p ps=5.52u w=5u l=1u
X446 VSS a_60246_182443# a_58462_185843# VSS nfet_06v0 ad=1.1p pd=5.88u as=0.65p ps=3.02u w=2.5u l=1u
X447 a_99874_128810# a_103470_136796# a_100422_135712# VDD pfet_06v0 ad=1.76p pd=8.88u as=1.76p ps=8.88u w=4u l=1u
X448 a_87214_152822# a_74274_159564# VSS VSS nfet_06v0 ad=0.25p pd=1.5u as=0.44p ps=2.88u w=1u l=1u
X449 VSS VDD VSS VSS nfet_06v0 ad=7.92p pd=36.88u as=0 ps=0 w=18u l=2u
X450 a_58782_160764# a_58782_160764# a_60418_159564# VDD pfet_06v0 ad=4.4p pd=20.88u as=3.3p ps=10.66u w=10u l=1u
X451 a_29586_194421# a_29586_194421# a_32242_190997# VSS nfet_06v0 ad=0.44p pd=2.88u as=0.25p ps=1.5u w=1u l=1u
X452 a_105306_159680# a_105106_159564# VDD VDD pfet_06v0 ad=2.5p pd=10.5u as=4.4p ps=20.88u w=10u l=1u
X453 VSS a_46710_173707# a_115398_173624# VSS nfet_06v0 ad=0.44p pd=2.88u as=0.25p ps=1.5u w=1u l=1u
X454 a_52560_146650# a_35862_173591# VSS ppolyf_u_1k r_width=1u r_length=76.45u
X455 a_51846_128854# a_51646_128810# VSS VSS nfet_06v0 ad=1.25p pd=5.5u as=2.2p ps=10.88u w=5u l=1u
X456 a_34926_152778# a_29586_159564# a_39662_159680# VDD pfet_06v0 ad=4.4p pd=20.88u as=2.5p ps=10.5u w=10u l=1u
X457 a_56658_190997# a_35862_190951# a_59134_191067# VSS nfet_06v0 ad=2.2p pd=10.88u as=1.3p ps=5.52u w=5u l=1u
X458 a_58462_194467# a_60246_191067# VSS VSS nfet_06v0 ad=0.65p pd=3.02u as=0.65p ps=3.02u w=2.5u l=1u
X459 a_76854_168553# a_75542_168437# VDD VDD pfet_06v0 ad=2.5p pd=10.5u as=4.4p ps=20.88u w=10u l=1u
X460 VSS a_60246_173707# a_59578_177107# VSS nfet_06v0 ad=0.65p pd=3.02u as=0.65p ps=3.02u w=2.5u l=1u
X461 a_51686_135596# a_51986_135596# a_63894_128854# VSS nfet_06v0 ad=0.44p pd=2.88u as=0.25p ps=1.5u w=1u l=1u
X462 a_82318_173707# a_83878_178107# VDD VDD pfet_06v0 ad=1.3p pd=5.52u as=2.2p ps=10.88u w=5u l=1u
X463 a_58462_168483# a_60246_165083# VSS VSS nfet_06v0 ad=0.65p pd=3.02u as=1.1p ps=5.88u w=2.5u l=1u
X464 a_58022_165083# a_52658_168437# a_61810_169483# VDD pfet_06v0 ad=2.2p pd=10.88u as=1.3p ps=5.52u w=5u l=1u
X465 a_30160_134666# a_45578_134216# VSS ppolyf_u_1k r_width=1u r_length=76.45u
D19 VSS S4P diode_nd2ps_06v0 pj=40u area=99.99999p
X466 a_29246_164969# a_29246_164969# VSS VSS nfet_06v0 ad=0.44p pd=2.88u as=0.44p ps=2.88u w=1u l=1u
X467 a_65710_164969# a_52658_168437# a_69454_168553# VDD pfet_06v0 ad=4.4p pd=20.88u as=2.5p ps=10.5u w=10u l=1u
X468 a_38998_140838# a_31510_140838# cap_mim_2f0_m4m5_noshield c_width=25u c_length=8u
X469 a_55314_173637# a_52658_177061# VSS VSS nfet_06v0 ad=0.25p pd=1.5u as=0.44p ps=2.88u w=1u l=1u
X470 a_33334_135712# a_29586_135596# a_32242_128854# VDD pfet_06v0 ad=4.4p pd=20.88u as=4.4p ps=20.88u w=10u l=1u
X471 VSS VDD VSS VSS nfet_06v0 ad=4.29p pd=20.38u as=0 ps=0 w=9.75u l=2u
X472 a_87214_128854# a_74274_135596# VSS VSS nfet_06v0 ad=0.25p pd=1.5u as=0.44p ps=2.88u w=1u l=1u
X473 a_92966_182443# a_84542_182443# VSS VSS nfet_06v0 ad=1.3p pd=5.52u as=2.2p ps=10.88u w=5u l=1u
X474 VSS a_76234_190953# a_80174_190997# VSS nfet_06v0 ad=2.2p pd=10.88u as=1.25p ps=5.5u w=5u l=1u
X475 a_34950_191067# a_37622_195467# VDD VDD pfet_06v0 ad=1.3p pd=5.52u as=2.2p ps=10.88u w=5u l=1u
D20 S1P VDD diode_pd2nw_06v0 pj=40u area=99.99999p
X476 a_58022_191067# a_57822_190951# a_56658_190997# VSS nfet_06v0 ad=1.3p pd=5.52u as=2.2p ps=10.88u w=5u l=1u
X477 a_100246_166332# a_114466_173580# VDD VDD pfet_06v0 ad=1.32p pd=6.88u as=1.32p ps=6.88u w=3u l=1u
X478 a_81206_173707# a_83878_178107# VDD VDD pfet_06v0 ad=1.3p pd=5.52u as=1.3p ps=5.52u w=5u l=1u
X479 a_59134_191067# a_60694_195467# VDD VDD pfet_06v0 ad=1.3p pd=5.52u as=1.3p ps=5.52u w=5u l=1u
X480 a_78498_165013# a_75842_168437# VSS VSS nfet_06v0 ad=0.25p pd=1.5u as=0.44p ps=2.88u w=1u l=1u
X481 a_91402_164969# a_75502_164969# a_91602_165013# VSS nfet_06v0 ad=1.65p pd=5.66u as=1.25p ps=5.5u w=5u l=1u
D21 VSS S1P diode_nd2ps_06v0 pj=40u area=99.99999p
X482 VDD VSS VDD VDD pfet_06v0 ad=4.29p pd=20.38u as=0 ps=0 w=9.75u l=2u
X483 a_64926_140838# a_51986_147580# VSS VSS nfet_06v0 ad=0.25p pd=1.5u as=0.44p ps=2.88u w=1u l=1u
X484 a_97248_157284# a_102014_152778# a_101482_152822# VSS nfet_06v0 ad=0.88p pd=4.88u as=0.88p ps=4.88u w=2u l=1u
X485 a_33586_173637# a_34750_173591# a_34950_173707# VSS nfet_06v0 ad=2.2p pd=10.88u as=1.3p ps=5.52u w=5u l=1u
X486 a_56990_190997# a_52318_190953# a_56658_190997# VSS nfet_06v0 ad=1.25p pd=5.5u as=1.65p ps=5.66u w=5u l=1u
X487 a_35862_173591# a_52560_145300# VDD VDD pfet_06v0 ad=0.44p pd=2.88u as=0.44p ps=2.88u w=1u l=1u
X488 a_54110_161570# a_31310_152778# a_52186_159680# VDD pfet_06v0 ad=0.242p pd=1.98u as=0.242p ps=1.98u w=0.55u l=1u
X489 a_100760_182600# a_99096_182484# VSS VSS nfet_06v0 ad=0.175p pd=1.2u as=0.308p ps=2.28u w=0.7u l=1u
X490 a_75286_135712# a_73974_135596# VDD VDD pfet_06v0 ad=2.5p pd=10.5u as=4.4p ps=20.88u w=10u l=1u
X491 a_69782_165083# a_58022_165083# cap_mim_2f0_m4m5_noshield c_width=20u c_length=10u
X492 ZP_OUT ZN_OUT VDD VDD pfet_05v0 ad=0.8052p pd=4.54u as=0.8052p ps=4.54u w=1.83u l=0.5u
X493 VDD VSS VDD VDD pfet_06v0 ad=7.92p pd=36.88u as=0 ps=0 w=18u l=2u
X494 a_42638_190953# a_29586_194421# a_46382_194537# VDD pfet_06v0 ad=4.4p pd=20.88u as=2.5p ps=10.5u w=10u l=1u
X495 VDD VSS VDD VDD pfet_06v0 ad=0.44p pd=2.88u as=0 ps=0 w=1u l=2u
X496 a_53050_164969# a_52318_164969# a_53250_165013# VSS nfet_06v0 ad=2.2p pd=10.88u as=1.25p ps=5.5u w=5u l=1u
X497 VDD a_83878_169483# a_81206_165083# VDD pfet_06v0 ad=2.2p pd=10.88u as=1.3p ps=5.52u w=5u l=1u
X498 VSS a_83430_173707# a_81646_177107# VSS nfet_06v0 ad=1.1p pd=5.88u as=0.65p ps=3.02u w=2.5u l=1u
X499 a_81206_191067# a_83878_195467# VDD VDD pfet_06v0 ad=1.3p pd=5.52u as=2.2p ps=10.88u w=5u l=1u
X500 a_58990_140838# a_51646_140794# VSS VSS nfet_06v0 ad=1.25p pd=5.5u as=2.2p ps=10.88u w=5u l=1u
X501 a_35862_182327# a_30160_157284# VDD VDD pfet_06v0 ad=0.44p pd=2.88u as=0.44p ps=2.88u w=1u l=1u
X502 a_36382_148780# a_36382_148780# a_38018_147580# VDD pfet_06v0 ad=4.4p pd=20.88u as=3.3p ps=10.66u w=10u l=1u
X503 a_58462_168483# a_57822_164967# a_57018_168553# VDD pfet_06v0 ad=2.6p pd=10.52u as=4.4p ps=20.88u w=10u l=1u
X504 a_29246_128810# a_29586_135596# a_45134_135712# VDD pfet_06v0 ad=4.4p pd=20.88u as=2.5p ps=10.5u w=10u l=1u
X505 a_84994_178107# a_88894_173593# a_84542_173707# VSS nfet_06v0 ad=1.1p pd=5.88u as=1.1p ps=5.88u w=2.5u l=1u
D22 S4P VDD diode_pd2nw_06v0 pj=40u area=99.99999p
X506 a_52558_168553# a_52358_168437# VDD VDD pfet_06v0 ad=2.5p pd=10.5u as=4.4p ps=20.88u w=10u l=1u
X507 a_82318_165083# a_34750_164967# a_79842_165013# VSS nfet_06v0 ad=1.3p pd=5.52u as=2.2p ps=10.88u w=5u l=1u
X508 a_97248_133316# a_102014_128810# a_101482_128854# VSS nfet_06v0 ad=0.88p pd=4.88u as=0.88p ps=4.88u w=2u l=1u
X509 VDD VSS VDD VDD pfet_06v0 ad=4.29p pd=20.38u as=0 ps=0 w=9.75u l=2u
X510 a_36506_185843# a_37174_182443# VSS VSS nfet_06v0 ad=0.65p pd=3.02u as=1.1p ps=5.88u w=2.5u l=1u
X511 a_23448_190688# a_23448_190688# VDD VDD pfet_06v0 ad=0.52p pd=2.52u as=0.52p ps=2.52u w=2u l=1u
X512 a_33586_165013# a_29246_164969# a_33286_165013# VSS nfet_06v0 ad=1.65p pd=5.66u as=1.25p ps=5.5u w=5u l=1u
X513 a_60694_186843# a_65710_182329# a_60246_182443# VSS nfet_06v0 ad=1.1p pd=5.88u as=1.1p ps=5.88u w=2.5u l=1u
X514 a_84542_182443# a_75502_182329# a_81646_185843# VSS nfet_06v0 ad=0.65p pd=3.02u as=1.1p ps=5.88u w=2.5u l=1u
X515 a_57350_168553# a_52658_168437# a_57018_168553# VDD pfet_06v0 ad=2.5p pd=10.5u as=3.3p ps=10.66u w=10u l=1u
X516 VDD VSS VDD VDD pfet_06v0 ad=7.92p pd=36.88u as=0 ps=0 w=18u l=2u
X517 a_46710_182443# a_38738_186843# VDD VDD pfet_06v0 ad=4.4p pd=20.88u as=2.6p ps=10.52u w=10u l=1u
X518 a_89358_169437# a_89358_169437# a_90994_168437# VDD pfet_06v0 ad=4.4p pd=20.88u as=3.3p ps=10.66u w=10u l=1u
X519 VSS a_38286_173707# a_46710_173707# VSS nfet_06v0 ad=1.3p pd=5.52u as=1.3p ps=5.52u w=5u l=1u
X520 a_92966_191067# a_84994_195467# VDD VDD pfet_06v0 ad=4.4p pd=20.88u as=2.6p ps=10.52u w=10u l=1u
X521 a_35390_194467# a_34750_190951# a_33946_194537# VDD pfet_06v0 ad=2.6p pd=10.52u as=4.4p ps=20.88u w=10u l=1u
X522 VDD VSS VDD VDD pfet_06v0 ad=0.44p pd=2.88u as=0 ps=0 w=1u l=2u
X523 a_91746_147696# a_73974_147580# VDD VDD pfet_06v0 ad=2.5p pd=10.5u as=4.4p ps=20.88u w=10u l=1u
X524 a_92966_165083# a_84994_169483# VDD VDD pfet_06v0 ad=2.6p pd=10.52u as=4.4p ps=20.88u w=10u l=1u
X525 a_32786_152778# a_29546_152778# a_32522_161580# VSS nfet_06v0 ad=1.1p pd=5.88u as=0.825p ps=3.16u w=2.5u l=1u
X526 a_81206_182443# a_75842_185797# a_84994_186843# VDD pfet_06v0 ad=2.2p pd=10.88u as=1.3p ps=5.52u w=5u l=1u
X527 a_40462_152822# a_29246_152778# VSS VSS nfet_06v0 ad=1.25p pd=5.5u as=2.2p ps=10.88u w=5u l=1u
X528 a_29286_147580# a_29586_147580# a_41494_140838# VSS nfet_06v0 ad=0.44p pd=2.88u as=0.25p ps=1.5u w=1u l=1u
X529 a_52560_158634# a_67978_158184# VSS ppolyf_u_1k r_width=1u r_length=76.45u
X530 VDD a_38738_195467# a_46710_191067# VDD pfet_06v0 ad=2.6p pd=10.52u as=2.6p ps=10.52u w=10u l=1u
X531 a_79842_165013# a_75502_164969# a_79542_165013# VSS nfet_06v0 ad=1.65p pd=5.66u as=1.25p ps=5.5u w=5u l=1u
X532 VSS a_37174_165083# a_36506_168483# VSS nfet_06v0 ad=1.1p pd=5.88u as=0.65p ps=3.02u w=2.5u l=1u
X533 VSS a_83430_173707# a_82762_177107# VSS nfet_06v0 ad=0.65p pd=3.02u as=0.65p ps=3.02u w=2.5u l=1u
X534 a_57822_164967# a_52560_133316# VDD VDD pfet_06v0 ad=0.44p pd=2.88u as=0.44p ps=2.88u w=1u l=1u
X535 a_99046_175184# a_99134_175068# a_23448_131216# VSS nfet_06v0 ad=1.0912p pd=5.84u as=0.6448p ps=3u w=2.48u l=1u
X536 a_96374_159564# a_96674_159564# a_114146_159680# VDD pfet_06v0 ad=4.4p pd=20.88u as=2.5p ps=10.5u w=10u l=1u
X537 a_32242_152822# a_32042_152778# a_29746_152822# VSS nfet_06v0 ad=3.74p pd=17.88u as=3.74p ps=17.88u w=8.5u l=1u
X538 VDD a_23448_131216# a_23448_131216# VDD pfet_06v0 ad=0.52p pd=2.52u as=0.52p ps=2.52u w=2u l=1u
D23 VSS S1P diode_nd2ps_06v0 pj=40u area=99.99999p
X539 VSS a_60246_191067# a_58462_194467# VSS nfet_06v0 ad=0.65p pd=3.02u as=0.65p ps=3.02u w=2.5u l=1u
X540 a_74474_159680# a_74274_159564# a_74174_159680# VDD pfet_06v0 ad=4.4p pd=20.88u as=2.5p ps=10.5u w=10u l=1u
X541 a_59578_177107# a_60246_173707# VSS VSS nfet_06v0 ad=0.65p pd=3.02u as=1.1p ps=5.88u w=2.5u l=1u
X542 a_80202_185913# a_34750_182327# a_82762_185843# VDD pfet_06v0 ad=4.4p pd=20.88u as=2.6p ps=10.52u w=10u l=1u
X543 a_68218_164969# a_52318_164969# a_68418_165013# VSS nfet_06v0 ad=1.65p pd=5.66u as=1.25p ps=5.5u w=5u l=1u
X544 a_61810_169483# a_52658_168437# a_58022_165083# VDD pfet_06v0 ad=1.3p pd=5.52u as=2.2p ps=10.88u w=5u l=1u
X545 VSS a_69782_173707# a_100246_183692# VSS nfet_06v0 ad=0.44p pd=2.88u as=0.33p ps=1.66u w=1u l=1u
X546 VSS VDD VSS VSS nfet_06v0 ad=0.44p pd=2.88u as=0 ps=0 w=1u l=2u
X547 a_92966_182443# a_81206_182443# cap_mim_2f0_m4m5_noshield c_width=20u c_length=10u
X548 a_97248_145300# a_96674_147580# a_98598_140838# VDD pfet_06v0 ad=4.4p pd=20.88u as=4.4p ps=20.88u w=10u l=1u
X549 a_29978_164969# a_29246_164969# a_30178_165013# VSS nfet_06v0 ad=2.2p pd=10.88u as=1.25p ps=5.5u w=5u l=1u
X550 VSS VDD VSS VSS nfet_06v0 ad=4.29p pd=20.38u as=0 ps=0 w=9.75u l=2u
X551 a_96334_140794# a_96634_140794# a_107550_140838# VSS nfet_06v0 ad=2.2p pd=10.88u as=1.25p ps=5.5u w=5u l=1u
X552 a_30160_134666# a_34750_164967# VSS ppolyf_u_1k r_width=1u r_length=76.45u
X553 VSS VDD VSS VSS nfet_06v0 ad=7.92p pd=36.88u as=0 ps=0 w=18u l=2u
X554 a_38738_195467# a_42638_190953# a_38286_191067# VSS nfet_06v0 ad=1.1p pd=5.88u as=1.1p ps=5.88u w=2.5u l=1u
X555 a_32786_128810# a_29546_128810# a_32522_137612# VSS nfet_06v0 ad=1.1p pd=5.88u as=0.825p ps=3.16u w=2.5u l=1u
X556 a_52560_157734# a_67978_158184# VSS ppolyf_u_1k r_width=1u r_length=76.45u
X557 a_104234_175068# a_111626_164956# VDD VDD pfet_06v0 ad=1.32p pd=6.88u as=1.32p ps=6.88u w=3u l=1u
X558 a_40462_128854# a_29246_128810# VSS VSS nfet_06v0 ad=1.25p pd=5.5u as=2.2p ps=10.88u w=5u l=1u
X559 a_75742_194537# a_75542_194421# VDD VDD pfet_06v0 ad=2.5p pd=10.5u as=4.4p ps=20.88u w=10u l=1u
X560 a_60246_182443# a_52318_182329# a_59578_185843# VSS nfet_06v0 ad=0.65p pd=3.02u as=1.1p ps=5.88u w=2.5u l=1u
X561 a_82318_191067# a_83878_195467# VDD VDD pfet_06v0 ad=1.3p pd=5.52u as=1.3p ps=5.52u w=5u l=1u
X562 a_77474_140794# a_81070_148780# a_78022_147696# VDD pfet_06v0 ad=1.76p pd=8.88u as=1.76p ps=8.88u w=4u l=1u
X563 a_102014_152778# a_96674_159564# a_106750_159680# VDD pfet_06v0 ad=4.4p pd=20.88u as=2.5p ps=10.5u w=10u l=1u
X564 a_66174_195421# a_66174_195421# a_67810_194421# VDD pfet_06v0 ad=4.4p pd=20.88u as=3.3p ps=10.66u w=10u l=1u
X565 VDD a_75542_185797# a_80534_185913# VDD pfet_06v0 ad=4.4p pd=20.88u as=2.5p ps=10.5u w=10u l=1u
X566 a_32242_128854# a_32042_128810# a_29746_128854# VSS nfet_06v0 ad=3.74p pd=17.88u as=3.74p ps=17.88u w=8.5u l=1u
X567 a_35390_185843# a_46710_182443# cap_mim_2f0_m4m5_noshield c_width=20u c_length=10u
X568 a_82318_165083# a_83878_169483# VDD VDD pfet_06v0 ad=1.3p pd=5.52u as=2.2p ps=10.88u w=5u l=1u
X569 VDD a_60694_195467# a_59134_191067# VDD pfet_06v0 ad=1.3p pd=5.52u as=1.3p ps=5.52u w=5u l=1u
X570 a_67374_182373# a_53050_182329# VSS VSS nfet_06v0 ad=1.25p pd=5.5u as=2.2p ps=10.88u w=5u l=1u
X571 a_80174_190997# a_75502_190953# a_79842_190997# VSS nfet_06v0 ad=1.25p pd=5.5u as=1.65p ps=5.66u w=5u l=1u
X572 a_37622_186843# a_42638_182329# a_37174_182443# VSS nfet_06v0 ad=1.1p pd=5.88u as=1.1p ps=5.88u w=2.5u l=1u
X573 a_23448_190688# a_23448_190688# VDD VDD pfet_06v0 ad=0.52p pd=2.52u as=0.52p ps=2.52u w=2u l=1u
X574 VDD a_37622_195467# a_36062_191067# VDD pfet_06v0 ad=1.3p pd=5.52u as=1.3p ps=5.52u w=5u l=1u
X575 a_100422_135712# a_96674_135596# a_99330_128854# VDD pfet_06v0 ad=4.4p pd=20.88u as=4.4p ps=20.88u w=10u l=1u
X576 a_34278_168553# a_29586_168437# a_33946_168553# VDD pfet_06v0 ad=2.5p pd=10.5u as=3.3p ps=10.66u w=10u l=1u
X577 VSS VDD VSS VSS nfet_06v0 ad=4.29p pd=20.38u as=0 ps=0 w=9.75u l=2u
X578 a_76234_164969# a_75502_164969# a_76434_165013# VSS nfet_06v0 ad=2.2p pd=10.88u as=1.25p ps=5.5u w=5u l=1u
X579 a_44022_135712# a_29286_135596# VDD VDD pfet_06v0 ad=2.5p pd=10.5u as=4.4p ps=20.88u w=10u l=1u
X580 a_76198_152822# a_23448_31424# a_74434_152822# VSS nfet_06v0 ad=3.3p pd=15.88u as=3.3p ps=15.88u w=7.5u l=1u
X581 a_60418_159564# a_51986_159564# a_60618_159680# VDD pfet_06v0 ad=3.3p pd=10.66u as=2.5p ps=10.5u w=10u l=1u
X582 a_101360_173976# a_99096_173860# a_101060_173976# VSS nfet_06v0 ad=0.175p pd=1.2u as=0.175p ps=1.2u w=0.7u l=1u
X583 a_52186_147696# a_51986_147580# a_51886_147696# VDD pfet_06v0 ad=4.4p pd=20.88u as=2.5p ps=10.5u w=10u l=1u
X584 a_81206_165083# a_83878_169483# VDD VDD pfet_06v0 ad=1.3p pd=5.52u as=1.3p ps=5.52u w=5u l=1u
X585 a_68010_177177# a_67810_177061# VDD VDD pfet_06v0 ad=2.5p pd=10.5u as=4.4p ps=20.88u w=10u l=1u
X586 a_52878_140838# a_51646_140794# VSS VSS nfet_06v0 ad=1.25p pd=5.5u as=2.2p ps=10.88u w=5u l=1u
X587 a_63894_152822# a_51986_159564# VSS VSS nfet_06v0 ad=0.25p pd=1.5u as=0.44p ps=2.88u w=1u l=1u
X588 a_59578_168483# a_60246_165083# VSS VSS nfet_06v0 ad=0.65p pd=3.02u as=0.65p ps=3.02u w=2.5u l=1u
X589 VDD VSS VDD VDD pfet_06v0 ad=0.44p pd=2.88u as=0 ps=0 w=1u l=2u
X590 a_35390_185843# a_37174_182443# VSS VSS nfet_06v0 ad=0.65p pd=3.02u as=0.65p ps=3.02u w=2.5u l=1u
X591 a_98798_149586# a_63208_205808# a_96874_147696# VDD pfet_06v0 ad=0.242p pd=1.98u as=0.242p ps=1.98u w=0.55u l=1u
X592 a_103402_175114# a_23448_131216# VSS VSS nfet_06v0 ad=0.5p pd=2.5u as=0.88p ps=4.88u w=2u l=1u
X593 a_89358_178061# a_75502_173593# a_90558_173637# VSS nfet_06v0 ad=2.2p pd=10.88u as=1.25p ps=5.5u w=5u l=1u
X594 a_66422_135712# a_51686_135596# VDD VDD pfet_06v0 ad=2.5p pd=10.5u as=4.4p ps=20.88u w=10u l=1u
X595 a_56794_152822# a_51946_152778# a_54110_161570# VSS nfet_06v0 ad=1.1p pd=5.88u as=0.825p ps=3.16u w=2.5u l=1u
X596 a_98598_152822# a_31310_128810# a_96834_152822# VSS nfet_06v0 ad=3.3p pd=15.88u as=3.3p ps=15.88u w=7.5u l=1u
X597 VSS VDD VSS VSS nfet_06v0 ad=0.44p pd=2.88u as=0 ps=0 w=1u l=2u
X598 a_76398_161570# a_77474_152778# VSS VSS nfet_06v0 ad=0.825p pd=3.16u as=1.1p ps=5.88u w=2.5u l=1u
X599 VSS VDD VSS VSS nfet_06v0 ad=4.29p pd=20.38u as=0 ps=0 w=9.75u l=2u
X600 a_32242_190997# a_29586_194421# VSS VSS nfet_06v0 ad=0.25p pd=1.5u as=0.44p ps=2.88u w=1u l=1u
X601 VSS VDD VSS VSS nfet_06v0 ad=7.92p pd=36.88u as=0 ps=0 w=18u l=2u
X602 a_115398_173624# a_69782_173707# a_114466_173580# VSS nfet_06v0 ad=0.25p pd=1.5u as=0.44p ps=2.88u w=1u l=1u
X603 a_91194_185913# a_90994_185797# VDD VDD pfet_06v0 ad=2.5p pd=10.5u as=4.4p ps=20.88u w=10u l=1u
X604 a_76198_128854# a_63208_205808# a_74434_128854# VSS nfet_06v0 ad=3.3p pd=15.88u as=3.3p ps=15.88u w=7.5u l=1u
X605 a_96334_128810# a_96674_135596# a_112222_135712# VDD pfet_06v0 ad=4.4p pd=20.88u as=2.5p ps=10.5u w=10u l=1u
X606 a_81206_191067# a_57822_190951# a_79842_190997# VSS nfet_06v0 ad=1.3p pd=5.52u as=2.2p ps=10.88u w=5u l=1u
X607 a_76930_128854# a_78022_135712# VDD VDD pfet_06v0 ad=2.2p pd=10.88u as=2.2p ps=10.88u w=5u l=1u
X608 a_39662_159680# a_29286_159564# VDD VDD pfet_06v0 ad=2.5p pd=10.5u as=4.4p ps=20.88u w=10u l=1u
X609 a_63894_128854# a_51986_135596# VSS VSS nfet_06v0 ad=0.25p pd=1.5u as=0.44p ps=2.88u w=1u l=1u
X610 a_58462_185843# a_69782_182443# cap_mim_2f0_m4m5_noshield c_width=20u c_length=10u
X611 a_69454_168553# a_52358_168437# VDD VDD pfet_06v0 ad=2.5p pd=10.5u as=4.4p ps=20.88u w=10u l=1u
X612 a_110806_182360# a_46710_182443# VDD VDD pfet_06v0 ad=1.32p pd=6.88u as=1.32p ps=6.88u w=3u l=1u
X613 a_56794_128854# a_51946_128810# a_54110_137602# VSS nfet_06v0 ad=1.1p pd=5.88u as=0.825p ps=3.16u w=2.5u l=1u
D24 VSS Z diode_nd2ps_06v0 pj=40u area=99.99999p
X614 a_46710_173707# a_38286_173707# VSS VSS nfet_06v0 ad=1.3p pd=5.52u as=2.2p ps=10.88u w=5u l=1u
X615 a_98598_128854# a_63208_205808# a_96834_128854# VSS nfet_06v0 ad=3.3p pd=15.88u as=3.3p ps=15.88u w=7.5u l=1u
X616 a_29286_194421# a_29586_194421# a_32522_194537# VDD pfet_06v0 ad=4.4p pd=20.88u as=2.5p ps=10.5u w=10u l=1u
X617 a_52318_190953# a_52318_190953# VSS VSS nfet_06v0 ad=0.44p pd=2.88u as=0.44p ps=2.88u w=1u l=1u
D25 VSS Z diode_nd2ps_06v0 pj=40u area=99.99999p
X618 a_77210_149596# a_23448_50576# a_74474_147696# VDD pfet_06v0 ad=0.22p pd=1.88u as=0.22p ps=1.88u w=0.5u l=1u
X619 a_76398_137602# a_77474_128810# VSS VSS nfet_06v0 ad=0.825p pd=3.16u as=1.1p ps=5.88u w=2.5u l=1u
X620 a_34950_182443# a_37622_186843# VDD VDD pfet_06v0 ad=1.3p pd=5.52u as=1.3p ps=5.52u w=5u l=1u
X621 a_46710_191067# a_38738_195467# VDD VDD pfet_06v0 ad=2.6p pd=10.52u as=4.4p ps=20.88u w=10u l=1u
X622 a_52560_133316# a_67978_133316# VSS ppolyf_u_1k r_width=1u r_length=76.45u
X623 VSS a_83430_191067# a_81646_194467# VSS nfet_06v0 ad=0.65p pd=3.02u as=0.65p ps=3.02u w=2.5u l=1u
X624 a_82762_177107# a_83430_173707# VSS VSS nfet_06v0 ad=0.65p pd=3.02u as=1.1p ps=5.88u w=2.5u l=1u
X625 a_23448_131216# a_99134_175068# a_99046_175184# VSS nfet_06v0 ad=0.6448p pd=3u as=1.0912p ps=5.84u w=2.48u l=1u
X626 a_33334_147696# a_34926_140794# a_32786_140794# VSS nfet_06v0 ad=0.88p pd=4.88u as=0.88p ps=4.88u w=2u l=1u
X627 a_91602_165013# a_91402_164969# VSS VSS nfet_06v0 ad=1.25p pd=5.5u as=2.2p ps=10.88u w=5u l=1u
X628 a_82762_185843# a_34750_182327# a_80202_185913# VDD pfet_06v0 ad=2.6p pd=10.52u as=4.4p ps=20.88u w=10u l=1u
X629 a_78022_147696# a_74274_147580# a_76930_140838# VDD pfet_06v0 ad=4.4p pd=20.88u as=4.4p ps=20.88u w=10u l=1u
X630 a_79614_140794# a_79614_140794# a_82122_140794# VSS nfet_06v0 ad=2.2p pd=10.88u as=1.65p ps=5.66u w=5u l=1u
X631 a_103470_148780# a_96634_140794# a_103678_140838# VSS nfet_06v0 ad=2.2p pd=10.88u as=1.25p ps=5.5u w=5u l=1u
X632 a_99874_152778# a_96634_152778# a_99610_161580# VSS nfet_06v0 ad=1.1p pd=5.88u as=0.825p ps=3.16u w=2.5u l=1u
X633 a_44938_177177# a_44738_177061# VDD VDD pfet_06v0 ad=2.5p pd=10.5u as=4.4p ps=20.88u w=10u l=1u
X634 a_79614_128810# a_74274_135596# a_84350_135712# VDD pfet_06v0 ad=4.4p pd=20.88u as=2.5p ps=10.5u w=10u l=1u
X635 a_55734_147696# a_57326_140794# a_55186_140794# VSS nfet_06v0 ad=0.88p pd=4.88u as=0.88p ps=4.88u w=2u l=1u
X636 a_29786_147696# a_29586_147580# a_30598_147696# VDD pfet_06v0 ad=4.4p pd=20.88u as=2.5p ps=10.5u w=10u l=1u
X637 a_46382_194537# a_29286_194421# VDD VDD pfet_06v0 ad=2.5p pd=10.5u as=4.4p ps=20.88u w=10u l=1u
X638 a_29586_159564# a_29586_159564# VDD VDD pfet_06v0 ad=0.88p pd=4.88u as=0.88p ps=4.88u w=2u l=1u
X639 a_53250_165013# a_53050_164969# VSS VSS nfet_06v0 ad=1.25p pd=5.5u as=2.2p ps=10.88u w=5u l=1u
X640 VSS VDD VSS VSS nfet_06v0 ad=0.44p pd=2.88u as=0 ps=0 w=1u l=2u
X641 VDD VSS VDD VDD pfet_06v0 ad=7.92p pd=36.88u as=0 ps=0 w=18u l=2u
X642 a_75842_177061# a_75842_177061# a_78498_173637# VSS nfet_06v0 ad=0.44p pd=2.88u as=0.25p ps=1.5u w=1u l=1u
X643 VDD a_83878_195467# a_82318_191067# VDD pfet_06v0 ad=1.3p pd=5.52u as=1.3p ps=5.52u w=5u l=1u
X644 a_30178_165013# a_29978_164969# VSS VSS nfet_06v0 ad=1.25p pd=5.5u as=2.2p ps=10.88u w=5u l=1u
X645 a_57018_168553# a_52658_168437# a_56718_168553# VDD pfet_06v0 ad=3.3p pd=10.66u as=2.5p ps=10.5u w=10u l=1u
X646 a_33918_165013# a_29246_164969# a_33586_165013# VSS nfet_06v0 ad=1.25p pd=5.5u as=1.65p ps=5.66u w=5u l=1u
X647 a_52186_147696# a_51986_147580# a_52998_147696# VDD pfet_06v0 ad=4.4p pd=20.88u as=2.5p ps=10.5u w=10u l=1u
X648 a_53050_173593# a_52658_177061# a_53670_177177# VDD pfet_06v0 ad=4.4p pd=20.88u as=2.5p ps=10.5u w=10u l=1u
X649 VDD a_23448_190688# a_23448_190688# VDD pfet_06v0 ad=0.52p pd=2.52u as=0.52p ps=2.52u w=2u l=1u
X650 a_36062_191067# a_37622_195467# VDD VDD pfet_06v0 ad=1.3p pd=5.52u as=2.2p ps=10.88u w=5u l=1u
X651 a_88894_182329# a_75842_185797# a_92638_185913# VDD pfet_06v0 ad=4.4p pd=20.88u as=2.5p ps=10.5u w=10u l=1u
X652 a_99874_128810# a_96634_128810# a_99610_137612# VSS nfet_06v0 ad=1.1p pd=5.88u as=0.825p ps=3.16u w=2.5u l=1u
X653 VDD VSS VDD VDD pfet_06v0 ad=4.29p pd=20.38u as=0 ps=0 w=9.75u l=2u
X654 a_33286_165013# a_29978_164969# VSS VSS nfet_06v0 ad=1.25p pd=5.5u as=2.2p ps=10.88u w=5u l=1u
X655 a_73934_140794# a_74274_147580# a_89822_147696# VDD pfet_06v0 ad=4.4p pd=20.88u as=2.5p ps=10.5u w=10u l=1u
X656 a_59134_173707# a_52658_177061# a_60694_178107# VDD pfet_06v0 ad=2.2p pd=10.88u as=1.3p ps=5.52u w=5u l=1u
X657 a_61358_173707# a_52318_173593# a_58462_177107# VSS nfet_06v0 ad=0.65p pd=3.02u as=1.1p ps=5.88u w=2.5u l=1u
X658 VSS a_60246_165083# a_59578_168483# VSS nfet_06v0 ad=0.65p pd=3.02u as=0.65p ps=3.02u w=2.5u l=1u
X659 VSS a_37174_182443# a_35390_185843# VSS nfet_06v0 ad=0.65p pd=3.02u as=0.65p ps=3.02u w=2.5u l=1u
X660 a_84542_173707# a_89358_178061# a_84994_178107# VDD pfet_06v0 ad=2.2p pd=10.88u as=2.2p ps=10.88u w=5u l=1u
X661 a_33946_194537# a_29586_194421# a_33646_194537# VDD pfet_06v0 ad=3.3p pd=10.66u as=2.5p ps=10.5u w=10u l=1u
X662 a_45146_182329# a_29246_182329# a_45346_182373# VSS nfet_06v0 ad=1.65p pd=5.66u as=1.25p ps=5.5u w=5u l=1u
X663 a_111110_135712# a_96374_135596# VDD VDD pfet_06v0 ad=2.5p pd=10.5u as=4.4p ps=20.88u w=10u l=1u
X664 a_51946_152778# a_51946_152778# VSS VSS nfet_06v0 ad=0.44p pd=2.88u as=0.44p ps=2.88u w=1u l=1u
X665 a_54110_149586# a_23448_31424# a_52186_147696# VDD pfet_06v0 ad=0.242p pd=1.98u as=0.242p ps=1.98u w=0.55u l=1u
X666 a_41494_140838# a_29586_147580# VSS VSS nfet_06v0 ad=0.25p pd=1.5u as=0.44p ps=2.88u w=1u l=1u
X667 a_69782_173707# a_61358_173707# VSS VSS nfet_06v0 ad=2.2p pd=10.88u as=1.3p ps=5.52u w=5u l=1u
X668 a_103470_160764# a_103470_160764# a_105106_159564# VDD pfet_06v0 ad=4.4p pd=20.88u as=3.3p ps=10.66u w=10u l=1u
X669 a_79542_165013# a_76234_164969# VSS VSS nfet_06v0 ad=1.25p pd=5.5u as=2.2p ps=10.88u w=5u l=1u
X670 a_23448_131216# a_23448_131216# VDD VDD pfet_06v0 ad=0.52p pd=2.52u as=0.88p ps=4.88u w=2u l=1u
X671 a_53910_152822# a_31310_152778# a_52146_152822# VSS nfet_06v0 ad=3.3p pd=15.88u as=3.3p ps=15.88u w=7.5u l=1u
X672 a_52998_159680# a_51686_159564# VDD VDD pfet_06v0 ad=2.5p pd=10.5u as=4.4p ps=20.88u w=10u l=1u
X673 a_34394_140838# a_29546_140794# a_31710_149586# VSS nfet_06v0 ad=1.1p pd=5.88u as=0.825p ps=3.16u w=2.5u l=1u
X674 a_30160_145750# a_45578_145300# VSS ppolyf_u_1k r_width=1u r_length=76.45u
X675 a_96834_152822# a_96634_152778# a_96534_152822# VSS nfet_06v0 ad=2.2p pd=10.88u as=1.25p ps=5.5u w=5u l=1u
X676 a_59834_152778# a_51946_152778# a_60034_152822# VSS nfet_06v0 ad=1.65p pd=5.66u as=1.25p ps=5.5u w=5u l=1u
X677 a_34926_152778# a_34926_152778# a_37434_152778# VSS nfet_06v0 ad=2.2p pd=10.88u as=1.65p ps=5.66u w=5u l=1u
X678 VSS VDD VSS VSS nfet_06v0 ad=0.44p pd=2.88u as=0 ps=0 w=1u l=2u
X679 a_38998_140838# a_30160_145300# VDD VDD pfet_06v0 ad=0.44p pd=2.88u as=0.44p ps=2.88u w=1u l=1u
X680 VSS a_114466_182316# a_106078_166332# VSS nfet_06v0 ad=0.44p pd=2.88u as=0.44p ps=2.88u w=1u l=1u
X681 a_59578_185843# a_35862_182327# a_57018_185913# VDD pfet_06v0 ad=2.6p pd=10.52u as=4.4p ps=20.88u w=10u l=1u
X682 a_81646_185843# a_57822_182327# a_80202_185913# VDD pfet_06v0 ad=2.6p pd=10.52u as=4.4p ps=20.88u w=10u l=1u
X683 a_68418_165013# a_68218_164969# VSS VSS nfet_06v0 ad=1.25p pd=5.5u as=2.2p ps=10.88u w=5u l=1u
X684 S1N a_43160_205808# VDD ppolyf_u r_width=16u r_length=4u
X685 VDD VSS VDD VDD pfet_06v0 ad=0.44p pd=2.88u as=0 ps=0 w=1u l=2u
X686 a_104146_175184# a_99096_173860# VSS VSS nfet_06v0 ad=0.5456p pd=3.36u as=0.5456p ps=3.36u w=1.24u l=1u
X687 a_107550_140838# a_96334_140794# VSS VSS nfet_06v0 ad=1.25p pd=5.5u as=2.2p ps=10.88u w=5u l=1u
X688 a_33586_165013# a_34750_164967# a_34950_165083# VSS nfet_06v0 ad=2.2p pd=10.88u as=1.3p ps=5.52u w=5u l=1u
X689 a_29546_152778# a_29586_159564# a_44022_159680# VDD pfet_06v0 ad=4.4p pd=20.88u as=2.5p ps=10.5u w=10u l=1u
X690 a_51946_128810# a_51946_128810# VSS VSS nfet_06v0 ad=0.44p pd=2.88u as=0.44p ps=2.88u w=1u l=1u
X691 VDD a_37622_186843# a_34950_182443# VDD pfet_06v0 ad=1.3p pd=5.52u as=1.3p ps=5.52u w=5u l=1u
X692 a_69782_182443# a_61810_186843# VDD VDD pfet_06v0 ad=2.6p pd=10.52u as=4.4p ps=20.88u w=10u l=1u
X693 a_32242_152822# a_33334_159680# VDD VDD pfet_06v0 ad=2.2p pd=10.88u as=2.2p ps=10.88u w=5u l=1u
X694 a_29978_173593# a_29586_177061# a_30598_177177# VDD pfet_06v0 ad=4.4p pd=20.88u as=2.5p ps=10.5u w=10u l=1u
X695 a_53910_128854# a_31310_152778# a_52146_128854# VSS nfet_06v0 ad=3.3p pd=15.88u as=3.3p ps=15.88u w=7.5u l=1u
X696 a_106750_159680# a_96374_159564# VDD VDD pfet_06v0 ad=2.5p pd=10.5u as=4.4p ps=20.88u w=10u l=1u
X697 VSS a_83430_165083# a_81646_168483# VSS nfet_06v0 ad=1.1p pd=5.88u as=0.65p ps=3.02u w=2.5u l=1u
X698 a_81646_194467# a_83430_191067# VSS VSS nfet_06v0 ad=0.65p pd=3.02u as=1.1p ps=5.88u w=2.5u l=1u
X699 a_80534_185913# a_75842_185797# a_80202_185913# VDD pfet_06v0 ad=2.5p pd=10.5u as=3.3p ps=10.66u w=10u l=1u
X700 a_34926_128810# a_34926_128810# a_37434_128810# VSS nfet_06v0 ad=2.2p pd=10.88u as=1.65p ps=5.66u w=5u l=1u
X701 a_59834_128810# a_51946_128810# a_60034_128854# VSS nfet_06v0 ad=1.65p pd=5.66u as=1.25p ps=5.5u w=5u l=1u
X702 a_96834_128854# a_96634_128810# a_96534_128854# VSS nfet_06v0 ad=2.2p pd=10.88u as=1.25p ps=5.5u w=5u l=1u
X703 a_34750_164967# a_30160_133316# VDD VDD pfet_06v0 ad=0.44p pd=2.88u as=0.44p ps=2.88u w=1u l=1u
X704 a_57822_190951# a_74848_157284# VDD VDD pfet_06v0 ad=0.44p pd=2.88u as=0.44p ps=2.88u w=1u l=1u
X705 VSS a_111626_164956# a_104234_175068# VSS nfet_06v0 ad=0.44p pd=2.88u as=0.44p ps=2.88u w=1u l=1u
X706 VDD a_69782_182443# a_114466_182316# VDD pfet_06v0 ad=1.32p pd=6.88u as=0.99p ps=3.66u w=3u l=1u
X707 a_38738_195467# a_29586_194421# a_34950_191067# VDD pfet_06v0 ad=1.3p pd=5.52u as=2.2p ps=10.88u w=5u l=1u
X708 a_54642_152822# a_55734_159680# VDD VDD pfet_06v0 ad=2.2p pd=10.88u as=2.2p ps=10.88u w=5u l=1u
X709 a_76434_165013# a_76234_164969# VSS VSS nfet_06v0 ad=1.25p pd=5.5u as=2.2p ps=10.88u w=5u l=1u
X710 a_60618_159680# a_60418_159564# VDD VDD pfet_06v0 ad=2.5p pd=10.5u as=4.4p ps=20.88u w=10u l=1u
X711 a_51886_147696# a_51686_147580# VDD VDD pfet_06v0 ad=2.5p pd=10.5u as=4.4p ps=20.88u w=10u l=1u
X712 a_31510_152822# a_33334_159680# VDD VDD pfet_06v0 ad=2.2p pd=10.88u as=2.2p ps=10.88u w=5u l=1u
X713 a_66174_195421# a_52318_190953# a_67374_190997# VSS nfet_06v0 ad=2.2p pd=10.88u as=1.25p ps=5.5u w=5u l=1u
X714 a_29586_177061# a_29586_177061# VDD VDD pfet_06v0 ad=0.88p pd=4.88u as=0.88p ps=4.88u w=2u l=1u
X715 a_76234_173593# a_75842_177061# a_76854_177177# VDD pfet_06v0 ad=4.4p pd=20.88u as=2.5p ps=10.5u w=10u l=1u
X716 a_37434_140794# a_29546_140794# a_37634_140838# VSS nfet_06v0 ad=1.65p pd=5.66u as=1.25p ps=5.5u w=5u l=1u
X717 a_90558_173637# a_76234_173593# VSS VSS nfet_06v0 ad=1.25p pd=5.5u as=2.2p ps=10.88u w=5u l=1u
X718 VSS VDD VSS VSS nfet_06v0 ad=0.44p pd=2.88u as=0 ps=0 w=1u l=2u
X719 a_74848_157284# a_74274_159564# a_76198_152822# VDD pfet_06v0 ad=4.4p pd=20.88u as=4.4p ps=20.88u w=10u l=1u
X720 a_57822_190951# a_76198_152822# cap_mim_2f0_m4m5_noshield c_width=25u c_length=8u
X721 a_59134_182443# a_60694_186843# VDD VDD pfet_06v0 ad=1.3p pd=5.52u as=2.2p ps=10.88u w=5u l=1u
X722 VSS a_38286_165083# a_46710_165083# VSS nfet_06v0 ad=1.3p pd=5.52u as=1.3p ps=5.52u w=5u l=1u
X723 a_96674_159564# a_96674_159564# VDD VDD pfet_06v0 ad=0.88p pd=4.88u as=0.88p ps=4.88u w=2u l=1u
X724 a_112222_135712# a_96374_135596# VDD VDD pfet_06v0 ad=2.5p pd=10.5u as=4.4p ps=20.88u w=10u l=1u
X725 VSS a_83430_165083# a_82762_168483# VSS nfet_06v0 ad=0.65p pd=3.02u as=0.65p ps=3.02u w=2.5u l=1u
X726 a_80202_194537# a_75842_194421# a_79902_194537# VDD pfet_06v0 ad=3.3p pd=10.66u as=2.5p ps=10.5u w=10u l=1u
X727 a_74848_146650# a_90266_146200# VSS ppolyf_u_1k r_width=1u r_length=76.45u
X728 a_60694_178107# a_52658_177061# a_59134_173707# VDD pfet_06v0 ad=1.3p pd=5.52u as=2.2p ps=10.88u w=5u l=1u
X729 VSS VDD VSS VSS nfet_06v0 ad=7.92p pd=36.88u as=0 ps=0 w=18u l=2u
X730 a_102002_183808# a_23448_70736# a_103402_183738# VSS nfet_06v0 ad=0.88p pd=4.88u as=0.5p ps=2.5u w=2u l=1u
X731 a_59578_168483# a_60246_165083# VSS VSS nfet_06v0 ad=0.65p pd=3.02u as=1.1p ps=5.88u w=2.5u l=1u
X732 a_58022_182443# a_60694_186843# VDD VDD pfet_06v0 ad=1.3p pd=5.52u as=1.3p ps=5.52u w=5u l=1u
X733 VDD VSS VDD VDD pfet_06v0 ad=7.92p pd=36.88u as=0 ps=0 w=18u l=2u
D26 S1N VDD diode_pd2nw_06v0 pj=40u area=99.99999p
X734 a_32522_194537# a_29286_194421# VDD VDD pfet_06v0 ad=2.5p pd=10.5u as=4.4p ps=20.88u w=10u l=1u
X735 a_81070_136796# a_81070_136796# a_82706_135596# VDD pfet_06v0 ad=4.4p pd=20.88u as=3.3p ps=10.66u w=10u l=1u
X736 a_92966_173707# a_84542_173707# VSS VSS nfet_06v0 ad=2.2p pd=10.88u as=1.3p ps=5.52u w=5u l=1u
X737 a_97248_146650# a_112666_146200# VSS ppolyf_u_1k r_width=1u r_length=76.45u
X738 a_35862_190951# a_97248_157284# VDD VDD pfet_06v0 ad=0.44p pd=2.88u as=0.44p ps=2.88u w=1u l=1u
X739 VDD VSS VDD VDD pfet_06v0 ad=7.92p pd=36.88u as=0 ps=0 w=18u l=2u
X740 VDD a_37622_186843# a_36062_182443# VDD pfet_06v0 ad=2.2p pd=10.88u as=1.3p ps=5.52u w=5u l=1u
X741 a_84994_178107# a_75842_177061# a_81206_173707# VDD pfet_06v0 ad=1.3p pd=5.52u as=2.2p ps=10.88u w=5u l=1u
X742 a_58462_194467# a_52318_190953# a_61358_191067# VSS nfet_06v0 ad=1.1p pd=5.88u as=0.65p ps=3.02u w=2.5u l=1u
X743 a_59134_165083# a_52658_168437# a_60694_169483# VDD pfet_06v0 ad=2.2p pd=10.88u as=1.3p ps=5.52u w=5u l=1u
X744 a_35862_173591# a_53910_140838# cap_mim_2f0_m4m5_noshield c_width=25u c_length=8u
X745 VSS a_29978_182329# a_33918_182373# VSS nfet_06v0 ad=2.2p pd=10.88u as=1.25p ps=5.5u w=5u l=1u
X746 a_46710_182443# a_34950_182443# cap_mim_2f0_m4m5_noshield c_width=20u c_length=10u
X747 a_29246_173593# a_29246_173593# VSS VSS nfet_06v0 ad=0.44p pd=2.88u as=0.44p ps=2.88u w=1u l=1u
X748 a_52318_173593# a_52658_177061# a_52558_177177# VDD pfet_06v0 ad=4.4p pd=20.88u as=2.5p ps=10.5u w=10u l=1u
X749 a_30160_145750# a_45578_146200# VSS ppolyf_u_1k r_width=1u r_length=76.45u
X750 a_103678_140838# a_96334_140794# VSS VSS nfet_06v0 ad=1.25p pd=5.5u as=2.2p ps=10.88u w=5u l=1u
X751 a_54922_137612# a_32042_152778# a_52186_135712# VDD pfet_06v0 ad=0.22p pd=1.88u as=0.22p ps=1.88u w=0.5u l=1u
X752 a_31510_140838# a_31310_128810# a_29746_140838# VSS nfet_06v0 ad=3.3p pd=15.88u as=3.3p ps=15.88u w=7.5u l=1u
X753 a_60034_152822# a_59834_152778# VSS VSS nfet_06v0 ad=1.25p pd=5.5u as=2.2p ps=10.88u w=5u l=1u
X754 a_84350_135712# a_73974_135596# VDD VDD pfet_06v0 ad=2.5p pd=10.5u as=4.4p ps=20.88u w=10u l=1u
X755 a_30598_147696# a_29286_147580# VDD VDD pfet_06v0 ad=2.5p pd=10.5u as=4.4p ps=20.88u w=10u l=1u
X756 a_74434_140838# a_74234_140794# a_74134_140838# VSS nfet_06v0 ad=2.2p pd=10.88u as=1.25p ps=5.5u w=5u l=1u
X757 a_73934_152778# a_74234_152778# a_85150_152822# VSS nfet_06v0 ad=2.2p pd=10.88u as=1.25p ps=5.5u w=5u l=1u
X758 VDD a_52358_177061# a_57350_177177# VDD pfet_06v0 ad=4.4p pd=20.88u as=2.5p ps=10.5u w=10u l=1u
X759 a_101482_140838# a_96634_140794# a_98798_149586# VSS nfet_06v0 ad=1.1p pd=5.88u as=0.825p ps=3.16u w=2.5u l=1u
X760 a_102014_152778# a_102014_152778# a_104522_152778# VSS nfet_06v0 ad=2.2p pd=10.88u as=1.65p ps=5.66u w=5u l=1u
X761 a_78498_173637# a_75842_177061# VSS VSS nfet_06v0 ad=0.25p pd=1.5u as=0.44p ps=2.88u w=1u l=1u
X762 a_56718_168553# a_52358_168437# VDD VDD pfet_06v0 ad=2.5p pd=10.5u as=4.4p ps=20.88u w=10u l=1u
X763 VDD VSS VDD VDD pfet_06v0 ad=4.29p pd=20.38u as=0 ps=0 w=9.75u l=2u
X764 VDD a_83878_186843# a_82318_182443# VDD pfet_06v0 ad=2.2p pd=10.88u as=1.3p ps=5.52u w=5u l=1u
X765 a_91402_173593# a_75502_173593# a_91602_173637# VSS nfet_06v0 ad=1.65p pd=5.66u as=1.25p ps=5.5u w=5u l=1u
X766 a_33946_177177# a_35862_173591# a_36506_177107# VDD pfet_06v0 ad=4.4p pd=20.88u as=2.6p ps=10.52u w=10u l=1u
X767 VDD VSS VDD VDD pfet_06v0 ad=4.29p pd=20.38u as=0 ps=0 w=9.75u l=2u
X768 a_53670_177177# a_52358_177061# VDD VDD pfet_06v0 ad=2.5p pd=10.5u as=4.4p ps=20.88u w=10u l=1u
D27 VSS Y diode_nd2ps_06v0 pj=40u area=99.99999p
X769 a_61358_191067# a_66174_195421# a_61810_195467# VDD pfet_06v0 ad=2.2p pd=10.88u as=2.2p ps=10.88u w=5u l=1u
X770 a_29586_168437# a_29586_168437# a_32242_165013# VSS nfet_06v0 ad=0.44p pd=2.88u as=0.25p ps=1.5u w=1u l=1u
X771 a_92638_185913# a_75542_185797# VDD VDD pfet_06v0 ad=2.5p pd=10.5u as=4.4p ps=20.88u w=10u l=1u
X772 a_52358_185797# a_52658_185797# a_54282_182373# VSS nfet_06v0 ad=0.44p pd=2.88u as=0.25p ps=1.5u w=1u l=1u
X773 a_96634_152778# a_96674_159564# a_111110_159680# VDD pfet_06v0 ad=4.4p pd=20.88u as=2.5p ps=10.5u w=10u l=1u
X774 a_60034_128854# a_59834_128810# VSS VSS nfet_06v0 ad=1.25p pd=5.5u as=2.2p ps=10.88u w=5u l=1u
D28 VSS S4N diode_nd2ps_06v0 pj=40u area=99.99999p
X775 a_53050_173593# a_52318_173593# a_53250_173637# VSS nfet_06v0 ad=2.2p pd=10.88u as=1.25p ps=5.5u w=5u l=1u
X776 a_73934_128810# a_74234_128810# a_85150_128854# VSS nfet_06v0 ad=2.2p pd=10.88u as=1.25p ps=5.5u w=5u l=1u
X777 a_89822_147696# a_73974_147580# VDD VDD pfet_06v0 ad=2.5p pd=10.5u as=4.4p ps=20.88u w=10u l=1u
X778 a_99330_152822# a_100422_159680# VDD VDD pfet_06v0 ad=2.2p pd=10.88u as=2.2p ps=10.88u w=5u l=1u
X779 a_90994_177061# a_75842_177061# a_91194_177177# VDD pfet_06v0 ad=3.3p pd=10.66u as=2.5p ps=10.5u w=10u l=1u
X780 a_76398_137602# a_63208_205808# a_74474_135712# VDD pfet_06v0 ad=0.242p pd=1.98u as=0.242p ps=1.98u w=0.55u l=1u
X781 a_102014_128810# a_102014_128810# a_104522_128810# VSS nfet_06v0 ad=2.2p pd=10.88u as=1.65p ps=5.66u w=5u l=1u
D29 S3N VDD diode_pd2nw_06v0 pj=40u area=99.99999p
X782 VDD VSS VDD VDD pfet_06v0 ad=7.92p pd=36.88u as=0 ps=0 w=18u l=2u
X783 a_37174_191067# a_43102_195421# a_37622_195467# VDD pfet_06v0 ad=2.2p pd=10.88u as=2.2p ps=10.88u w=5u l=1u
X784 a_35390_177107# a_29246_173593# a_38286_173707# VSS nfet_06v0 ad=1.1p pd=5.88u as=0.65p ps=3.02u w=2.5u l=1u
X785 a_34750_190951# a_52560_157284# VDD VDD pfet_06v0 ad=0.44p pd=2.88u as=0.44p ps=2.88u w=1u l=1u
X786 VDD VSS VDD VDD pfet_06v0 ad=4.29p pd=20.38u as=0 ps=0 w=9.75u l=2u
D30 S1N VDD diode_pd2nw_06v0 pj=40u area=99.99999p
X787 VSS a_76234_164969# a_80174_165013# VSS nfet_06v0 ad=2.2p pd=10.88u as=1.25p ps=5.5u w=5u l=1u
X788 a_33646_194537# a_29286_194421# VDD VDD pfet_06v0 ad=2.5p pd=10.5u as=4.4p ps=20.88u w=10u l=1u
X789 a_46710_191067# a_38286_191067# VSS VSS nfet_06v0 ad=2.2p pd=10.88u as=1.3p ps=5.52u w=5u l=1u
X790 a_74134_152822# a_73934_152778# VSS VSS nfet_06v0 ad=1.25p pd=5.5u as=2.2p ps=10.88u w=5u l=1u
X791 XN_OUT a_102380_168788# VSS VSS nfet_05v0 ad=0.5808p pd=3.52u as=0.5808p ps=3.52u w=1.32u l=0.6u
X792 a_82318_191067# a_75842_194421# a_83878_195467# VDD pfet_06v0 ad=2.2p pd=10.88u as=1.3p ps=5.52u w=5u l=1u
X793 a_102380_186148# a_23448_70736# VDD VDD pfet_05v0 ad=0.8052p pd=4.54u as=0.8052p ps=4.54u w=1.83u l=0.5u
X794 a_60694_195467# a_65710_190953# a_60246_191067# VSS nfet_06v0 ad=1.1p pd=5.88u as=1.1p ps=5.88u w=2.5u l=1u
X795 a_45346_182373# a_45146_182329# VSS VSS nfet_06v0 ad=1.25p pd=5.5u as=2.2p ps=10.88u w=5u l=1u
X796 a_46710_165083# a_38286_165083# VSS VSS nfet_06v0 ad=1.3p pd=5.52u as=2.2p ps=10.88u w=5u l=1u
X797 a_33586_173637# a_29246_173593# a_33286_173637# VSS nfet_06v0 ad=1.65p pd=5.66u as=1.25p ps=5.5u w=5u l=1u
X798 a_100158_183808# a_100246_183692# a_23448_70736# VSS nfet_06v0 ad=1.0912p pd=5.84u as=0.6448p ps=3u w=2.48u l=1u
X799 a_32522_149596# a_32786_140794# VSS VSS nfet_06v0 ad=0.825p pd=3.16u as=1.1p ps=5.88u w=2.5u l=1u
X800 a_51646_140794# a_51946_140794# a_62862_140838# VSS nfet_06v0 ad=2.2p pd=10.88u as=1.25p ps=5.5u w=5u l=1u
X801 a_36506_185843# a_37174_182443# VSS VSS nfet_06v0 ad=0.65p pd=3.02u as=0.65p ps=3.02u w=2.5u l=1u
D31 VSS S1N diode_nd2ps_06v0 pj=40u area=99.99999p
D32 S3P VDD diode_pd2nw_06v0 pj=40u area=99.99999p
X802 a_74234_128810# a_74274_135596# a_88710_135712# VDD pfet_06v0 ad=4.4p pd=20.88u as=2.5p ps=10.5u w=10u l=1u
X803 a_83878_178107# a_75842_177061# a_82318_173707# VDD pfet_06v0 ad=1.3p pd=5.52u as=2.2p ps=10.88u w=5u l=1u
X804 a_33586_182373# a_35862_182327# a_36062_182443# VSS nfet_06v0 ad=2.2p pd=10.88u as=1.3p ps=5.52u w=5u l=1u
X805 a_52358_168437# a_52658_168437# a_55594_168553# VDD pfet_06v0 ad=4.4p pd=20.88u as=2.5p ps=10.5u w=10u l=1u
X806 a_29586_147580# a_29586_147580# VDD VDD pfet_06v0 ad=0.88p pd=4.88u as=0.88p ps=4.88u w=2u l=1u
X807 a_96534_152822# a_96334_152778# VSS VSS nfet_06v0 ad=1.25p pd=5.5u as=2.2p ps=10.88u w=5u l=1u
X808 a_96834_140838# a_96634_140794# a_97566_140838# VSS nfet_06v0 ad=2.2p pd=10.88u as=1.25p ps=5.5u w=5u l=1u
X809 a_82762_168483# a_83430_165083# VSS VSS nfet_06v0 ad=0.65p pd=3.02u as=1.1p ps=5.88u w=2.5u l=1u
X810 a_56990_165013# a_52318_164969# a_56658_165013# VSS nfet_06v0 ad=1.25p pd=5.5u as=1.65p ps=5.66u w=5u l=1u
X811 a_79842_182373# a_57822_182327# a_81206_182443# VSS nfet_06v0 ad=2.2p pd=10.88u as=1.3p ps=5.52u w=5u l=1u
X812 a_104522_140794# a_96634_140794# a_104722_140838# VSS nfet_06v0 ad=1.65p pd=5.66u as=1.25p ps=5.5u w=5u l=1u
X813 a_54922_149596# a_55186_140794# VSS VSS nfet_06v0 ad=0.825p pd=3.16u as=1.1p ps=5.88u w=2.5u l=1u
X814 a_111626_182316# a_92966_182443# VDD VDD pfet_06v0 ad=0.99p pd=3.66u as=1.32p ps=6.88u w=3u l=1u
X815 a_83878_186843# a_88894_182329# a_83430_182443# VSS nfet_06v0 ad=1.1p pd=5.88u as=1.1p ps=5.88u w=2.5u l=1u
D33 Y VDD diode_pd2nw_06v0 pj=40u area=99.99999p
X816 a_74848_146650# a_34750_182327# VSS ppolyf_u_1k r_width=1u r_length=76.45u
X817 a_74134_128854# a_73934_128810# VSS VSS nfet_06v0 ad=1.25p pd=5.5u as=2.2p ps=10.88u w=5u l=1u
X818 VDD a_29286_177061# a_34278_177177# VDD pfet_06v0 ad=4.4p pd=20.88u as=2.5p ps=10.5u w=10u l=1u
X819 a_34750_173591# a_97248_133316# VDD VDD pfet_06v0 ad=0.44p pd=2.88u as=0.44p ps=2.88u w=1u l=1u
X820 a_79902_194537# a_75542_194421# VDD VDD pfet_06v0 ad=2.5p pd=10.5u as=4.4p ps=20.88u w=10u l=1u
X821 a_29246_182329# a_29586_185797# a_29486_185913# VDD pfet_06v0 ad=4.4p pd=20.88u as=2.5p ps=10.5u w=10u l=1u
X822 a_32786_152778# a_36382_160764# a_33334_159680# VDD pfet_06v0 ad=1.76p pd=8.88u as=1.76p ps=8.88u w=4u l=1u
X823 a_34950_182443# a_34750_182327# a_33586_182373# VSS nfet_06v0 ad=1.3p pd=5.52u as=2.2p ps=10.88u w=5u l=1u
X824 VSS a_84542_173707# a_92966_173707# VSS nfet_06v0 ad=1.3p pd=5.52u as=1.3p ps=5.52u w=5u l=1u
X825 VSS VDD VSS VSS nfet_06v0 ad=4.29p pd=20.38u as=0 ps=0 w=9.75u l=2u
X826 a_81646_194467# a_75502_190953# a_84542_191067# VSS nfet_06v0 ad=1.1p pd=5.88u as=0.65p ps=3.02u w=2.5u l=1u
X827 a_79842_173637# a_75502_173593# a_79542_173637# VSS nfet_06v0 ad=1.65p pd=5.66u as=1.25p ps=5.5u w=5u l=1u
X828 a_36062_182443# a_37622_186843# VDD VDD pfet_06v0 ad=1.3p pd=5.52u as=1.3p ps=5.52u w=5u l=1u
X829 a_30598_177177# a_29286_177061# VDD VDD pfet_06v0 ad=2.5p pd=10.5u as=4.4p ps=20.88u w=10u l=1u
X830 a_97248_146650# a_57822_182327# VSS ppolyf_u_1k r_width=1u r_length=76.45u
X831 a_60694_169483# a_52658_168437# a_59134_165083# VDD pfet_06v0 ad=1.3p pd=5.52u as=2.2p ps=10.88u w=5u l=1u
X832 a_96534_128854# a_96334_128810# VSS VSS nfet_06v0 ad=1.25p pd=5.5u as=2.2p ps=10.88u w=5u l=1u
X833 a_68218_173593# a_52318_173593# a_68418_173637# VSS nfet_06v0 ad=1.65p pd=5.66u as=1.25p ps=5.5u w=5u l=1u
X834 a_81646_185843# a_83430_182443# VSS VSS nfet_06v0 ad=0.65p pd=3.02u as=0.65p ps=3.02u w=2.5u l=1u
X835 a_30160_157734# a_45578_157284# VSS ppolyf_u_1k r_width=1u r_length=76.45u
X836 a_29978_173593# a_29246_173593# a_30178_173637# VSS nfet_06v0 ad=2.2p pd=10.88u as=1.25p ps=5.5u w=5u l=1u
D34 VSS X diode_nd2ps_06v0 pj=40u area=99.99999p
X837 VSS a_60246_191067# a_58462_194467# VSS nfet_06v0 ad=1.1p pd=5.88u as=0.65p ps=3.02u w=2.5u l=1u
X838 a_38018_135596# a_29586_135596# a_38218_135712# VDD pfet_06v0 ad=3.3p pd=10.66u as=2.5p ps=10.5u w=10u l=1u
X839 a_52658_185797# a_52658_185797# VDD VDD pfet_06v0 ad=0.88p pd=4.88u as=0.88p ps=4.88u w=2u l=1u
X840 a_98486_190984# a_46710_191067# VDD VDD pfet_06v0 ad=1.32p pd=6.88u as=1.32p ps=6.88u w=3u l=1u
X841 a_81070_160764# a_74234_152778# a_81278_152822# VSS nfet_06v0 ad=2.2p pd=10.88u as=1.25p ps=5.5u w=5u l=1u
X842 VSS VDD VSS VSS nfet_06v0 ad=7.92p pd=36.88u as=0 ps=0 w=18u l=2u
X843 a_35862_182327# a_34394_152822# VSS VSS nfet_06v0 ad=0.44p pd=2.88u as=0.44p ps=2.88u w=1u l=1u
X844 a_84994_169483# a_75842_168437# a_81206_165083# VDD pfet_06v0 ad=1.3p pd=5.52u as=2.2p ps=10.88u w=5u l=1u
D35 S3N VDD diode_pd2nw_06v0 pj=40u area=99.99999p
X845 a_67374_190997# a_53050_190953# VSS VSS nfet_06v0 ad=1.25p pd=5.5u as=2.2p ps=10.88u w=5u l=1u
X846 a_51686_147580# a_51986_147580# a_69458_147696# VDD pfet_06v0 ad=4.4p pd=20.88u as=2.5p ps=10.5u w=10u l=1u
X847 a_30160_157284# a_45578_157284# VSS ppolyf_u_1k r_width=1u r_length=76.45u
X848 a_76854_177177# a_75542_177061# VDD VDD pfet_06v0 ad=2.5p pd=10.5u as=4.4p ps=20.88u w=10u l=1u
X849 a_37622_195467# a_42638_190953# a_37174_191067# VSS nfet_06v0 ad=1.1p pd=5.88u as=1.1p ps=5.88u w=2.5u l=1u
X850 a_61358_165083# a_52318_164969# a_58462_168483# VSS nfet_06v0 ad=0.65p pd=3.02u as=1.1p ps=5.88u w=2.5u l=1u
X851 a_37634_140838# a_37434_140794# VSS VSS nfet_06v0 ad=1.25p pd=5.5u as=2.2p ps=10.88u w=5u l=1u
D36 VSS S3N diode_nd2ps_06v0 pj=40u area=99.99999p
X852 a_75542_185797# a_75842_185797# a_77466_182373# VSS nfet_06v0 ad=0.44p pd=2.88u as=0.25p ps=1.5u w=1u l=1u
X853 a_65710_173593# a_52658_177061# a_69454_177177# VDD pfet_06v0 ad=4.4p pd=20.88u as=2.5p ps=10.5u w=10u l=1u
X854 a_96674_159564# a_96674_159564# a_109614_152822# VSS nfet_06v0 ad=0.44p pd=2.88u as=0.25p ps=1.5u w=1u l=1u
X855 a_76234_173593# a_75502_173593# a_76434_173637# VSS nfet_06v0 ad=2.2p pd=10.88u as=1.25p ps=5.5u w=5u l=1u
X856 a_35862_164967# a_76198_128854# cap_mim_2f0_m4m5_noshield c_width=25u c_length=8u
X857 a_56794_128854# a_58782_136796# a_52560_133316# VDD pfet_06v0 ad=1.76p pd=8.88u as=1.76p ps=8.88u w=4u l=1u
D37 VSS S1N diode_nd2ps_06v0 pj=40u area=99.99999p
D38 S3P VDD diode_pd2nw_06v0 pj=40u area=99.99999p
X858 a_92966_191067# a_84542_191067# VSS VSS nfet_06v0 ad=1.3p pd=5.52u as=2.2p ps=10.88u w=5u l=1u
X859 VDD VSS VDD VDD pfet_06v0 ad=0.44p pd=2.88u as=0 ps=0 w=1u l=2u
X860 a_81070_136796# a_74234_128810# a_81278_128854# VSS nfet_06v0 ad=2.2p pd=10.88u as=1.25p ps=5.5u w=5u l=1u
X861 a_34750_164967# a_34394_128854# VSS VSS nfet_06v0 ad=0.44p pd=2.88u as=0.44p ps=2.88u w=1u l=1u
X862 a_69782_165083# a_61358_165083# VSS VSS nfet_06v0 ad=2.2p pd=10.88u as=1.3p ps=5.52u w=5u l=1u
X863 a_79082_152822# a_81070_160764# a_74848_157284# VDD pfet_06v0 ad=1.76p pd=8.88u as=1.76p ps=8.88u w=4u l=1u
X864 a_57822_190951# a_74848_157284# VDD VDD pfet_06v0 ad=0.44p pd=2.88u as=0.44p ps=2.88u w=1u l=1u
X865 a_33946_168553# a_35862_164967# a_36506_168483# VDD pfet_06v0 ad=4.4p pd=20.88u as=2.6p ps=10.52u w=10u l=1u
X866 ZP_OUT ZN_OUT VSS VSS nfet_05v0 ad=0.5808p pd=3.52u as=0.5808p ps=3.52u w=1.32u l=0.6u
D39 VSS S3P diode_nd2ps_06v0 pj=40u area=99.99999p
X867 a_32242_140838# a_33334_147696# VDD VDD pfet_06v0 ad=2.2p pd=10.88u as=2.2p ps=10.88u w=5u l=1u
X868 a_103402_183738# a_23448_70736# VSS VSS nfet_06v0 ad=0.5p pd=2.5u as=0.88p ps=4.88u w=2u l=1u
X869 a_56658_182373# a_57822_182327# a_58022_182443# VSS nfet_06v0 ad=2.2p pd=10.88u as=1.3p ps=5.52u w=5u l=1u
X870 a_74274_135596# a_74274_135596# VDD VDD pfet_06v0 ad=0.88p pd=4.88u as=0.88p ps=4.88u w=2u l=1u
X871 a_38738_169483# a_42638_164969# a_38286_165083# VSS nfet_06v0 ad=1.1p pd=5.88u as=1.1p ps=5.88u w=2.5u l=1u
X872 a_31710_137602# a_31310_128810# a_29786_135712# VDD pfet_06v0 ad=0.242p pd=1.98u as=0.242p ps=1.98u w=0.55u l=1u
X873 a_34750_182327# a_74848_145300# VDD VDD pfet_06v0 ad=0.44p pd=2.88u as=0.44p ps=2.88u w=1u l=1u
X874 a_96674_135596# a_96674_135596# a_109614_128854# VSS nfet_06v0 ad=0.44p pd=2.88u as=0.25p ps=1.5u w=1u l=1u
X875 a_75542_168437# a_75842_168437# a_78778_168553# VDD pfet_06v0 ad=4.4p pd=20.88u as=2.5p ps=10.5u w=10u l=1u
X876 a_54642_140838# a_55734_147696# VDD VDD pfet_06v0 ad=2.2p pd=10.88u as=2.2p ps=10.88u w=5u l=1u
X877 VSS a_37174_182443# a_36506_185843# VSS nfet_06v0 ad=0.65p pd=3.02u as=0.65p ps=3.02u w=2.5u l=1u
X878 a_113914_166412# a_92966_165083# a_104234_183692# VDD pfet_06v0 ad=0.75p pd=3.5u as=1.32p ps=6.88u w=3u l=1u
X879 a_80174_165013# a_75502_164969# a_79842_165013# VSS nfet_06v0 ad=1.25p pd=5.5u as=1.65p ps=5.66u w=5u l=1u
X880 VSS VDD VSS VSS nfet_06v0 ad=7.92p pd=36.88u as=0 ps=0 w=18u l=2u
X881 a_31510_140838# a_33334_147696# VDD VDD pfet_06v0 ad=2.2p pd=10.88u as=2.2p ps=10.88u w=5u l=1u
X882 a_52558_177177# a_52358_177061# VDD VDD pfet_06v0 ad=2.5p pd=10.5u as=4.4p ps=20.88u w=10u l=1u
X883 a_74848_158634# a_90266_158184# VSS ppolyf_u_1k r_width=1u r_length=76.45u
X884 a_35862_164967# a_74848_133316# VDD VDD pfet_06v0 ad=0.44p pd=2.88u as=0.44p ps=2.88u w=1u l=1u
X885 a_36506_194467# a_37174_191067# VSS VSS nfet_06v0 ad=0.65p pd=3.02u as=1.1p ps=5.88u w=2.5u l=1u
X886 a_38286_182443# a_43102_186797# a_38738_186843# VDD pfet_06v0 ad=2.2p pd=10.88u as=2.2p ps=10.88u w=5u l=1u
D40 Z VDD diode_pd2nw_06v0 pj=40u area=99.99999p
X887 a_84542_191067# a_75502_190953# a_81646_194467# VSS nfet_06v0 ad=0.65p pd=3.02u as=1.1p ps=5.88u w=2.5u l=1u
X888 a_99296_165240# a_106078_166332# a_23448_190688# VSS nfet_06v0 ad=1.0912p pd=5.84u as=0.6448p ps=3u w=2.48u l=1u
X889 a_83878_169483# a_75842_168437# a_82318_165083# VDD pfet_06v0 ad=1.3p pd=5.52u as=2.2p ps=10.88u w=5u l=1u
X890 a_43102_186797# a_43102_186797# a_44738_185797# VDD pfet_06v0 ad=4.4p pd=20.88u as=3.3p ps=10.66u w=10u l=1u
X891 a_73974_147580# a_74274_147580# a_86182_140838# VSS nfet_06v0 ad=0.44p pd=2.88u as=0.25p ps=1.5u w=1u l=1u
X892 a_31710_161570# a_35862_182327# cap_mim_2f0_m4m5_noshield c_width=25u c_length=8u
X893 a_97248_158634# a_112666_158184# VSS ppolyf_u_1k r_width=1u r_length=76.45u
X894 a_57350_177177# a_52658_177061# a_57018_177177# VDD pfet_06v0 ad=2.5p pd=10.5u as=3.3p ps=10.66u w=10u l=1u
X895 X a_23448_190688# VDD ppolyf_u r_width=16u r_length=4u
X896 a_96674_147580# a_96674_147580# VDD VDD pfet_06v0 ad=0.88p pd=4.88u as=0.88p ps=4.88u w=2u l=1u
X897 a_104146_183808# a_104234_183692# a_23448_70736# VSS nfet_06v0 ad=1.0912p pd=5.84u as=0.6448p ps=3u w=2.48u l=1u
X898 a_91602_173637# a_91402_173593# VSS VSS nfet_06v0 ad=1.25p pd=5.5u as=2.2p ps=10.88u w=5u l=1u
X899 a_36506_177107# a_29246_173593# a_37174_173707# VSS nfet_06v0 ad=1.1p pd=5.88u as=0.65p ps=3.02u w=2.5u l=1u
X900 a_96874_159680# a_96674_159564# a_97686_159680# VDD pfet_06v0 ad=4.4p pd=20.88u as=2.5p ps=10.5u w=10u l=1u
X901 a_74848_157734# a_90266_158184# VSS ppolyf_u_1k r_width=1u r_length=76.45u
D41 VSS S3N diode_nd2ps_06v0 pj=40u area=99.99999p
X902 a_46710_191067# a_38738_195467# VDD VDD pfet_06v0 ad=4.4p pd=20.88u as=2.6p ps=10.52u w=10u l=1u
X903 VSS VDD VSS VSS nfet_06v0 ad=0.44p pd=2.88u as=0 ps=0 w=1u l=2u
X904 a_89358_178061# a_89358_178061# a_90994_177061# VDD pfet_06v0 ad=4.4p pd=20.88u as=3.3p ps=10.66u w=10u l=1u
X905 a_75842_185797# a_75842_185797# VDD VDD pfet_06v0 ad=0.88p pd=4.88u as=0.88p ps=4.88u w=2u l=1u
X906 a_57326_140794# a_51986_147580# a_62062_147696# VDD pfet_06v0 ad=4.4p pd=20.88u as=2.5p ps=10.5u w=10u l=1u
X907 a_79842_173637# a_34750_173591# a_82318_173707# VSS nfet_06v0 ad=2.2p pd=10.88u as=1.3p ps=5.52u w=5u l=1u
X908 a_32242_165013# a_29586_168437# VSS VSS nfet_06v0 ad=0.25p pd=1.5u as=0.44p ps=2.88u w=1u l=1u
X909 a_67810_168437# a_52658_168437# a_68010_168553# VDD pfet_06v0 ad=3.3p pd=10.66u as=2.5p ps=10.5u w=10u l=1u
X910 a_54282_182373# a_52658_185797# VSS VSS nfet_06v0 ad=0.25p pd=1.5u as=0.44p ps=2.88u w=1u l=1u
X911 a_99874_152778# a_103470_160764# a_100422_159680# VDD pfet_06v0 ad=1.76p pd=8.88u as=1.76p ps=8.88u w=4u l=1u
X912 a_34950_182443# a_29586_185797# a_38738_186843# VDD pfet_06v0 ad=2.2p pd=10.88u as=1.3p ps=5.52u w=5u l=1u
X913 a_53250_173637# a_53050_173593# VSS VSS nfet_06v0 ad=1.25p pd=5.5u as=2.2p ps=10.88u w=5u l=1u
X914 a_81206_191067# a_75842_194421# a_84994_195467# VDD pfet_06v0 ad=2.2p pd=10.88u as=1.3p ps=5.52u w=5u l=1u
X915 a_97248_157734# a_112666_158184# VSS ppolyf_u_1k r_width=1u r_length=76.45u
X916 a_36062_173707# a_35862_173591# a_33586_173637# VSS nfet_06v0 ad=1.3p pd=5.52u as=2.2p ps=10.88u w=5u l=1u
X917 a_33918_173637# a_29246_173593# a_33586_173637# VSS nfet_06v0 ad=1.25p pd=5.5u as=1.65p ps=5.66u w=5u l=1u
X918 a_30178_173637# a_29978_173593# VSS VSS nfet_06v0 ad=1.25p pd=5.5u as=2.2p ps=10.88u w=5u l=1u
D42 VSS S3P diode_nd2ps_06v0 pj=40u area=99.99999p
X919 a_57822_182327# a_97248_145300# VDD VDD pfet_06v0 ad=0.44p pd=2.88u as=0.44p ps=2.88u w=1u l=1u
X920 VDD a_23448_70736# a_23448_70736# VDD pfet_06v0 ad=0.52p pd=2.52u as=0.52p ps=2.52u w=2u l=1u
X921 VSS a_53050_182329# a_56990_182373# VSS nfet_06v0 ad=2.2p pd=10.88u as=1.25p ps=5.5u w=5u l=1u
X922 a_80202_194537# a_34750_190951# a_82762_194467# VDD pfet_06v0 ad=4.4p pd=20.88u as=2.6p ps=10.52u w=10u l=1u
X923 a_57822_182327# a_98598_140838# cap_mim_2f0_m4m5_noshield c_width=25u c_length=8u
X924 a_43102_186797# a_29246_182329# a_44302_182373# VSS nfet_06v0 ad=2.2p pd=10.88u as=1.25p ps=5.5u w=5u l=1u
X925 a_52318_164969# a_52318_164969# VSS VSS nfet_06v0 ad=0.44p pd=2.88u as=0.44p ps=2.88u w=1u l=1u
X926 a_105106_135596# a_96674_135596# a_105306_135712# VDD pfet_06v0 ad=3.3p pd=10.66u as=2.5p ps=10.5u w=10u l=1u
X927 a_75166_140838# a_73934_140794# VSS VSS nfet_06v0 ad=1.25p pd=5.5u as=2.2p ps=10.88u w=5u l=1u
X928 VDD VSS VDD VDD pfet_06v0 ad=4.29p pd=20.38u as=0 ps=0 w=9.75u l=2u
X929 a_86182_152822# a_74274_159564# VSS VSS nfet_06v0 ad=0.25p pd=1.5u as=0.44p ps=2.88u w=1u l=1u
X930 a_33286_173637# a_29978_173593# VSS VSS nfet_06v0 ad=1.25p pd=5.5u as=2.2p ps=10.88u w=5u l=1u
X931 a_55186_140794# a_51946_140794# a_54922_149596# VSS nfet_06v0 ad=1.1p pd=5.88u as=0.825p ps=3.16u w=2.5u l=1u
X932 VDD a_110806_182360# a_111626_182316# VDD pfet_06v0 ad=1.32p pd=6.88u as=0.99p ps=3.66u w=3u l=1u
X933 a_62862_140838# a_51646_140794# VSS VSS nfet_06v0 ad=1.25p pd=5.5u as=2.2p ps=10.88u w=5u l=1u
X934 a_35862_190951# a_101482_152822# VSS VSS nfet_06v0 ad=0.44p pd=2.88u as=0.44p ps=2.88u w=1u l=1u
X935 a_92966_165083# a_84542_165083# VSS VSS nfet_06v0 ad=2.2p pd=10.88u as=1.3p ps=5.52u w=5u l=1u
X936 a_100246_175068# a_111626_173580# VDD VDD pfet_06v0 ad=1.32p pd=6.88u as=1.32p ps=6.88u w=3u l=1u
X937 a_88710_135712# a_73974_135596# VDD VDD pfet_06v0 ad=2.5p pd=10.5u as=4.4p ps=20.88u w=10u l=1u
X938 a_79082_152822# a_74234_152778# a_76398_161570# VSS nfet_06v0 ad=1.1p pd=5.88u as=0.825p ps=3.16u w=2.5u l=1u
X939 a_60246_191067# a_52318_190953# a_59578_194467# VSS nfet_06v0 ad=0.65p pd=3.02u as=1.1p ps=5.88u w=2.5u l=1u
X940 a_55594_168553# a_52358_168437# VDD VDD pfet_06v0 ad=2.5p pd=10.5u as=4.4p ps=20.88u w=10u l=1u
X941 a_99096_182484# a_99096_182484# a_101360_182600# VSS nfet_06v0 ad=0.308p pd=2.28u as=0.175p ps=1.2u w=0.7u l=1u
X942 a_34750_173591# a_97248_133316# VDD VDD pfet_06v0 ad=0.44p pd=2.88u as=0.44p ps=2.88u w=1u l=1u
X943 a_54642_140838# a_23448_50576# a_52146_140838# VSS nfet_06v0 ad=3.74p pd=17.88u as=3.74p ps=17.88u w=8.5u l=1u
X944 a_62062_159680# a_51686_159564# VDD VDD pfet_06v0 ad=2.5p pd=10.5u as=4.4p ps=20.88u w=10u l=1u
X945 VDD a_75542_194421# a_80534_194537# VDD pfet_06v0 ad=4.4p pd=20.88u as=2.5p ps=10.5u w=10u l=1u
X946 a_97566_140838# a_96334_140794# VSS VSS nfet_06v0 ad=1.25p pd=5.5u as=2.2p ps=10.88u w=5u l=1u
X947 a_96874_147696# a_96674_147580# a_96574_147696# VDD pfet_06v0 ad=4.4p pd=20.88u as=2.5p ps=10.5u w=10u l=1u
X948 YN_OUT a_102380_177524# VDD VDD pfet_05v0 ad=0.8052p pd=4.54u as=0.8052p ps=4.54u w=1.83u l=0.5u
X949 a_104722_140838# a_104522_140794# VSS VSS nfet_06v0 ad=1.25p pd=5.5u as=2.2p ps=10.88u w=5u l=1u
X950 a_102380_168788# a_23448_190688# VSS VSS nfet_05v0 ad=0.5808p pd=3.52u as=0.5808p ps=3.52u w=1.32u l=0.6u
X951 VSS a_60246_182443# a_59578_185843# VSS nfet_06v0 ad=1.1p pd=5.88u as=0.65p ps=3.02u w=2.5u l=1u
X952 a_102104_182600# a_99096_182484# VSS VSS nfet_06v0 ad=0.5456p pd=3.36u as=0.5456p ps=3.36u w=1.24u l=1u
X953 a_45146_190953# a_29246_190953# a_45346_190997# VSS nfet_06v0 ad=1.65p pd=5.66u as=1.25p ps=5.5u w=5u l=1u
X954 a_34278_177177# a_29586_177061# a_33946_177177# VDD pfet_06v0 ad=2.5p pd=10.5u as=3.3p ps=10.66u w=10u l=1u
X955 a_86182_128854# a_74274_135596# VSS VSS nfet_06v0 ad=0.25p pd=1.5u as=0.44p ps=2.88u w=1u l=1u
X956 VSS VDD VSS VSS nfet_06v0 ad=0.44p pd=2.88u as=0 ps=0 w=1u l=2u
X957 VDD a_60694_178107# a_58022_173707# VDD pfet_06v0 ad=1.3p pd=5.52u as=1.3p ps=5.52u w=5u l=1u
X958 a_29486_185913# a_29286_185797# VDD VDD pfet_06v0 ad=2.5p pd=10.5u as=4.4p ps=20.88u w=10u l=1u
X959 a_34750_173591# a_101482_128854# VSS VSS nfet_06v0 ad=0.44p pd=2.88u as=0.44p ps=2.88u w=1u l=1u
X960 a_79542_173637# a_76234_173593# VSS VSS nfet_06v0 ad=1.25p pd=5.5u as=2.2p ps=10.88u w=5u l=1u
X961 a_30160_133316# a_29586_135596# a_31510_128854# VDD pfet_06v0 ad=4.4p pd=20.88u as=4.4p ps=20.88u w=10u l=1u
X962 a_79082_128854# a_74234_128810# a_76398_137602# VSS nfet_06v0 ad=1.1p pd=5.88u as=0.825p ps=3.16u w=2.5u l=1u
X963 a_114466_164956# a_46710_165083# VDD VDD pfet_06v0 ad=0.99p pd=3.66u as=1.32p ps=6.88u w=3u l=1u
D43 S4N VDD diode_pd2nw_06v0 pj=40u area=99.99999p
X964 a_44738_168437# a_29586_168437# a_44938_168553# VDD pfet_06v0 ad=3.3p pd=10.66u as=2.5p ps=10.5u w=10u l=1u
X965 a_65710_182329# a_65710_182329# a_68218_182329# VSS nfet_06v0 ad=2.2p pd=10.88u as=1.65p ps=5.66u w=5u l=1u
X966 a_99330_140838# a_100422_147696# VDD VDD pfet_06v0 ad=2.2p pd=10.88u as=2.2p ps=10.88u w=5u l=1u
X967 a_68418_173637# a_68218_173593# VSS VSS nfet_06v0 ad=1.25p pd=5.5u as=2.2p ps=10.88u w=5u l=1u
D44 X VDD diode_pd2nw_06v0 pj=40u area=99.99999p
X968 a_35390_194467# a_37174_191067# VSS VSS nfet_06v0 ad=0.65p pd=3.02u as=0.65p ps=3.02u w=2.5u l=1u
X969 a_104146_183808# a_99096_182484# VSS VSS nfet_06v0 ad=0.5456p pd=3.36u as=0.5456p ps=3.36u w=1.24u l=1u
X970 a_74848_133316# a_90266_133316# VSS ppolyf_u_1k r_width=1u r_length=76.45u
X971 a_58462_177107# a_60246_173707# VSS VSS nfet_06v0 ad=0.65p pd=3.02u as=0.65p ps=3.02u w=2.5u l=1u
X972 a_56658_173637# a_35862_173591# a_59134_173707# VSS nfet_06v0 ad=2.2p pd=10.88u as=1.3p ps=5.52u w=5u l=1u
X973 a_52560_133316# a_51986_135596# a_53910_128854# VDD pfet_06v0 ad=4.4p pd=20.88u as=4.4p ps=20.88u w=10u l=1u
X974 a_47058_147696# a_29286_147580# VDD VDD pfet_06v0 ad=2.5p pd=10.5u as=4.4p ps=20.88u w=10u l=1u
X975 a_38218_135712# a_38018_135596# VDD VDD pfet_06v0 ad=2.5p pd=10.5u as=4.4p ps=20.88u w=10u l=1u
X976 a_35862_173591# a_52560_145300# VDD VDD pfet_06v0 ad=0.44p pd=2.88u as=0.44p ps=2.88u w=1u l=1u
X977 a_36062_182443# a_29586_185797# a_37622_186843# VDD pfet_06v0 ad=2.2p pd=10.88u as=1.3p ps=5.52u w=5u l=1u
X978 a_102104_165240# VDD a_23448_190688# VSS nfet_06v0 ad=1.0912p pd=5.84u as=0.6448p ps=3u w=2.48u l=1u
X979 a_81278_152822# a_73934_152778# VSS VSS nfet_06v0 ad=1.25p pd=5.5u as=2.2p ps=10.88u w=5u l=1u
X980 a_91194_194537# a_90994_194421# VDD VDD pfet_06v0 ad=2.5p pd=10.5u as=4.4p ps=20.88u w=10u l=1u
X981 a_97248_133316# a_112666_133316# VSS ppolyf_u_1k r_width=1u r_length=76.45u
X982 a_96634_140794# a_96634_140794# VSS VSS nfet_06v0 ad=0.44p pd=2.88u as=0.44p ps=2.88u w=1u l=1u
X983 a_69458_147696# a_51686_147580# VDD VDD pfet_06v0 ad=2.5p pd=10.5u as=4.4p ps=20.88u w=10u l=1u
X984 a_23448_70736# a_104234_183692# a_104146_183808# VSS nfet_06v0 ad=0.6448p pd=3u as=1.0912p ps=5.84u w=2.48u l=1u
X985 a_29786_159680# a_29586_159564# a_29486_159680# VDD pfet_06v0 ad=4.4p pd=20.88u as=2.5p ps=10.5u w=10u l=1u
X986 VSS VDD VSS VSS nfet_06v0 ad=4.29p pd=20.38u as=0 ps=0 w=9.75u l=2u
X987 a_78022_147696# a_79614_140794# a_77474_140794# VSS nfet_06v0 ad=0.88p pd=4.88u as=0.88p ps=4.88u w=2u l=1u
X988 a_58022_173707# a_38998_140838# a_56658_173637# VSS nfet_06v0 ad=1.3p pd=5.52u as=2.2p ps=10.88u w=5u l=1u
X989 VSS a_92966_182443# a_112558_182360# VSS nfet_06v0 ad=0.44p pd=2.88u as=0.25p ps=1.5u w=1u l=1u
X990 VSS a_111626_173580# a_100246_175068# VSS nfet_06v0 ad=0.44p pd=2.88u as=0.44p ps=2.88u w=1u l=1u
X991 S2N a_32042_128810# VDD ppolyf_u r_width=16u r_length=4u
X992 a_35390_168483# a_29246_164969# a_38286_165083# VSS nfet_06v0 ad=1.1p pd=5.88u as=0.65p ps=3.02u w=2.5u l=1u
X993 a_69454_177177# a_52358_177061# VDD VDD pfet_06v0 ad=2.5p pd=10.5u as=4.4p ps=20.88u w=10u l=1u
X994 a_77466_182373# a_75842_185797# VSS VSS nfet_06v0 ad=0.25p pd=1.5u as=0.44p ps=2.88u w=1u l=1u
X995 a_109614_152822# a_96674_159564# VSS VSS nfet_06v0 ad=0.25p pd=1.5u as=0.44p ps=2.88u w=1u l=1u
X996 a_76434_173637# a_76234_173593# VSS VSS nfet_06v0 ad=1.25p pd=5.5u as=2.2p ps=10.88u w=5u l=1u
X997 a_60246_165083# a_66174_169437# a_60694_169483# VDD pfet_06v0 ad=2.2p pd=10.88u as=2.2p ps=10.88u w=5u l=1u
X998 a_52658_168437# a_52658_168437# VDD VDD pfet_06v0 ad=0.88p pd=4.88u as=0.88p ps=4.88u w=2u l=1u
X999 a_100158_175184# a_100246_175068# a_23448_131216# VSS nfet_06v0 ad=1.0912p pd=5.84u as=0.6448p ps=3u w=2.48u l=1u
X1000 a_81278_128854# a_73934_128810# VSS VSS nfet_06v0 ad=1.25p pd=5.5u as=2.2p ps=10.88u w=5u l=1u
X1001 a_34950_191067# a_37622_195467# VDD VDD pfet_06v0 ad=1.3p pd=5.52u as=1.3p ps=5.52u w=5u l=1u
X1002 a_74474_147696# a_74274_147580# a_75286_147696# VDD pfet_06v0 ad=4.4p pd=20.88u as=2.5p ps=10.5u w=10u l=1u
X1003 a_32786_140794# a_36382_148780# a_33334_147696# VDD pfet_06v0 ad=1.76p pd=8.88u as=1.76p ps=8.88u w=4u l=1u
X1004 a_34750_190951# a_52560_157284# VDD VDD pfet_06v0 ad=0.44p pd=2.88u as=0.44p ps=2.88u w=1u l=1u
X1005 VDD a_69782_182443# a_113914_183772# VDD pfet_06v0 ad=1.32p pd=6.88u as=0.75p ps=3.5u w=3u l=1u
X1006 a_99096_165124# a_99096_165124# VDD VDD pfet_06v0 ad=0.88p pd=4.88u as=0.88p ps=4.88u w=2u l=1u
X1007 VSS VDD VSS VSS nfet_06v0 ad=7.92p pd=36.88u as=0 ps=0 w=18u l=2u
X1008 a_82762_194467# a_34750_190951# a_80202_194537# VDD pfet_06v0 ad=2.6p pd=10.52u as=4.4p ps=20.88u w=10u l=1u
X1009 a_109614_128854# a_96674_135596# VSS VSS nfet_06v0 ad=0.25p pd=1.5u as=0.44p ps=2.88u w=1u l=1u
X1010 VDD a_60694_178107# a_59134_173707# VDD pfet_06v0 ad=2.2p pd=10.88u as=1.3p ps=5.52u w=5u l=1u
X1011 a_42638_182329# a_42638_182329# a_45146_182329# VSS nfet_06v0 ad=2.2p pd=10.88u as=1.65p ps=5.66u w=5u l=1u
X1012 a_78778_168553# a_75542_168437# VDD VDD pfet_06v0 ad=2.5p pd=10.5u as=4.4p ps=20.88u w=10u l=1u
X1013 VSS a_84542_165083# a_92966_165083# VSS nfet_06v0 ad=1.3p pd=5.52u as=1.3p ps=5.52u w=5u l=1u
D45 X VDD diode_pd2nw_06v0 pj=40u area=99.99999p
X1014 a_55734_159680# a_51986_159564# a_54642_152822# VDD pfet_06v0 ad=4.4p pd=20.88u as=4.4p ps=20.88u w=10u l=1u
X1015 a_57018_177177# a_52658_177061# a_56718_177177# VDD pfet_06v0 ad=3.3p pd=10.66u as=2.5p ps=10.5u w=10u l=1u
X1016 VSS a_83430_182443# a_82762_185843# VSS nfet_06v0 ad=1.1p pd=5.88u as=0.65p ps=3.02u w=2.5u l=1u
X1017 a_57326_152778# a_57326_152778# a_59834_152778# VSS nfet_06v0 ad=2.2p pd=10.88u as=1.65p ps=5.66u w=5u l=1u
D46 S1P VDD diode_pd2nw_06v0 pj=40u area=99.99999p
X1018 VDD a_83878_178107# a_81206_173707# VDD pfet_06v0 ad=1.3p pd=5.52u as=1.3p ps=5.52u w=5u l=1u
X1019 a_82122_152778# a_74234_152778# a_82322_152822# VSS nfet_06v0 ad=1.65p pd=5.66u as=1.25p ps=5.5u w=5u l=1u
X1020 a_88894_190953# a_75842_194421# a_92638_194537# VDD pfet_06v0 ad=4.4p pd=20.88u as=2.5p ps=10.5u w=10u l=1u
X1021 a_58022_173707# a_60694_178107# VDD VDD pfet_06v0 ad=1.3p pd=5.52u as=2.2p ps=10.88u w=5u l=1u
X1022 a_102002_183808# a_23448_70736# a_23448_70736# VSS nfet_06v0 ad=0.88p pd=4.88u as=0.52p ps=2.52u w=2u l=1u
X1023 a_82706_147580# a_74274_147580# a_82906_147696# VDD pfet_06v0 ad=3.3p pd=10.66u as=2.5p ps=10.5u w=10u l=1u
X1024 a_66174_169437# a_52318_164969# a_67374_165013# VSS nfet_06v0 ad=2.2p pd=10.88u as=1.25p ps=5.5u w=5u l=1u
X1025 VSS a_29978_190953# a_33918_190997# VSS nfet_06v0 ad=2.2p pd=10.88u as=1.25p ps=5.5u w=5u l=1u
X1026 a_31710_137602# a_34750_164967# cap_mim_2f0_m4m5_noshield c_width=25u c_length=8u
X1027 a_97686_159680# a_96374_159564# VDD VDD pfet_06v0 ad=2.5p pd=10.5u as=4.4p ps=20.88u w=10u l=1u
X1028 a_57326_128810# a_57326_128810# a_59834_128810# VSS nfet_06v0 ad=2.2p pd=10.88u as=1.65p ps=5.66u w=5u l=1u
X1029 a_79082_140838# a_81070_148780# a_74848_145300# VDD pfet_06v0 ad=1.76p pd=8.88u as=1.76p ps=8.88u w=4u l=1u
X1030 VSS VDD VSS VSS nfet_06v0 ad=7.92p pd=36.88u as=0 ps=0 w=18u l=2u
X1031 VSS a_37174_191067# a_35390_194467# VSS nfet_06v0 ad=0.65p pd=3.02u as=0.65p ps=3.02u w=2.5u l=1u
X1032 a_34750_182327# a_74848_145300# VDD VDD pfet_06v0 ad=0.44p pd=2.88u as=0.44p ps=2.88u w=1u l=1u
X1033 VSS a_60246_173707# a_58462_177107# VSS nfet_06v0 ad=0.65p pd=3.02u as=0.65p ps=3.02u w=2.5u l=1u
X1034 VSS VDD VSS VSS nfet_06v0 ad=4.29p pd=20.38u as=0 ps=0 w=9.75u l=2u
X1035 a_82122_128810# a_74234_128810# a_82322_128854# VSS nfet_06v0 ad=1.65p pd=5.66u as=1.25p ps=5.5u w=5u l=1u
X1036 VDD a_60694_169483# a_58022_165083# VDD pfet_06v0 ad=1.3p pd=5.52u as=1.3p ps=5.52u w=5u l=1u
D47 S2N VDD diode_pd2nw_06v0 pj=40u area=99.99999p
X1037 a_51646_152778# a_51986_159564# a_67534_159680# VDD pfet_06v0 ad=4.4p pd=20.88u as=2.5p ps=10.5u w=10u l=1u
X1038 a_37622_186843# a_29586_185797# a_36062_182443# VDD pfet_06v0 ad=1.3p pd=5.52u as=2.2p ps=10.88u w=5u l=1u
X1039 a_29286_135596# a_29586_135596# a_47058_135712# VDD pfet_06v0 ad=4.4p pd=20.88u as=2.5p ps=10.5u w=10u l=1u
X1040 a_23448_190688# VDD a_102104_165240# VSS nfet_06v0 ad=0.6448p pd=3u as=1.0912p ps=5.84u w=2.48u l=1u
X1041 a_33946_177177# a_34750_173591# a_35390_177107# VDD pfet_06v0 ad=4.4p pd=20.88u as=2.6p ps=10.52u w=10u l=1u
X1042 a_23448_70736# a_23448_70736# VDD VDD pfet_06v0 ad=0.52p pd=2.52u as=0.88p ps=4.88u w=2u l=1u
X1043 a_76930_152822# a_78022_159680# VDD VDD pfet_06v0 ad=2.2p pd=10.88u as=2.2p ps=10.88u w=5u l=1u
X1044 VDD a_37622_178107# a_34950_173707# VDD pfet_06v0 ad=2.2p pd=10.88u as=1.3p ps=5.52u w=5u l=1u
X1045 VDD a_23448_131216# a_23448_131216# VDD pfet_06v0 ad=0.88p pd=4.88u as=0.52p ps=2.52u w=2u l=1u
X1046 a_35862_164967# a_74848_133316# VDD VDD pfet_06v0 ad=0.44p pd=2.88u as=0.44p ps=2.88u w=1u l=1u
X1047 a_59578_194467# a_35862_190951# a_57018_194537# VDD pfet_06v0 ad=2.6p pd=10.52u as=4.4p ps=20.88u w=10u l=1u
X1048 a_81646_194467# a_57822_190951# a_80202_194537# VDD pfet_06v0 ad=2.6p pd=10.52u as=4.4p ps=20.88u w=10u l=1u
X1049 a_44302_182373# a_29978_182329# VSS VSS nfet_06v0 ad=1.25p pd=5.5u as=2.2p ps=10.88u w=5u l=1u
X1050 a_29586_177061# a_29586_177061# a_32242_173637# VSS nfet_06v0 ad=0.44p pd=2.88u as=0.25p ps=1.5u w=1u l=1u
X1051 a_58782_136796# a_58782_136796# a_60418_135596# VDD pfet_06v0 ad=4.4p pd=20.88u as=3.3p ps=10.66u w=10u l=1u
X1052 a_114146_147696# a_96374_147580# VDD VDD pfet_06v0 ad=2.5p pd=10.5u as=4.4p ps=20.88u w=10u l=1u
X1053 a_83430_165083# a_89358_169437# a_83878_169483# VDD pfet_06v0 ad=2.2p pd=10.88u as=2.2p ps=10.88u w=5u l=1u
X1054 a_52358_194421# a_52658_194421# a_54282_190997# VSS nfet_06v0 ad=0.44p pd=2.88u as=0.25p ps=1.5u w=1u l=1u
X1055 a_105306_135712# a_105106_135596# VDD VDD pfet_06v0 ad=2.5p pd=10.5u as=4.4p ps=20.88u w=10u l=1u
X1056 a_82906_159680# a_82706_159564# VDD VDD pfet_06v0 ad=2.5p pd=10.5u as=4.4p ps=20.88u w=10u l=1u
X1057 a_75842_168437# a_75842_168437# VDD VDD pfet_06v0 ad=0.88p pd=4.88u as=0.88p ps=4.88u w=2u l=1u
X1058 a_74174_147696# a_73974_147580# VDD VDD pfet_06v0 ad=2.5p pd=10.5u as=4.4p ps=20.88u w=10u l=1u
X1059 VSS VDD VSS VSS nfet_06v0 ad=4.29p pd=20.38u as=0 ps=0 w=9.75u l=2u
X1060 a_34926_128810# a_29586_135596# a_39662_135712# VDD pfet_06v0 ad=4.4p pd=20.88u as=2.5p ps=10.5u w=10u l=1u
X1061 a_75502_182329# a_75502_182329# VSS VSS nfet_06v0 ad=0.44p pd=2.88u as=0.44p ps=2.88u w=1u l=1u
X1062 VDD a_37622_195467# a_34950_191067# VDD pfet_06v0 ad=1.3p pd=5.52u as=1.3p ps=5.52u w=5u l=1u
X1063 a_69782_191067# a_61810_195467# VDD VDD pfet_06v0 ad=2.6p pd=10.52u as=4.4p ps=20.88u w=10u l=1u
X1064 a_52560_133766# a_67978_133316# VSS ppolyf_u_1k r_width=1u r_length=76.45u
X1065 a_101360_182600# a_99096_182484# a_101060_182600# VSS nfet_06v0 ad=0.175p pd=1.2u as=0.175p ps=1.2u w=0.7u l=1u
D48 S1P VDD diode_pd2nw_06v0 pj=40u area=99.99999p
X1066 VDD VSS VDD VDD pfet_06v0 ad=0.44p pd=2.88u as=0 ps=0 w=1u l=2u
X1067 a_96574_147696# a_96374_147580# VDD VDD pfet_06v0 ad=2.5p pd=10.5u as=4.4p ps=20.88u w=10u l=1u
X1068 a_99610_161580# a_99874_152778# VSS VSS nfet_06v0 ad=0.825p pd=3.16u as=1.1p ps=5.88u w=2.5u l=1u
X1069 a_80534_194537# a_75842_194421# a_80202_194537# VDD pfet_06v0 ad=2.5p pd=10.5u as=3.3p ps=10.66u w=10u l=1u
X1070 VDD VSS VDD VDD pfet_06v0 ad=4.29p pd=20.38u as=0 ps=0 w=9.75u l=2u
X1071 VSS a_76234_173593# a_80174_173637# VSS nfet_06v0 ad=2.2p pd=10.88u as=1.25p ps=5.5u w=5u l=1u
X1072 a_34950_173707# a_37622_178107# VDD VDD pfet_06v0 ad=1.3p pd=5.52u as=2.2p ps=10.88u w=5u l=1u
X1073 a_88894_182329# a_88894_182329# a_91402_182329# VSS nfet_06v0 ad=2.2p pd=10.88u as=1.65p ps=5.66u w=5u l=1u
D49 VSS S1P diode_nd2ps_06v0 pj=40u area=99.99999p
X1074 a_45346_190997# a_45146_190953# VSS VSS nfet_06v0 ad=1.25p pd=5.5u as=2.2p ps=10.88u w=5u l=1u
X1075 a_51946_140794# a_51986_147580# a_66422_147696# VDD pfet_06v0 ad=4.4p pd=20.88u as=2.5p ps=10.5u w=10u l=1u
X1076 a_59134_173707# a_60694_178107# VDD VDD pfet_06v0 ad=1.3p pd=5.52u as=1.3p ps=5.52u w=5u l=1u
X1077 VSS VDD VSS VSS nfet_06v0 ad=4.29p pd=20.38u as=0 ps=0 w=9.75u l=2u
X1078 a_99874_140794# a_103470_148780# a_100422_147696# VDD pfet_06v0 ad=1.76p pd=8.88u as=1.76p ps=8.88u w=4u l=1u
X1079 a_56990_173637# a_52318_173593# a_56658_173637# VSS nfet_06v0 ad=1.25p pd=5.5u as=1.65p ps=5.66u w=5u l=1u
X1080 a_83878_195467# a_88894_190953# a_83430_191067# VSS nfet_06v0 ad=1.1p pd=5.88u as=1.1p ps=5.88u w=2.5u l=1u
X1081 a_99610_137612# a_99874_128810# VSS VSS nfet_06v0 ad=0.825p pd=3.16u as=1.1p ps=5.88u w=2.5u l=1u
X1082 a_52560_158634# a_34750_190951# VSS ppolyf_u_1k r_width=1u r_length=76.45u
X1083 a_104146_175184# a_104234_175068# a_23448_131216# VSS nfet_06v0 ad=1.0912p pd=5.84u as=0.6448p ps=3u w=2.48u l=1u
X1084 a_82762_185843# a_83430_182443# VSS VSS nfet_06v0 ad=0.65p pd=3.02u as=0.65p ps=3.02u w=2.5u l=1u
X1085 a_36506_168483# a_29246_164969# a_37174_165083# VSS nfet_06v0 ad=1.1p pd=5.88u as=0.65p ps=3.02u w=2.5u l=1u
X1086 VDD VSS VDD VDD pfet_06v0 ad=7.92p pd=36.88u as=0 ps=0 w=18u l=2u
D50 S2N VDD diode_pd2nw_06v0 pj=40u area=99.99999p
X1087 a_81206_173707# a_38998_140838# a_79842_173637# VSS nfet_06v0 ad=1.3p pd=5.52u as=2.2p ps=10.88u w=5u l=1u
X1088 a_68010_185913# a_67810_185797# VDD VDD pfet_06v0 ad=2.5p pd=10.5u as=4.4p ps=20.88u w=10u l=1u
X1089 a_81206_173707# a_83878_178107# VDD VDD pfet_06v0 ad=1.3p pd=5.52u as=2.2p ps=10.88u w=5u l=1u
X1090 a_79842_165013# a_34750_164967# a_82318_165083# VSS nfet_06v0 ad=2.2p pd=10.88u as=1.3p ps=5.52u w=5u l=1u
X1091 VDD a_60694_169483# a_59134_165083# VDD pfet_06v0 ad=2.2p pd=10.88u as=1.3p ps=5.52u w=5u l=1u
X1092 a_59134_191067# a_60694_195467# VDD VDD pfet_06v0 ad=1.3p pd=5.52u as=2.2p ps=10.88u w=5u l=1u
X1093 a_54110_149586# a_35862_173591# cap_mim_2f0_m4m5_noshield c_width=25u c_length=8u
X1094 VSS VDD VSS VSS nfet_06v0 ad=0.44p pd=2.88u as=0 ps=0 w=1u l=2u
X1095 a_33334_147696# a_29586_147580# a_32242_140838# VDD pfet_06v0 ad=4.4p pd=20.88u as=4.4p ps=20.88u w=10u l=1u
X1096 VDD VSS VDD VDD pfet_06v0 ad=4.29p pd=20.38u as=0 ps=0 w=9.75u l=2u
X1097 a_23448_70736# a_23448_70736# a_102002_183808# VSS nfet_06v0 ad=0.52p pd=2.52u as=0.88p ps=4.88u w=2u l=1u
D51 VSS S2N diode_nd2ps_06v0 pj=40u area=99.99999p
X1098 VDD VSS VDD VDD pfet_06v0 ad=4.29p pd=20.38u as=0 ps=0 w=9.75u l=2u
X1099 a_36062_165083# a_35862_164967# a_33586_165013# VSS nfet_06v0 ad=1.3p pd=5.52u as=2.2p ps=10.88u w=5u l=1u
X1100 a_29486_159680# a_29286_159564# VDD VDD pfet_06v0 ad=2.5p pd=10.5u as=4.4p ps=20.88u w=10u l=1u
X1101 a_112558_182360# a_110806_182360# a_111626_182316# VSS nfet_06v0 ad=0.25p pd=1.5u as=0.44p ps=2.88u w=1u l=1u
X1102 a_60694_169483# a_65710_164969# a_60246_165083# VSS nfet_06v0 ad=1.1p pd=5.88u as=1.1p ps=5.88u w=2.5u l=1u
X1103 a_75502_164969# a_75842_168437# a_75742_168553# VDD pfet_06v0 ad=4.4p pd=20.88u as=2.5p ps=10.5u w=10u l=1u
X1104 VSS a_83430_173707# a_81646_177107# VSS nfet_06v0 ad=0.65p pd=3.02u as=0.65p ps=3.02u w=2.5u l=1u
X1105 VDD a_83878_169483# a_81206_165083# VDD pfet_06v0 ad=1.3p pd=5.52u as=1.3p ps=5.52u w=5u l=1u
X1106 a_58022_191067# a_60694_195467# VDD VDD pfet_06v0 ad=1.3p pd=5.52u as=1.3p ps=5.52u w=5u l=1u
X1107 a_99610_137612# a_43160_205808# a_96874_135712# VDD pfet_06v0 ad=0.22p pd=1.88u as=0.22p ps=1.88u w=0.5u l=1u
X1108 a_58022_165083# a_60694_169483# VDD VDD pfet_06v0 ad=1.3p pd=5.52u as=2.2p ps=10.88u w=5u l=1u
X1109 a_35390_177107# a_46710_173707# cap_mim_2f0_m4m5_noshield c_width=20u c_length=10u
X1110 a_75286_147696# a_73974_147580# VDD VDD pfet_06v0 ad=2.5p pd=10.5u as=4.4p ps=20.88u w=10u l=1u
X1111 a_76198_128854# a_78022_135712# VDD VDD pfet_06v0 ad=2.2p pd=10.88u as=2.2p ps=10.88u w=5u l=1u
X1112 a_92966_173707# a_84994_178107# VDD VDD pfet_06v0 ad=4.4p pd=20.88u as=2.6p ps=10.52u w=10u l=1u
X1113 VSS a_61358_182443# a_69782_182443# VSS nfet_06v0 ad=1.3p pd=5.52u as=1.3p ps=5.52u w=5u l=1u
X1114 VDD a_37622_195467# a_36062_191067# VDD pfet_06v0 ad=2.2p pd=10.88u as=1.3p ps=5.52u w=5u l=1u
X1115 a_35390_177107# a_34750_173591# a_33946_177177# VDD pfet_06v0 ad=2.6p pd=10.52u as=4.4p ps=20.88u w=10u l=1u
X1116 VDD VSS VDD VDD pfet_06v0 ad=4.29p pd=20.38u as=0 ps=0 w=9.75u l=2u
X1117 a_75542_194421# a_75842_194421# a_77466_190997# VSS nfet_06v0 ad=0.44p pd=2.88u as=0.25p ps=1.5u w=1u l=1u
X1118 a_23448_131216# a_23448_131216# VDD VDD pfet_06v0 ad=0.52p pd=2.52u as=0.52p ps=2.52u w=2u l=1u
D52 VSS S1P diode_nd2ps_06v0 pj=40u area=99.99999p
X1119 a_29246_140794# a_29586_147580# a_45134_147696# VDD pfet_06v0 ad=4.4p pd=20.88u as=2.5p ps=10.5u w=10u l=1u
X1120 VDD a_38738_178107# a_46710_173707# VDD pfet_06v0 ad=2.6p pd=10.52u as=2.6p ps=10.52u w=10u l=1u
X1121 a_96374_135596# a_96674_135596# a_114146_135712# VDD pfet_06v0 ad=4.4p pd=20.88u as=2.5p ps=10.5u w=10u l=1u
X1122 a_73974_159564# a_74274_159564# a_91746_159680# VDD pfet_06v0 ad=4.4p pd=20.88u as=2.5p ps=10.5u w=10u l=1u
X1123 a_74474_135712# a_74274_135596# a_74174_135712# VDD pfet_06v0 ad=4.4p pd=20.88u as=2.5p ps=10.5u w=10u l=1u
X1124 a_33946_168553# a_34750_164967# a_35390_168483# VDD pfet_06v0 ad=4.4p pd=20.88u as=2.6p ps=10.52u w=10u l=1u
X1125 VDD a_37622_169483# a_34950_165083# VDD pfet_06v0 ad=2.2p pd=10.88u as=1.3p ps=5.52u w=5u l=1u
X1126 VSS VDD VSS VSS nfet_06v0 ad=4.29p pd=20.38u as=0 ps=0 w=9.75u l=2u
X1127 a_44938_185913# a_44738_185797# VDD VDD pfet_06v0 ad=2.5p pd=10.5u as=4.4p ps=20.88u w=10u l=1u
X1128 a_59578_185843# a_52318_182329# a_60246_182443# VSS nfet_06v0 ad=1.1p pd=5.88u as=0.65p ps=3.02u w=2.5u l=1u
X1129 VDD a_83878_195467# a_82318_191067# VDD pfet_06v0 ad=2.2p pd=10.88u as=1.3p ps=5.52u w=5u l=1u
X1130 a_56718_177177# a_52358_177061# VDD VDD pfet_06v0 ad=2.5p pd=10.5u as=4.4p ps=20.88u w=10u l=1u
X1131 a_35862_182327# a_30160_157284# VDD VDD pfet_06v0 ad=0.44p pd=2.88u as=0.44p ps=2.88u w=1u l=1u
X1132 a_38738_178107# a_42638_173593# a_38286_173707# VSS nfet_06v0 ad=1.1p pd=5.88u as=1.1p ps=5.88u w=2.5u l=1u
X1133 VSS VDD VSS VSS nfet_06v0 ad=7.92p pd=36.88u as=0 ps=0 w=18u l=2u
X1134 VDD VSS VDD VDD pfet_06v0 ad=4.29p pd=20.38u as=0 ps=0 w=9.75u l=2u
X1135 a_52560_133766# a_67978_134216# VSS ppolyf_u_1k r_width=1u r_length=76.45u
X1136 a_102146_190940# a_46710_191067# VDD VDD pfet_06v0 ad=0.99p pd=3.66u as=1.32p ps=6.88u w=3u l=1u
X1137 a_82318_173707# a_83878_178107# VDD VDD pfet_06v0 ad=1.3p pd=5.52u as=1.3p ps=5.52u w=5u l=1u
X1138 a_82322_152822# a_82122_152778# VSS VSS nfet_06v0 ad=1.25p pd=5.5u as=2.2p ps=10.88u w=5u l=1u
X1139 a_102014_128810# a_96674_135596# a_106750_135712# VDD pfet_06v0 ad=4.4p pd=20.88u as=2.5p ps=10.5u w=10u l=1u
X1140 a_58462_168483# a_60246_165083# VSS VSS nfet_06v0 ad=0.65p pd=3.02u as=0.65p ps=3.02u w=2.5u l=1u
X1141 a_56658_165013# a_35862_164967# a_59134_165083# VSS nfet_06v0 ad=2.2p pd=10.88u as=1.3p ps=5.52u w=5u l=1u
X1142 a_92638_194537# a_75542_194421# VDD VDD pfet_06v0 ad=2.5p pd=10.5u as=4.4p ps=20.88u w=10u l=1u
D53 VSS S2N diode_nd2ps_06v0 pj=40u area=99.99999p
X1143 a_77210_149596# a_77474_140794# VSS VSS nfet_06v0 ad=0.825p pd=3.16u as=1.1p ps=5.88u w=2.5u l=1u
X1144 a_67374_165013# a_53050_164969# VSS VSS nfet_06v0 ad=1.25p pd=5.5u as=2.2p ps=10.88u w=5u l=1u
X1145 VDD a_60694_178107# a_59134_173707# VDD pfet_06v0 ad=1.3p pd=5.52u as=1.3p ps=5.52u w=5u l=1u
X1146 a_53050_182329# a_52658_185797# a_53670_185913# VDD pfet_06v0 ad=4.4p pd=20.88u as=2.5p ps=10.5u w=10u l=1u
X1147 a_80174_173637# a_75502_173593# a_79842_173637# VSS nfet_06v0 ad=1.25p pd=5.5u as=1.65p ps=5.66u w=5u l=1u
X1148 a_37622_169483# a_42638_164969# a_37174_165083# VSS nfet_06v0 ad=1.1p pd=5.88u as=1.1p ps=5.88u w=2.5u l=1u
X1149 a_58462_177107# a_69782_173707# cap_mim_2f0_m4m5_noshield c_width=20u c_length=10u
X1150 a_45134_159680# a_29286_159564# VDD VDD pfet_06v0 ad=2.5p pd=10.5u as=4.4p ps=20.88u w=10u l=1u
X1151 VDD a_37622_178107# a_36062_173707# VDD pfet_06v0 ad=1.3p pd=5.52u as=1.3p ps=5.52u w=5u l=1u
X1152 VSS VDD VSS VSS nfet_06v0 ad=4.29p pd=20.38u as=0 ps=0 w=9.75u l=2u
X1153 a_34750_164967# a_30160_133316# VDD VDD pfet_06v0 ad=0.44p pd=2.88u as=0.44p ps=2.88u w=1u l=1u
X1154 a_35862_173591# a_52560_145300# VDD VDD pfet_06v0 ad=0.44p pd=2.88u as=0.44p ps=2.88u w=1u l=1u
X1155 VDD a_69782_191067# a_101594_192396# VDD pfet_06v0 ad=1.32p pd=6.88u as=0.75p ps=3.5u w=3u l=1u
X1156 a_34950_165083# a_37622_169483# VDD VDD pfet_06v0 ad=1.3p pd=5.52u as=2.2p ps=10.88u w=5u l=1u
X1157 a_23448_131216# a_104234_175068# a_104146_175184# VSS nfet_06v0 ad=0.6448p pd=3u as=1.0912p ps=5.84u w=2.48u l=1u
X1158 VSS a_37174_182443# a_35390_185843# VSS nfet_06v0 ad=1.1p pd=5.88u as=0.65p ps=3.02u w=2.5u l=1u
X1159 a_56658_182373# a_52318_182329# a_56358_182373# VSS nfet_06v0 ad=1.65p pd=5.66u as=1.25p ps=5.5u w=5u l=1u
X1160 a_58022_165083# a_57822_164967# a_56658_165013# VSS nfet_06v0 ad=1.3p pd=5.52u as=2.2p ps=10.88u w=5u l=1u
X1161 a_36506_185843# a_35862_182327# a_33946_185913# VDD pfet_06v0 ad=2.6p pd=10.52u as=4.4p ps=20.88u w=10u l=1u
X1162 VDD VSS VDD VDD pfet_06v0 ad=7.92p pd=36.88u as=0 ps=0 w=18u l=2u
X1163 a_82322_128854# a_82122_128810# VSS VSS nfet_06v0 ad=1.25p pd=5.5u as=2.2p ps=10.88u w=5u l=1u
X1164 a_60418_135596# a_51986_135596# a_60618_135712# VDD pfet_06v0 ad=3.3p pd=10.66u as=2.5p ps=10.5u w=10u l=1u
X1165 a_67534_159680# a_51686_159564# VDD VDD pfet_06v0 ad=2.5p pd=10.5u as=4.4p ps=20.88u w=10u l=1u
X1166 a_59134_165083# a_60694_169483# VDD VDD pfet_06v0 ad=1.3p pd=5.52u as=1.3p ps=5.52u w=5u l=1u
X1167 a_36506_194467# a_37174_191067# VSS VSS nfet_06v0 ad=0.65p pd=3.02u as=0.65p ps=3.02u w=2.5u l=1u
X1168 a_84542_182443# a_89358_186797# a_84994_186843# VDD pfet_06v0 ad=2.2p pd=10.88u as=2.2p ps=10.88u w=5u l=1u
X1169 a_33586_190997# a_35862_190951# a_36062_191067# VSS nfet_06v0 ad=2.2p pd=10.88u as=1.3p ps=5.52u w=5u l=1u
X1170 a_23448_131216# a_23448_131216# VDD VDD pfet_06v0 ad=0.52p pd=2.52u as=0.52p ps=2.52u w=2u l=1u
X1171 a_52358_177061# a_52658_177061# a_55594_177177# VDD pfet_06v0 ad=4.4p pd=20.88u as=2.5p ps=10.5u w=10u l=1u
X1172 a_57822_164967# a_52560_133316# VDD VDD pfet_06v0 ad=0.44p pd=2.88u as=0.44p ps=2.88u w=1u l=1u
X1173 a_79842_190997# a_57822_190951# a_81206_191067# VSS nfet_06v0 ad=2.2p pd=10.88u as=1.3p ps=5.52u w=5u l=1u
D54 VSS Z diode_nd2ps_06v0 pj=40u area=99.99999p
X1174 a_52146_152822# a_51946_152778# a_52878_152822# VSS nfet_06v0 ad=2.2p pd=10.88u as=1.25p ps=5.5u w=5u l=1u
X1175 VSS VDD VSS VSS nfet_06v0 ad=4.29p pd=20.38u as=0 ps=0 w=9.75u l=2u
X1176 a_42638_164969# a_29586_168437# a_46382_168553# VDD pfet_06v0 ad=4.4p pd=20.88u as=2.5p ps=10.5u w=10u l=1u
X1177 a_29586_147580# a_29586_147580# a_42526_140838# VSS nfet_06v0 ad=0.44p pd=2.88u as=0.25p ps=1.5u w=1u l=1u
X1178 a_74848_145300# a_79614_140794# a_79082_140838# VSS nfet_06v0 ad=0.88p pd=4.88u as=0.88p ps=4.88u w=2u l=1u
X1179 a_74234_152778# a_74234_152778# VSS VSS nfet_06v0 ad=0.44p pd=2.88u as=0.44p ps=2.88u w=1u l=1u
X1180 a_32242_173637# a_29586_177061# VSS VSS nfet_06v0 ad=0.25p pd=1.5u as=0.44p ps=2.88u w=1u l=1u
X1181 VDD VSS VDD VDD pfet_06v0 ad=7.92p pd=36.88u as=0 ps=0 w=18u l=2u
X1182 a_81206_165083# a_83878_169483# VDD VDD pfet_06v0 ad=1.3p pd=5.52u as=2.2p ps=10.88u w=5u l=1u
X1183 a_81646_177107# a_83430_173707# VSS VSS nfet_06v0 ad=0.65p pd=3.02u as=1.1p ps=5.88u w=2.5u l=1u
X1184 a_54282_190997# a_52658_194421# VSS VSS nfet_06v0 ad=0.25p pd=1.5u as=0.44p ps=2.88u w=1u l=1u
X1185 a_35390_185843# a_37174_182443# VSS VSS nfet_06v0 ad=0.65p pd=3.02u as=1.1p ps=5.88u w=2.5u l=1u
X1186 a_39662_135712# a_29286_135596# VDD VDD pfet_06v0 ad=2.5p pd=10.5u as=4.4p ps=20.88u w=10u l=1u
X1187 a_100422_147696# a_96674_147580# a_99330_140838# VDD pfet_06v0 ad=4.4p pd=20.88u as=4.4p ps=20.88u w=10u l=1u
X1188 a_29246_190953# a_29586_194421# a_29486_194537# VDD pfet_06v0 ad=4.4p pd=20.88u as=2.5p ps=10.5u w=10u l=1u
X1189 a_34950_191067# a_34750_190951# a_33586_190997# VSS nfet_06v0 ad=1.3p pd=5.52u as=2.2p ps=10.88u w=5u l=1u
X1190 a_92966_191067# a_81206_191067# cap_mim_2f0_m4m5_noshield c_width=20u c_length=10u
X1191 a_29746_140838# a_29546_140794# a_29446_140838# VSS nfet_06v0 ad=2.2p pd=10.88u as=1.25p ps=5.5u w=5u l=1u
X1192 a_36382_148780# a_29546_140794# a_36590_140838# VSS nfet_06v0 ad=2.2p pd=10.88u as=1.25p ps=5.5u w=5u l=1u
X1193 a_110806_165000# a_46710_165083# VDD VDD pfet_06v0 ad=1.32p pd=6.88u as=1.32p ps=6.88u w=3u l=1u
X1194 a_51986_147580# a_51986_147580# a_64926_140838# VSS nfet_06v0 ad=0.44p pd=2.88u as=0.25p ps=1.5u w=1u l=1u
X1195 a_44022_147696# a_29286_147580# VDD VDD pfet_06v0 ad=2.5p pd=10.5u as=4.4p ps=20.88u w=10u l=1u
X1196 YN_OUT a_102380_177524# VSS VSS nfet_05v0 ad=0.5808p pd=3.52u as=0.5808p ps=3.52u w=1.32u l=0.6u
X1197 a_69782_182443# a_61358_182443# VSS VSS nfet_06v0 ad=1.3p pd=5.52u as=2.2p ps=10.88u w=5u l=1u
X1198 a_36062_191067# a_37622_195467# VDD VDD pfet_06v0 ad=1.3p pd=5.52u as=1.3p ps=5.52u w=5u l=1u
X1199 VSS a_53050_190953# a_56990_190997# VSS nfet_06v0 ad=2.2p pd=10.88u as=1.25p ps=5.5u w=5u l=1u
X1200 a_69782_182443# a_61810_186843# VDD VDD pfet_06v0 ad=4.4p pd=20.88u as=2.6p ps=10.52u w=10u l=1u
X1201 a_81646_194467# a_83430_191067# VSS VSS nfet_06v0 ad=0.65p pd=3.02u as=0.65p ps=3.02u w=2.5u l=1u
X1202 a_23448_70736# a_106078_183692# a_99296_182600# VSS nfet_06v0 ad=0.6448p pd=3u as=1.0912p ps=5.84u w=2.48u l=1u
X1203 a_43102_195421# a_29246_190953# a_44302_190997# VSS nfet_06v0 ad=2.2p pd=10.88u as=1.25p ps=5.5u w=5u l=1u
X1204 a_52318_173593# a_52318_173593# VSS VSS nfet_06v0 ad=0.44p pd=2.88u as=0.44p ps=2.88u w=1u l=1u
X1205 a_52146_128854# a_51946_128810# a_52878_128854# VSS nfet_06v0 ad=2.2p pd=10.88u as=1.25p ps=5.5u w=5u l=1u
X1206 a_92966_173707# a_81206_173707# cap_mim_2f0_m4m5_noshield c_width=20u c_length=10u
X1207 a_74234_128810# a_74234_128810# VSS VSS nfet_06v0 ad=0.44p pd=2.88u as=0.44p ps=2.88u w=1u l=1u
X1208 a_35390_194467# a_46710_191067# cap_mim_2f0_m4m5_noshield c_width=20u c_length=10u
X1209 a_29978_182329# a_29586_185797# a_30598_185913# VDD pfet_06v0 ad=4.4p pd=20.88u as=2.5p ps=10.5u w=10u l=1u
X1210 a_58782_148780# a_51946_140794# a_58990_140838# VSS nfet_06v0 ad=2.2p pd=10.88u as=1.25p ps=5.5u w=5u l=1u
X1211 a_30160_146650# a_45578_146200# VSS ppolyf_u_1k r_width=1u r_length=76.45u
X1212 a_54922_161580# a_32042_152778# a_52186_159680# VDD pfet_06v0 ad=0.22p pd=1.88u as=0.22p ps=1.88u w=0.5u l=1u
X1213 a_46710_173707# a_38738_178107# VDD VDD pfet_06v0 ad=2.6p pd=10.52u as=4.4p ps=20.88u w=10u l=1u
X1214 VDD VSS VDD VDD pfet_06v0 ad=0.44p pd=2.88u as=0 ps=0 w=1u l=2u
X1215 a_66422_147696# a_51686_147580# VDD VDD pfet_06v0 ad=2.5p pd=10.5u as=4.4p ps=20.88u w=10u l=1u
X1216 a_52658_194421# a_52658_194421# VDD VDD pfet_06v0 ad=0.88p pd=4.88u as=0.88p ps=4.88u w=2u l=1u
X1217 a_102002_175184# a_23448_131216# a_23448_131216# VSS nfet_06v0 ad=0.88p pd=4.88u as=0.52p ps=2.52u w=2u l=1u
X1218 VDD VSS VDD VDD pfet_06v0 ad=0.44p pd=2.88u as=0 ps=0 w=1u l=2u
X1219 a_92966_165083# a_84994_169483# VDD VDD pfet_06v0 ad=4.4p pd=20.88u as=2.6p ps=10.52u w=10u l=1u
X1220 a_82762_185843# a_75502_182329# a_83430_182443# VSS nfet_06v0 ad=1.1p pd=5.88u as=0.65p ps=3.02u w=2.5u l=1u
X1221 a_35390_168483# a_34750_164967# a_33946_168553# VDD pfet_06v0 ad=2.6p pd=10.52u as=4.4p ps=20.88u w=10u l=1u
X1222 a_96334_140794# a_96674_147580# a_112222_147696# VDD pfet_06v0 ad=4.4p pd=20.88u as=2.5p ps=10.5u w=10u l=1u
X1223 a_76930_140838# a_78022_147696# VDD VDD pfet_06v0 ad=2.2p pd=10.88u as=2.2p ps=10.88u w=5u l=1u
X1224 a_37174_182443# a_29246_182329# a_36506_185843# VSS nfet_06v0 ad=0.65p pd=3.02u as=1.1p ps=5.88u w=2.5u l=1u
X1225 VDD a_38738_169483# a_46710_165083# VDD pfet_06v0 ad=2.6p pd=10.52u as=2.6p ps=10.52u w=10u l=1u
X1226 VSS VDD VSS VSS nfet_06v0 ad=7.92p pd=36.88u as=0 ps=0 w=18u l=2u
X1227 VDD a_83878_178107# a_82318_173707# VDD pfet_06v0 ad=1.3p pd=5.52u as=1.3p ps=5.52u w=5u l=1u
X1228 a_76234_182329# a_75842_185797# a_76854_185913# VDD pfet_06v0 ad=4.4p pd=20.88u as=2.5p ps=10.5u w=10u l=1u
X1229 a_64926_152822# a_51986_159564# VSS VSS nfet_06v0 ad=0.25p pd=1.5u as=0.44p ps=2.88u w=1u l=1u
X1230 VSS a_60246_165083# a_58462_168483# VSS nfet_06v0 ad=0.65p pd=3.02u as=0.65p ps=3.02u w=2.5u l=1u
X1231 a_65710_190953# a_65710_190953# a_68218_190953# VSS nfet_06v0 ad=2.2p pd=10.88u as=1.65p ps=5.66u w=5u l=1u
X1232 a_76398_161570# a_23448_31424# a_74474_159680# VDD pfet_06v0 ad=0.242p pd=1.98u as=0.242p ps=1.98u w=0.55u l=1u
X1233 a_36062_173707# a_37622_178107# VDD VDD pfet_06v0 ad=1.3p pd=5.52u as=2.2p ps=10.88u w=5u l=1u
X1234 a_58990_152822# a_51646_152778# VSS VSS nfet_06v0 ad=1.25p pd=5.5u as=2.2p ps=10.88u w=5u l=1u
X1235 a_36382_160764# a_36382_160764# a_38018_159564# VDD pfet_06v0 ad=4.4p pd=20.88u as=3.3p ps=10.66u w=10u l=1u
X1236 a_58462_177107# a_52318_173593# a_61358_173707# VSS nfet_06v0 ad=1.1p pd=5.88u as=0.65p ps=3.02u w=2.5u l=1u
X1237 a_56658_190997# a_57822_190951# a_58022_191067# VSS nfet_06v0 ad=2.2p pd=10.88u as=1.3p ps=5.52u w=5u l=1u
X1238 a_75742_168553# a_75542_168437# VDD VDD pfet_06v0 ad=2.5p pd=10.5u as=4.4p ps=20.88u w=10u l=1u
X1239 a_82318_165083# a_83878_169483# VDD VDD pfet_06v0 ad=1.3p pd=5.52u as=1.3p ps=5.52u w=5u l=1u
X1240 a_66174_169437# a_66174_169437# a_67810_168437# VDD pfet_06v0 ad=4.4p pd=20.88u as=3.3p ps=10.66u w=10u l=1u
X1241 a_58462_194467# a_69782_191067# cap_mim_2f0_m4m5_noshield c_width=20u c_length=10u
X1242 a_64926_128854# a_51986_135596# VSS VSS nfet_06v0 ad=0.25p pd=1.5u as=0.44p ps=2.88u w=1u l=1u
X1243 VDD a_60694_169483# a_59134_165083# VDD pfet_06v0 ad=1.3p pd=5.52u as=1.3p ps=5.52u w=5u l=1u
X1244 a_75542_177061# a_75842_177061# a_78778_177177# VDD pfet_06v0 ad=4.4p pd=20.88u as=2.5p ps=10.5u w=10u l=1u
X1245 a_79614_140794# a_74274_147580# a_84350_147696# VDD pfet_06v0 ad=4.4p pd=20.88u as=2.5p ps=10.5u w=10u l=1u
X1246 VDD a_37622_169483# a_36062_165083# VDD pfet_06v0 ad=1.3p pd=5.52u as=1.3p ps=5.52u w=5u l=1u
X1247 VSS a_37174_191067# a_36506_194467# VSS nfet_06v0 ad=0.65p pd=3.02u as=0.65p ps=3.02u w=2.5u l=1u
X1248 a_113914_175036# a_92966_173707# a_100246_183692# VDD pfet_06v0 ad=0.75p pd=3.5u as=1.32p ps=6.88u w=3u l=1u
X1249 a_100158_166448# a_99096_165124# VSS VSS nfet_06v0 ad=0.5456p pd=3.36u as=0.5456p ps=3.36u w=1.24u l=1u
X1250 a_45146_164969# a_29246_164969# a_45346_165013# VSS nfet_06v0 ad=1.65p pd=5.66u as=1.25p ps=5.5u w=5u l=1u
X1251 VDD a_23448_131216# a_23448_131216# VDD pfet_06v0 ad=0.52p pd=2.52u as=0.52p ps=2.52u w=2u l=1u
X1252 a_58990_128854# a_51646_128810# VSS VSS nfet_06v0 ad=1.25p pd=5.5u as=2.2p ps=10.88u w=5u l=1u
X1253 a_77466_190997# a_75842_194421# VSS VSS nfet_06v0 ad=0.25p pd=1.5u as=0.44p ps=2.88u w=1u l=1u
X1254 a_81646_185843# a_92966_182443# cap_mim_2f0_m4m5_noshield c_width=20u c_length=10u
X1255 VDD VSS VDD VDD pfet_06v0 ad=7.92p pd=36.88u as=0 ps=0 w=18u l=2u
X1256 a_57018_185913# a_35862_182327# a_59578_185843# VDD pfet_06v0 ad=4.4p pd=20.88u as=2.6p ps=10.52u w=10u l=1u
X1257 a_80202_185913# a_57822_182327# a_81646_185843# VDD pfet_06v0 ad=4.4p pd=20.88u as=2.6p ps=10.52u w=10u l=1u
X1258 a_103470_136796# a_103470_136796# a_105106_135596# VDD pfet_06v0 ad=4.4p pd=20.88u as=3.3p ps=10.66u w=10u l=1u
X1259 a_38286_191067# a_43102_195421# a_38738_195467# VDD pfet_06v0 ad=2.2p pd=10.88u as=2.2p ps=10.88u w=5u l=1u
X1260 a_35862_190951# a_97248_157284# VDD VDD pfet_06v0 ad=0.44p pd=2.88u as=0.44p ps=2.88u w=1u l=1u
D55 VSS S4P diode_nd2ps_06v0 pj=40u area=99.99999p
X1261 a_52998_135712# a_51686_135596# VDD VDD pfet_06v0 ad=2.5p pd=10.5u as=4.4p ps=20.88u w=10u l=1u
X1262 a_91746_159680# a_73974_159564# VDD VDD pfet_06v0 ad=2.5p pd=10.5u as=4.4p ps=20.88u w=10u l=1u
X1263 a_52318_182329# a_52658_185797# a_52558_185913# VDD pfet_06v0 ad=4.4p pd=20.88u as=2.5p ps=10.5u w=10u l=1u
X1264 a_29286_185797# a_29586_185797# a_31210_182373# VSS nfet_06v0 ad=0.44p pd=2.88u as=0.25p ps=1.5u w=1u l=1u
X1265 VSS a_114466_164956# a_104234_166332# VSS nfet_06v0 ad=0.44p pd=2.88u as=0.44p ps=2.88u w=1u l=1u
X1266 VSS VDD VSS VSS nfet_06v0 ad=4.29p pd=20.38u as=0 ps=0 w=9.75u l=2u
X1267 a_43102_195421# a_43102_195421# a_44738_194421# VDD pfet_06v0 ad=4.4p pd=20.88u as=3.3p ps=10.66u w=10u l=1u
D56 VSS S4P diode_nd2ps_06v0 pj=40u area=99.99999p
X1268 a_29746_140838# a_29546_140794# a_30478_140838# VSS nfet_06v0 ad=2.2p pd=10.88u as=1.25p ps=5.5u w=5u l=1u
X1269 a_23448_190688# a_100246_166332# a_100158_166448# VSS nfet_06v0 ad=0.6448p pd=3u as=1.0912p ps=5.84u w=2.48u l=1u
X1270 a_29286_159564# a_29586_159564# a_41494_152822# VSS nfet_06v0 ad=0.44p pd=2.88u as=0.25p ps=1.5u w=1u l=1u
X1271 VDD a_61810_186843# a_69782_182443# VDD pfet_06v0 ad=2.6p pd=10.52u as=2.6p ps=10.52u w=10u l=1u
X1272 a_77474_140794# a_74234_140794# a_77210_149596# VSS nfet_06v0 ad=1.1p pd=5.88u as=0.825p ps=3.16u w=2.5u l=1u
X1273 a_85150_140838# a_73934_140794# VSS VSS nfet_06v0 ad=1.25p pd=5.5u as=2.2p ps=10.88u w=5u l=1u
X1274 a_35862_173591# a_56794_140838# VSS VSS nfet_06v0 ad=0.44p pd=2.88u as=0.44p ps=2.88u w=1u l=1u
X1275 a_29546_128810# a_29586_135596# a_44022_135712# VDD pfet_06v0 ad=4.4p pd=20.88u as=2.5p ps=10.5u w=10u l=1u
X1276 VDD a_52358_185797# a_57350_185913# VDD pfet_06v0 ad=4.4p pd=20.88u as=2.5p ps=10.5u w=10u l=1u
X1277 a_75842_194421# a_75842_194421# VDD VDD pfet_06v0 ad=0.88p pd=4.88u as=0.88p ps=4.88u w=2u l=1u
X1278 VSS a_46710_182443# a_110806_182360# VSS nfet_06v0 ad=0.44p pd=2.88u as=0.44p ps=2.88u w=1u l=1u
X1279 a_67810_177061# a_52658_177061# a_68010_177177# VDD pfet_06v0 ad=3.3p pd=10.66u as=2.5p ps=10.5u w=10u l=1u
X1280 a_42638_190953# a_42638_190953# a_45146_190953# VSS nfet_06v0 ad=2.2p pd=10.88u as=1.65p ps=5.66u w=5u l=1u
X1281 a_76930_140838# a_23448_50576# a_74434_140838# VSS nfet_06v0 ad=3.74p pd=17.88u as=3.74p ps=17.88u w=8.5u l=1u
X1282 a_81206_165083# a_57822_164967# a_79842_165013# VSS nfet_06v0 ad=1.3p pd=5.52u as=2.2p ps=10.88u w=5u l=1u
X1283 a_106750_135712# a_96374_135596# VDD VDD pfet_06v0 ad=2.5p pd=10.5u as=4.4p ps=20.88u w=10u l=1u
X1284 a_59134_182443# a_35862_182327# a_56658_182373# VSS nfet_06v0 ad=1.3p pd=5.52u as=2.2p ps=10.88u w=5u l=1u
X1285 a_97248_157284# a_96674_159564# a_98598_152822# VDD pfet_06v0 ad=4.4p pd=20.88u as=4.4p ps=20.88u w=10u l=1u
X1286 a_34950_191067# a_29586_194421# a_38738_195467# VDD pfet_06v0 ad=2.2p pd=10.88u as=1.3p ps=5.52u w=5u l=1u
X1287 a_38286_182443# a_29246_182329# a_35390_185843# VSS nfet_06v0 ad=0.65p pd=3.02u as=1.1p ps=5.88u w=2.5u l=1u
X1288 a_96334_152778# a_96634_152778# a_107550_152822# VSS nfet_06v0 ad=2.2p pd=10.88u as=1.25p ps=5.5u w=5u l=1u
X1289 a_53670_185913# a_52358_185797# VDD VDD pfet_06v0 ad=2.5p pd=10.5u as=4.4p ps=20.88u w=10u l=1u
X1290 a_30160_146650# a_38998_140838# VSS ppolyf_u_1k r_width=1u r_length=76.45u
X1291 a_46710_173707# a_38286_173707# VSS VSS nfet_06v0 ad=2.2p pd=10.88u as=1.3p ps=5.52u w=5u l=1u
X1292 a_99046_166448# a_99096_165124# VSS VSS nfet_06v0 ad=0.5456p pd=3.36u as=0.5456p ps=3.36u w=1.24u l=1u
X1293 a_111110_147696# a_96374_147580# VDD VDD pfet_06v0 ad=2.5p pd=10.5u as=4.4p ps=20.88u w=10u l=1u
X1294 a_23448_131216# a_23448_131216# a_102002_175184# VSS nfet_06v0 ad=0.52p pd=2.52u as=0.88p ps=4.88u w=2u l=1u
X1295 a_106078_183692# a_92966_182443# VSS VSS nfet_06v0 ad=0.33p pd=1.66u as=0.44p ps=2.88u w=1u l=1u
X1296 a_83430_182443# a_75502_182329# a_82762_185843# VSS nfet_06v0 ad=0.65p pd=3.02u as=1.1p ps=5.88u w=2.5u l=1u
X1297 VDD a_69782_165083# a_114466_164956# VDD pfet_06v0 ad=1.32p pd=6.88u as=0.99p ps=3.66u w=3u l=1u
X1298 a_29286_135596# a_29586_135596# a_41494_128854# VSS nfet_06v0 ad=0.44p pd=2.88u as=0.25p ps=1.5u w=1u l=1u
X1299 a_38738_178107# a_29586_177061# a_34950_173707# VDD pfet_06v0 ad=1.3p pd=5.52u as=2.2p ps=10.88u w=5u l=1u
X1300 a_29286_168437# a_29586_168437# a_32522_168553# VDD pfet_06v0 ad=4.4p pd=20.88u as=2.5p ps=10.5u w=10u l=1u
X1301 a_99330_140838# a_43160_205808# a_96834_140838# VSS nfet_06v0 ad=3.74p pd=17.88u as=3.74p ps=17.88u w=8.5u l=1u
X1302 a_101594_192396# a_92966_191067# a_99134_183692# VDD pfet_06v0 ad=0.75p pd=3.5u as=1.32p ps=6.88u w=3u l=1u
X1303 a_56358_182373# a_53050_182329# VSS VSS nfet_06v0 ad=1.25p pd=5.5u as=2.2p ps=10.88u w=5u l=1u
X1304 a_90994_185797# a_75842_185797# a_91194_185913# VDD pfet_06v0 ad=3.3p pd=10.66u as=2.5p ps=10.5u w=10u l=1u
X1305 a_46710_165083# a_38738_169483# VDD VDD pfet_06v0 ad=2.6p pd=10.52u as=4.4p ps=20.88u w=10u l=1u
X1306 VSS a_83430_165083# a_81646_168483# VSS nfet_06v0 ad=0.65p pd=3.02u as=0.65p ps=3.02u w=2.5u l=1u
X1307 VSS VDD VSS VSS nfet_06v0 ad=7.92p pd=36.88u as=0 ps=0 w=18u l=2u
X1308 a_60618_135712# a_60418_135596# VDD VDD pfet_06v0 ad=2.5p pd=10.5u as=4.4p ps=20.88u w=10u l=1u
D57 S4P VDD diode_pd2nw_06v0 pj=40u area=99.99999p
X1309 a_66174_178061# a_52318_173593# a_67374_173637# VSS nfet_06v0 ad=2.2p pd=10.88u as=1.25p ps=5.5u w=5u l=1u
X1310 a_56794_152822# a_58782_160764# a_52560_157284# VDD pfet_06v0 ad=1.76p pd=8.88u as=1.76p ps=8.88u w=4u l=1u
X1311 a_96334_128810# a_96634_128810# a_107550_128854# VSS nfet_06v0 ad=2.2p pd=10.88u as=1.25p ps=5.5u w=5u l=1u
X1312 a_98798_161570# a_35862_190951# cap_mim_2f0_m4m5_noshield c_width=25u c_length=8u
D58 S4P VDD diode_pd2nw_06v0 pj=40u area=99.99999p
X1313 a_74848_133316# a_74274_135596# a_76198_128854# VDD pfet_06v0 ad=4.4p pd=20.88u as=4.4p ps=20.88u w=10u l=1u
X1314 a_51986_135596# a_51986_135596# VDD VDD pfet_06v0 ad=0.88p pd=4.88u as=0.88p ps=4.88u w=2u l=1u
X1315 VSS VDD VSS VSS nfet_06v0 ad=4.29p pd=20.38u as=0 ps=0 w=9.75u l=2u
X1316 a_55594_177177# a_52358_177061# VDD VDD pfet_06v0 ad=2.5p pd=10.5u as=4.4p ps=20.88u w=10u l=1u
X1317 a_81646_177107# a_75502_173593# a_84542_173707# VSS nfet_06v0 ad=1.1p pd=5.88u as=0.65p ps=3.02u w=2.5u l=1u
X1318 ZN_OUT a_102380_186148# VDD VDD pfet_05v0 ad=0.8052p pd=4.54u as=0.8052p ps=4.54u w=1.83u l=0.5u
X1319 a_52878_152822# a_51646_152778# VSS VSS nfet_06v0 ad=1.25p pd=5.5u as=2.2p ps=10.88u w=5u l=1u
X1320 a_52186_159680# a_51986_159564# a_51886_159680# VDD pfet_06v0 ad=4.4p pd=20.88u as=2.5p ps=10.5u w=10u l=1u
X1321 a_46382_168553# a_29286_168437# VDD VDD pfet_06v0 ad=2.5p pd=10.5u as=4.4p ps=20.88u w=10u l=1u
X1322 a_42526_140838# a_29586_147580# VSS VSS nfet_06v0 ad=0.25p pd=1.5u as=0.44p ps=2.88u w=1u l=1u
X1323 VSS a_60246_191067# a_59578_194467# VSS nfet_06v0 ad=1.1p pd=5.88u as=0.65p ps=3.02u w=2.5u l=1u
X1324 VSS VDD VSS VSS nfet_06v0 ad=4.29p pd=20.38u as=0 ps=0 w=9.75u l=2u
X1325 a_74274_159564# a_74274_159564# VDD VDD pfet_06v0 ad=0.88p pd=4.88u as=0.88p ps=4.88u w=2u l=1u
X1326 a_38998_140838# a_30160_145300# VDD VDD pfet_06v0 ad=0.44p pd=2.88u as=0.44p ps=2.88u w=1u l=1u
X1327 a_31710_161570# a_31310_152778# a_29786_159680# VDD pfet_06v0 ad=0.242p pd=1.98u as=0.242p ps=1.98u w=0.55u l=1u
X1328 a_57018_185913# a_57822_182327# a_58462_185843# VDD pfet_06v0 ad=4.4p pd=20.88u as=2.6p ps=10.52u w=10u l=1u
X1329 VDD a_83878_169483# a_82318_165083# VDD pfet_06v0 ad=1.3p pd=5.52u as=1.3p ps=5.52u w=5u l=1u
X1330 VDD a_60694_186843# a_58022_182443# VDD pfet_06v0 ad=2.2p pd=10.88u as=1.3p ps=5.52u w=5u l=1u
X1331 a_29486_194537# a_29286_194421# VDD VDD pfet_06v0 ad=2.5p pd=10.5u as=4.4p ps=20.88u w=10u l=1u
X1332 a_29586_185797# a_29586_185797# VDD VDD pfet_06v0 ad=0.88p pd=4.88u as=0.88p ps=4.88u w=2u l=1u
X1333 a_29446_140838# a_29246_140794# VSS VSS nfet_06v0 ad=1.25p pd=5.5u as=2.2p ps=10.88u w=5u l=1u
D59 S1N VDD diode_pd2nw_06v0 pj=40u area=99.99999p
X1334 a_36590_140838# a_29246_140794# VSS VSS nfet_06v0 ad=1.25p pd=5.5u as=2.2p ps=10.88u w=5u l=1u
X1335 a_76398_149586# a_34750_182327# cap_mim_2f0_m4m5_noshield c_width=25u c_length=8u
X1336 VSS a_60246_173707# a_58462_177107# VSS nfet_06v0 ad=1.1p pd=5.88u as=0.65p ps=3.02u w=2.5u l=1u
X1337 a_114466_173580# a_46710_173707# VDD VDD pfet_06v0 ad=0.99p pd=3.66u as=1.32p ps=6.88u w=3u l=1u
X1338 VDD a_29286_185797# a_34278_185913# VDD pfet_06v0 ad=4.4p pd=20.88u as=2.5p ps=10.5u w=10u l=1u
X1339 a_36062_165083# a_37622_169483# VDD VDD pfet_06v0 ad=1.3p pd=5.52u as=2.2p ps=10.88u w=5u l=1u
X1340 a_44738_177061# a_29586_177061# a_44938_177177# VDD pfet_06v0 ad=3.3p pd=10.66u as=2.5p ps=10.5u w=10u l=1u
X1341 a_44302_190997# a_29978_190953# VSS VSS nfet_06v0 ad=1.25p pd=5.5u as=2.2p ps=10.88u w=5u l=1u
X1342 a_52878_128854# a_51646_128810# VSS VSS nfet_06v0 ad=1.25p pd=5.5u as=2.2p ps=10.88u w=5u l=1u
X1343 a_35862_182327# a_31510_152822# cap_mim_2f0_m4m5_noshield c_width=25u c_length=8u
X1344 a_30598_185913# a_29286_185797# VDD VDD pfet_06v0 ad=2.5p pd=10.5u as=4.4p ps=20.88u w=10u l=1u
X1345 a_57822_190951# a_74848_157284# VDD VDD pfet_06v0 ad=0.44p pd=2.88u as=0.44p ps=2.88u w=1u l=1u
X1346 VSS a_29978_164969# a_33918_165013# VSS nfet_06v0 ad=2.2p pd=10.88u as=1.25p ps=5.5u w=5u l=1u
X1347 a_36062_191067# a_29586_194421# a_37622_195467# VDD pfet_06v0 ad=2.2p pd=10.88u as=1.3p ps=5.52u w=5u l=1u
X1348 a_75502_190953# a_75502_190953# VSS VSS nfet_06v0 ad=0.44p pd=2.88u as=0.44p ps=2.88u w=1u l=1u
X1349 a_102380_177524# a_23448_131216# VSS VSS nfet_05v0 ad=0.5808p pd=3.52u as=0.5808p ps=3.52u w=1.32u l=0.6u
X1350 a_99296_165240# a_99096_165124# VSS VSS nfet_06v0 ad=0.5456p pd=3.36u as=0.5456p ps=3.36u w=1.24u l=1u
X1351 VDD a_84994_186843# a_92966_182443# VDD pfet_06v0 ad=2.6p pd=10.52u as=2.6p ps=10.52u w=10u l=1u
X1352 a_33946_168553# a_29586_168437# a_33646_168553# VDD pfet_06v0 ad=3.3p pd=10.66u as=2.5p ps=10.5u w=10u l=1u
X1353 a_92966_173707# a_84542_173707# VSS VSS nfet_06v0 ad=1.3p pd=5.52u as=2.2p ps=10.88u w=5u l=1u
X1354 a_88894_190953# a_88894_190953# a_91402_190953# VSS nfet_06v0 ad=2.2p pd=10.88u as=1.65p ps=5.66u w=5u l=1u
X1355 a_52560_145300# a_67978_145300# VSS ppolyf_u_1k r_width=1u r_length=76.45u
X1356 a_112222_147696# a_96374_147580# VDD VDD pfet_06v0 ad=2.5p pd=10.5u as=4.4p ps=20.88u w=10u l=1u
X1357 a_33334_159680# a_34926_152778# a_32786_152778# VSS nfet_06v0 ad=0.88p pd=4.88u as=0.88p ps=4.88u w=2u l=1u
X1358 a_78022_159680# a_74274_159564# a_76930_152822# VDD pfet_06v0 ad=4.4p pd=20.88u as=4.4p ps=20.88u w=10u l=1u
X1359 a_76854_185913# a_75542_185797# VDD VDD pfet_06v0 ad=2.5p pd=10.5u as=4.4p ps=20.88u w=10u l=1u
D60 VSS S4N diode_nd2ps_06v0 pj=40u area=99.99999p
X1360 a_79614_152778# a_79614_152778# a_82122_152778# VSS nfet_06v0 ad=2.2p pd=10.88u as=1.65p ps=5.66u w=5u l=1u
X1361 a_60246_173707# a_66174_178061# a_60694_178107# VDD pfet_06v0 ad=2.2p pd=10.88u as=2.2p ps=10.88u w=5u l=1u
X1362 a_58022_182443# a_52658_185797# a_61810_186843# VDD pfet_06v0 ad=2.2p pd=10.88u as=1.3p ps=5.52u w=5u l=1u
X1363 a_103470_160764# a_96634_152778# a_103678_152822# VSS nfet_06v0 ad=2.2p pd=10.88u as=1.25p ps=5.5u w=5u l=1u
X1364 a_30160_158634# a_45578_158184# VSS ppolyf_u_1k r_width=1u r_length=76.45u
D61 VSS X diode_nd2ps_06v0 pj=40u area=99.99999p
X1365 a_58462_185843# a_60246_182443# VSS VSS nfet_06v0 ad=0.65p pd=3.02u as=1.1p ps=5.88u w=2.5u l=1u
X1366 a_81070_148780# a_81070_148780# a_82706_147580# VDD pfet_06v0 ad=4.4p pd=20.88u as=3.3p ps=10.66u w=10u l=1u
X1367 a_65710_182329# a_52658_185797# a_69454_185913# VDD pfet_06v0 ad=4.4p pd=20.88u as=2.5p ps=10.5u w=10u l=1u
X1368 a_34750_164967# a_30160_133316# VDD VDD pfet_06v0 ad=0.44p pd=2.88u as=0.44p ps=2.88u w=1u l=1u
X1369 a_55734_159680# a_57326_152778# a_55186_152778# VSS nfet_06v0 ad=0.88p pd=4.88u as=0.88p ps=4.88u w=2u l=1u
X1370 a_29786_159680# a_29586_159564# a_30598_159680# VDD pfet_06v0 ad=4.4p pd=20.88u as=2.5p ps=10.5u w=10u l=1u
X1371 VSS a_102146_190940# a_99134_166332# VSS nfet_06v0 ad=0.44p pd=2.88u as=0.44p ps=2.88u w=1u l=1u
X1372 a_52358_168437# a_52658_168437# a_54282_165013# VSS nfet_06v0 ad=0.44p pd=2.88u as=0.25p ps=1.5u w=1u l=1u
X1373 a_96634_128810# a_96674_135596# a_111110_135712# VDD pfet_06v0 ad=4.4p pd=20.88u as=2.5p ps=10.5u w=10u l=1u
X1374 a_102104_173976# VDD a_23448_131216# VSS nfet_06v0 ad=1.0912p pd=5.84u as=0.6448p ps=3u w=2.48u l=1u
X1375 a_92966_165083# a_81206_165083# cap_mim_2f0_m4m5_noshield c_width=20u c_length=10u
D62 S3N VDD diode_pd2nw_06v0 pj=40u area=99.99999p
X1376 a_33334_135712# a_34926_128810# a_32786_128810# VSS nfet_06v0 ad=0.88p pd=4.88u as=0.88p ps=4.88u w=2u l=1u
X1377 a_52186_159680# a_51986_159564# a_52998_159680# VDD pfet_06v0 ad=4.4p pd=20.88u as=2.5p ps=10.5u w=10u l=1u
X1378 a_81646_168483# a_83430_165083# VSS VSS nfet_06v0 ad=0.65p pd=3.02u as=1.1p ps=5.88u w=2.5u l=1u
X1379 a_30160_157734# a_45578_158184# VSS ppolyf_u_1k r_width=1u r_length=76.45u
X1380 VDD VSS VDD VDD pfet_06v0 ad=4.29p pd=20.38u as=0 ps=0 w=9.75u l=2u
D63 S1N VDD diode_pd2nw_06v0 pj=40u area=99.99999p
X1381 a_79614_128810# a_79614_128810# a_82122_128810# VSS nfet_06v0 ad=2.2p pd=10.88u as=1.65p ps=5.66u w=5u l=1u
X1382 a_103470_136796# a_96634_128810# a_103678_128854# VSS nfet_06v0 ad=2.2p pd=10.88u as=1.25p ps=5.5u w=5u l=1u
X1383 a_54922_149596# a_23448_50576# a_52186_147696# VDD pfet_06v0 ad=0.22p pd=1.88u as=0.22p ps=1.88u w=0.5u l=1u
X1384 VSS VDD VSS VSS nfet_06v0 ad=7.92p pd=36.88u as=0 ps=0 w=18u l=2u
X1385 a_78778_177177# a_75542_177061# VDD VDD pfet_06v0 ad=2.5p pd=10.5u as=4.4p ps=20.88u w=10u l=1u
X1386 a_35390_168483# a_46710_165083# cap_mim_2f0_m4m5_noshield c_width=20u c_length=10u
X1387 a_36506_177107# a_37174_173707# VSS VSS nfet_06v0 ad=0.65p pd=3.02u as=1.1p ps=5.88u w=2.5u l=1u
X1388 a_55734_135712# a_57326_128810# a_55186_128810# VSS nfet_06v0 ad=0.88p pd=4.88u as=0.88p ps=4.88u w=2u l=1u
X1389 a_84350_147696# a_73974_147580# VDD VDD pfet_06v0 ad=2.5p pd=10.5u as=4.4p ps=20.88u w=10u l=1u
X1390 a_35862_190951# a_97248_157284# VDD VDD pfet_06v0 ad=0.44p pd=2.88u as=0.44p ps=2.88u w=1u l=1u
X1391 a_38738_169483# a_29586_168437# a_34950_165083# VDD pfet_06v0 ad=1.3p pd=5.52u as=2.2p ps=10.88u w=5u l=1u
D64 VSS S1N diode_nd2ps_06v0 pj=40u area=99.99999p
X1392 a_73934_152778# a_74274_159564# a_89822_159680# VDD pfet_06v0 ad=4.4p pd=20.88u as=2.5p ps=10.5u w=10u l=1u
X1393 a_82318_173707# a_75842_177061# a_83878_178107# VDD pfet_06v0 ad=2.2p pd=10.88u as=1.3p ps=5.52u w=5u l=1u
X1394 a_45346_165013# a_45146_164969# VSS VSS nfet_06v0 ad=1.25p pd=5.5u as=2.2p ps=10.88u w=5u l=1u
X1395 a_60694_178107# a_65710_173593# a_60246_173707# VSS nfet_06v0 ad=1.1p pd=5.88u as=1.1p ps=5.88u w=2.5u l=1u
X1396 VSS a_83430_191067# a_82762_194467# VSS nfet_06v0 ad=1.1p pd=5.88u as=0.65p ps=3.02u w=2.5u l=1u
X1397 a_84542_173707# a_75502_173593# a_81646_177107# VSS nfet_06v0 ad=0.65p pd=3.02u as=1.1p ps=5.88u w=2.5u l=1u
X1398 a_53910_128854# a_55734_135712# VDD VDD pfet_06v0 ad=2.2p pd=10.88u as=2.2p ps=10.88u w=5u l=1u
X1399 a_23448_131216# a_106078_175068# a_99296_173976# VSS nfet_06v0 ad=0.6448p pd=3u as=1.0912p ps=5.84u w=2.48u l=1u
X1400 a_46710_191067# a_34950_191067# cap_mim_2f0_m4m5_noshield c_width=20u c_length=10u
X1401 VDD a_83878_186843# a_81206_182443# VDD pfet_06v0 ad=2.2p pd=10.88u as=1.3p ps=5.52u w=5u l=1u
X1402 a_58462_185843# a_57822_182327# a_57018_185913# VDD pfet_06v0 ad=2.6p pd=10.52u as=4.4p ps=20.88u w=10u l=1u
X1403 a_52558_185913# a_52358_185797# VDD VDD pfet_06v0 ad=2.5p pd=10.5u as=4.4p ps=20.88u w=10u l=1u
X1404 a_31210_182373# a_29586_185797# VSS VSS nfet_06v0 ad=0.25p pd=1.5u as=0.44p ps=2.88u w=1u l=1u
X1405 a_111626_164956# a_92966_165083# VDD VDD pfet_06v0 ad=0.99p pd=3.66u as=1.32p ps=6.88u w=3u l=1u
X1406 a_83878_169483# a_88894_164969# a_83430_165083# VSS nfet_06v0 ad=1.1p pd=5.88u as=1.1p ps=5.88u w=2.5u l=1u
X1407 a_46710_173707# a_34950_173707# cap_mim_2f0_m4m5_noshield c_width=20u c_length=10u
X1408 a_30478_140838# a_29246_140794# VSS VSS nfet_06v0 ad=1.25p pd=5.5u as=2.2p ps=10.88u w=5u l=1u
X1409 a_82318_182443# a_34750_182327# a_79842_182373# VSS nfet_06v0 ad=1.3p pd=5.52u as=2.2p ps=10.88u w=5u l=1u
X1410 a_41494_152822# a_29586_159564# VSS VSS nfet_06v0 ad=0.25p pd=1.5u as=0.44p ps=2.88u w=1u l=1u
X1411 VSS VDD VSS VSS nfet_06v0 ad=7.92p pd=36.88u as=0 ps=0 w=18u l=2u
X1412 a_76398_149586# a_23448_31424# a_74474_147696# VDD pfet_06v0 ad=0.242p pd=1.98u as=0.242p ps=1.98u w=0.55u l=1u
X1413 a_34394_152822# a_29546_152778# a_31710_161570# VSS nfet_06v0 ad=1.1p pd=5.88u as=0.825p ps=3.16u w=2.5u l=1u
X1414 a_99046_166448# a_99134_166332# a_23448_190688# VSS nfet_06v0 ad=1.0912p pd=5.84u as=0.6448p ps=3u w=2.48u l=1u
X1415 a_57350_185913# a_52658_185797# a_57018_185913# VDD pfet_06v0 ad=2.5p pd=10.5u as=3.3p ps=10.66u w=10u l=1u
X1416 a_74848_133766# a_90266_133316# VSS ppolyf_u_1k r_width=1u r_length=76.45u
X1417 a_80202_168553# a_75842_168437# a_79902_168553# VDD pfet_06v0 ad=3.3p pd=10.66u as=2.5p ps=10.5u w=10u l=1u
D65 VSS X diode_nd2ps_06v0 pj=40u area=99.99999p
X1418 VSS a_46710_191067# a_98486_190984# VSS nfet_06v0 ad=0.44p pd=2.88u as=0.44p ps=2.88u w=1u l=1u
X1419 a_89358_186797# a_89358_186797# a_90994_185797# VDD pfet_06v0 ad=4.4p pd=20.88u as=3.3p ps=10.66u w=10u l=1u
X1420 a_107550_152822# a_96334_152778# VSS VSS nfet_06v0 ad=1.25p pd=5.5u as=2.2p ps=10.88u w=5u l=1u
X1421 a_37622_195467# a_29586_194421# a_36062_191067# VDD pfet_06v0 ad=1.3p pd=5.52u as=2.2p ps=10.88u w=5u l=1u
X1422 a_96374_147580# a_96674_147580# a_108582_140838# VSS nfet_06v0 ad=0.44p pd=2.88u as=0.25p ps=1.5u w=1u l=1u
X1423 VDD VSS VDD VDD pfet_06v0 ad=0.44p pd=2.88u as=0 ps=0 w=1u l=2u
X1424 a_41494_128854# a_29586_135596# VSS VSS nfet_06v0 ad=0.25p pd=1.5u as=0.44p ps=2.88u w=1u l=1u
X1425 a_101060_165240# a_99096_165124# a_100760_165240# VSS nfet_06v0 ad=0.175p pd=1.2u as=0.175p ps=1.2u w=0.7u l=1u
X1426 a_92966_182443# a_84994_186843# VDD VDD pfet_06v0 ad=2.6p pd=10.52u as=4.4p ps=20.88u w=10u l=1u
X1427 a_74234_140794# a_74274_147580# a_88710_147696# VDD pfet_06v0 ad=4.4p pd=20.88u as=2.5p ps=10.5u w=10u l=1u
X1428 a_52658_185797# a_52658_185797# a_55314_182373# VSS nfet_06v0 ad=0.44p pd=2.88u as=0.25p ps=1.5u w=1u l=1u
X1429 a_58462_168483# a_69782_165083# cap_mim_2f0_m4m5_noshield c_width=20u c_length=10u
X1430 a_32522_168553# a_29286_168437# VDD VDD pfet_06v0 ad=2.5p pd=10.5u as=4.4p ps=20.88u w=10u l=1u
D66 S3N VDD diode_pd2nw_06v0 pj=40u area=99.99999p
X1431 a_97248_133766# a_112666_133316# VSS ppolyf_u_1k r_width=1u r_length=76.45u
X1432 VDD a_23448_70736# a_23448_70736# VDD pfet_06v0 ad=0.88p pd=4.88u as=0.52p ps=2.52u w=2u l=1u
X1433 a_34394_128854# a_29546_128810# a_31710_137602# VSS nfet_06v0 ad=1.1p pd=5.88u as=0.825p ps=3.16u w=2.5u l=1u
X1434 a_60246_173707# a_52318_173593# a_59578_177107# VSS nfet_06v0 ad=0.65p pd=3.02u as=1.1p ps=5.88u w=2.5u l=1u
X1435 a_58462_168483# a_52318_164969# a_61358_165083# VSS nfet_06v0 ad=1.1p pd=5.88u as=0.65p ps=3.02u w=2.5u l=1u
X1436 a_83430_173707# a_89358_178061# a_83878_178107# VDD pfet_06v0 ad=2.2p pd=10.88u as=2.2p ps=10.88u w=5u l=1u
X1437 VSS a_37174_182443# a_36506_185843# VSS nfet_06v0 ad=1.1p pd=5.88u as=0.65p ps=3.02u w=2.5u l=1u
D67 VSS S3N diode_nd2ps_06v0 pj=40u area=99.99999p
X1438 a_74848_158634# a_57822_190951# VSS ppolyf_u_1k r_width=1u r_length=76.45u
X1439 a_67374_173637# a_53050_173593# VSS VSS nfet_06v0 ad=1.25p pd=5.5u as=2.2p ps=10.88u w=5u l=1u
X1440 a_107550_128854# a_96334_128810# VSS VSS nfet_06v0 ad=1.25p pd=5.5u as=2.2p ps=10.88u w=5u l=1u
X1441 a_37622_178107# a_42638_173593# a_37174_173707# VSS nfet_06v0 ad=1.1p pd=5.88u as=1.1p ps=5.88u w=2.5u l=1u
X1442 a_61810_186843# a_52658_185797# a_58022_182443# VDD pfet_06v0 ad=1.3p pd=5.52u as=2.2p ps=10.88u w=5u l=1u
X1443 a_30160_133316# a_45578_133316# VSS ppolyf_u_1k r_width=1u r_length=76.45u
X1444 a_57822_182327# a_97248_145300# VDD VDD pfet_06v0 ad=0.44p pd=2.88u as=0.44p ps=2.88u w=1u l=1u
D68 VSS S1N diode_nd2ps_06v0 pj=40u area=99.99999p
X1445 a_98798_137602# a_34750_173591# cap_mim_2f0_m4m5_noshield c_width=25u c_length=8u
X1446 a_75542_168437# a_75842_168437# a_77466_165013# VSS nfet_06v0 ad=0.44p pd=2.88u as=0.25p ps=1.5u w=1u l=1u
X1447 a_56658_190997# a_52318_190953# a_56358_190997# VSS nfet_06v0 ad=1.65p pd=5.66u as=1.25p ps=5.5u w=5u l=1u
X1448 a_97248_158634# a_35862_190951# VSS ppolyf_u_1k r_width=1u r_length=76.45u
X1449 a_51886_159680# a_51686_159564# VDD VDD pfet_06v0 ad=2.5p pd=10.5u as=4.4p ps=20.88u w=10u l=1u
X1450 a_23448_131216# VDD a_102104_173976# VSS nfet_06v0 ad=0.6448p pd=3u as=1.0912p ps=5.84u w=2.48u l=1u
X1451 a_31710_149586# a_32786_140794# VSS VSS nfet_06v0 ad=0.825p pd=3.16u as=1.1p ps=5.88u w=2.5u l=1u
X1452 a_37434_152778# a_29546_152778# a_37634_152822# VSS nfet_06v0 ad=1.65p pd=5.66u as=1.25p ps=5.5u w=5u l=1u
X1453 VDD VSS VDD VDD pfet_06v0 ad=4.29p pd=20.38u as=0 ps=0 w=9.75u l=2u
X1454 a_35390_177107# a_37174_173707# VSS VSS nfet_06v0 ad=0.65p pd=3.02u as=0.65p ps=3.02u w=2.5u l=1u
X1455 a_82318_182443# a_83878_186843# VDD VDD pfet_06v0 ad=1.3p pd=5.52u as=2.2p ps=10.88u w=5u l=1u
X1456 VDD VSS VDD VDD pfet_06v0 ad=7.92p pd=36.88u as=0 ps=0 w=18u l=2u
X1457 a_38018_147580# a_29586_147580# a_38218_147696# VDD pfet_06v0 ad=3.3p pd=10.66u as=2.5p ps=10.5u w=10u l=1u
X1458 XP_OUT XN_OUT VDD VDD pfet_05v0 ad=0.8052p pd=4.54u as=0.8052p ps=4.54u w=1.83u l=0.5u
X1459 a_61358_165083# a_66174_169437# a_61810_169483# VDD pfet_06v0 ad=2.2p pd=10.88u as=2.2p ps=10.88u w=5u l=1u
X1460 a_34278_185913# a_29586_185797# a_33946_185913# VDD pfet_06v0 ad=2.5p pd=10.5u as=3.3p ps=10.66u w=10u l=1u
X1461 a_54110_149586# a_55186_140794# VSS VSS nfet_06v0 ad=0.825p pd=3.16u as=1.1p ps=5.88u w=2.5u l=1u
X1462 VSS VDD VSS VSS nfet_06v0 ad=4.29p pd=20.38u as=0 ps=0 w=9.75u l=2u
X1463 a_82762_194467# a_83430_191067# VSS VSS nfet_06v0 ad=0.65p pd=3.02u as=0.65p ps=3.02u w=2.5u l=1u
X1464 a_106078_166332# a_114466_182316# VDD VDD pfet_06v0 ad=1.32p pd=6.88u as=1.32p ps=6.88u w=3u l=1u
X1465 a_34750_164967# a_31510_128854# cap_mim_2f0_m4m5_noshield c_width=25u c_length=8u
X1466 a_68010_194537# a_67810_194421# VDD VDD pfet_06v0 ad=2.5p pd=10.5u as=4.4p ps=20.88u w=10u l=1u
X1467 a_81206_182443# a_83878_186843# VDD VDD pfet_06v0 ad=1.3p pd=5.52u as=1.3p ps=5.52u w=5u l=1u
X1468 a_37434_128810# a_29546_128810# a_37634_128854# VSS nfet_06v0 ad=1.65p pd=5.66u as=1.25p ps=5.5u w=5u l=1u
X1469 a_59578_185843# a_60246_182443# VSS VSS nfet_06v0 ad=0.65p pd=3.02u as=0.65p ps=3.02u w=2.5u l=1u
X1470 a_37174_165083# a_43102_169437# a_37622_169483# VDD pfet_06v0 ad=2.2p pd=10.88u as=2.2p ps=10.88u w=5u l=1u
X1471 a_29586_168437# a_29586_168437# VDD VDD pfet_06v0 ad=0.88p pd=4.88u as=0.88p ps=4.88u w=2u l=1u
X1472 a_56794_140838# a_58782_148780# a_52560_145300# VDD pfet_06v0 ad=1.76p pd=8.88u as=1.76p ps=8.88u w=4u l=1u
X1473 VDD VSS VDD VDD pfet_06v0 ad=0.44p pd=2.88u as=0 ps=0 w=1u l=2u
X1474 a_46710_165083# a_38286_165083# VSS VSS nfet_06v0 ad=2.2p pd=10.88u as=1.3p ps=5.52u w=5u l=1u
X1475 a_33646_168553# a_29286_168437# VDD VDD pfet_06v0 ad=2.5p pd=10.5u as=4.4p ps=20.88u w=10u l=1u
X1476 VDD VSS VDD VDD pfet_06v0 ad=4.29p pd=20.38u as=0 ps=0 w=9.75u l=2u
X1477 a_82318_165083# a_75842_168437# a_83878_169483# VDD pfet_06v0 ad=2.2p pd=10.88u as=1.3p ps=5.52u w=5u l=1u
X1478 a_75502_173593# a_75842_177061# a_75742_177177# VDD pfet_06v0 ad=4.4p pd=20.88u as=2.5p ps=10.5u w=10u l=1u
D69 VSS S3N diode_nd2ps_06v0 pj=40u area=99.99999p
X1479 a_23448_190688# a_99134_166332# a_99046_166448# VSS nfet_06v0 ad=0.6448p pd=3u as=1.0912p ps=5.84u w=2.48u l=1u
X1480 VDD a_69782_191067# a_102146_190940# VDD pfet_06v0 ad=1.32p pd=6.88u as=0.99p ps=3.66u w=3u l=1u
X1481 a_74274_147580# a_74274_147580# VDD VDD pfet_06v0 ad=0.88p pd=4.88u as=0.88p ps=4.88u w=2u l=1u
X1482 a_31710_149586# a_31310_128810# a_29786_147696# VDD pfet_06v0 ad=0.242p pd=1.98u as=0.242p ps=1.98u w=0.55u l=1u
X1483 a_103678_152822# a_96334_152778# VSS VSS nfet_06v0 ad=1.25p pd=5.5u as=2.2p ps=10.88u w=5u l=1u
X1484 a_96874_135712# a_96674_135596# a_97686_135712# VDD pfet_06v0 ad=4.4p pd=20.88u as=2.5p ps=10.5u w=10u l=1u
X1485 a_74848_133766# a_90266_134216# VSS ppolyf_u_1k r_width=1u r_length=76.45u
X1486 a_69454_185913# a_52358_185797# VDD VDD pfet_06v0 ad=2.5p pd=10.5u as=4.4p ps=20.88u w=10u l=1u
X1487 a_55186_128810# a_58782_136796# a_55734_135712# VDD pfet_06v0 ad=1.76p pd=8.88u as=1.76p ps=8.88u w=4u l=1u
X1488 a_31510_152822# a_31310_152778# a_29746_152822# VSS nfet_06v0 ad=3.3p pd=15.88u as=3.3p ps=15.88u w=7.5u l=1u
X1489 a_46710_173707# a_38738_178107# VDD VDD pfet_06v0 ad=4.4p pd=20.88u as=2.6p ps=10.52u w=10u l=1u
X1490 VSS a_61358_191067# a_69782_191067# VSS nfet_06v0 ad=1.3p pd=5.52u as=1.3p ps=5.52u w=5u l=1u
X1491 a_30598_159680# a_29286_159564# VDD VDD pfet_06v0 ad=2.5p pd=10.5u as=4.4p ps=20.88u w=10u l=1u
X1492 a_74434_152822# a_74234_152778# a_74134_152822# VSS nfet_06v0 ad=2.2p pd=10.88u as=1.25p ps=5.5u w=5u l=1u
X1493 a_54282_165013# a_52658_168437# VSS VSS nfet_06v0 ad=0.25p pd=1.5u as=0.44p ps=2.88u w=1u l=1u
X1494 a_79902_168553# a_75542_168437# VDD VDD pfet_06v0 ad=2.5p pd=10.5u as=4.4p ps=20.88u w=10u l=1u
X1495 VDD VSS VDD VDD pfet_06v0 ad=4.29p pd=20.38u as=0 ps=0 w=9.75u l=2u
X1496 a_101482_152822# a_96634_152778# a_98798_161570# VSS nfet_06v0 ad=1.1p pd=5.88u as=0.825p ps=3.16u w=2.5u l=1u
X1497 a_81646_168483# a_75502_164969# a_84542_165083# VSS nfet_06v0 ad=1.1p pd=5.88u as=0.65p ps=3.02u w=2.5u l=1u
X1498 a_57822_190951# a_74848_157284# VDD VDD pfet_06v0 ad=0.44p pd=2.88u as=0.44p ps=2.88u w=1u l=1u
X1499 a_23448_70736# a_23448_70736# VDD VDD pfet_06v0 ad=0.52p pd=2.52u as=0.52p ps=2.52u w=2u l=1u
X1500 a_81206_173707# a_75842_177061# a_84994_178107# VDD pfet_06v0 ad=2.2p pd=10.88u as=1.3p ps=5.52u w=5u l=1u
X1501 a_97248_133766# a_112666_134216# VSS ppolyf_u_1k r_width=1u r_length=76.45u
X1502 a_103678_128854# a_96334_128810# VSS VSS nfet_06v0 ad=1.25p pd=5.5u as=2.2p ps=10.88u w=5u l=1u
X1503 a_34750_182327# a_74848_145300# VDD VDD pfet_06v0 ad=0.44p pd=2.88u as=0.44p ps=2.88u w=1u l=1u
X1504 VSS a_53050_164969# a_56990_165013# VSS nfet_06v0 ad=2.2p pd=10.88u as=1.25p ps=5.5u w=5u l=1u
X1505 a_80202_177177# a_34750_173591# a_82762_177107# VDD pfet_06v0 ad=4.4p pd=20.88u as=2.6p ps=10.52u w=10u l=1u
X1506 a_31510_128854# a_31310_128810# a_29746_128854# VSS nfet_06v0 ad=3.3p pd=15.88u as=3.3p ps=15.88u w=7.5u l=1u
X1507 a_43102_169437# a_29246_164969# a_44302_165013# VSS nfet_06v0 ad=2.2p pd=10.88u as=1.25p ps=5.5u w=5u l=1u
X1508 a_74434_128854# a_74234_128810# a_74134_128854# VSS nfet_06v0 ad=2.2p pd=10.88u as=1.25p ps=5.5u w=5u l=1u
X1509 VSS a_60246_165083# a_58462_168483# VSS nfet_06v0 ad=1.1p pd=5.88u as=0.65p ps=3.02u w=2.5u l=1u
X1510 a_61810_186843# a_65710_182329# a_61358_182443# VSS nfet_06v0 ad=1.1p pd=5.88u as=1.1p ps=5.88u w=2.5u l=1u
X1511 a_89822_159680# a_73974_159564# VDD VDD pfet_06v0 ad=2.5p pd=10.5u as=4.4p ps=20.88u w=10u l=1u
X1512 a_44938_194537# a_44738_194421# VDD VDD pfet_06v0 ad=2.5p pd=10.5u as=4.4p ps=20.88u w=10u l=1u
X1513 a_59578_194467# a_52318_190953# a_60246_191067# VSS nfet_06v0 ad=1.1p pd=5.88u as=0.65p ps=3.02u w=2.5u l=1u
X1514 a_101482_128854# a_96634_128810# a_98798_137602# VSS nfet_06v0 ad=1.1p pd=5.88u as=0.825p ps=3.16u w=2.5u l=1u
X1515 VDD a_110806_165000# a_111626_164956# VDD pfet_06v0 ad=1.32p pd=6.88u as=0.99p ps=3.66u w=3u l=1u
X1516 VDD VSS VDD VDD pfet_06v0 ad=7.92p pd=36.88u as=0 ps=0 w=18u l=2u
X1517 a_57018_185913# a_52658_185797# a_56718_185913# VDD pfet_06v0 ad=3.3p pd=10.66u as=2.5p ps=10.5u w=10u l=1u
X1518 VSS a_37174_173707# a_35390_177107# VSS nfet_06v0 ad=0.65p pd=3.02u as=0.65p ps=3.02u w=2.5u l=1u
X1519 a_62062_135712# a_51686_135596# VDD VDD pfet_06v0 ad=2.5p pd=10.5u as=4.4p ps=20.88u w=10u l=1u
X1520 a_52146_140838# a_51946_140794# a_51846_140838# VSS nfet_06v0 ad=2.2p pd=10.88u as=1.25p ps=5.5u w=5u l=1u
X1521 a_53050_190953# a_52658_194421# a_53670_194537# VDD pfet_06v0 ad=4.4p pd=20.88u as=2.5p ps=10.5u w=10u l=1u
X1522 a_103078_190984# a_69782_191067# a_102146_190940# VSS nfet_06v0 ad=0.25p pd=1.5u as=0.44p ps=2.88u w=1u l=1u
X1523 a_32522_161580# a_32786_152778# VSS VSS nfet_06v0 ad=0.825p pd=3.16u as=1.1p ps=5.88u w=2.5u l=1u
X1524 a_51646_152778# a_51946_152778# a_62862_152822# VSS nfet_06v0 ad=2.2p pd=10.88u as=1.25p ps=5.5u w=5u l=1u
X1525 a_45146_173593# a_29246_173593# a_45346_173637# VSS nfet_06v0 ad=1.65p pd=5.66u as=1.25p ps=5.5u w=5u l=1u
X1526 VDD VSS VDD VDD pfet_06v0 ad=4.29p pd=20.38u as=0 ps=0 w=9.75u l=2u
X1527 a_92966_165083# a_84542_165083# VSS VSS nfet_06v0 ad=1.3p pd=5.52u as=2.2p ps=10.88u w=5u l=1u
X1528 a_96834_152822# a_96634_152778# a_97566_152822# VSS nfet_06v0 ad=2.2p pd=10.88u as=1.25p ps=5.5u w=5u l=1u
X1529 VSS a_37174_191067# a_35390_194467# VSS nfet_06v0 ad=1.1p pd=5.88u as=0.65p ps=3.02u w=2.5u l=1u
X1530 a_74274_147580# a_74274_147580# a_87214_140838# VSS nfet_06v0 ad=0.44p pd=2.88u as=0.25p ps=1.5u w=1u l=1u
X1531 a_98798_149586# a_99874_140794# VSS VSS nfet_06v0 ad=0.825p pd=3.16u as=1.1p ps=5.88u w=2.5u l=1u
X1532 a_29546_140794# a_29546_140794# VSS VSS nfet_06v0 ad=0.44p pd=2.88u as=0.44p ps=2.88u w=1u l=1u
X1533 a_104522_152778# a_96634_152778# a_104722_152822# VSS nfet_06v0 ad=1.65p pd=5.66u as=1.25p ps=5.5u w=5u l=1u
X1534 a_54922_161580# a_55186_152778# VSS VSS nfet_06v0 ad=0.825p pd=3.16u as=1.1p ps=5.88u w=2.5u l=1u
X1535 a_36506_194467# a_35862_190951# a_33946_194537# VDD pfet_06v0 ad=2.6p pd=10.52u as=4.4p ps=20.88u w=10u l=1u
X1536 a_100422_147696# a_102014_140794# a_99874_140794# VSS nfet_06v0 ad=0.88p pd=4.88u as=0.88p ps=4.88u w=2u l=1u
X1537 VSS a_46710_182443# a_115398_182360# VSS nfet_06v0 ad=0.44p pd=2.88u as=0.25p ps=1.5u w=1u l=1u
X1538 a_29286_194421# a_29586_194421# a_31210_190997# VSS nfet_06v0 ad=0.44p pd=2.88u as=0.25p ps=1.5u w=1u l=1u
X1539 a_65710_164969# a_65710_164969# a_68218_164969# VSS nfet_06v0 ad=2.2p pd=10.88u as=1.65p ps=5.66u w=5u l=1u
X1540 VSS a_114466_173580# a_100246_166332# VSS nfet_06v0 ad=0.44p pd=2.88u as=0.44p ps=2.88u w=1u l=1u
X1541 S4P a_23448_31424# VDD ppolyf_u r_width=16u r_length=4u
X1542 a_105106_147580# a_96674_147580# a_105306_147696# VDD pfet_06v0 ad=3.3p pd=10.66u as=2.5p ps=10.5u w=10u l=1u
X1543 S2P a_31310_128810# VDD ppolyf_u r_width=16u r_length=4u
X1544 VSS a_60246_182443# a_59578_185843# VSS nfet_06v0 ad=0.65p pd=3.02u as=0.65p ps=3.02u w=2.5u l=1u
X1545 a_108582_140838# a_96674_147580# VSS VSS nfet_06v0 ad=0.25p pd=1.5u as=0.44p ps=2.88u w=1u l=1u
X1546 a_32522_137612# a_32786_128810# VSS VSS nfet_06v0 ad=0.825p pd=3.16u as=1.1p ps=5.88u w=2.5u l=1u
X1547 a_84542_191067# a_89358_195421# a_84994_195467# VDD pfet_06v0 ad=2.2p pd=10.88u as=2.2p ps=10.88u w=5u l=1u
X1548 a_51646_128810# a_51946_128810# a_62862_128854# VSS nfet_06v0 ad=2.2p pd=10.88u as=1.25p ps=5.5u w=5u l=1u
X1549 a_100760_165240# a_99096_165124# VSS VSS nfet_06v0 ad=0.175p pd=1.2u as=0.308p ps=2.28u w=0.7u l=1u
X1550 a_23448_70736# a_23448_70736# VDD VDD pfet_06v0 ad=0.52p pd=2.52u as=0.52p ps=2.52u w=2u l=1u
D70 VSS Y diode_nd2ps_06v0 pj=40u area=99.99999p
X1551 a_88710_147696# a_73974_147580# VDD VDD pfet_06v0 ad=2.5p pd=10.5u as=4.4p ps=20.88u w=10u l=1u
X1552 a_55314_182373# a_52658_185797# VSS VSS nfet_06v0 ad=0.25p pd=1.5u as=0.44p ps=2.88u w=1u l=1u
X1553 a_57822_182327# a_97248_145300# VDD VDD pfet_06v0 ad=0.44p pd=2.88u as=0.44p ps=2.88u w=1u l=1u
X1554 VSS VDD VSS VSS nfet_06v0 ad=7.92p pd=36.88u as=0 ps=0 w=18u l=2u
X1555 a_42638_173593# a_29586_177061# a_46382_177177# VDD pfet_06v0 ad=4.4p pd=20.88u as=2.5p ps=10.5u w=10u l=1u
X1556 VDD VSS VDD VDD pfet_06v0 ad=7.92p pd=36.88u as=0 ps=0 w=18u l=2u
X1557 VDD VSS VDD VDD pfet_06v0 ad=0.44p pd=2.88u as=0 ps=0 w=1u l=2u
X1558 a_96834_128854# a_96634_128810# a_97566_128854# VSS nfet_06v0 ad=2.2p pd=10.88u as=1.25p ps=5.5u w=5u l=1u
X1559 a_104522_128810# a_96634_128810# a_104722_128854# VSS nfet_06v0 ad=1.65p pd=5.66u as=1.25p ps=5.5u w=5u l=1u
X1560 a_54922_137612# a_55186_128810# VSS VSS nfet_06v0 ad=0.825p pd=3.16u as=1.1p ps=5.88u w=2.5u l=1u
X1561 a_99610_161580# a_32042_128810# a_96874_159680# VDD pfet_06v0 ad=0.22p pd=1.88u as=0.22p ps=1.88u w=0.5u l=1u
X1562 VDD VSS VDD VDD pfet_06v0 ad=0.44p pd=2.88u as=0 ps=0 w=1u l=2u
X1563 a_35390_194467# a_37174_191067# VSS VSS nfet_06v0 ad=0.65p pd=3.02u as=1.1p ps=5.88u w=2.5u l=1u
X1564 VSS a_92966_165083# a_112558_165000# VSS nfet_06v0 ad=0.44p pd=2.88u as=0.25p ps=1.5u w=1u l=1u
X1565 VSS VDD VSS VSS nfet_06v0 ad=4.29p pd=20.38u as=0 ps=0 w=9.75u l=2u
X1566 a_29786_135712# a_29586_135596# a_29486_135712# VDD pfet_06v0 ad=4.4p pd=20.88u as=2.5p ps=10.5u w=10u l=1u
X1567 a_76198_152822# a_78022_159680# VDD VDD pfet_06v0 ad=2.2p pd=10.88u as=2.2p ps=10.88u w=5u l=1u
X1568 a_46710_165083# a_34950_165083# cap_mim_2f0_m4m5_noshield c_width=20u c_length=10u
X1569 a_77466_165013# a_75842_168437# VSS VSS nfet_06v0 ad=0.25p pd=1.5u as=0.44p ps=2.88u w=1u l=1u
X1570 a_110806_173624# a_46710_173707# VDD VDD pfet_06v0 ad=1.32p pd=6.88u as=1.32p ps=6.88u w=3u l=1u
X1571 a_69782_191067# a_61358_191067# VSS VSS nfet_06v0 ad=1.3p pd=5.52u as=2.2p ps=10.88u w=5u l=1u
X1572 a_36506_168483# a_37174_165083# VSS VSS nfet_06v0 ad=0.65p pd=3.02u as=1.1p ps=5.88u w=2.5u l=1u
X1573 a_33586_182373# a_34750_182327# a_34950_182443# VSS nfet_06v0 ad=2.2p pd=10.88u as=1.3p ps=5.52u w=5u l=1u
X1574 a_30160_145300# a_29586_147580# a_31510_140838# VDD pfet_06v0 ad=4.4p pd=20.88u as=4.4p ps=20.88u w=10u l=1u
X1575 a_69782_191067# a_61810_195467# VDD VDD pfet_06v0 ad=4.4p pd=20.88u as=2.6p ps=10.52u w=10u l=1u
X1576 a_56358_190997# a_53050_190953# VSS VSS nfet_06v0 ad=1.25p pd=5.5u as=2.2p ps=10.88u w=5u l=1u
X1577 a_34750_173591# a_97248_133316# VDD VDD pfet_06v0 ad=0.44p pd=2.88u as=0.44p ps=2.88u w=1u l=1u
X1578 a_51686_159564# a_51986_159564# a_69458_159680# VDD pfet_06v0 ad=4.4p pd=20.88u as=2.5p ps=10.5u w=10u l=1u
X1579 a_84542_165083# a_75502_164969# a_81646_168483# VSS nfet_06v0 ad=0.65p pd=3.02u as=1.1p ps=5.88u w=2.5u l=1u
X1580 a_32522_137612# a_32042_128810# a_29786_135712# VDD pfet_06v0 ad=0.22p pd=1.88u as=0.22p ps=1.88u w=0.5u l=1u
X1581 a_34950_173707# a_37622_178107# VDD VDD pfet_06v0 ad=1.3p pd=5.52u as=1.3p ps=5.52u w=5u l=1u
X1582 a_29978_190953# a_29586_194421# a_30598_194537# VDD pfet_06v0 ad=4.4p pd=20.88u as=2.5p ps=10.5u w=10u l=1u
X1583 VDD a_69782_165083# a_113914_166412# VDD pfet_06v0 ad=1.32p pd=6.88u as=0.75p ps=3.5u w=3u l=1u
X1584 a_37634_152822# a_37434_152778# VSS VSS nfet_06v0 ad=1.25p pd=5.5u as=2.2p ps=10.88u w=5u l=1u
X1585 VSS a_83430_182443# a_81646_185843# VSS nfet_06v0 ad=1.1p pd=5.88u as=0.65p ps=3.02u w=2.5u l=1u
X1586 a_52560_145300# a_51986_147580# a_53910_140838# VDD pfet_06v0 ad=4.4p pd=20.88u as=4.4p ps=20.88u w=10u l=1u
X1587 a_38218_147696# a_38018_147580# VDD VDD pfet_06v0 ad=2.5p pd=10.5u as=4.4p ps=20.88u w=10u l=1u
X1588 a_46710_165083# a_38738_169483# VDD VDD pfet_06v0 ad=4.4p pd=20.88u as=2.6p ps=10.52u w=10u l=1u
X1589 a_84994_186843# a_88894_182329# a_84542_182443# VSS nfet_06v0 ad=1.1p pd=5.88u as=1.1p ps=5.88u w=2.5u l=1u
X1590 a_82762_177107# a_34750_173591# a_80202_177177# VDD pfet_06v0 ad=2.6p pd=10.52u as=4.4p ps=20.88u w=10u l=1u
X1591 a_82762_194467# a_75502_190953# a_83430_191067# VSS nfet_06v0 ad=1.1p pd=5.88u as=0.65p ps=3.02u w=2.5u l=1u
D71 Y VDD diode_pd2nw_06v0 pj=40u area=99.99999p
X1592 VSS VDD VSS VSS nfet_06v0 ad=7.92p pd=36.88u as=0 ps=0 w=18u l=2u
D72 X VDD diode_pd2nw_06v0 pj=40u area=99.99999p
X1593 a_42638_164969# a_42638_164969# a_45146_164969# VSS nfet_06v0 ad=2.2p pd=10.88u as=1.65p ps=5.66u w=5u l=1u
X1594 a_81206_165083# a_75842_168437# a_84994_169483# VDD pfet_06v0 ad=2.2p pd=10.88u as=1.3p ps=5.52u w=5u l=1u
X1595 a_99306_190940# a_92966_191067# VDD VDD pfet_06v0 ad=0.99p pd=3.66u as=1.32p ps=6.88u w=3u l=1u
X1596 VSS VDD VSS VSS nfet_06v0 ad=0.44p pd=2.88u as=0 ps=0 w=1u l=2u
X1597 a_37174_191067# a_29246_190953# a_36506_194467# VSS nfet_06v0 ad=0.65p pd=3.02u as=1.1p ps=5.88u w=2.5u l=1u
X1598 a_52560_134666# a_67978_134216# VSS ppolyf_u_1k r_width=1u r_length=76.45u
X1599 a_37634_128854# a_37434_128810# VSS VSS nfet_06v0 ad=1.25p pd=5.5u as=2.2p ps=10.88u w=5u l=1u
X1600 a_76234_190953# a_75842_194421# a_76854_194537# VDD pfet_06v0 ad=4.4p pd=20.88u as=2.5p ps=10.5u w=10u l=1u
X1601 a_55734_135712# a_51986_135596# a_54642_128854# VDD pfet_06v0 ad=4.4p pd=20.88u as=4.4p ps=20.88u w=10u l=1u
X1602 a_80202_168553# a_34750_164967# a_82762_168483# VDD pfet_06v0 ad=4.4p pd=20.88u as=2.6p ps=10.52u w=10u l=1u
X1603 a_34750_190951# a_53910_152822# cap_mim_2f0_m4m5_noshield c_width=25u c_length=8u
X1604 VDD VSS VDD VDD pfet_06v0 ad=7.92p pd=36.88u as=0 ps=0 w=18u l=2u
D73 S2P VDD diode_pd2nw_06v0 pj=40u area=99.99999p
X1605 VSS a_38286_182443# a_46710_182443# VSS nfet_06v0 ad=1.3p pd=5.52u as=1.3p ps=5.52u w=5u l=1u
X1606 a_35862_182327# a_30160_157284# VDD VDD pfet_06v0 ad=0.44p pd=2.88u as=0.44p ps=2.88u w=1u l=1u
X1607 VSS VDD VSS VSS nfet_06v0 ad=7.92p pd=36.88u as=0 ps=0 w=18u l=2u
X1608 a_30160_145300# a_34926_140794# a_34394_140838# VSS nfet_06v0 ad=0.88p pd=4.88u as=0.88p ps=4.88u w=2u l=1u
X1609 a_75742_177177# a_75542_177061# VDD VDD pfet_06v0 ad=2.5p pd=10.5u as=4.4p ps=20.88u w=10u l=1u
X1610 a_60246_165083# a_52318_164969# a_59578_168483# VSS nfet_06v0 ad=0.65p pd=3.02u as=1.1p ps=5.88u w=2.5u l=1u
X1611 VSS a_29978_173593# a_33918_173637# VSS nfet_06v0 ad=2.2p pd=10.88u as=1.25p ps=5.5u w=5u l=1u
X1612 VSS a_83430_182443# a_82762_185843# VSS nfet_06v0 ad=0.65p pd=3.02u as=0.65p ps=3.02u w=2.5u l=1u
X1613 a_29246_140794# a_29546_140794# a_40462_140838# VSS nfet_06v0 ad=2.2p pd=10.88u as=1.25p ps=5.5u w=5u l=1u
X1614 a_66174_178061# a_66174_178061# a_67810_177061# VDD pfet_06v0 ad=4.4p pd=20.88u as=3.3p ps=10.66u w=10u l=1u
X1615 VDD a_75542_168437# a_80534_168553# VDD pfet_06v0 ad=4.4p pd=20.88u as=2.5p ps=10.5u w=10u l=1u
X1616 a_34750_182327# a_79082_140838# VSS VSS nfet_06v0 ad=0.44p pd=2.88u as=0.44p ps=2.88u w=1u l=1u
D74 S2N VDD diode_pd2nw_06v0 pj=40u area=99.99999p
X1617 a_97686_135712# a_96374_135596# VDD VDD pfet_06v0 ad=2.5p pd=10.5u as=4.4p ps=20.88u w=10u l=1u
X1618 a_59578_185843# a_60246_182443# VSS VSS nfet_06v0 ad=0.65p pd=3.02u as=1.1p ps=5.88u w=2.5u l=1u
X1619 a_69782_182443# a_58022_182443# cap_mim_2f0_m4m5_noshield c_width=20u c_length=10u
X1620 a_52560_145300# a_57326_140794# a_56794_140838# VSS nfet_06v0 ad=0.88p pd=4.88u as=0.88p ps=4.88u w=2u l=1u
X1621 a_74434_140838# a_74234_140794# a_75166_140838# VSS nfet_06v0 ad=2.2p pd=10.88u as=1.25p ps=5.5u w=5u l=1u
X1622 VSS a_69782_182443# a_106078_183692# VSS nfet_06v0 ad=0.44p pd=2.88u as=0.33p ps=1.66u w=1u l=1u
X1623 VDD a_23448_70736# a_23448_70736# VDD pfet_06v0 ad=0.52p pd=2.52u as=0.52p ps=2.52u w=2u l=1u
X1624 a_73974_159564# a_74274_159564# a_86182_152822# VSS nfet_06v0 ad=0.44p pd=2.88u as=0.25p ps=1.5u w=1u l=1u
X1625 a_34750_190951# a_52560_157284# VDD VDD pfet_06v0 ad=0.44p pd=2.88u as=0.44p ps=2.88u w=1u l=1u
X1626 a_51646_128810# a_51986_135596# a_67534_135712# VDD pfet_06v0 ad=4.4p pd=20.88u as=2.5p ps=10.5u w=10u l=1u
X1627 VSS VDD VSS VSS nfet_06v0 ad=7.92p pd=36.88u as=0 ps=0 w=18u l=2u
X1628 a_59134_182443# a_52658_185797# a_60694_186843# VDD pfet_06v0 ad=2.2p pd=10.88u as=1.3p ps=5.52u w=5u l=1u
X1629 a_57018_194537# a_35862_190951# a_59578_194467# VDD pfet_06v0 ad=4.4p pd=20.88u as=2.6p ps=10.52u w=10u l=1u
X1630 a_80202_194537# a_57822_190951# a_81646_194467# VDD pfet_06v0 ad=4.4p pd=20.88u as=2.6p ps=10.52u w=10u l=1u
X1631 a_57326_152778# a_51986_159564# a_62062_159680# VDD pfet_06v0 ad=4.4p pd=20.88u as=2.5p ps=10.5u w=10u l=1u
X1632 a_35390_168483# a_37174_165083# VSS VSS nfet_06v0 ad=0.65p pd=3.02u as=0.65p ps=3.02u w=2.5u l=1u
X1633 a_98598_128854# a_100422_135712# VDD VDD pfet_06v0 ad=2.2p pd=10.88u as=2.2p ps=10.88u w=5u l=1u
X1634 a_52318_190953# a_52658_194421# a_52558_194537# VDD pfet_06v0 ad=4.4p pd=20.88u as=2.5p ps=10.5u w=10u l=1u
X1635 a_44302_165013# a_29978_164969# VSS VSS nfet_06v0 ad=1.25p pd=5.5u as=2.2p ps=10.88u w=5u l=1u
X1636 a_81646_177107# a_38998_140838# a_80202_177177# VDD pfet_06v0 ad=2.6p pd=10.52u as=4.4p ps=20.88u w=10u l=1u
X1637 a_59578_177107# a_35862_173591# a_57018_177177# VDD pfet_06v0 ad=2.6p pd=10.52u as=4.4p ps=20.88u w=10u l=1u
X1638 a_52358_177061# a_52658_177061# a_54282_173637# VSS nfet_06v0 ad=0.44p pd=2.88u as=0.25p ps=1.5u w=1u l=1u
X1639 a_82906_135712# a_82706_135596# VDD VDD pfet_06v0 ad=2.5p pd=10.5u as=4.4p ps=20.88u w=10u l=1u
X1640 a_73974_135596# a_74274_135596# a_86182_128854# VSS nfet_06v0 ad=0.44p pd=2.88u as=0.25p ps=1.5u w=1u l=1u
X1641 VDD a_61810_195467# a_69782_191067# VDD pfet_06v0 ad=2.6p pd=10.52u as=2.6p ps=10.52u w=10u l=1u
X1642 VDD a_52358_194421# a_57350_194537# VDD pfet_06v0 ad=4.4p pd=20.88u as=2.5p ps=10.5u w=10u l=1u
X1643 a_75502_164969# a_75502_164969# VSS VSS nfet_06v0 ad=0.44p pd=2.88u as=0.44p ps=2.88u w=1u l=1u
X1644 a_91194_168553# a_90994_168437# VDD VDD pfet_06v0 ad=2.5p pd=10.5u as=4.4p ps=20.88u w=10u l=1u
X1645 VDD a_37622_178107# a_34950_173707# VDD pfet_06v0 ad=1.3p pd=5.52u as=1.3p ps=5.52u w=5u l=1u
X1646 VSS VDD VSS VSS nfet_06v0 ad=7.92p pd=36.88u as=0 ps=0 w=18u l=2u
X1647 a_56718_185913# a_52358_185797# VDD VDD pfet_06v0 ad=2.5p pd=10.5u as=4.4p ps=20.88u w=10u l=1u
X1648 a_69782_173707# a_61810_178107# VDD VDD pfet_06v0 ad=2.6p pd=10.52u as=4.4p ps=20.88u w=10u l=1u
X1649 a_38286_191067# a_29246_190953# a_35390_194467# VSS nfet_06v0 ad=0.65p pd=3.02u as=1.1p ps=5.88u w=2.5u l=1u
X1650 a_59134_191067# a_35862_190951# a_56658_190997# VSS nfet_06v0 ad=1.3p pd=5.52u as=2.2p ps=10.88u w=5u l=1u
X1651 a_75166_152822# a_73934_152778# VSS VSS nfet_06v0 ad=1.25p pd=5.5u as=2.2p ps=10.88u w=5u l=1u
X1652 a_51846_140838# a_51646_140794# VSS VSS nfet_06v0 ad=1.25p pd=5.5u as=2.2p ps=10.88u w=5u l=1u
X1653 a_55186_152778# a_51946_152778# a_54922_161580# VSS nfet_06v0 ad=1.1p pd=5.88u as=0.825p ps=3.16u w=2.5u l=1u
X1654 a_88894_164969# a_88894_164969# a_91402_164969# VSS nfet_06v0 ad=2.2p pd=10.88u as=1.65p ps=5.66u w=5u l=1u
X1655 VDD VSS VDD VDD pfet_06v0 ad=0.44p pd=2.88u as=0 ps=0 w=1u l=2u
D75 S2P VDD diode_pd2nw_06v0 pj=40u area=99.99999p
X1656 a_53670_194537# a_52358_194421# VDD VDD pfet_06v0 ad=2.5p pd=10.5u as=4.4p ps=20.88u w=10u l=1u
X1657 a_62862_152822# a_51646_152778# VSS VSS nfet_06v0 ad=1.25p pd=5.5u as=2.2p ps=10.88u w=5u l=1u
X1658 a_51686_147580# a_51986_147580# a_63894_140838# VSS nfet_06v0 ad=0.44p pd=2.88u as=0.25p ps=1.5u w=1u l=1u
X1659 a_29286_147580# a_29586_147580# a_47058_147696# VDD pfet_06v0 ad=4.4p pd=20.88u as=2.5p ps=10.5u w=10u l=1u
X1660 a_89358_186797# a_75502_182329# a_90558_182373# VSS nfet_06v0 ad=2.2p pd=10.88u as=1.25p ps=5.5u w=5u l=1u
X1661 a_83430_191067# a_75502_190953# a_82762_194467# VSS nfet_06v0 ad=0.65p pd=3.02u as=1.1p ps=5.88u w=2.5u l=1u
X1662 VDD a_69782_173707# a_114466_173580# VDD pfet_06v0 ad=1.32p pd=6.88u as=0.99p ps=3.66u w=3u l=1u
X1663 a_45346_173637# a_45146_173593# VSS VSS nfet_06v0 ad=1.25p pd=5.5u as=2.2p ps=10.88u w=5u l=1u
X1664 VSS a_92966_191067# a_100238_190984# VSS nfet_06v0 ad=0.44p pd=2.88u as=0.25p ps=1.5u w=1u l=1u
X1665 a_29286_177061# a_29586_177061# a_32522_177177# VDD pfet_06v0 ad=4.4p pd=20.88u as=2.5p ps=10.5u w=10u l=1u
X1666 a_36506_177107# a_37174_173707# VSS VSS nfet_06v0 ad=0.65p pd=3.02u as=0.65p ps=3.02u w=2.5u l=1u
D76 VSS S2P diode_nd2ps_06v0 pj=40u area=99.99999p
X1667 a_54642_152822# a_32042_152778# a_52146_152822# VSS nfet_06v0 ad=3.74p pd=17.88u as=3.74p ps=17.88u w=8.5u l=1u
X1668 a_96874_159680# a_96674_159564# a_96574_159680# VDD pfet_06v0 ad=4.4p pd=20.88u as=2.5p ps=10.5u w=10u l=1u
X1669 a_34950_165083# a_37622_169483# VDD VDD pfet_06v0 ad=1.3p pd=5.52u as=1.3p ps=5.52u w=5u l=1u
X1670 a_33586_173637# a_35862_173591# a_36062_173707# VSS nfet_06v0 ad=2.2p pd=10.88u as=1.3p ps=5.52u w=5u l=1u
X1671 a_97566_152822# a_96334_152778# VSS VSS nfet_06v0 ad=1.25p pd=5.5u as=2.2p ps=10.88u w=5u l=1u
X1672 a_87214_140838# a_74274_147580# VSS VSS nfet_06v0 ad=0.25p pd=1.5u as=0.44p ps=2.88u w=1u l=1u
X1673 a_90994_194421# a_75842_194421# a_91194_194537# VDD pfet_06v0 ad=3.3p pd=10.66u as=2.5p ps=10.5u w=10u l=1u
X1674 a_104722_152822# a_104522_152778# VSS VSS nfet_06v0 ad=1.25p pd=5.5u as=2.2p ps=10.88u w=5u l=1u
X1675 a_34750_182327# a_74848_145300# VDD VDD pfet_06v0 ad=0.44p pd=2.88u as=0.44p ps=2.88u w=1u l=1u
X1676 a_115398_182360# a_69782_182443# a_114466_182316# VSS nfet_06v0 ad=0.25p pd=1.5u as=0.44p ps=2.88u w=1u l=1u
X1677 a_31210_190997# a_29586_194421# VSS VSS nfet_06v0 ad=0.25p pd=1.5u as=0.44p ps=2.88u w=1u l=1u
X1678 a_34394_128854# a_36382_136796# a_30160_133316# VDD pfet_06v0 ad=1.76p pd=8.88u as=1.76p ps=8.88u w=4u l=1u
D77 S2N VDD diode_pd2nw_06v0 pj=40u area=99.99999p
X1679 a_105306_147696# a_105106_147580# VDD VDD pfet_06v0 ad=2.5p pd=10.5u as=4.4p ps=20.88u w=10u l=1u
X1680 a_58782_148780# a_58782_148780# a_60418_147580# VDD pfet_06v0 ad=4.4p pd=20.88u as=3.3p ps=10.66u w=10u l=1u
X1681 a_79842_173637# a_38998_140838# a_81206_173707# VSS nfet_06v0 ad=2.2p pd=10.88u as=1.3p ps=5.52u w=5u l=1u
X1682 a_83878_178107# a_88894_173593# a_83430_173707# VSS nfet_06v0 ad=1.1p pd=5.88u as=1.1p ps=5.88u w=2.5u l=1u
X1683 a_52560_134666# a_57822_164967# VSS ppolyf_u_1k r_width=1u r_length=76.45u
X1684 a_75166_128854# a_73934_128810# VSS VSS nfet_06v0 ad=1.25p pd=5.5u as=2.2p ps=10.88u w=5u l=1u
X1685 a_82762_168483# a_34750_164967# a_80202_168553# VDD pfet_06v0 ad=2.6p pd=10.52u as=4.4p ps=20.88u w=10u l=1u
X1686 VDD VSS VDD VDD pfet_06v0 ad=4.29p pd=20.38u as=0 ps=0 w=9.75u l=2u
X1687 a_55186_128810# a_51946_128810# a_54922_137612# VSS nfet_06v0 ad=1.1p pd=5.88u as=0.825p ps=3.16u w=2.5u l=1u
X1688 a_34926_140794# a_29586_147580# a_39662_147696# VDD pfet_06v0 ad=4.4p pd=20.88u as=2.5p ps=10.5u w=10u l=1u
X1689 a_62862_128854# a_51646_128810# VSS VSS nfet_06v0 ad=1.25p pd=5.5u as=2.2p ps=10.88u w=5u l=1u
D78 Z VDD diode_pd2nw_06v0 pj=40u area=99.99999p
X1690 ZN_OUT a_102380_186148# VSS VSS nfet_05v0 ad=0.5808p pd=3.52u as=0.5808p ps=3.52u w=1.32u l=0.6u
D79 VSS S2N diode_nd2ps_06v0 pj=40u area=99.99999p
X1691 a_34950_173707# a_34750_173591# a_33586_173637# VSS nfet_06v0 ad=1.3p pd=5.52u as=2.2p ps=10.88u w=5u l=1u
X1692 a_46710_182443# a_38286_182443# VSS VSS nfet_06v0 ad=1.3p pd=5.52u as=2.2p ps=10.88u w=5u l=1u
X1693 a_59134_173707# a_60694_178107# VDD VDD pfet_06v0 ad=1.3p pd=5.52u as=2.2p ps=10.88u w=5u l=1u
D80 Z VDD diode_pd2nw_06v0 pj=40u area=99.99999p
X1694 a_54642_128854# a_32042_152778# a_52146_128854# VSS nfet_06v0 ad=3.74p pd=17.88u as=3.74p ps=17.88u w=8.5u l=1u
X1695 a_46382_177177# a_29286_177061# VDD VDD pfet_06v0 ad=2.5p pd=10.5u as=4.4p ps=20.88u w=10u l=1u
X1696 VSS VDD VSS VSS nfet_06v0 ad=0.44p pd=2.88u as=0 ps=0 w=1u l=2u
X1697 a_99046_175184# a_99096_173860# VSS VSS nfet_06v0 ad=0.5456p pd=3.36u as=0.5456p ps=3.36u w=1.24u l=1u
X1698 a_97566_128854# a_96334_128810# VSS VSS nfet_06v0 ad=1.25p pd=5.5u as=2.2p ps=10.88u w=5u l=1u
X1699 a_52358_185797# a_52658_185797# a_55594_185913# VDD pfet_06v0 ad=4.4p pd=20.88u as=2.5p ps=10.5u w=10u l=1u
X1700 a_104722_128854# a_104522_128810# VSS VSS nfet_06v0 ad=1.25p pd=5.5u as=2.2p ps=10.88u w=5u l=1u
X1701 a_81646_177107# a_83430_173707# VSS VSS nfet_06v0 ad=0.65p pd=3.02u as=0.65p ps=3.02u w=2.5u l=1u
X1702 a_57018_194537# a_57822_190951# a_58462_194467# VDD pfet_06v0 ad=4.4p pd=20.88u as=2.6p ps=10.52u w=10u l=1u
X1703 a_74848_145300# a_90266_145300# VSS ppolyf_u_1k r_width=1u r_length=76.45u
X1704 a_47058_159680# a_29286_159564# VDD VDD pfet_06v0 ad=2.5p pd=10.5u as=4.4p ps=20.88u w=10u l=1u
X1705 a_82762_185843# a_83430_182443# VSS VSS nfet_06v0 ad=0.65p pd=3.02u as=1.1p ps=5.88u w=2.5u l=1u
X1706 VDD a_60694_195467# a_58022_191067# VDD pfet_06v0 ad=2.2p pd=10.88u as=1.3p ps=5.52u w=5u l=1u
X1707 a_112558_165000# a_110806_165000# a_111626_164956# VSS nfet_06v0 ad=0.25p pd=1.5u as=0.44p ps=2.88u w=1u l=1u
X1708 a_29586_194421# a_29586_194421# VDD VDD pfet_06v0 ad=0.88p pd=4.88u as=0.88p ps=4.88u w=2u l=1u
X1709 a_29486_135712# a_29286_135596# VDD VDD pfet_06v0 ad=2.5p pd=10.5u as=4.4p ps=20.88u w=10u l=1u
X1710 VSS VDD VSS VSS nfet_06v0 ad=0.44p pd=2.88u as=0 ps=0 w=1u l=2u
X1711 a_52658_194421# a_52658_194421# a_55314_190997# VSS nfet_06v0 ad=0.44p pd=2.88u as=0.25p ps=1.5u w=1u l=1u
X1712 a_58022_173707# a_60694_178107# VDD VDD pfet_06v0 ad=1.3p pd=5.52u as=1.3p ps=5.52u w=5u l=1u
X1713 VDD a_29286_194421# a_34278_194537# VDD pfet_06v0 ad=4.4p pd=20.88u as=2.5p ps=10.5u w=10u l=1u
X1714 a_88894_164969# a_75842_168437# a_92638_168553# VDD pfet_06v0 ad=4.4p pd=20.88u as=2.5p ps=10.5u w=10u l=1u
X1715 a_97248_145300# a_102014_140794# a_101482_140838# VSS nfet_06v0 ad=0.88p pd=4.88u as=0.88p ps=4.88u w=2u l=1u
X1716 a_97248_145300# a_112666_145300# VSS ppolyf_u_1k r_width=1u r_length=76.45u
X1717 a_96634_152778# a_96634_152778# VSS VSS nfet_06v0 ad=0.44p pd=2.88u as=0.44p ps=2.88u w=1u l=1u
X1718 a_69458_159680# a_51686_159564# VDD VDD pfet_06v0 ad=2.5p pd=10.5u as=4.4p ps=20.88u w=10u l=1u
X1719 a_78022_159680# a_79614_152778# a_77474_152778# VSS nfet_06v0 ad=0.88p pd=4.88u as=0.88p ps=4.88u w=2u l=1u
X1720 a_30598_194537# a_29286_194421# VDD VDD pfet_06v0 ad=2.5p pd=10.5u as=4.4p ps=20.88u w=10u l=1u
X1721 VDD a_37622_178107# a_36062_173707# VDD pfet_06v0 ad=2.2p pd=10.88u as=1.3p ps=5.52u w=5u l=1u
X1722 a_60694_186843# a_52658_185797# a_59134_182443# VDD pfet_06v0 ad=1.3p pd=5.52u as=2.2p ps=10.88u w=5u l=1u
X1723 VDD VSS VDD VDD pfet_06v0 ad=7.92p pd=36.88u as=0 ps=0 w=18u l=2u
X1724 a_75842_185797# a_75842_185797# a_78498_182373# VSS nfet_06v0 ad=0.44p pd=2.88u as=0.25p ps=1.5u w=1u l=1u
X1725 a_75542_177061# a_75842_177061# a_77466_173637# VSS nfet_06v0 ad=0.44p pd=2.88u as=0.25p ps=1.5u w=1u l=1u
X1726 VSS a_37174_165083# a_35390_168483# VSS nfet_06v0 ad=0.65p pd=3.02u as=0.65p ps=3.02u w=2.5u l=1u
X1727 a_33946_177177# a_29586_177061# a_33646_177177# VDD pfet_06v0 ad=3.3p pd=10.66u as=2.5p ps=10.5u w=10u l=1u
X1728 VDD a_84994_195467# a_92966_191067# VDD pfet_06v0 ad=2.6p pd=10.52u as=2.6p ps=10.52u w=10u l=1u
X1729 a_74474_159680# a_74274_159564# a_75286_159680# VDD pfet_06v0 ad=4.4p pd=20.88u as=2.5p ps=10.5u w=10u l=1u
D81 VSS S2P diode_nd2ps_06v0 pj=40u area=99.99999p
X1730 a_73974_135596# a_74274_135596# a_91746_135712# VDD pfet_06v0 ad=4.4p pd=20.88u as=2.5p ps=10.5u w=10u l=1u
X1731 a_96634_128810# a_96634_128810# VSS VSS nfet_06v0 ad=0.44p pd=2.88u as=0.44p ps=2.88u w=1u l=1u
X1732 a_84994_186843# a_75842_185797# a_81206_182443# VDD pfet_06v0 ad=1.3p pd=5.52u as=2.2p ps=10.88u w=5u l=1u
X1733 a_78022_135712# a_79614_128810# a_77474_128810# VSS nfet_06v0 ad=0.88p pd=4.88u as=0.88p ps=4.88u w=2u l=1u
X1734 VDD VSS VDD VDD pfet_06v0 ad=4.29p pd=20.38u as=0 ps=0 w=9.75u l=2u
X1735 VSS VDD VSS VSS nfet_06v0 ad=0.44p pd=2.88u as=0 ps=0 w=1u l=2u
X1736 a_56658_173637# a_38998_140838# a_58022_173707# VSS nfet_06v0 ad=2.2p pd=10.88u as=1.3p ps=5.52u w=5u l=1u
X1737 a_76854_194537# a_75542_194421# VDD VDD pfet_06v0 ad=2.5p pd=10.5u as=4.4p ps=20.88u w=10u l=1u
X1738 VDD a_83878_178107# a_82318_173707# VDD pfet_06v0 ad=2.2p pd=10.88u as=1.3p ps=5.52u w=5u l=1u
X1739 a_61358_182443# a_52318_182329# a_58462_185843# VSS nfet_06v0 ad=0.65p pd=3.02u as=1.1p ps=5.88u w=2.5u l=1u
X1740 a_58022_191067# a_52658_194421# a_61810_195467# VDD pfet_06v0 ad=2.2p pd=10.88u as=1.3p ps=5.52u w=5u l=1u
X1741 a_58462_194467# a_60246_191067# VSS VSS nfet_06v0 ad=0.65p pd=3.02u as=1.1p ps=5.88u w=2.5u l=1u
X1742 a_99610_149596# a_43160_205808# a_96874_147696# VDD pfet_06v0 ad=0.22p pd=1.88u as=0.22p ps=1.88u w=0.5u l=1u
X1743 a_81646_168483# a_57822_164967# a_80202_168553# VDD pfet_06v0 ad=2.6p pd=10.52u as=4.4p ps=20.88u w=10u l=1u
X1744 a_59578_168483# a_35862_164967# a_57018_168553# VDD pfet_06v0 ad=2.6p pd=10.52u as=4.4p ps=20.88u w=10u l=1u
D82 VSS S2N diode_nd2ps_06v0 pj=40u area=99.99999p
X1745 a_65710_190953# a_52658_194421# a_69454_194537# VDD pfet_06v0 ad=4.4p pd=20.88u as=2.5p ps=10.5u w=10u l=1u
X1746 a_57822_164967# a_53910_128854# cap_mim_2f0_m4m5_noshield c_width=25u c_length=8u
X1747 a_76198_140838# a_78022_147696# VDD VDD pfet_06v0 ad=2.2p pd=10.88u as=2.2p ps=10.88u w=5u l=1u
X1748 VSS VDD VSS VSS nfet_06v0 ad=0.44p pd=2.88u as=0 ps=0 w=1u l=2u
X1749 a_99296_173976# a_99096_173860# VSS VSS nfet_06v0 ad=0.5456p pd=3.36u as=0.5456p ps=3.36u w=1.24u l=1u
X1750 VSS a_37174_173707# a_36506_177107# VSS nfet_06v0 ad=0.65p pd=3.02u as=0.65p ps=3.02u w=2.5u l=1u
D83 S4N VDD diode_pd2nw_06v0 pj=40u area=99.99999p
X1751 VSS VDD VSS VSS nfet_06v0 ad=7.92p pd=36.88u as=0 ps=0 w=18u l=2u
X1752 VDD a_37622_169483# a_34950_165083# VDD pfet_06v0 ad=1.3p pd=5.52u as=1.3p ps=5.52u w=5u l=1u
X1753 a_32786_140794# a_29546_140794# a_32522_149596# VSS nfet_06v0 ad=1.1p pd=5.88u as=0.825p ps=3.16u w=2.5u l=1u
X1754 a_69782_165083# a_61810_169483# VDD VDD pfet_06v0 ad=2.6p pd=10.52u as=4.4p ps=20.88u w=10u l=1u
X1755 a_69782_182443# a_61358_182443# VSS VSS nfet_06v0 ad=2.2p pd=10.88u as=1.3p ps=5.52u w=5u l=1u
X1756 a_40462_140838# a_29246_140794# VSS VSS nfet_06v0 ad=1.25p pd=5.5u as=2.2p ps=10.88u w=5u l=1u
X1757 a_33946_185913# a_35862_182327# a_36506_185843# VDD pfet_06v0 ad=4.4p pd=20.88u as=2.6p ps=10.52u w=10u l=1u
X1758 a_45134_135712# a_29286_135596# VDD VDD pfet_06v0 ad=2.5p pd=10.5u as=4.4p ps=20.88u w=10u l=1u
D84 S4N VDD diode_pd2nw_06v0 pj=40u area=99.99999p
X1759 a_80534_168553# a_75842_168437# a_80202_168553# VDD pfet_06v0 ad=2.5p pd=10.5u as=3.3p ps=10.66u w=10u l=1u
X1760 a_102380_168788# a_23448_190688# VDD VDD pfet_05v0 ad=0.8052p pd=4.54u as=0.8052p ps=4.54u w=1.83u l=0.5u
X1761 a_96374_147580# a_96674_147580# a_114146_147696# VDD pfet_06v0 ad=4.4p pd=20.88u as=2.5p ps=10.5u w=10u l=1u
X1762 a_56658_165013# a_52318_164969# a_56358_165013# VSS nfet_06v0 ad=1.65p pd=5.66u as=1.25p ps=5.5u w=5u l=1u
X1763 a_32242_140838# a_32042_128810# a_29746_140838# VSS nfet_06v0 ad=3.74p pd=17.88u as=3.74p ps=17.88u w=8.5u l=1u
X1764 a_82706_159564# a_74274_159564# a_82906_159680# VDD pfet_06v0 ad=3.3p pd=10.66u as=2.5p ps=10.5u w=10u l=1u
X1765 a_74474_147696# a_74274_147580# a_74174_147696# VDD pfet_06v0 ad=4.4p pd=20.88u as=2.5p ps=10.5u w=10u l=1u
X1766 a_51986_159564# a_51986_159564# VDD VDD pfet_06v0 ad=0.88p pd=4.88u as=0.88p ps=4.88u w=2u l=1u
D85 VSS Z diode_nd2ps_06v0 pj=40u area=99.99999p
X1767 VSS VDD VSS VSS nfet_06v0 ad=0.44p pd=2.88u as=0 ps=0 w=1u l=2u
X1768 a_67534_135712# a_51686_135596# VDD VDD pfet_06v0 ad=2.5p pd=10.5u as=4.4p ps=20.88u w=10u l=1u
X1769 a_75542_185797# a_75842_185797# a_78778_185913# VDD pfet_06v0 ad=4.4p pd=20.88u as=2.5p ps=10.5u w=10u l=1u
X1770 VDD a_83878_195467# a_81206_191067# VDD pfet_06v0 ad=2.2p pd=10.88u as=1.3p ps=5.52u w=5u l=1u
X1771 a_101482_128854# a_103470_136796# a_97248_133316# VDD pfet_06v0 ad=1.76p pd=8.88u as=1.76p ps=8.88u w=4u l=1u
X1772 VSS VDD VSS VSS nfet_06v0 ad=4.29p pd=20.38u as=0 ps=0 w=9.75u l=2u
X1773 VSS VDD VSS VSS nfet_06v0 ad=7.92p pd=36.88u as=0 ps=0 w=18u l=2u
X1774 a_58462_194467# a_57822_190951# a_57018_194537# VDD pfet_06v0 ad=2.6p pd=10.52u as=4.4p ps=20.88u w=10u l=1u
X1775 a_52558_194537# a_52358_194421# VDD VDD pfet_06v0 ad=2.5p pd=10.5u as=4.4p ps=20.88u w=10u l=1u
X1776 VDD VSS VDD VDD pfet_06v0 ad=0.44p pd=2.88u as=0 ps=0 w=1u l=2u
X1777 VSS VDD VSS VSS nfet_06v0 ad=0.44p pd=2.88u as=0 ps=0 w=1u l=2u
X1778 a_102014_140794# a_96674_147580# a_106750_147696# VDD pfet_06v0 ad=4.4p pd=20.88u as=2.5p ps=10.5u w=10u l=1u
X1779 a_111626_173580# a_92966_173707# VDD VDD pfet_06v0 ad=0.99p pd=3.66u as=1.32p ps=6.88u w=3u l=1u
X1780 a_82318_191067# a_34750_190951# a_79842_190997# VSS nfet_06v0 ad=1.3p pd=5.52u as=2.2p ps=10.88u w=5u l=1u
X1781 a_54282_173637# a_52658_177061# VSS VSS nfet_06v0 ad=0.25p pd=1.5u as=0.44p ps=2.88u w=1u l=1u
X1782 a_59134_165083# a_60694_169483# VDD VDD pfet_06v0 ad=1.3p pd=5.52u as=2.2p ps=10.88u w=5u l=1u
X1783 a_35862_190951# a_98598_152822# cap_mim_2f0_m4m5_noshield c_width=25u c_length=8u
X1784 VSS VDD VSS VSS nfet_06v0 ad=0.44p pd=2.88u as=0 ps=0 w=1u l=2u
X1785 a_99296_182600# a_106078_183692# a_23448_70736# VSS nfet_06v0 ad=1.0912p pd=5.84u as=0.6448p ps=3u w=2.48u l=1u
X1786 a_83878_186843# a_75842_185797# a_82318_182443# VDD pfet_06v0 ad=1.3p pd=5.52u as=2.2p ps=10.88u w=5u l=1u
X1787 a_57350_194537# a_52658_194421# a_57018_194537# VDD pfet_06v0 ad=2.5p pd=10.5u as=3.3p ps=10.66u w=10u l=1u
X1788 a_38998_140838# a_30160_145300# VDD VDD pfet_06v0 ad=0.44p pd=2.88u as=0.44p ps=2.88u w=1u l=1u
X1789 a_114146_159680# a_96374_159564# VDD VDD pfet_06v0 ad=2.5p pd=10.5u as=4.4p ps=20.88u w=10u l=1u
X1790 VSS a_53050_173593# a_56990_173637# VSS nfet_06v0 ad=2.2p pd=10.88u as=1.25p ps=5.5u w=5u l=1u
X1791 a_80202_177177# a_75842_177061# a_79902_177177# VDD pfet_06v0 ad=3.3p pd=10.66u as=2.5p ps=10.5u w=10u l=1u
X1792 a_36062_173707# a_37622_178107# VDD VDD pfet_06v0 ad=1.3p pd=5.52u as=1.3p ps=5.52u w=5u l=1u
X1793 VSS VDD VSS VSS nfet_06v0 ad=7.92p pd=36.88u as=0 ps=0 w=18u l=2u
X1794 a_74174_159680# a_73974_159564# VDD VDD pfet_06v0 ad=2.5p pd=10.5u as=4.4p ps=20.88u w=10u l=1u
X1795 a_102002_166448# a_23448_190688# a_103402_166378# VSS nfet_06v0 ad=0.88p pd=4.88u as=0.5p ps=2.5u w=2u l=1u
X1796 a_76198_140838# a_23448_31424# a_74434_140838# VSS nfet_06v0 ad=3.3p pd=15.88u as=3.3p ps=15.88u w=7.5u l=1u
X1797 a_60418_147580# a_51986_147580# a_60618_147696# VDD pfet_06v0 ad=3.3p pd=10.66u as=2.5p ps=10.5u w=10u l=1u
X1798 a_43102_178061# a_29246_173593# a_44302_173637# VSS nfet_06v0 ad=2.2p pd=10.88u as=1.25p ps=5.5u w=5u l=1u
X1799 a_89358_195421# a_89358_195421# a_90994_194421# VDD pfet_06v0 ad=4.4p pd=20.88u as=3.3p ps=10.66u w=10u l=1u
X1800 a_61810_195467# a_65710_190953# a_61358_191067# VSS nfet_06v0 ad=1.1p pd=5.88u as=1.1p ps=5.88u w=2.5u l=1u
X1801 a_67810_185797# a_52658_185797# a_68010_185913# VDD pfet_06v0 ad=3.3p pd=10.66u as=2.5p ps=10.5u w=10u l=1u
X1802 a_63894_140838# a_51986_147580# VSS VSS nfet_06v0 ad=0.25p pd=1.5u as=0.44p ps=2.88u w=1u l=1u
X1803 a_58022_165083# a_60694_169483# VDD VDD pfet_06v0 ad=1.3p pd=5.52u as=1.3p ps=5.52u w=5u l=1u
X1804 a_90558_182373# a_76234_182329# VSS VSS nfet_06v0 ad=1.25p pd=5.5u as=2.2p ps=10.88u w=5u l=1u
X1805 a_100238_190984# a_98486_190984# a_99306_190940# VSS nfet_06v0 ad=0.25p pd=1.5u as=0.44p ps=2.88u w=1u l=1u
X1806 a_92966_191067# a_84994_195467# VDD VDD pfet_06v0 ad=2.6p pd=10.52u as=4.4p ps=20.88u w=10u l=1u
X1807 VDD VSS VDD VDD pfet_06v0 ad=7.92p pd=36.88u as=0 ps=0 w=18u l=2u
X1808 a_32522_177177# a_29286_177061# VDD VDD pfet_06v0 ad=2.5p pd=10.5u as=4.4p ps=20.88u w=10u l=1u
X1809 a_56794_140838# a_51946_140794# a_54110_149586# VSS nfet_06v0 ad=1.1p pd=5.88u as=0.825p ps=3.16u w=2.5u l=1u
X1810 a_52560_145750# a_67978_145300# VSS ppolyf_u_1k r_width=1u r_length=76.45u
X1811 VDD VSS VDD VDD pfet_06v0 ad=0.44p pd=2.88u as=0 ps=0 w=1u l=2u
X1812 a_96574_159680# a_96374_159564# VDD VDD pfet_06v0 ad=2.5p pd=10.5u as=4.4p ps=20.88u w=10u l=1u
X1813 a_35862_173591# a_52560_145300# VDD VDD pfet_06v0 ad=0.44p pd=2.88u as=0.44p ps=2.88u w=1u l=1u
X1814 VSS VDD VSS VSS nfet_06v0 ad=4.29p pd=20.38u as=0 ps=0 w=9.75u l=2u
X1815 a_98598_140838# a_63208_205808# a_96834_140838# VSS nfet_06v0 ad=3.3p pd=15.88u as=3.3p ps=15.88u w=7.5u l=1u
X1816 VDD a_37622_169483# a_36062_165083# VDD pfet_06v0 ad=2.2p pd=10.88u as=1.3p ps=5.52u w=5u l=1u
X1817 VSS VDD VSS VSS nfet_06v0 ad=0.44p pd=2.88u as=0 ps=0 w=1u l=2u
X1818 VSS a_37174_191067# a_36506_194467# VSS nfet_06v0 ad=1.1p pd=5.88u as=0.65p ps=3.02u w=2.5u l=1u
X1819 VDD VSS VDD VDD pfet_06v0 ad=7.92p pd=36.88u as=0 ps=0 w=18u l=2u
X1820 a_76398_149586# a_77474_140794# VSS VSS nfet_06v0 ad=0.825p pd=3.16u as=1.1p ps=5.88u w=2.5u l=1u
X1821 a_34750_182327# a_76198_140838# cap_mim_2f0_m4m5_noshield c_width=25u c_length=8u
X1822 VSS a_60246_173707# a_59578_177107# VSS nfet_06v0 ad=1.1p pd=5.88u as=0.65p ps=3.02u w=2.5u l=1u
X1823 VSS VDD VSS VSS nfet_06v0 ad=4.29p pd=20.38u as=0 ps=0 w=9.75u l=2u
X1824 VSS VDD VSS VSS nfet_06v0 ad=7.92p pd=36.88u as=0 ps=0 w=18u l=2u
X1825 a_51946_152778# a_51986_159564# a_66422_159680# VDD pfet_06v0 ad=4.4p pd=20.88u as=2.5p ps=10.5u w=10u l=1u
X1826 a_61810_195467# a_52658_194421# a_58022_191067# VDD pfet_06v0 ad=1.3p pd=5.52u as=2.2p ps=10.88u w=5u l=1u
X1827 a_35862_182327# a_30160_157284# VDD VDD pfet_06v0 ad=0.44p pd=2.88u as=0.44p ps=2.88u w=1u l=1u
X1828 a_81646_177107# a_92966_173707# cap_mim_2f0_m4m5_noshield c_width=20u c_length=10u
X1829 a_39662_147696# a_29286_147580# VDD VDD pfet_06v0 ad=2.5p pd=10.5u as=4.4p ps=20.88u w=10u l=1u
X1830 a_92966_182443# a_84542_182443# VSS VSS nfet_06v0 ad=2.2p pd=10.88u as=1.3p ps=5.52u w=5u l=1u
X1831 a_57822_164967# a_52560_133316# VDD VDD pfet_06v0 ad=0.44p pd=2.88u as=0.44p ps=2.88u w=1u l=1u
X1832 a_65710_173593# a_65710_173593# a_68218_173593# VSS nfet_06v0 ad=2.2p pd=10.88u as=1.65p ps=5.66u w=5u l=1u
X1833 a_55594_185913# a_52358_185797# VDD VDD pfet_06v0 ad=2.5p pd=10.5u as=4.4p ps=20.88u w=10u l=1u
X1834 a_101060_173976# a_99096_173860# a_100760_173976# VSS nfet_06v0 ad=0.175p pd=1.2u as=0.175p ps=1.2u w=0.7u l=1u
X1835 VSS VDD VSS VSS nfet_06v0 ad=0.44p pd=2.88u as=0 ps=0 w=1u l=2u
X1836 VDD a_83878_169483# a_82318_165083# VDD pfet_06v0 ad=2.2p pd=10.88u as=1.3p ps=5.52u w=5u l=1u
X1837 a_82318_191067# a_83878_195467# VDD VDD pfet_06v0 ad=1.3p pd=5.52u as=2.2p ps=10.88u w=5u l=1u
X1838 VDD VSS VDD VDD pfet_06v0 ad=0.44p pd=2.88u as=0 ps=0 w=1u l=2u
X1839 a_29246_182329# a_29246_182329# VSS VSS nfet_06v0 ad=0.44p pd=2.88u as=0.44p ps=2.88u w=1u l=1u
X1840 VDD VSS VDD VDD pfet_06v0 ad=4.29p pd=20.38u as=0 ps=0 w=9.75u l=2u
X1841 a_36382_136796# a_36382_136796# a_38018_135596# VDD pfet_06v0 ad=4.4p pd=20.88u as=3.3p ps=10.66u w=10u l=1u
X1842 a_102380_186148# a_23448_70736# VSS VSS nfet_05v0 ad=0.5808p pd=3.52u as=0.5808p ps=3.52u w=1.32u l=0.6u
X1843 a_33334_159680# a_29586_159564# a_32242_152822# VDD pfet_06v0 ad=4.4p pd=20.88u as=4.4p ps=20.88u w=10u l=1u
X1844 a_55314_190997# a_52658_194421# VSS VSS nfet_06v0 ad=0.25p pd=1.5u as=0.44p ps=2.88u w=1u l=1u
X1845 a_61358_173707# a_66174_178061# a_61810_178107# VDD pfet_06v0 ad=2.2p pd=10.88u as=2.2p ps=10.88u w=5u l=1u
X1846 a_34278_194537# a_29586_194421# a_33946_194537# VDD pfet_06v0 ad=2.5p pd=10.5u as=3.3p ps=10.66u w=10u l=1u
X1847 a_92638_168553# a_75542_168437# VDD VDD pfet_06v0 ad=2.5p pd=10.5u as=4.4p ps=20.88u w=10u l=1u
X1848 a_53910_152822# a_55734_159680# VDD VDD pfet_06v0 ad=2.2p pd=10.88u as=2.2p ps=10.88u w=5u l=1u
X1849 a_99874_140794# a_96634_140794# a_99610_149596# VSS nfet_06v0 ad=1.1p pd=5.88u as=0.825p ps=3.16u w=2.5u l=1u
D86 VSS S4P diode_nd2ps_06v0 pj=40u area=99.99999p
X1850 a_81206_191067# a_83878_195467# VDD VDD pfet_06v0 ad=1.3p pd=5.52u as=1.3p ps=5.52u w=5u l=1u
X1851 a_44738_185797# a_29586_185797# a_44938_185913# VDD pfet_06v0 ad=3.3p pd=10.66u as=2.5p ps=10.5u w=10u l=1u
X1852 VSS a_92966_173707# a_112558_173624# VSS nfet_06v0 ad=0.44p pd=2.88u as=0.25p ps=1.5u w=1u l=1u
X1853 a_78498_182373# a_75842_185797# VSS VSS nfet_06v0 ad=0.25p pd=1.5u as=0.44p ps=2.88u w=1u l=1u
X1854 a_59578_194467# a_60246_191067# VSS VSS nfet_06v0 ad=0.65p pd=3.02u as=0.65p ps=3.02u w=2.5u l=1u
X1855 a_77466_173637# a_75842_177061# VSS VSS nfet_06v0 ad=0.25p pd=1.5u as=0.44p ps=2.88u w=1u l=1u
X1856 a_37174_173707# a_43102_178061# a_37622_178107# VDD pfet_06v0 ad=2.2p pd=10.88u as=2.2p ps=10.88u w=5u l=1u
X1857 a_91402_182329# a_75502_182329# a_91602_182373# VSS nfet_06v0 ad=1.65p pd=5.66u as=1.25p ps=5.5u w=5u l=1u
X1858 a_33646_177177# a_29286_177061# VDD VDD pfet_06v0 ad=2.5p pd=10.5u as=4.4p ps=20.88u w=10u l=1u
X1859 a_75286_159680# a_73974_159564# VDD VDD pfet_06v0 ad=2.5p pd=10.5u as=4.4p ps=20.88u w=10u l=1u
X1860 a_100158_166448# a_100246_166332# a_23448_190688# VSS nfet_06v0 ad=1.0912p pd=5.84u as=0.6448p ps=3u w=2.48u l=1u
X1861 a_102104_182600# VDD a_23448_70736# VSS nfet_06v0 ad=1.0912p pd=5.84u as=0.6448p ps=3u w=2.48u l=1u
X1862 a_91746_135712# a_73974_135596# VDD VDD pfet_06v0 ad=2.5p pd=10.5u as=4.4p ps=20.88u w=10u l=1u
X1863 a_29286_168437# a_29586_168437# a_31210_165013# VSS nfet_06v0 ad=0.44p pd=2.88u as=0.25p ps=1.5u w=1u l=1u
X1864 a_53050_182329# a_52318_182329# a_53250_182373# VSS nfet_06v0 ad=2.2p pd=10.88u as=1.25p ps=5.5u w=5u l=1u
X1865 a_36506_168483# a_37174_165083# VSS VSS nfet_06v0 ad=0.65p pd=3.02u as=0.65p ps=3.02u w=2.5u l=1u
X1866 a_33586_165013# a_35862_164967# a_36062_165083# VSS nfet_06v0 ad=2.2p pd=10.88u as=1.3p ps=5.52u w=5u l=1u
X1867 a_29246_152778# a_29586_159564# a_45134_159680# VDD pfet_06v0 ad=4.4p pd=20.88u as=2.5p ps=10.5u w=10u l=1u
X1868 a_84994_195467# a_88894_190953# a_84542_191067# VSS nfet_06v0 ad=1.1p pd=5.88u as=1.1p ps=5.88u w=2.5u l=1u
X1869 a_79842_165013# a_57822_164967# a_81206_165083# VSS nfet_06v0 ad=2.2p pd=10.88u as=1.3p ps=5.52u w=5u l=1u
X1870 a_100158_175184# a_99096_173860# VSS VSS nfet_06v0 ad=0.5456p pd=3.36u as=0.5456p ps=3.36u w=1.24u l=1u
X1871 VSS VDD VSS VSS nfet_06v0 ad=0.44p pd=2.88u as=0 ps=0 w=1u l=2u
X1872 a_35390_185843# a_29246_182329# a_38286_182443# VSS nfet_06v0 ad=1.1p pd=5.88u as=0.65p ps=3.02u w=2.5u l=1u
X1873 a_69454_194537# a_52358_194421# VDD VDD pfet_06v0 ad=2.5p pd=10.5u as=4.4p ps=20.88u w=10u l=1u
X1874 VSS a_46710_165083# a_110806_165000# VSS nfet_06v0 ad=0.44p pd=2.88u as=0.44p ps=2.88u w=1u l=1u
X1875 a_60246_182443# a_66174_186797# a_60694_186843# VDD pfet_06v0 ad=2.2p pd=10.88u as=2.2p ps=10.88u w=5u l=1u
X1876 a_42638_173593# a_42638_173593# a_45146_173593# VSS nfet_06v0 ad=2.2p pd=10.88u as=1.65p ps=5.66u w=5u l=1u
X1877 a_34950_165083# a_34750_164967# a_33586_165013# VSS nfet_06v0 ad=1.3p pd=5.52u as=2.2p ps=10.88u w=5u l=1u
X1878 a_29246_164969# a_29586_168437# a_29486_168553# VDD pfet_06v0 ad=4.4p pd=20.88u as=2.5p ps=10.5u w=10u l=1u
X1879 a_79902_177177# a_75542_177061# VDD VDD pfet_06v0 ad=2.5p pd=10.5u as=4.4p ps=20.88u w=10u l=1u
X1880 a_33586_182373# a_29246_182329# a_33286_182373# VSS nfet_06v0 ad=1.65p pd=5.66u as=1.25p ps=5.5u w=5u l=1u
X1881 a_34950_173707# a_29586_177061# a_38738_178107# VDD pfet_06v0 ad=2.2p pd=10.88u as=1.3p ps=5.52u w=5u l=1u
X1882 a_97248_133316# a_96674_135596# a_98598_128854# VDD pfet_06v0 ad=4.4p pd=20.88u as=4.4p ps=20.88u w=10u l=1u
D87 S4P VDD diode_pd2nw_06v0 pj=40u area=99.99999p
X1883 VDD a_23448_190688# a_23448_190688# VDD pfet_06v0 ad=0.52p pd=2.52u as=0.52p ps=2.52u w=2u l=1u
X1884 a_51946_140794# a_51946_140794# VSS VSS nfet_06v0 ad=0.44p pd=2.88u as=0.44p ps=2.88u w=1u l=1u
X1885 a_104234_183692# a_92966_165083# VSS VSS nfet_06v0 ad=0.33p pd=1.66u as=0.44p ps=2.88u w=1u l=1u
X1886 a_36062_165083# a_37622_169483# VDD VDD pfet_06v0 ad=1.3p pd=5.52u as=1.3p ps=5.52u w=5u l=1u
X1887 VSS a_83430_173707# a_82762_177107# VSS nfet_06v0 ad=1.1p pd=5.88u as=0.65p ps=3.02u w=2.5u l=1u
X1888 a_52560_145750# a_67978_146200# VSS ppolyf_u_1k r_width=1u r_length=76.45u
X1889 a_81646_168483# a_83430_165083# VSS VSS nfet_06v0 ad=0.65p pd=3.02u as=0.65p ps=3.02u w=2.5u l=1u
X1890 a_77474_128810# a_81070_136796# a_78022_135712# VDD pfet_06v0 ad=1.76p pd=8.88u as=1.76p ps=8.88u w=4u l=1u
X1891 a_103470_148780# a_103470_148780# a_105106_147580# VDD pfet_06v0 ad=4.4p pd=20.88u as=3.3p ps=10.66u w=10u l=1u
X1892 a_53910_140838# a_23448_31424# a_52146_140838# VSS nfet_06v0 ad=3.3p pd=15.88u as=3.3p ps=15.88u w=7.5u l=1u
X1893 a_52998_147696# a_51686_147580# VDD VDD pfet_06v0 ad=2.5p pd=10.5u as=4.4p ps=20.88u w=10u l=1u
X1894 a_30160_133766# a_45578_133316# VSS ppolyf_u_1k r_width=1u r_length=76.45u
X1895 a_59834_140794# a_51946_140794# a_60034_140838# VSS nfet_06v0 ad=1.65p pd=5.66u as=1.25p ps=5.5u w=5u l=1u
X1896 a_34926_140794# a_34926_140794# a_37434_140794# VSS nfet_06v0 ad=2.2p pd=10.88u as=1.65p ps=5.66u w=5u l=1u
X1897 a_56358_165013# a_53050_164969# VSS VSS nfet_06v0 ad=1.25p pd=5.5u as=2.2p ps=10.88u w=5u l=1u
X1898 a_96834_140838# a_96634_140794# a_96534_140838# VSS nfet_06v0 ad=2.2p pd=10.88u as=1.25p ps=5.5u w=5u l=1u
X1899 a_77210_161580# a_77474_152778# VSS VSS nfet_06v0 ad=0.825p pd=3.16u as=1.1p ps=5.88u w=2.5u l=1u
X1900 VDD a_110806_173624# a_111626_173580# VDD pfet_06v0 ad=1.32p pd=6.88u as=0.99p ps=3.66u w=3u l=1u
X1901 a_78778_185913# a_75542_185797# VDD VDD pfet_06v0 ad=2.5p pd=10.5u as=4.4p ps=20.88u w=10u l=1u
X1902 VSS a_84542_182443# a_92966_182443# VSS nfet_06v0 ad=1.3p pd=5.52u as=1.3p ps=5.52u w=5u l=1u
X1903 a_79842_182373# a_75502_182329# a_79542_182373# VSS nfet_06v0 ad=1.65p pd=5.66u as=1.25p ps=5.5u w=5u l=1u
X1904 a_29546_140794# a_29586_147580# a_44022_147696# VDD pfet_06v0 ad=4.4p pd=20.88u as=2.5p ps=10.5u w=10u l=1u
X1905 VSS VDD VSS VSS nfet_06v0 ad=7.92p pd=36.88u as=0 ps=0 w=18u l=2u
X1906 a_81646_194467# a_92966_191067# cap_mim_2f0_m4m5_noshield c_width=20u c_length=10u
X1907 a_57018_194537# a_52658_194421# a_56718_194537# VDD pfet_06v0 ad=3.3p pd=10.66u as=2.5p ps=10.5u w=10u l=1u
X1908 VSS VDD VSS VSS nfet_06v0 ad=7.92p pd=36.88u as=0 ps=0 w=18u l=2u
X1909 a_68218_182329# a_52318_182329# a_68418_182373# VSS nfet_06v0 ad=1.65p pd=5.66u as=1.25p ps=5.5u w=5u l=1u
X1910 a_106750_147696# a_96374_147580# VDD VDD pfet_06v0 ad=2.5p pd=10.5u as=4.4p ps=20.88u w=10u l=1u
X1911 a_52186_135712# a_51986_135596# a_51886_135712# VDD pfet_06v0 ad=4.4p pd=20.88u as=2.5p ps=10.5u w=10u l=1u
X1912 VSS VDD VSS VSS nfet_06v0 ad=4.29p pd=20.38u as=0 ps=0 w=9.75u l=2u
X1913 a_29978_182329# a_29246_182329# a_30178_182373# VSS nfet_06v0 ad=2.2p pd=10.88u as=1.25p ps=5.5u w=5u l=1u
X1914 a_77210_137612# a_77474_128810# VSS VSS nfet_06v0 ad=0.825p pd=3.16u as=1.1p ps=5.88u w=2.5u l=1u
X1915 a_30160_158634# a_35862_182327# VSS ppolyf_u_1k r_width=1u r_length=76.45u
X1916 VDD VSS VDD VDD pfet_06v0 ad=4.29p pd=20.38u as=0 ps=0 w=9.75u l=2u
X1917 VDD VSS VDD VDD pfet_06v0 ad=0.44p pd=2.88u as=0 ps=0 w=1u l=2u
X1918 a_98798_137602# a_63208_205808# a_96874_135712# VDD pfet_06v0 ad=0.242p pd=1.98u as=0.242p ps=1.98u w=0.55u l=1u
X1919 a_34750_173591# a_98598_128854# cap_mim_2f0_m4m5_noshield c_width=25u c_length=8u
X1920 a_106078_175068# a_111626_182316# VDD VDD pfet_06v0 ad=1.32p pd=6.88u as=1.32p ps=6.88u w=3u l=1u
X1921 a_29586_159564# a_29586_159564# a_42526_152822# VSS nfet_06v0 ad=0.44p pd=2.88u as=0.25p ps=1.5u w=1u l=1u
X1922 a_74848_157284# a_79614_152778# a_79082_152822# VSS nfet_06v0 ad=0.88p pd=4.88u as=0.88p ps=4.88u w=2u l=1u
X1923 XP_OUT XN_OUT VSS VSS nfet_05v0 ad=0.5808p pd=3.52u as=0.5808p ps=3.52u w=1.32u l=0.6u
X1924 a_103402_166378# a_23448_190688# VSS VSS nfet_06v0 ad=0.5p pd=2.5u as=0.88p ps=4.88u w=2u l=1u
X1925 VSS a_60246_191067# a_59578_194467# VSS nfet_06v0 ad=0.65p pd=3.02u as=0.65p ps=3.02u w=2.5u l=1u
X1926 a_60618_147696# a_60418_147580# VDD VDD pfet_06v0 ad=2.5p pd=10.5u as=4.4p ps=20.88u w=10u l=1u
X1927 a_56658_165013# a_57822_164967# a_58022_165083# VSS nfet_06v0 ad=2.2p pd=10.88u as=1.3p ps=5.52u w=5u l=1u
X1928 a_44302_173637# a_29978_173593# VSS VSS nfet_06v0 ad=1.25p pd=5.5u as=2.2p ps=10.88u w=5u l=1u
X1929 a_100422_159680# a_96674_159564# a_99330_152822# VDD pfet_06v0 ad=4.4p pd=20.88u as=4.4p ps=20.88u w=10u l=1u
X1930 VSS VDD VSS VSS nfet_06v0 ad=7.92p pd=36.88u as=0 ps=0 w=18u l=2u
X1931 a_29746_152822# a_29546_152778# a_29446_152822# VSS nfet_06v0 ad=2.2p pd=10.88u as=1.25p ps=5.5u w=5u l=1u
X1932 Z a_23448_70736# VDD ppolyf_u r_width=16u r_length=4u
X1933 VDD a_60694_186843# a_58022_182443# VDD pfet_06v0 ad=1.3p pd=5.52u as=1.3p ps=5.52u w=5u l=1u
X1934 a_36382_160764# a_29546_152778# a_36590_152822# VSS nfet_06v0 ad=2.2p pd=10.88u as=1.25p ps=5.5u w=5u l=1u
X1935 a_51986_159564# a_51986_159564# a_64926_152822# VSS nfet_06v0 ad=0.44p pd=2.88u as=0.25p ps=1.5u w=1u l=1u
X1936 a_74848_145300# a_74274_147580# a_76198_140838# VDD pfet_06v0 ad=4.4p pd=20.88u as=4.4p ps=20.88u w=10u l=1u
X1937 a_44022_159680# a_29286_159564# VDD VDD pfet_06v0 ad=2.5p pd=10.5u as=4.4p ps=20.88u w=10u l=1u
X1938 a_76234_182329# a_75502_182329# a_76434_182373# VSS nfet_06v0 ad=2.2p pd=10.88u as=1.25p ps=5.5u w=5u l=1u
X1939 a_51986_147580# a_51986_147580# VDD VDD pfet_06v0 ad=0.88p pd=4.88u as=0.88p ps=4.88u w=2u l=1u
X1940 a_36062_173707# a_29586_177061# a_37622_178107# VDD pfet_06v0 ad=2.2p pd=10.88u as=1.3p ps=5.52u w=5u l=1u
X1941 a_75502_173593# a_75502_173593# VSS VSS nfet_06v0 ad=0.44p pd=2.88u as=0.44p ps=2.88u w=1u l=1u
X1942 a_23448_70736# VDD a_102104_182600# VSS nfet_06v0 ad=0.6448p pd=3u as=1.0912p ps=5.84u w=2.48u l=1u
X1943 VDD a_98486_190984# a_99306_190940# VDD pfet_06v0 ad=1.32p pd=6.88u as=0.99p ps=3.66u w=3u l=1u
X1944 VSS a_37174_165083# a_36506_168483# VSS nfet_06v0 ad=0.65p pd=3.02u as=0.65p ps=3.02u w=2.5u l=1u
X1945 a_77210_137612# a_43160_205808# a_74474_135712# VDD pfet_06v0 ad=0.22p pd=1.88u as=0.22p ps=1.88u w=0.5u l=1u
X1946 a_29586_135596# a_29586_135596# a_42526_128854# VSS nfet_06v0 ad=0.44p pd=2.88u as=0.25p ps=1.5u w=1u l=1u
X1947 a_74848_133316# a_79614_128810# a_79082_128854# VSS nfet_06v0 ad=0.88p pd=4.88u as=0.88p ps=4.88u w=2u l=1u
X1948 a_58782_160764# a_51946_152778# a_58990_152822# VSS nfet_06v0 ad=2.2p pd=10.88u as=1.25p ps=5.5u w=5u l=1u
X1949 a_88894_173593# a_88894_173593# a_91402_173593# VSS nfet_06v0 ad=2.2p pd=10.88u as=1.65p ps=5.66u w=5u l=1u
X1950 a_66422_159680# a_51686_159564# VDD VDD pfet_06v0 ad=2.5p pd=10.5u as=4.4p ps=20.88u w=10u l=1u
X1951 a_89358_195421# a_75502_190953# a_90558_190997# VSS nfet_06v0 ad=2.2p pd=10.88u as=1.25p ps=5.5u w=5u l=1u
X1952 a_55186_152778# a_58782_160764# a_55734_159680# VDD pfet_06v0 ad=1.76p pd=8.88u as=1.76p ps=8.88u w=4u l=1u
X1953 a_83430_182443# a_89358_186797# a_83878_186843# VDD pfet_06v0 ad=2.2p pd=10.88u as=2.2p ps=10.88u w=5u l=1u
X1954 a_74848_134666# a_90266_134216# VSS ppolyf_u_1k r_width=1u r_length=76.45u
X1955 VSS VDD VSS VSS nfet_06v0 ad=7.92p pd=36.88u as=0 ps=0 w=18u l=2u
X1956 a_29746_128854# a_29546_128810# a_29446_128854# VSS nfet_06v0 ad=2.2p pd=10.88u as=1.25p ps=5.5u w=5u l=1u
X1957 a_36382_136796# a_29546_128810# a_36590_128854# VSS nfet_06v0 ad=2.2p pd=10.88u as=1.25p ps=5.5u w=5u l=1u
X1958 a_38286_165083# a_43102_169437# a_38738_169483# VDD pfet_06v0 ad=2.2p pd=10.88u as=2.2p ps=10.88u w=5u l=1u
X1959 a_33586_190997# a_34750_190951# a_34950_191067# VSS nfet_06v0 ad=2.2p pd=10.88u as=1.3p ps=5.52u w=5u l=1u
X1960 a_78022_135712# a_74274_135596# a_76930_128854# VDD pfet_06v0 ad=4.4p pd=20.88u as=4.4p ps=20.88u w=10u l=1u
X1961 a_51986_135596# a_51986_135596# a_64926_128854# VSS nfet_06v0 ad=0.44p pd=2.88u as=0.25p ps=1.5u w=1u l=1u
X1962 VDD VSS VDD VDD pfet_06v0 ad=7.92p pd=36.88u as=0 ps=0 w=18u l=2u
X1963 a_96334_152778# a_96674_159564# a_112222_159680# VDD pfet_06v0 ad=4.4p pd=20.88u as=2.5p ps=10.5u w=10u l=1u
X1964 a_43102_169437# a_43102_169437# a_44738_168437# VDD pfet_06v0 ad=4.4p pd=20.88u as=3.3p ps=10.66u w=10u l=1u
X1965 a_52560_157734# a_67978_157284# VSS ppolyf_u_1k r_width=1u r_length=76.45u
X1966 a_104146_166448# a_104234_166332# a_23448_190688# VSS nfet_06v0 ad=1.0912p pd=5.84u as=0.6448p ps=3u w=2.48u l=1u
X1967 a_100760_173976# a_99096_173860# VSS VSS nfet_06v0 ad=0.175p pd=1.2u as=0.308p ps=2.28u w=0.7u l=1u
X1968 VSS a_83430_191067# a_81646_194467# VSS nfet_06v0 ad=1.1p pd=5.88u as=0.65p ps=3.02u w=2.5u l=1u
X1969 a_29786_135712# a_29586_135596# a_30598_135712# VDD pfet_06v0 ad=4.4p pd=20.88u as=2.5p ps=10.5u w=10u l=1u
X1970 a_97248_134666# a_112666_134216# VSS ppolyf_u_1k r_width=1u r_length=76.45u
X1971 a_54110_161570# a_34750_190951# cap_mim_2f0_m4m5_noshield c_width=25u c_length=8u
X1972 VDD a_69782_173707# a_113914_175036# VDD pfet_06v0 ad=1.32p pd=6.88u as=0.75p ps=3.5u w=3u l=1u
X1973 a_82762_177107# a_83430_173707# VSS VSS nfet_06v0 ad=0.65p pd=3.02u as=0.65p ps=3.02u w=2.5u l=1u
X1974 a_58782_136796# a_51946_128810# a_58990_128854# VSS nfet_06v0 ad=2.2p pd=10.88u as=1.25p ps=5.5u w=5u l=1u
X1975 VDD VSS VDD VDD pfet_06v0 ad=7.92p pd=36.88u as=0 ps=0 w=18u l=2u
X1976 a_52186_135712# a_51986_135596# a_52998_135712# VDD pfet_06v0 ad=4.4p pd=20.88u as=2.5p ps=10.5u w=10u l=1u
X1977 a_34950_165083# a_29586_168437# a_38738_169483# VDD pfet_06v0 ad=2.2p pd=10.88u as=1.3p ps=5.52u w=5u l=1u
X1978 a_30160_133766# a_45578_134216# VSS ppolyf_u_1k r_width=1u r_length=76.45u
.ends
