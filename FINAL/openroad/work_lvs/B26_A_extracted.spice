* NGSPICE file created from B26_A.ext - technology: gf180mcuD

.subckt B26_A S1N S1P S2N S2P S3N S3P S4N S4P VDD VSS X XN_IN XN_OUT XP_IN XP_OUT
+ Y YN_IN YN_OUT YP_IN YP_OUT Z ZN_IN ZN_OUT ZP_IN ZP_OUT
X0 a_32310_183333# a_32610_183333# a_34234_179909# VSS nfet_06v0 ad=0.44p pd=2.88u as=0.25p ps=1.5u w=1u l=1u
X1 a_49406_174825# a_32310_174709# VDD VDD pfet_06v0 ad=2.5p pd=10.5u as=4.4p ps=20.88u w=10u l=1u
X2 a_57946_150492# a_58210_141690# VSS VSS nfet_06v0 ad=0.825p pd=3.16u as=1.1p ps=5.88u w=2.5u l=1u
X3 VSS a_49734_171355# a_118422_171272# VSS nfet_06v0 ad=0.44p pd=2.88u as=0.25p ps=1.5u w=1u l=1u
X4 a_63442_136492# a_55010_136492# a_63642_136608# VDD pfet_06v0 ad=3.3p pd=10.66u as=2.5p ps=10.5u w=10u l=1u
X5 a_82638_141690# a_77298_148476# a_87374_148592# VDD pfet_06v0 ad=4.4p pd=20.88u as=2.5p ps=10.5u w=10u l=1u
X6 a_82866_171285# a_37774_171239# a_85342_171355# VSS nfet_06v0 ad=2.2p pd=10.88u as=1.3p ps=5.52u w=5u l=1u
X7 VDD a_12580_76961# a_12580_76961# VDD pfet_06v0 ad=0.88p pd=4.88u as=0.52p ps=2.52u w=2u l=1u
X8 a_58758_136608# a_60350_129706# a_58210_129706# VSS nfet_06v0 ad=0.88p pd=4.88u as=0.88p ps=4.88u w=2u l=1u
X9 a_56274_171285# a_56074_171241# VSS VSS nfet_06v0 ad=1.25p pd=5.5u as=2.2p ps=10.88u w=5u l=1u
X10 a_35546_126524# a_35810_117722# VSS VSS nfet_06v0 ad=0.825p pd=3.16u as=1.1p ps=5.88u w=2.5u l=1u
X11 a_47762_165973# a_32610_165973# a_47962_166089# VDD pfet_06v0 ad=3.3p pd=10.66u as=2.5p ps=10.5u w=10u l=1u
X12 a_81522_153925# a_78866_157349# VSS VSS nfet_06v0 ad=0.25p pd=1.5u as=0.44p ps=2.88u w=1u l=1u
X13 a_82866_179909# a_60846_179863# a_84230_179979# VSS nfet_06v0 ad=2.2p pd=10.88u as=1.3p ps=5.52u w=5u l=1u
X14 a_39086_171355# a_38886_171239# a_36610_171285# VSS nfet_06v0 ad=1.3p pd=5.52u as=2.2p ps=10.88u w=5u l=1u
X15 a_102120_154036# a_102120_154036# a_104384_154152# VSS nfet_06v0 ad=0.308p pd=2.28u as=0.175p ps=1.2u w=0.7u l=1u
X16 a_57134_126514# a_34334_141690# a_55210_124624# VDD pfet_06v0 ad=0.242p pd=1.98u as=0.242p ps=1.98u w=0.55u l=1u
X17 VDD a_78566_165973# a_83558_166089# VDD pfet_06v0 ad=4.4p pd=20.88u as=2.5p ps=10.5u w=10u l=1u
X18 a_78526_171241# a_78866_174709# a_78766_174825# VDD pfet_06v0 ad=4.4p pd=20.88u as=2.5p ps=10.5u w=10u l=1u
X19 a_105128_154152# a_102120_154036# VSS VSS nfet_06v0 ad=0.5456p pd=3.36u as=0.5456p ps=3.36u w=1.24u l=1u
X20 VSS VDD VSS VSS nfet_06v0 ad=4.29p pd=20.38u as=1.23306n ps=6.04388m w=9.75u l=2u
X21 a_85342_162619# a_78866_165973# a_86902_167019# VDD pfet_06v0 ad=2.2p pd=10.88u as=1.3p ps=5.52u w=5u l=1u
X22 a_37974_179979# a_37774_179863# a_36610_179909# VSS nfet_06v0 ad=1.3p pd=5.52u as=2.2p ps=10.88u w=5u l=1u
X23 a_37774_171239# a_77872_134212# VDD VDD pfet_06v0 ad=0.44p pd=2.88u as=0.44p ps=2.88u w=1u l=1u
X24 a_57946_126524# a_58210_117722# VSS VSS nfet_06v0 ad=0.825p pd=3.16u as=1.1p ps=5.88u w=2.5u l=1u
X25 a_105404_166436# a_12580_136433# VSS VSS nfet_05v0 ad=0.5808p pd=3.52u as=0.5808p ps=3.52u w=1.32u l=0.6u
D0 a_12580_196913# VDD diode_pd2nw_06v0 pj=40u area=99.99999p
X26 a_77872_135562# a_93290_135112# VSS ppolyf_u_1k r_width=1u r_length=76.45u
X27 a_61046_171355# a_63718_175755# VDD VDD pfet_06v0 ad=1.3p pd=5.52u as=2.2p ps=10.88u w=5u l=1u
X28 a_36970_157465# a_32610_157349# a_36670_157465# VDD pfet_06v0 ad=3.3p pd=10.66u as=2.5p ps=10.5u w=10u l=1u
X29 a_64834_158395# a_68734_153881# a_64382_153995# VSS nfet_06v0 ad=1.1p pd=5.88u as=1.1p ps=5.88u w=2.5u l=1u
X30 a_95990_162619# a_87566_162619# VSS VSS nfet_06v0 ad=1.3p pd=5.52u as=2.2p ps=10.88u w=5u l=1u
X31 a_68734_162505# a_55682_165973# a_72478_166089# VDD pfet_06v0 ad=4.4p pd=20.88u as=2.5p ps=10.5u w=10u l=1u
X32 a_88174_141734# a_76958_141690# VSS VSS nfet_06v0 ad=1.25p pd=5.5u as=2.2p ps=10.88u w=5u l=1u
X33 a_99698_148476# a_99698_148476# a_112638_141734# VSS nfet_06v0 ad=0.44p pd=2.88u as=0.25p ps=1.5u w=1u l=1u
X34 a_62602_166019# a_55342_162505# a_63270_162619# VSS nfet_06v0 ad=1.1p pd=5.88u as=0.65p ps=3.02u w=2.5u l=1u
X35 a_12580_76961# a_12580_76961# VDD VDD pfet_06v0 ad=0.52p pd=2.52u as=0.52p ps=2.52u w=2u l=1u
X36 a_36358_148592# a_37950_141690# a_35810_141690# VSS nfet_06v0 ad=0.88p pd=4.88u as=0.88p ps=4.88u w=2u l=1u
X37 VDD a_40646_175755# a_39086_171355# VDD pfet_06v0 ad=1.3p pd=5.52u as=1.3p ps=5.52u w=5u l=1u
X38 a_79954_141734# a_12580_56801# a_77458_141734# VSS nfet_06v0 ad=3.74p pd=17.88u as=3.74p ps=17.88u w=8.5u l=1u
D1 a_12580_76961# VDD diode_pd2nw_06v0 pj=40u area=99.99999p
X39 VSS VDD VSS VSS nfet_06v0 ad=4.29p pd=20.38u as=0 ps=0 w=9.75u l=2u
X40 a_33002_179865# a_32610_183333# a_33622_183449# VDD pfet_06v0 ad=4.4p pd=20.88u as=2.5p ps=10.5u w=10u l=1u
X41 a_114134_148592# a_99398_148476# VDD VDD pfet_06v0 ad=2.5p pd=10.5u as=4.4p ps=20.88u w=10u l=1u
X42 a_37418_141734# a_39406_149676# a_33184_146196# VDD pfet_06v0 ad=1.76p pd=8.88u as=1.76p ps=8.88u w=4u l=1u
D2 VSS a_12580_136433# diode_nd2ps_06v0 pj=40u area=99.99999p
X43 a_100710_148592# a_99398_148476# VDD VDD pfet_06v0 ad=2.5p pd=10.5u as=4.4p ps=20.88u w=10u l=1u
X44 a_35546_150492# a_35066_141690# a_32810_148592# VDD pfet_06v0 ad=0.22p pd=1.88u as=0.22p ps=1.88u w=0.5u l=1u
X45 a_111606_129750# a_99698_136492# VSS VSS nfet_06v0 ad=0.25p pd=1.5u as=0.44p ps=2.88u w=1u l=1u
X46 a_88174_117766# a_76958_117722# VSS VSS nfet_06v0 ad=1.25p pd=5.5u as=2.2p ps=10.88u w=5u l=1u
X47 a_99698_124508# a_99698_124508# a_112638_117766# VSS nfet_06v0 ad=0.44p pd=2.88u as=0.25p ps=1.5u w=1u l=1u
X48 a_84094_137692# a_77258_129706# a_84302_129750# VSS nfet_06v0 ad=2.2p pd=10.88u as=1.25p ps=5.5u w=5u l=1u
X49 a_100272_134212# a_99698_136492# a_101622_129750# VDD pfet_06v0 ad=4.4p pd=20.88u as=4.4p ps=20.88u w=10u l=1u
X50 a_36358_124624# a_37950_117722# a_35810_117722# VSS nfet_06v0 ad=0.88p pd=4.88u as=0.88p ps=4.88u w=2u l=1u
X51 a_104506_129750# a_99658_129706# a_101822_138498# VSS nfet_06v0 ad=1.1p pd=5.88u as=0.825p ps=3.16u w=2.5u l=1u
X52 a_32510_166089# a_32310_165973# VDD VDD pfet_06v0 ad=2.5p pd=10.5u as=4.4p ps=20.88u w=10u l=1u
X53 VSS a_40198_162619# a_38414_166019# VSS nfet_06v0 ad=1.1p pd=5.88u as=0.65p ps=3.02u w=2.5u l=1u
X54 a_79954_117766# a_31060_204977# a_77458_117766# VSS nfet_06v0 ad=3.74p pd=17.88u as=3.74p ps=17.88u w=8.5u l=1u
X55 a_84230_153995# a_78866_157349# a_88018_158395# VDD pfet_06v0 ad=2.2p pd=10.88u as=1.3p ps=5.52u w=5u l=1u
X56 VSS a_40198_171355# a_39530_174755# VSS nfet_06v0 ad=0.65p pd=3.02u as=0.65p ps=3.02u w=2.5u l=1u
X57 VDD VSS VDD VDD pfet_06v0 ad=4.29p pd=20.38u as=1.86749n ps=8.9035m w=9.75u l=2u
X58 a_55584_123578# a_71002_123128# VSS ppolyf_u_1k r_width=1u r_length=76.45u
X59 a_80498_129706# a_84094_137692# a_81046_136608# VDD pfet_06v0 ad=1.76p pd=8.88u as=1.76p ps=8.88u w=4u l=1u
X60 a_102898_129706# a_99658_129706# a_102634_138508# VSS nfet_06v0 ad=1.1p pd=5.88u as=0.825p ps=3.16u w=2.5u l=1u
X61 a_54710_124508# a_55010_124508# a_72482_124624# VDD pfet_06v0 ad=4.4p pd=20.88u as=2.5p ps=10.5u w=10u l=1u
X62 VSS VDD VSS VSS nfet_06v0 ad=4.29p pd=20.38u as=0 ps=0 w=9.75u l=2u
X63 a_48170_179865# a_32270_179865# a_48370_179909# VSS nfet_06v0 ad=1.65p pd=5.66u as=1.25p ps=5.5u w=5u l=1u
X64 a_38414_183379# a_32270_179865# a_41310_179979# VSS nfet_06v0 ad=1.1p pd=5.88u as=0.65p ps=3.02u w=2.5u l=1u
X65 a_58338_153925# a_55682_157349# VSS VSS nfet_06v0 ad=0.25p pd=1.5u as=0.44p ps=2.88u w=1u l=1u
X66 a_60846_171239# a_100272_134212# VDD VDD pfet_06v0 ad=0.44p pd=2.88u as=0.44p ps=2.88u w=1u l=1u
X67 a_85786_157395# a_86454_153995# VSS VSS nfet_06v0 ad=0.65p pd=3.02u as=0.65p ps=3.02u w=2.5u l=1u
X68 a_60374_166089# a_55682_165973# a_60042_166089# VDD pfet_06v0 ad=2.5p pd=10.5u as=3.3p ps=10.66u w=10u l=1u
X69 a_55582_174825# a_55382_174709# VDD VDD pfet_06v0 ad=2.5p pd=10.5u as=4.4p ps=20.88u w=10u l=1u
X70 a_41042_148476# a_32610_148476# a_41242_148592# VDD pfet_06v0 ad=3.3p pd=10.66u as=2.5p ps=10.5u w=10u l=1u
X71 VSS VDD VSS VSS nfet_06v0 ad=0.44p pd=2.88u as=0 ps=0 w=1u l=2u
X72 a_62158_171355# a_63718_175755# VDD VDD pfet_06v0 ad=1.3p pd=5.52u as=1.3p ps=5.52u w=5u l=1u
X73 a_85342_171355# a_37774_171239# a_82866_171285# VSS nfet_06v0 ad=1.3p pd=5.52u as=2.2p ps=10.88u w=5u l=1u
X74 a_79458_171285# a_79258_171241# VSS VSS nfet_06v0 ad=1.25p pd=5.5u as=2.2p ps=10.88u w=5u l=1u
D3 VSS a_34334_141690# diode_nd2ps_06v0 pj=40u area=99.99999p
X75 a_49734_179979# a_41762_184379# VDD VDD pfet_06v0 ad=4.4p pd=20.88u as=2.6p ps=10.52u w=10u l=1u
X76 VSS VDD VSS VSS nfet_06v0 ad=0.44p pd=2.88u as=0 ps=0 w=1u l=2u
X77 a_84670_157395# a_78526_153881# a_87566_153995# VSS nfet_06v0 ad=1.1p pd=5.88u as=0.65p ps=3.02u w=2.5u l=1u
X78 a_38886_171239# a_34534_141734# cap_mim_2f0_m4m5_noshield c_width=25u c_length=8u
X79 a_70834_157349# a_55682_157349# a_71034_157465# VDD pfet_06v0 ad=3.3p pd=10.66u as=2.5p ps=10.5u w=10u l=1u
X80 a_84230_179979# a_60846_179863# a_82866_179909# VSS nfet_06v0 ad=1.3p pd=5.52u as=2.2p ps=10.88u w=5u l=1u
X81 a_37974_171355# a_32610_174709# a_41762_175755# VDD pfet_06v0 ad=2.2p pd=10.88u as=1.3p ps=5.52u w=5u l=1u
X82 YP_OUT YN_OUT VDD VDD pfet_05v0 ad=0.8052p pd=4.54u as=0.8052p ps=4.54u w=1.83u l=0.5u
X83 a_37774_179863# a_55584_146196# VDD VDD pfet_06v0 ad=0.44p pd=2.88u as=0.44p ps=2.88u w=1u l=1u
X84 a_49734_171355# a_37974_171355# cap_mim_2f0_m4m5_noshield c_width=20u c_length=10u
X85 a_57666_117766# a_58758_124624# VDD VDD pfet_06v0 ad=2.2p pd=10.88u as=2.2p ps=10.88u w=5u l=1u
X86 a_62158_171355# a_55682_174709# a_63718_175755# VDD pfet_06v0 ad=2.2p pd=10.88u as=1.3p ps=5.52u w=5u l=1u
X87 a_106494_137692# a_106494_137692# a_108130_136492# VDD pfet_06v0 ad=4.4p pd=20.88u as=3.3p ps=10.66u w=10u l=1u
X88 a_92382_175709# a_92382_175709# a_94018_174709# VDD pfet_06v0 ad=4.4p pd=20.88u as=3.3p ps=10.66u w=10u l=1u
D4 VSS a_12580_136433# diode_nd2ps_06v0 pj=40u area=99.99999p
X89 VDD VSS VDD VDD pfet_06v0 ad=0.44p pd=2.88u as=0 ps=0 w=1u l=2u
X90 a_85786_166019# a_78526_162505# a_86454_162619# VSS nfet_06v0 ad=1.1p pd=5.88u as=0.65p ps=3.02u w=2.5u l=1u
X91 a_78866_183333# a_78866_183333# a_81522_179909# VSS nfet_06v0 ad=0.44p pd=2.88u as=0.25p ps=1.5u w=1u l=1u
X92 a_77872_135562# a_37774_171239# VSS ppolyf_u_1k r_width=1u r_length=76.45u
X93 a_115246_148592# a_99398_148476# VDD VDD pfet_06v0 ad=2.5p pd=10.5u as=4.4p ps=20.88u w=10u l=1u
X94 a_69198_158349# a_55342_153881# a_70398_153925# VSS nfet_06v0 ad=2.2p pd=10.88u as=1.25p ps=5.5u w=5u l=1u
X95 a_63270_162619# a_55342_162505# a_62602_166019# VSS nfet_06v0 ad=0.65p pd=3.02u as=1.1p ps=5.88u w=2.5u l=1u
X96 VDD a_12580_76961# a_12580_76961# VDD pfet_06v0 ad=0.52p pd=2.52u as=0.52p ps=2.52u w=2u l=1u
X97 a_40198_162619# a_32270_162505# a_39530_166019# VSS nfet_06v0 ad=0.65p pd=3.02u as=1.1p ps=5.88u w=2.5u l=1u
X98 a_85342_153995# a_78866_157349# a_86902_158395# VDD pfet_06v0 ad=2.2p pd=10.88u as=1.3p ps=5.52u w=5u l=1u
X99 a_91734_124624# a_76998_124508# VDD VDD pfet_06v0 ad=2.5p pd=10.5u as=4.4p ps=20.88u w=10u l=1u
X100 a_35810_117722# a_39406_125708# a_36358_124624# VDD pfet_06v0 ad=1.76p pd=8.88u as=1.76p ps=8.88u w=4u l=1u
X101 a_37774_162503# a_100272_122228# VDD VDD pfet_06v0 ad=0.44p pd=2.88u as=0.44p ps=2.88u w=1u l=1u
X102 a_40646_167019# a_45662_162505# a_40198_162619# VSS nfet_06v0 ad=1.1p pd=5.88u as=1.1p ps=5.88u w=2.5u l=1u
X103 a_95990_153995# a_87566_153995# VSS VSS nfet_06v0 ad=1.3p pd=5.52u as=2.2p ps=10.88u w=5u l=1u
X104 VSS a_86454_162619# a_84670_166019# VSS nfet_06v0 ad=1.1p pd=5.88u as=0.65p ps=3.02u w=2.5u l=1u
X105 a_62602_157395# a_55342_153881# a_63270_153995# VSS nfet_06v0 ad=1.1p pd=5.88u as=0.65p ps=3.02u w=2.5u l=1u
X106 VSS VDD VSS VSS nfet_06v0 ad=0.44p pd=2.88u as=0 ps=0 w=1u l=2u
X107 VDD VSS VDD VDD pfet_06v0 ad=4.29p pd=20.38u as=0 ps=0 w=9.75u l=2u
X108 a_82566_162549# a_79258_162505# VSS VSS nfet_06v0 ad=1.25p pd=5.5u as=2.2p ps=10.88u w=5u l=1u
D5 VSS a_35066_117722# diode_nd2ps_06v0 pj=40u area=99.99999p
X109 a_82638_129706# a_82638_129706# a_85146_129706# VSS nfet_06v0 ad=2.2p pd=10.88u as=1.65p ps=5.66u w=5u l=1u
X110 VDD VSS VDD VDD pfet_06v0 ad=4.29p pd=20.38u as=0 ps=0 w=9.75u l=2u
X111 a_38414_166019# a_40198_162619# VSS VSS nfet_06v0 ad=0.65p pd=3.02u as=0.65p ps=3.02u w=2.5u l=1u
X112 a_84670_183379# a_95990_179979# cap_mim_2f0_m4m5_noshield c_width=20u c_length=10u
X113 a_39530_174755# a_40198_171355# VSS VSS nfet_06v0 ad=0.65p pd=3.02u as=1.1p ps=5.88u w=2.5u l=1u
X114 a_78866_165973# a_78866_165973# VDD VDD pfet_06v0 ad=0.88p pd=4.88u as=0.88p ps=4.88u w=2u l=1u
X115 a_34234_179909# a_32610_183333# VSS VSS nfet_06v0 ad=0.25p pd=1.5u as=0.44p ps=2.88u w=1u l=1u
X116 a_77258_129706# a_77298_136492# a_91734_136608# VDD pfet_06v0 ad=4.4p pd=20.88u as=2.5p ps=10.5u w=10u l=1u
X117 a_118422_171272# a_72806_171355# a_117490_171228# VSS nfet_06v0 ad=0.25p pd=1.5u as=0.44p ps=2.88u w=1u l=1u
X118 a_68734_171241# a_68734_171241# a_71242_171241# VSS nfet_06v0 ad=2.2p pd=10.88u as=1.65p ps=5.66u w=5u l=1u
X119 a_63642_136608# a_63442_136492# VDD VDD pfet_06v0 ad=2.5p pd=10.5u as=4.4p ps=20.88u w=10u l=1u
X120 a_87374_148592# a_76998_148476# VDD VDD pfet_06v0 ad=2.5p pd=10.5u as=4.4p ps=20.88u w=10u l=1u
X121 VDD VSS VDD VDD pfet_06v0 ad=7.92p pd=36.88u as=0 ps=0 w=18u l=2u
X122 a_55584_123578# a_60846_153879# VSS ppolyf_u_1k r_width=1u r_length=76.45u
X123 a_102634_150492# a_35066_117722# a_99898_148592# VDD pfet_06v0 ad=0.22p pd=1.88u as=0.22p ps=1.88u w=0.5u l=1u
X124 VSS a_72806_153995# a_107258_172604# VSS nfet_06v0 ad=0.44p pd=2.88u as=0.33p ps=1.66u w=1u l=1u
X125 a_41310_179979# a_32270_179865# a_38414_183379# VSS nfet_06v0 ad=0.65p pd=3.02u as=1.1p ps=5.88u w=2.5u l=1u
X126 a_84670_166019# a_95990_162619# cap_mim_2f0_m4m5_noshield c_width=20u c_length=10u
X127 a_60846_171239# a_104506_129750# VSS VSS nfet_06v0 ad=0.44p pd=2.88u as=0.44p ps=2.88u w=1u l=1u
X128 a_104384_154152# a_102120_154036# a_104084_154152# VSS nfet_06v0 ad=0.175p pd=1.2u as=0.175p ps=1.2u w=0.7u l=1u
X129 VDD VSS VDD VDD pfet_06v0 ad=0.44p pd=2.88u as=0 ps=0 w=1u l=2u
X130 ZN_OUT a_105404_175060# VSS VSS nfet_05v0 ad=0.5808p pd=3.52u as=0.5808p ps=3.52u w=1.32u l=0.6u
X131 a_109102_155244# a_117490_171228# VDD VDD pfet_06v0 ad=1.32p pd=6.88u as=1.32p ps=6.88u w=3u l=1u
X132 VSS a_33002_179865# a_36942_179909# VSS nfet_06v0 ad=2.2p pd=10.88u as=1.25p ps=5.5u w=5u l=1u
X133 a_36970_183449# a_38886_179863# a_39530_183379# VDD pfet_06v0 ad=4.4p pd=20.88u as=2.6p ps=10.52u w=10u l=1u
X134 a_83558_166089# a_78866_165973# a_83226_166089# VDD pfet_06v0 ad=2.5p pd=10.5u as=3.3p ps=10.66u w=10u l=1u
X135 VSS a_40198_153995# a_38414_157395# VSS nfet_06v0 ad=1.1p pd=5.88u as=0.65p ps=3.02u w=2.5u l=1u
X136 VSS a_95990_153995# a_115582_153912# VSS nfet_06v0 ad=0.44p pd=2.88u as=0.25p ps=1.5u w=1u l=1u
X137 a_78766_174825# a_78566_174709# VDD VDD pfet_06v0 ad=2.5p pd=10.5u as=4.4p ps=20.88u w=10u l=1u
D6 a_12580_56801# VDD diode_pd2nw_06v0 pj=40u area=99.99999p
X138 a_34734_126514# a_37774_153879# cap_mim_2f0_m4m5_noshield c_width=25u c_length=8u
X139 a_32610_174709# a_32610_174709# a_35266_171285# VSS nfet_06v0 ad=0.44p pd=2.88u as=0.25p ps=1.5u w=1u l=1u
X140 a_32310_165973# a_32610_165973# a_34234_162549# VSS nfet_06v0 ad=0.44p pd=2.88u as=0.25p ps=1.5u w=1u l=1u
X141 a_61046_162619# a_42022_129750# a_59682_162549# VSS nfet_06v0 ad=1.3p pd=5.52u as=2.2p ps=10.88u w=5u l=1u
X142 a_72806_171355# a_64382_171355# VSS VSS nfet_06v0 ad=1.3p pd=5.52u as=2.2p ps=10.88u w=5u l=1u
X143 VDD a_63718_175755# a_62158_171355# VDD pfet_06v0 ad=1.3p pd=5.52u as=1.3p ps=5.52u w=5u l=1u
X144 a_94018_157349# a_78866_157349# a_94218_157465# VDD pfet_06v0 ad=3.3p pd=10.66u as=2.5p ps=10.5u w=10u l=1u
X145 a_36670_157465# a_32310_157349# VDD VDD pfet_06v0 ad=2.5p pd=10.5u as=4.4p ps=20.88u w=10u l=1u
X146 VDD VSS VDD VDD pfet_06v0 ad=4.29p pd=20.38u as=0 ps=0 w=9.75u l=2u
X147 VDD VSS VDD VDD pfet_06v0 ad=0.44p pd=2.88u as=0 ps=0 w=1u l=2u
X148 a_107170_172720# a_107258_172604# a_12580_76961# VSS nfet_06v0 ad=1.0912p pd=5.84u as=0.6448p ps=3u w=2.48u l=1u
D7 VSS a_12580_136433# diode_nd2ps_06v0 pj=40u area=99.99999p
D8 a_35066_117722# VDD diode_pd2nw_06v0 pj=40u area=99.99999p
X149 VDD a_41762_184379# a_49734_179979# VDD pfet_06v0 ad=2.6p pd=10.52u as=2.6p ps=10.52u w=10u l=1u
X150 a_82106_117766# a_84094_125708# a_77872_122228# VDD pfet_06v0 ad=1.76p pd=8.88u as=1.76p ps=8.88u w=4u l=1u
X151 a_72478_166089# a_55382_165973# VDD VDD pfet_06v0 ad=2.5p pd=10.5u as=4.4p ps=20.88u w=10u l=1u
X152 a_55682_183333# a_55682_183333# a_58338_179909# VSS nfet_06v0 ad=0.44p pd=2.88u as=0.25p ps=1.5u w=1u l=1u
X153 a_112638_141734# a_99698_148476# VSS VSS nfet_06v0 ad=0.25p pd=1.5u as=0.44p ps=2.88u w=1u l=1u
X154 VDD a_32310_183333# a_37302_183449# VDD pfet_06v0 ad=4.4p pd=20.88u as=2.5p ps=10.5u w=10u l=1u
X155 a_102320_171512# a_109102_172604# a_12580_76961# VSS nfet_06v0 ad=1.0912p pd=5.84u as=0.6448p ps=3u w=2.48u l=1u
X156 a_41762_175755# a_32610_174709# a_37974_171355# VDD pfet_06v0 ad=1.3p pd=5.52u as=2.2p ps=10.88u w=5u l=1u
X157 a_49734_162619# a_41762_167019# VDD VDD pfet_06v0 ad=2.6p pd=10.52u as=4.4p ps=20.88u w=10u l=1u
X158 a_105404_166436# a_12580_136433# VDD VDD pfet_05v0 ad=0.8052p pd=4.54u as=0.8052p ps=4.54u w=1.83u l=0.5u
X159 a_102070_172720# a_102158_172604# a_12580_76961# VSS nfet_06v0 ad=1.0912p pd=5.84u as=0.6448p ps=3u w=2.48u l=1u
X160 VDD VSS VDD VDD pfet_06v0 ad=7.92p pd=36.88u as=0 ps=0 w=18u l=2u
X161 VSS a_79258_171241# a_83198_171285# VSS nfet_06v0 ad=2.2p pd=10.88u as=1.25p ps=5.5u w=5u l=1u
X162 a_33622_183449# a_32310_183333# VDD VDD pfet_06v0 ad=2.5p pd=10.5u as=4.4p ps=20.88u w=10u l=1u
X163 a_60042_166089# a_42022_129750# a_61486_166019# VDD pfet_06v0 ad=4.4p pd=20.88u as=2.6p ps=10.52u w=10u l=1u
X164 a_77872_147546# a_93290_147096# VSS ppolyf_u_1k r_width=1u r_length=76.45u
X165 a_103270_172604# a_95990_162619# VSS VSS nfet_06v0 ad=0.33p pd=1.66u as=0.44p ps=2.88u w=1u l=1u
X166 a_86454_162619# a_78526_162505# a_85786_166019# VSS nfet_06v0 ad=0.65p pd=3.02u as=1.1p ps=5.88u w=2.5u l=1u
X167 a_112638_117766# a_99698_124508# VSS VSS nfet_06v0 ad=0.25p pd=1.5u as=0.44p ps=2.88u w=1u l=1u
X168 a_45662_179865# a_45662_179865# a_48170_179865# VSS nfet_06v0 ad=2.2p pd=10.88u as=1.65p ps=5.66u w=5u l=1u
X169 a_84302_129750# a_76958_129706# VSS VSS nfet_06v0 ad=1.25p pd=5.5u as=2.2p ps=10.88u w=5u l=1u
X170 a_77498_148592# a_77298_148476# a_78310_148592# VDD pfet_06v0 ad=4.4p pd=20.88u as=2.5p ps=10.5u w=10u l=1u
X171 a_76998_136492# a_77298_136492# a_89206_129750# VSS nfet_06v0 ad=0.44p pd=2.88u as=0.25p ps=1.5u w=1u l=1u
X172 a_72806_162619# a_64834_167019# VDD VDD pfet_06v0 ad=4.4p pd=20.88u as=2.6p ps=10.52u w=10u l=1u
X173 a_83198_179909# a_78526_179865# a_82866_179909# VSS nfet_06v0 ad=1.25p pd=5.5u as=1.65p ps=5.66u w=5u l=1u
X174 a_12580_76961# a_12580_76961# VDD VDD pfet_06v0 ad=0.52p pd=2.52u as=0.88p ps=4.88u w=2u l=1u
X175 a_83226_166089# a_37774_162503# a_85786_166019# VDD pfet_06v0 ad=4.4p pd=20.88u as=2.6p ps=10.52u w=10u l=1u
X176 a_72482_124624# a_54710_124508# VDD VDD pfet_06v0 ad=2.5p pd=10.5u as=4.4p ps=20.88u w=10u l=1u
X177 a_48370_179909# a_48170_179865# VSS VSS nfet_06v0 ad=1.25p pd=5.5u as=2.2p ps=10.88u w=5u l=1u
X178 VDD VSS VDD VDD pfet_06v0 ad=7.92p pd=36.88u as=0 ps=0 w=18u l=2u
X179 a_85786_157395# a_78526_153881# a_86454_153995# VSS nfet_06v0 ad=1.1p pd=5.88u as=0.65p ps=3.02u w=2.5u l=1u
X180 a_77872_146646# a_93290_147096# VSS ppolyf_u_1k r_width=1u r_length=76.45u
X181 a_88018_184379# a_91918_179865# a_87566_179979# VSS nfet_06v0 ad=1.1p pd=5.88u as=1.1p ps=5.88u w=2.5u l=1u
X182 a_62014_141734# a_54670_141690# VSS VSS nfet_06v0 ad=1.25p pd=5.5u as=2.2p ps=10.88u w=5u l=1u
X183 a_47962_183449# a_47762_183333# VDD VDD pfet_06v0 ad=2.5p pd=10.5u as=4.4p ps=20.88u w=10u l=1u
X184 a_63270_153995# a_55342_153881# a_62602_157395# VSS nfet_06v0 ad=0.65p pd=3.02u as=1.1p ps=5.88u w=2.5u l=1u
X185 a_32310_174709# a_32610_174709# a_35546_174825# VDD pfet_06v0 ad=4.4p pd=20.88u as=2.5p ps=10.5u w=10u l=1u
X186 VDD a_72806_162619# a_117490_162492# VDD pfet_06v0 ad=1.32p pd=6.88u as=0.99p ps=3.66u w=3u l=1u
X187 VDD VSS VDD VDD pfet_06v0 ad=4.29p pd=20.38u as=0 ps=0 w=9.75u l=2u
X188 a_36970_183449# a_37774_179863# a_38414_183379# VDD pfet_06v0 ad=4.4p pd=20.88u as=2.6p ps=10.52u w=10u l=1u
X189 a_34734_150482# a_35810_141690# VSS VSS nfet_06v0 ad=0.825p pd=3.16u as=1.1p ps=5.88u w=2.5u l=1u
X190 a_40198_153995# a_32270_153881# a_39530_157395# VSS nfet_06v0 ad=0.65p pd=3.02u as=1.1p ps=5.88u w=2.5u l=1u
X191 VDD a_40646_184379# a_37974_179979# VDD pfet_06v0 ad=2.2p pd=10.88u as=1.3p ps=5.52u w=5u l=1u
X192 VDD VSS VDD VDD pfet_06v0 ad=7.92p pd=36.88u as=0 ps=0 w=18u l=2u
X193 a_60042_174825# a_55682_174709# a_59742_174825# VDD pfet_06v0 ad=3.3p pd=10.66u as=2.5p ps=10.5u w=10u l=1u
X194 a_86454_179979# a_92382_184333# a_86902_184379# VDD pfet_06v0 ad=2.2p pd=10.88u as=2.2p ps=10.88u w=5u l=1u
X195 a_41242_148592# a_41042_148476# VDD VDD pfet_06v0 ad=2.5p pd=10.5u as=4.4p ps=20.88u w=10u l=1u
D9 a_34334_117722# VDD diode_pd2nw_06v0 pj=40u area=99.99999p
D10 a_12580_36641# VDD diode_pd2nw_06v0 pj=40u area=99.99999p
X196 a_48170_162505# a_32270_162505# a_48370_162549# VSS nfet_06v0 ad=1.65p pd=5.66u as=1.25p ps=5.5u w=5u l=1u
X197 a_54710_136492# a_55010_136492# a_72482_136608# VDD pfet_06v0 ad=4.4p pd=20.88u as=2.5p ps=10.5u w=10u l=1u
X198 a_57134_150482# a_58210_141690# VSS VSS nfet_06v0 ad=0.825p pd=3.16u as=1.1p ps=5.88u w=2.5u l=1u
X199 VSS a_86454_153995# a_84670_157395# VSS nfet_06v0 ad=1.1p pd=5.88u as=0.65p ps=3.02u w=2.5u l=1u
X200 a_32270_153881# a_32270_153881# VSS VSS nfet_06v0 ad=0.44p pd=2.88u as=0.44p ps=2.88u w=1u l=1u
X201 a_62014_117766# a_54670_117722# VSS VSS nfet_06v0 ad=1.25p pd=5.5u as=2.2p ps=10.88u w=5u l=1u
X202 a_107170_172720# a_102120_171396# VSS VSS nfet_06v0 ad=0.5456p pd=3.36u as=0.5456p ps=3.36u w=1.24u l=1u
X203 a_57134_138498# a_38886_162503# cap_mim_2f0_m4m5_noshield c_width=25u c_length=8u
X204 a_54670_141690# a_55010_148476# a_70558_148592# VDD pfet_06v0 ad=4.4p pd=20.88u as=2.5p ps=10.5u w=10u l=1u
X205 a_40646_175755# a_32610_174709# a_39086_171355# VDD pfet_06v0 ad=1.3p pd=5.52u as=2.2p ps=10.88u w=5u l=1u
X206 a_60042_174825# a_38886_171239# a_62602_174755# VDD pfet_06v0 ad=4.4p pd=20.88u as=2.6p ps=10.52u w=10u l=1u
X207 a_34734_126514# a_35810_117722# VSS VSS nfet_06v0 ad=0.825p pd=3.16u as=1.1p ps=5.88u w=2.5u l=1u
X208 a_39530_183379# a_38886_179863# a_36970_183449# VDD pfet_06v0 ad=2.6p pd=10.52u as=4.4p ps=20.88u w=10u l=1u
X209 a_38414_157395# a_40198_153995# VSS VSS nfet_06v0 ad=0.65p pd=3.02u as=0.65p ps=3.02u w=2.5u l=1u
D11 a_35066_117722# VDD diode_pd2nw_06v0 pj=40u area=99.99999p
X210 VSS a_117490_162492# a_103270_155244# VSS nfet_06v0 ad=0.44p pd=2.88u as=0.44p ps=2.88u w=1u l=1u
X211 VDD a_86902_175755# a_85342_171355# VDD pfet_06v0 ad=1.3p pd=5.52u as=1.3p ps=5.52u w=5u l=1u
X212 a_34534_117766# a_36358_124624# VDD VDD pfet_06v0 ad=2.2p pd=10.88u as=2.2p ps=10.88u w=5u l=1u
X213 a_56074_153881# a_55682_157349# a_56694_157465# VDD pfet_06v0 ad=4.4p pd=20.88u as=2.5p ps=10.5u w=10u l=1u
X214 a_57134_126514# a_58210_117722# VSS VSS nfet_06v0 ad=0.825p pd=3.16u as=1.1p ps=5.88u w=2.5u l=1u
X215 a_81522_179909# a_78866_183333# VSS VSS nfet_06v0 ad=0.25p pd=1.5u as=0.44p ps=2.88u w=1u l=1u
X216 a_70398_153925# a_56074_153881# VSS VSS nfet_06v0 ad=1.25p pd=5.5u as=2.2p ps=10.88u w=5u l=1u
X217 a_37950_117722# a_32610_124508# a_42686_124624# VDD pfet_06v0 ad=4.4p pd=20.88u as=2.5p ps=10.5u w=10u l=1u
X218 a_12580_76961# a_109102_172604# a_102320_171512# VSS nfet_06v0 ad=0.6448p pd=3u as=1.0912p ps=5.84u w=2.48u l=1u
X219 a_99698_124508# a_99698_124508# VDD VDD pfet_06v0 ad=0.88p pd=4.88u as=0.88p ps=4.88u w=2u l=1u
X220 a_86902_175755# a_78866_174709# a_85342_171355# VDD pfet_06v0 ad=1.3p pd=5.52u as=2.2p ps=10.88u w=5u l=1u
X221 a_41762_175755# a_45662_171241# a_41310_171355# VSS nfet_06v0 ad=1.1p pd=5.88u as=1.1p ps=5.88u w=2.5u l=1u
X222 a_45662_179865# a_32610_183333# a_49406_183449# VDD pfet_06v0 ad=4.4p pd=20.88u as=2.5p ps=10.5u w=10u l=1u
X223 a_57666_129750# a_58758_136608# VDD VDD pfet_06v0 ad=2.2p pd=10.88u as=2.2p ps=10.88u w=5u l=1u
X224 a_83226_166089# a_42022_129750# a_84670_166019# VDD pfet_06v0 ad=4.4p pd=20.88u as=2.6p ps=10.52u w=10u l=1u
X225 a_61046_153995# a_60846_153879# a_59682_153925# VSS nfet_06v0 ad=1.3p pd=5.52u as=2.2p ps=10.88u w=5u l=1u
D12 VSS a_12580_76961# diode_nd2ps_06v0 pj=40u area=99.99999p
X226 VDD a_86902_167019# a_84230_162619# VDD pfet_06v0 ad=2.2p pd=10.88u as=1.3p ps=5.52u w=5u l=1u
X227 a_60350_117722# a_55010_124508# a_65086_124624# VDD pfet_06v0 ad=4.4p pd=20.88u as=2.5p ps=10.5u w=10u l=1u
X228 a_64834_184379# a_68734_179865# a_64382_179979# VSS nfet_06v0 ad=1.1p pd=5.88u as=1.1p ps=5.88u w=2.5u l=1u
X229 a_55584_146196# a_60350_141690# a_59818_141734# VSS nfet_06v0 ad=0.88p pd=4.88u as=0.88p ps=4.88u w=2u l=1u
X230 a_87566_153995# a_92382_158349# a_88018_158395# VDD pfet_06v0 ad=2.2p pd=10.88u as=2.2p ps=10.88u w=5u l=1u
X231 a_77872_122228# a_93290_122228# VSS ppolyf_u_1k r_width=1u r_length=76.45u
X232 a_78866_165973# a_78866_165973# a_81522_162549# VSS nfet_06v0 ad=0.44p pd=2.88u as=0.25p ps=1.5u w=1u l=1u
X233 a_116938_172684# a_95990_171355# a_109102_172604# VDD pfet_06v0 ad=0.75p pd=3.5u as=1.32p ps=6.88u w=3u l=1u
X234 a_49734_171355# a_41310_171355# VSS VSS nfet_06v0 ad=2.2p pd=10.88u as=1.3p ps=5.52u w=5u l=1u
X235 a_49734_153995# a_41762_158395# VDD VDD pfet_06v0 ad=2.6p pd=10.52u as=4.4p ps=20.88u w=10u l=1u
X236 a_31060_204977# S1N VDD ppolyf_u r_width=40u r_length=10u
X237 a_77298_136492# a_77298_136492# a_90238_129750# VSS nfet_06v0 ad=0.44p pd=2.88u as=0.25p ps=1.5u w=1u l=1u
X238 a_32570_129706# a_32570_129706# VSS VSS nfet_06v0 ad=0.44p pd=2.88u as=0.44p ps=2.88u w=1u l=1u
X239 a_55584_134662# a_71002_134212# VSS ppolyf_u_1k r_width=1u r_length=76.45u
X240 VDD a_64834_167019# a_72806_162619# VDD pfet_06v0 ad=2.6p pd=10.52u as=2.6p ps=10.52u w=10u l=1u
X241 a_86902_158395# a_91918_153881# a_86454_153995# VSS nfet_06v0 ad=1.1p pd=5.88u as=1.1p ps=5.88u w=2.5u l=1u
X242 a_91734_136608# a_76998_136492# VDD VDD pfet_06v0 ad=2.5p pd=10.5u as=4.4p ps=20.88u w=10u l=1u
X243 VDD a_86902_184379# a_84230_179979# VDD pfet_06v0 ad=1.3p pd=5.52u as=1.3p ps=5.52u w=5u l=1u
X244 a_34534_129750# a_34334_117722# a_32770_129750# VSS nfet_06v0 ad=3.3p pd=15.88u as=3.3p ps=15.88u w=7.5u l=1u
X245 a_63270_179979# a_69198_184333# a_63718_184379# VDD pfet_06v0 ad=2.2p pd=10.88u as=2.2p ps=10.88u w=5u l=1u
X246 a_77458_129750# a_77258_129706# a_77158_129750# VSS nfet_06v0 ad=2.2p pd=10.88u as=1.25p ps=5.5u w=5u l=1u
X247 a_60846_171239# a_100272_134212# VDD VDD pfet_06v0 ad=0.44p pd=2.88u as=0.44p ps=2.88u w=1u l=1u
X248 a_35810_129706# a_39406_137692# a_36358_136608# VDD pfet_06v0 ad=1.76p pd=8.88u as=1.76p ps=8.88u w=4u l=1u
X249 a_60042_157465# a_60846_153879# a_61486_157395# VDD pfet_06v0 ad=4.4p pd=20.88u as=2.6p ps=10.52u w=10u l=1u
X250 a_33184_147546# a_38886_171239# VSS ppolyf_u_1k r_width=1u r_length=76.45u
X251 a_86454_153995# a_78526_153881# a_85786_157395# VSS nfet_06v0 ad=0.65p pd=3.02u as=1.1p ps=5.88u w=2.5u l=1u
X252 a_55584_122228# a_60350_117722# a_59818_117766# VSS nfet_06v0 ad=0.88p pd=4.88u as=0.88p ps=4.88u w=2u l=1u
X253 a_38886_171239# a_33184_146196# VDD VDD pfet_06v0 ad=0.44p pd=2.88u as=0.44p ps=2.88u w=1u l=1u
X254 a_71034_174825# a_70834_174709# VDD VDD pfet_06v0 ad=2.5p pd=10.5u as=4.4p ps=20.88u w=10u l=1u
X255 a_84230_162619# a_86902_167019# VDD VDD pfet_06v0 ad=1.3p pd=5.52u as=2.2p ps=10.88u w=5u l=1u
X256 a_72806_153995# a_64834_158395# VDD VDD pfet_06v0 ad=4.4p pd=20.88u as=2.6p ps=10.52u w=10u l=1u
X257 a_35266_141734# a_36358_148592# VDD VDD pfet_06v0 ad=2.2p pd=10.88u as=2.2p ps=10.88u w=5u l=1u
X258 a_38414_183379# a_37774_179863# a_36970_183449# VDD pfet_06v0 ad=2.6p pd=10.52u as=4.4p ps=20.88u w=10u l=1u
X259 a_115582_153912# a_113830_153912# a_114650_153868# VSS nfet_06v0 ad=0.25p pd=1.5u as=0.44p ps=2.88u w=1u l=1u
X260 a_37974_179979# a_40646_184379# VDD VDD pfet_06v0 ad=1.3p pd=5.52u as=1.3p ps=5.52u w=5u l=1u
X261 a_102120_162772# a_102120_162772# VDD VDD pfet_06v0 ad=0.88p pd=4.88u as=0.88p ps=4.88u w=2u l=1u
X262 a_35266_171285# a_32610_174709# VSS VSS nfet_06v0 ad=0.25p pd=1.5u as=0.44p ps=2.88u w=1u l=1u
X263 a_99898_124624# a_99698_124508# a_99598_124624# VDD pfet_06v0 ad=4.4p pd=20.88u as=2.5p ps=10.5u w=10u l=1u
X264 a_83226_157465# a_37774_153879# a_85786_157395# VDD pfet_06v0 ad=4.4p pd=20.88u as=2.6p ps=10.52u w=10u l=1u
X265 a_34234_162549# a_32610_165973# VSS VSS nfet_06v0 ad=0.25p pd=1.5u as=0.44p ps=2.88u w=1u l=1u
X266 a_94218_157465# a_94018_157349# VDD VDD pfet_06v0 ad=2.5p pd=10.5u as=4.4p ps=20.88u w=10u l=1u
X267 a_71242_153881# a_55342_153881# a_71442_153925# VSS nfet_06v0 ad=1.65p pd=5.66u as=1.25p ps=5.5u w=5u l=1u
X268 a_37774_179863# a_55584_146196# VDD VDD pfet_06v0 ad=0.44p pd=2.88u as=0.44p ps=2.88u w=1u l=1u
X269 a_32310_148476# a_32610_148476# a_50082_148592# VDD pfet_06v0 ad=4.4p pd=20.88u as=2.5p ps=10.5u w=10u l=1u
X270 a_58338_179909# a_55682_183333# VSS VSS nfet_06v0 ad=0.25p pd=1.5u as=0.44p ps=2.88u w=1u l=1u
X271 a_85786_183379# a_86454_179979# VSS VSS nfet_06v0 ad=0.65p pd=3.02u as=0.65p ps=3.02u w=2.5u l=1u
X272 a_37302_183449# a_32610_183333# a_36970_183449# VDD pfet_06v0 ad=2.5p pd=10.5u as=3.3p ps=10.66u w=10u l=1u
X273 a_101822_150482# a_102898_141690# VSS VSS nfet_06v0 ad=0.825p pd=3.16u as=1.1p ps=5.88u w=2.5u l=1u
D13 VSS a_34334_117722# diode_nd2ps_06v0 pj=40u area=99.99999p
X274 VSS a_33002_162505# a_36942_162549# VSS nfet_06v0 ad=2.2p pd=10.88u as=1.25p ps=5.5u w=5u l=1u
X275 a_103446_148592# a_105038_141690# a_102898_141690# VSS nfet_06v0 ad=0.88p pd=4.88u as=0.88p ps=4.88u w=2u l=1u
X276 a_62602_174755# a_38886_171239# a_60042_174825# VDD pfet_06v0 ad=2.6p pd=10.52u as=4.4p ps=20.88u w=10u l=1u
X277 VSS a_86454_171355# a_85786_174755# VSS nfet_06v0 ad=0.65p pd=3.02u as=0.65p ps=3.02u w=2.5u l=1u
X278 a_54670_129706# a_54970_129706# a_65886_129750# VSS nfet_06v0 ad=2.2p pd=10.88u as=1.25p ps=5.5u w=5u l=1u
X279 a_79258_153881# a_78866_157349# a_79878_157465# VDD pfet_06v0 ad=4.4p pd=20.88u as=2.5p ps=10.5u w=10u l=1u
X280 VDD a_63718_167019# a_61046_162619# VDD pfet_06v0 ad=2.2p pd=10.88u as=1.3p ps=5.52u w=5u l=1u
X281 a_84670_183379# a_78526_179865# a_87566_179979# VSS nfet_06v0 ad=1.1p pd=5.88u as=0.65p ps=3.02u w=2.5u l=1u
X282 a_60846_153879# a_55584_122228# VDD VDD pfet_06v0 ad=0.44p pd=2.88u as=0.44p ps=2.88u w=1u l=1u
X283 a_84670_157395# a_95990_153995# cap_mim_2f0_m4m5_noshield c_width=20u c_length=10u
X284 a_55682_165973# a_55682_165973# a_58338_162549# VSS nfet_06v0 ad=0.44p pd=2.88u as=0.25p ps=1.5u w=1u l=1u
D14 VSS a_12580_56801# diode_nd2ps_06v0 pj=40u area=99.99999p
X285 a_78310_148592# a_76998_148476# VDD VDD pfet_06v0 ad=2.5p pd=10.5u as=4.4p ps=20.88u w=10u l=1u
X286 a_89206_129750# a_77298_136492# VSS VSS nfet_06v0 ad=0.25p pd=1.5u as=0.44p ps=2.88u w=1u l=1u
X287 a_82106_129750# a_84094_137692# a_77872_134212# VDD pfet_06v0 ad=1.76p pd=8.88u as=1.76p ps=8.88u w=4u l=1u
X288 a_101822_126514# a_102898_117722# VSS VSS nfet_06v0 ad=0.825p pd=3.16u as=1.1p ps=5.88u w=2.5u l=1u
X289 a_107546_129706# a_99658_129706# a_107746_129750# VSS nfet_06v0 ad=1.65p pd=5.66u as=1.25p ps=5.5u w=5u l=1u
X290 VSS VDD VSS VSS nfet_06v0 ad=4.29p pd=20.38u as=0 ps=0 w=9.75u l=2u
X291 a_105128_171512# VDD a_12580_76961# VSS nfet_06v0 ad=1.0912p pd=5.84u as=0.6448p ps=3u w=2.48u l=1u
X292 a_103446_124624# a_105038_117722# a_102898_117722# VSS nfet_06v0 ad=0.88p pd=4.88u as=0.88p ps=4.88u w=2u l=1u
X293 a_60846_179863# a_77872_146196# VDD VDD pfet_06v0 ad=0.44p pd=2.88u as=0.44p ps=2.88u w=1u l=1u
X294 VSS a_40198_162619# a_39530_166019# VSS nfet_06v0 ad=1.1p pd=5.88u as=0.65p ps=3.02u w=2.5u l=1u
D15 VSS a_12580_196913# diode_nd2ps_06v0 pj=40u area=99.99999p
X295 a_101622_117766# a_103446_124624# VDD VDD pfet_06v0 ad=2.2p pd=10.88u as=2.2p ps=10.88u w=5u l=1u
X296 a_55342_179865# a_55682_183333# a_55582_183449# VDD pfet_06v0 ad=4.4p pd=20.88u as=2.5p ps=10.5u w=10u l=1u
X297 a_83226_174825# a_78866_174709# a_82926_174825# VDD pfet_06v0 ad=3.3p pd=10.66u as=2.5p ps=10.5u w=10u l=1u
X298 VDD a_63718_184379# a_61046_179979# VDD pfet_06v0 ad=1.3p pd=5.52u as=1.3p ps=5.52u w=5u l=1u
X299 a_84670_166019# a_42022_129750# a_83226_166089# VDD pfet_06v0 ad=2.6p pd=10.52u as=4.4p ps=20.88u w=10u l=1u
X300 a_38414_183379# a_49734_179979# cap_mim_2f0_m4m5_noshield c_width=20u c_length=10u
X301 a_85930_124624# a_85730_124508# VDD VDD pfet_06v0 ad=2.5p pd=10.5u as=4.4p ps=20.88u w=10u l=1u
X302 VSS VDD VSS VSS nfet_06v0 ad=0.44p pd=2.88u as=0 ps=0 w=1u l=2u
X303 a_66918_141734# a_55010_148476# VSS VSS nfet_06v0 ad=0.25p pd=1.5u as=0.44p ps=2.88u w=1u l=1u
X304 a_117490_171228# a_49734_171355# VDD VDD pfet_06v0 ad=0.99p pd=3.66u as=1.32p ps=6.88u w=3u l=1u
X305 a_69198_184333# a_55342_179865# a_70398_179909# VSS nfet_06v0 ad=2.2p pd=10.88u as=1.25p ps=5.5u w=5u l=1u
X306 VDD a_88018_167019# a_95990_162619# VDD pfet_06v0 ad=2.6p pd=10.52u as=2.6p ps=10.52u w=10u l=1u
X307 a_104084_171512# a_102120_171396# a_103784_171512# VSS nfet_06v0 ad=0.175p pd=1.2u as=0.175p ps=1.2u w=0.7u l=1u
X308 a_35546_174825# a_32310_174709# VDD VDD pfet_06v0 ad=2.5p pd=10.5u as=4.4p ps=20.88u w=10u l=1u
X309 a_45662_162505# a_45662_162505# a_48170_162505# VSS nfet_06v0 ad=2.2p pd=10.88u as=1.65p ps=5.66u w=5u l=1u
X310 a_59818_141734# a_54970_141690# a_57134_150482# VSS nfet_06v0 ad=1.1p pd=5.88u as=0.825p ps=3.16u w=2.5u l=1u
X311 a_36610_171285# a_32270_171241# a_36310_171285# VSS nfet_06v0 ad=1.65p pd=5.66u as=1.25p ps=5.5u w=5u l=1u
X312 a_38414_166019# a_49734_162619# cap_mim_2f0_m4m5_noshield c_width=20u c_length=10u
X313 a_59742_174825# a_55382_174709# VDD VDD pfet_06v0 ad=2.5p pd=10.5u as=4.4p ps=20.88u w=10u l=1u
X314 a_83198_162549# a_78526_162505# a_82866_162549# VSS nfet_06v0 ad=1.25p pd=5.5u as=1.65p ps=5.66u w=5u l=1u
X315 a_72806_162619# a_64834_167019# VDD VDD pfet_06v0 ad=2.6p pd=10.52u as=4.4p ps=20.88u w=10u l=1u
X316 VSS VDD VSS VSS nfet_06v0 ad=0.44p pd=2.88u as=0 ps=0 w=1u l=2u
X317 a_61486_174755# a_55342_171241# a_64382_171355# VSS nfet_06v0 ad=1.1p pd=5.88u as=0.65p ps=3.02u w=2.5u l=1u
X318 a_64382_162619# a_69198_166973# a_64834_167019# VDD pfet_06v0 ad=2.2p pd=10.88u as=2.2p ps=10.88u w=5u l=1u
X319 a_78190_141734# a_76958_141690# VSS VSS nfet_06v0 ad=1.25p pd=5.5u as=2.2p ps=10.88u w=5u l=1u
X320 a_59682_153925# a_55342_153881# a_59382_153925# VSS nfet_06v0 ad=1.65p pd=5.66u as=1.25p ps=5.5u w=5u l=1u
X321 VDD VSS VDD VDD pfet_06v0 ad=7.92p pd=36.88u as=0 ps=0 w=18u l=2u
X322 a_83226_157465# a_60846_153879# a_84670_157395# VDD pfet_06v0 ad=4.4p pd=20.88u as=2.6p ps=10.52u w=10u l=1u
X323 a_55584_134662# a_71002_135112# VSS ppolyf_u_1k r_width=1u r_length=76.45u
X324 a_58210_141690# a_54970_141690# a_57946_150492# VSS nfet_06v0 ad=1.1p pd=5.88u as=0.825p ps=3.16u w=2.5u l=1u
X325 VDD a_86902_158395# a_84230_153995# VDD pfet_06v0 ad=2.2p pd=10.88u as=1.3p ps=5.52u w=5u l=1u
X326 a_41310_162619# a_46126_166973# a_41762_167019# VDD pfet_06v0 ad=2.2p pd=10.88u as=2.2p ps=10.88u w=5u l=1u
X327 YP_OUT YN_OUT VSS VSS nfet_05v0 ad=0.5808p pd=3.52u as=0.5808p ps=3.52u w=1.32u l=0.6u
X328 a_95990_179979# a_87566_179979# VSS VSS nfet_06v0 ad=1.3p pd=5.52u as=2.2p ps=10.88u w=5u l=1u
X329 a_48370_162549# a_48170_162505# VSS VSS nfet_06v0 ad=1.25p pd=5.5u as=2.2p ps=10.88u w=5u l=1u
X330 a_92382_175709# a_78526_171241# a_93582_171285# VSS nfet_06v0 ad=2.2p pd=10.88u as=1.25p ps=5.5u w=5u l=1u
X331 a_72482_136608# a_54710_136492# VDD VDD pfet_06v0 ad=2.5p pd=10.5u as=4.4p ps=20.88u w=10u l=1u
X332 a_61046_162619# a_55682_165973# a_64834_167019# VDD pfet_06v0 ad=2.2p pd=10.88u as=1.3p ps=5.52u w=5u l=1u
X333 a_62602_183379# a_55342_179865# a_63270_179979# VSS nfet_06v0 ad=1.1p pd=5.88u as=0.65p ps=3.02u w=2.5u l=1u
X334 a_88018_167019# a_91918_162505# a_87566_162619# VSS nfet_06v0 ad=1.1p pd=5.88u as=1.1p ps=5.88u w=2.5u l=1u
X335 a_33184_122678# a_48602_122228# VSS ppolyf_u_1k r_width=1u r_length=76.45u
X336 VDD VSS VDD VDD pfet_06v0 ad=7.92p pd=36.88u as=0 ps=0 w=18u l=2u
X337 a_66918_117766# a_55010_124508# VSS VSS nfet_06v0 ad=0.25p pd=1.5u as=0.44p ps=2.88u w=1u l=1u
X338 a_46126_166973# a_46126_166973# a_47762_165973# VDD pfet_06v0 ad=4.4p pd=20.88u as=3.3p ps=10.66u w=10u l=1u
X339 a_70558_148592# a_54710_148476# VDD VDD pfet_06v0 ad=2.5p pd=10.5u as=4.4p ps=20.88u w=10u l=1u
X340 a_36610_162549# a_38886_162503# a_39086_162619# VSS nfet_06v0 ad=2.2p pd=10.88u as=1.3p ps=5.52u w=5u l=1u
X341 VDD a_64834_158395# a_72806_153995# VDD pfet_06v0 ad=2.6p pd=10.52u as=2.6p ps=10.52u w=10u l=1u
X342 a_59818_117766# a_54970_117722# a_57134_126514# VSS nfet_06v0 ad=1.1p pd=5.88u as=0.825p ps=3.16u w=2.5u l=1u
X343 a_37774_179863# a_56934_141734# cap_mim_2f0_m4m5_noshield c_width=25u c_length=8u
X344 a_101622_129750# a_50996_204977# a_99858_129750# VSS nfet_06v0 ad=3.3p pd=15.88u as=3.3p ps=15.88u w=7.5u l=1u
X345 a_78190_117766# a_76958_117722# VSS VSS nfet_06v0 ad=1.25p pd=5.5u as=2.2p ps=10.88u w=5u l=1u
X346 VDD VSS VDD VDD pfet_06v0 ad=7.92p pd=36.88u as=0 ps=0 w=18u l=2u
X347 a_102320_154152# a_102120_154036# VSS VSS nfet_06v0 ad=0.5456p pd=3.36u as=0.5456p ps=3.36u w=1.24u l=1u
X348 a_94426_153881# a_78526_153881# a_94626_153925# VSS nfet_06v0 ad=1.65p pd=5.66u as=1.25p ps=5.5u w=5u l=1u
X349 a_58210_117722# a_54970_117722# a_57946_126524# VSS nfet_06v0 ad=1.1p pd=5.88u as=0.825p ps=3.16u w=2.5u l=1u
X350 a_100272_147546# a_38886_179863# VSS ppolyf_u_1k r_width=1u r_length=76.45u
X351 a_38886_179863# a_100272_146196# VDD VDD pfet_06v0 ad=0.44p pd=2.88u as=0.44p ps=2.88u w=1u l=1u
X352 a_56694_157465# a_55382_157349# VDD VDD pfet_06v0 ad=2.5p pd=10.5u as=4.4p ps=20.88u w=10u l=1u
X353 a_84670_166019# a_86454_162619# VSS VSS nfet_06v0 ad=0.65p pd=3.02u as=1.1p ps=5.88u w=2.5u l=1u
X354 a_84230_153995# a_86902_158395# VDD VDD pfet_06v0 ad=1.3p pd=5.52u as=2.2p ps=10.88u w=5u l=1u
X355 a_62158_162619# a_63718_167019# VDD VDD pfet_06v0 ad=1.3p pd=5.52u as=2.2p ps=10.88u w=5u l=1u
X356 a_33002_171241# a_32270_171241# a_33202_171285# VSS nfet_06v0 ad=2.2p pd=10.88u as=1.25p ps=5.5u w=5u l=1u
X357 VSS VDD VSS VSS nfet_06v0 ad=0.44p pd=2.88u as=0 ps=0 w=1u l=2u
X358 a_102354_141734# a_103446_148592# VDD VDD pfet_06v0 ad=2.2p pd=10.88u as=2.2p ps=10.88u w=5u l=1u
X359 VSS a_40198_179979# a_38414_183379# VSS nfet_06v0 ad=1.1p pd=5.88u as=0.65p ps=3.02u w=2.5u l=1u
X360 VDD VSS VDD VDD pfet_06v0 ad=0.44p pd=2.88u as=0 ps=0 w=1u l=2u
X361 a_42686_124624# a_32310_124508# VDD VDD pfet_06v0 ad=2.5p pd=10.5u as=4.4p ps=20.88u w=10u l=1u
X362 VSS a_56074_153881# a_60014_153925# VSS nfet_06v0 ad=2.2p pd=10.88u as=1.25p ps=5.5u w=5u l=1u
X363 a_56074_153881# a_55342_153881# a_56274_153925# VSS nfet_06v0 ad=2.2p pd=10.88u as=1.25p ps=5.5u w=5u l=1u
D16 VSS a_12580_196913# diode_nd2ps_06v0 pj=40u area=99.99999p
X364 a_32270_141690# a_32570_141690# a_43486_141734# VSS nfet_06v0 ad=2.2p pd=10.88u as=1.25p ps=5.5u w=5u l=1u
X365 a_50082_148592# a_32310_148476# VDD VDD pfet_06v0 ad=2.5p pd=10.5u as=4.4p ps=20.88u w=10u l=1u
D17 VSS a_12580_36641# diode_nd2ps_06v0 pj=40u area=99.99999p
X366 a_49406_183449# a_32310_183333# VDD VDD pfet_06v0 ad=2.5p pd=10.5u as=4.4p ps=20.88u w=10u l=1u
X367 VSS VDD VSS VSS nfet_06v0 ad=0.44p pd=2.88u as=0 ps=0 w=1u l=2u
X368 VSS VDD VSS VSS nfet_06v0 ad=4.29p pd=20.38u as=0 ps=0 w=9.75u l=2u
X369 a_38886_153879# a_77872_122228# VDD VDD pfet_06v0 ad=0.44p pd=2.88u as=0.44p ps=2.88u w=1u l=1u
X370 a_40198_171355# a_46126_175709# a_40646_175755# VDD pfet_06v0 ad=2.2p pd=10.88u as=2.2p ps=10.88u w=5u l=1u
X371 a_34534_129750# a_36358_136608# VDD VDD pfet_06v0 ad=2.2p pd=10.88u as=2.2p ps=10.88u w=5u l=1u
X372 a_61046_162619# a_63718_167019# VDD VDD pfet_06v0 ad=1.3p pd=5.52u as=1.3p ps=5.52u w=5u l=1u
X373 a_91918_153881# a_78866_157349# a_95662_157465# VDD pfet_06v0 ad=4.4p pd=20.88u as=2.5p ps=10.5u w=10u l=1u
X374 a_81522_162549# a_78866_165973# VSS VSS nfet_06v0 ad=0.25p pd=1.5u as=0.44p ps=2.88u w=1u l=1u
X375 VSS a_102330_179852# a_102158_163980# VSS nfet_06v0 ad=0.44p pd=2.88u as=0.44p ps=2.88u w=1u l=1u
X376 a_99658_141690# a_99658_141690# VSS VSS nfet_06v0 ad=0.44p pd=2.88u as=0.44p ps=2.88u w=1u l=1u
X377 a_79422_138498# a_37774_171239# cap_mim_2f0_m4m5_noshield c_width=25u c_length=8u
X378 a_105026_155360# a_12580_196913# a_106426_155290# VSS nfet_06v0 ad=0.88p pd=4.88u as=0.5p ps=2.5u w=2u l=1u
X379 VDD VSS VDD VDD pfet_06v0 ad=0.44p pd=2.88u as=0 ps=0 w=1u l=2u
X380 a_90238_129750# a_77298_136492# VSS VSS nfet_06v0 ad=0.25p pd=1.5u as=0.44p ps=2.88u w=1u l=1u
X381 VDD a_40646_167019# a_39086_162619# VDD pfet_06v0 ad=2.2p pd=10.88u as=1.3p ps=5.52u w=5u l=1u
X382 a_32270_117722# a_32570_117722# a_43486_117766# VSS nfet_06v0 ad=2.2p pd=10.88u as=1.25p ps=5.5u w=5u l=1u
X383 a_78526_179865# a_78866_183333# a_78766_183449# VDD pfet_06v0 ad=4.4p pd=20.88u as=2.5p ps=10.5u w=10u l=1u
X384 a_37950_129706# a_32610_136492# a_42686_136608# VDD pfet_06v0 ad=4.4p pd=20.88u as=2.5p ps=10.5u w=10u l=1u
X385 a_102634_138508# a_102898_129706# VSS VSS nfet_06v0 ad=0.825p pd=3.16u as=1.1p ps=5.88u w=2.5u l=1u
X386 a_84670_174755# a_95990_171355# cap_mim_2f0_m4m5_noshield c_width=20u c_length=10u
X387 a_99698_136492# a_99698_136492# VDD VDD pfet_06v0 ad=0.88p pd=4.88u as=0.88p ps=4.88u w=2u l=1u
X388 a_34334_141690# S3P VDD ppolyf_u r_width=40u r_length=10u
X389 VDD a_63718_158395# a_61046_153995# VDD pfet_06v0 ad=2.2p pd=10.88u as=1.3p ps=5.52u w=5u l=1u
X390 a_61046_179979# a_63718_184379# VDD VDD pfet_06v0 ad=1.3p pd=5.52u as=2.2p ps=10.88u w=5u l=1u
X391 a_32610_157349# a_32610_157349# VDD VDD pfet_06v0 ad=0.88p pd=4.88u as=0.88p ps=4.88u w=2u l=1u
X392 a_36970_166089# a_32610_165973# a_36670_166089# VDD pfet_06v0 ad=3.3p pd=10.66u as=2.5p ps=10.5u w=10u l=1u
X393 a_77198_124624# a_76998_124508# VDD VDD pfet_06v0 ad=2.5p pd=10.5u as=4.4p ps=20.88u w=10u l=1u
X394 a_64834_167019# a_68734_162505# a_64382_162619# VSS nfet_06v0 ad=1.1p pd=5.88u as=1.1p ps=5.88u w=2.5u l=1u
X395 a_60350_129706# a_55010_136492# a_65086_136608# VDD pfet_06v0 ad=4.4p pd=20.88u as=2.5p ps=10.5u w=10u l=1u
X396 a_76998_124508# a_77298_124508# a_94770_124624# VDD pfet_06v0 ad=4.4p pd=20.88u as=2.5p ps=10.5u w=10u l=1u
X397 a_99658_117722# a_99658_117722# VSS VSS nfet_06v0 ad=0.44p pd=2.88u as=0.44p ps=2.88u w=1u l=1u
X398 VDD a_40646_184379# a_39086_179979# VDD pfet_06v0 ad=1.3p pd=5.52u as=1.3p ps=5.52u w=5u l=1u
X399 a_95990_162619# a_88018_167019# VDD VDD pfet_06v0 ad=2.6p pd=10.52u as=4.4p ps=20.88u w=10u l=1u
X400 VDD VSS VDD VDD pfet_06v0 ad=4.29p pd=20.38u as=0 ps=0 w=9.75u l=2u
X401 VSS a_40198_153995# a_39530_157395# VSS nfet_06v0 ad=1.1p pd=5.88u as=0.65p ps=3.02u w=2.5u l=1u
X402 VSS VDD VSS VSS nfet_06v0 ad=0.44p pd=2.88u as=0 ps=0 w=1u l=2u
X403 a_99598_124624# a_99398_124508# VDD VDD pfet_06v0 ad=2.5p pd=10.5u as=4.4p ps=20.88u w=10u l=1u
X404 a_55584_146646# a_71002_146196# VSS ppolyf_u_1k r_width=1u r_length=76.45u
X405 a_39086_162619# a_40646_167019# VDD VDD pfet_06v0 ad=1.3p pd=5.52u as=2.2p ps=10.88u w=5u l=1u
X406 a_64382_171355# a_55342_171241# a_61486_174755# VSS nfet_06v0 ad=0.65p pd=3.02u as=1.1p ps=5.88u w=2.5u l=1u
X407 a_102120_162772# a_102120_162772# a_104384_162888# VSS nfet_06v0 ad=0.308p pd=2.28u as=0.175p ps=1.2u w=0.7u l=1u
X408 a_32810_124624# a_32610_124508# a_33622_124624# VDD pfet_06v0 ad=4.4p pd=20.88u as=2.5p ps=10.5u w=10u l=1u
X409 a_84670_157395# a_60846_153879# a_83226_157465# VDD pfet_06v0 ad=2.6p pd=10.52u as=4.4p ps=20.88u w=10u l=1u
X410 a_72806_162619# a_64382_162619# VSS VSS nfet_06v0 ad=2.2p pd=10.88u as=1.3p ps=5.52u w=5u l=1u
X411 a_85786_183379# a_78526_179865# a_86454_179979# VSS nfet_06v0 ad=1.1p pd=5.88u as=0.65p ps=3.02u w=2.5u l=1u
X412 a_39406_149676# a_39406_149676# a_41042_148476# VDD pfet_06v0 ad=4.4p pd=20.88u as=3.3p ps=10.66u w=10u l=1u
D18 a_50996_204977# VDD diode_pd2nw_06v0 pj=40u area=99.99999p
X413 a_71442_153925# a_71242_153881# VSS VSS nfet_06v0 ad=1.25p pd=5.5u as=2.2p ps=10.88u w=5u l=1u
X414 VSS VDD VSS VSS nfet_06v0 ad=0.44p pd=2.88u as=0 ps=0 w=1u l=2u
X415 VSS VDD VSS VSS nfet_06v0 ad=4.29p pd=20.38u as=0 ps=0 w=9.75u l=2u
X416 a_105128_162888# a_102120_162772# VSS VSS nfet_06v0 ad=0.5456p pd=3.36u as=0.5456p ps=3.36u w=1.24u l=1u
X417 VDD VSS VDD VDD pfet_06v0 ad=0.44p pd=2.88u as=0 ps=0 w=1u l=2u
X418 a_105026_164096# a_12580_136433# a_106426_164026# VSS nfet_06v0 ad=0.88p pd=4.88u as=0.5p ps=2.5u w=2u l=1u
X419 a_64834_167019# a_55682_165973# a_61046_162619# VDD pfet_06v0 ad=1.3p pd=5.52u as=2.2p ps=10.88u w=5u l=1u
X420 a_63270_179979# a_55342_179865# a_62602_183379# VSS nfet_06v0 ad=0.65p pd=3.02u as=1.1p ps=5.88u w=2.5u l=1u
X421 a_54970_117722# a_55010_124508# a_69446_124624# VDD pfet_06v0 ad=4.4p pd=20.88u as=2.5p ps=10.5u w=10u l=1u
X422 VDD a_88018_158395# a_95990_153995# VDD pfet_06v0 ad=2.6p pd=10.52u as=2.6p ps=10.52u w=10u l=1u
X423 a_69198_158349# a_69198_158349# a_70834_157349# VDD pfet_06v0 ad=4.4p pd=20.88u as=3.3p ps=10.66u w=10u l=1u
X424 VSS a_63270_171355# a_61486_174755# VSS nfet_06v0 ad=1.1p pd=5.88u as=0.65p ps=3.02u w=2.5u l=1u
X425 a_40198_179979# a_32270_179865# a_39530_183379# VSS nfet_06v0 ad=0.65p pd=3.02u as=1.1p ps=5.88u w=2.5u l=1u
X426 a_102898_117722# a_106494_125708# a_103446_124624# VDD pfet_06v0 ad=1.76p pd=8.88u as=1.76p ps=8.88u w=4u l=1u
X427 a_55210_124624# a_55010_124508# a_56022_124624# VDD pfet_06v0 ad=4.4p pd=20.88u as=2.5p ps=10.5u w=10u l=1u
X428 a_33184_122678# a_48602_123128# VSS ppolyf_u_1k r_width=1u r_length=76.45u
X429 a_72806_153995# a_64834_158395# VDD VDD pfet_06v0 ad=2.6p pd=10.52u as=4.4p ps=20.88u w=10u l=1u
X430 a_61806_149676# a_61806_149676# a_63442_148476# VDD pfet_06v0 ad=4.4p pd=20.88u as=3.3p ps=10.66u w=10u l=1u
X431 a_55584_146196# a_71002_146196# VSS ppolyf_u_1k r_width=1u r_length=76.45u
D19 VSS a_12580_196913# diode_nd2ps_06v0 pj=40u area=99.99999p
X432 a_32270_171241# a_32610_174709# a_32510_174825# VDD pfet_06v0 ad=4.4p pd=20.88u as=2.5p ps=10.5u w=10u l=1u
X433 a_65886_129750# a_54670_129706# VSS VSS nfet_06v0 ad=1.25p pd=5.5u as=2.2p ps=10.88u w=5u l=1u
X434 a_79878_157465# a_78566_157349# VDD VDD pfet_06v0 ad=2.5p pd=10.5u as=4.4p ps=20.88u w=10u l=1u
X435 VSS a_63270_162619# a_62602_166019# VSS nfet_06v0 ad=0.65p pd=3.02u as=0.65p ps=3.02u w=2.5u l=1u
X436 VDD a_40646_175755# a_37974_171355# VDD pfet_06v0 ad=1.3p pd=5.52u as=1.3p ps=5.52u w=5u l=1u
X437 a_99898_136608# a_99698_136492# a_99598_136608# VDD pfet_06v0 ad=4.4p pd=20.88u as=2.5p ps=10.5u w=10u l=1u
X438 a_85730_148476# a_77298_148476# a_85930_148592# VDD pfet_06v0 ad=3.3p pd=10.66u as=2.5p ps=10.5u w=10u l=1u
X439 a_85342_162619# a_86902_167019# VDD VDD pfet_06v0 ad=1.3p pd=5.52u as=2.2p ps=10.88u w=5u l=1u
X440 VSS a_86454_179979# a_84670_183379# VSS nfet_06v0 ad=1.1p pd=5.88u as=0.65p ps=3.02u w=2.5u l=1u
X441 a_61046_153995# a_55682_157349# a_64834_158395# VDD pfet_06v0 ad=2.2p pd=10.88u as=1.3p ps=5.52u w=5u l=1u
X442 a_32270_179865# a_32270_179865# VSS VSS nfet_06v0 ad=0.44p pd=2.88u as=0.44p ps=2.88u w=1u l=1u
X443 a_79954_117766# a_81046_124624# VDD VDD pfet_06v0 ad=2.2p pd=10.88u as=2.2p ps=10.88u w=5u l=1u
X444 a_100272_122678# a_115690_122228# VSS ppolyf_u_1k r_width=1u r_length=76.45u
X445 a_57666_129750# a_12580_56801# a_55170_129750# VSS nfet_06v0 ad=3.74p pd=17.88u as=3.74p ps=17.88u w=8.5u l=1u
X446 a_79258_153881# a_78526_153881# a_79458_153925# VSS nfet_06v0 ad=2.2p pd=10.88u as=1.25p ps=5.5u w=5u l=1u
X447 a_36610_153925# a_38886_153879# a_39086_153995# VSS nfet_06v0 ad=2.2p pd=10.88u as=1.3p ps=5.52u w=5u l=1u
X448 a_58338_162549# a_55682_165973# VSS VSS nfet_06v0 ad=0.25p pd=1.5u as=0.44p ps=2.88u w=1u l=1u
X449 a_36358_124624# a_32610_124508# a_35266_117766# VDD pfet_06v0 ad=4.4p pd=20.88u as=4.4p ps=20.88u w=10u l=1u
X450 VDD a_72806_179979# a_104618_181308# VDD pfet_06v0 ad=1.32p pd=6.88u as=0.75p ps=3.5u w=3u l=1u
X451 a_107746_129750# a_107546_129706# VSS VSS nfet_06v0 ad=1.25p pd=5.5u as=2.2p ps=10.88u w=5u l=1u
X452 a_60350_129706# a_60350_129706# a_62858_129706# VSS nfet_06v0 ad=2.2p pd=10.88u as=1.65p ps=5.66u w=5u l=1u
X453 a_38414_183379# a_40198_179979# VSS VSS nfet_06v0 ad=0.65p pd=3.02u as=0.65p ps=3.02u w=2.5u l=1u
X454 a_55582_183449# a_55382_183333# VDD VDD pfet_06v0 ad=2.5p pd=10.5u as=4.4p ps=20.88u w=10u l=1u
X455 VDD VSS VDD VDD pfet_06v0 ad=0.44p pd=2.88u as=0 ps=0 w=1u l=2u
X456 a_58210_117722# a_61806_125708# a_58758_124624# VDD pfet_06v0 ad=1.76p pd=8.88u as=1.76p ps=8.88u w=4u l=1u
X457 a_103182_155360# a_103270_155244# a_12580_196913# VSS nfet_06v0 ad=1.0912p pd=5.84u as=0.6448p ps=3u w=2.48u l=1u
X458 a_62158_179979# a_63718_184379# VDD VDD pfet_06v0 ad=1.3p pd=5.52u as=1.3p ps=5.52u w=5u l=1u
X459 a_84670_157395# a_86454_153995# VSS VSS nfet_06v0 ad=0.65p pd=3.02u as=1.1p ps=5.88u w=2.5u l=1u
X460 VDD a_55382_174709# a_60374_174825# VDD pfet_06v0 ad=4.4p pd=20.88u as=2.5p ps=10.5u w=10u l=1u
X461 a_38886_171239# a_37418_141734# VSS VSS nfet_06v0 ad=0.44p pd=2.88u as=0.44p ps=2.88u w=1u l=1u
X462 a_60014_153925# a_55342_153881# a_59682_153925# VSS nfet_06v0 ad=1.25p pd=5.5u as=1.65p ps=5.66u w=5u l=1u
X463 a_62158_153995# a_63718_158395# VDD VDD pfet_06v0 ad=1.3p pd=5.52u as=2.2p ps=10.88u w=5u l=1u
X464 VSS VDD VSS VSS nfet_06v0 ad=7.92p pd=36.88u as=0 ps=0 w=18u l=2u
X465 a_105026_155360# a_12580_196913# a_12580_196913# VSS nfet_06v0 ad=0.88p pd=4.88u as=0.52p ps=2.52u w=2u l=1u
X466 a_70398_179909# a_56074_179865# VSS VSS nfet_06v0 ad=1.25p pd=5.5u as=2.2p ps=10.88u w=5u l=1u
X467 a_70834_165973# a_55682_165973# a_71034_166089# VDD pfet_06v0 ad=3.3p pd=10.66u as=2.5p ps=10.5u w=10u l=1u
X468 a_36610_162549# a_37774_162503# a_37974_162619# VSS nfet_06v0 ad=2.2p pd=10.88u as=1.3p ps=5.52u w=5u l=1u
X469 a_103784_171512# a_102120_171396# VSS VSS nfet_06v0 ad=0.175p pd=1.2u as=0.308p ps=2.28u w=0.7u l=1u
X470 a_37774_153879# a_33184_122228# VDD VDD pfet_06v0 ad=0.44p pd=2.88u as=0.44p ps=2.88u w=1u l=1u
X471 a_38886_162503# a_55584_134212# VDD VDD pfet_06v0 ad=0.44p pd=2.88u as=0.44p ps=2.88u w=1u l=1u
X472 a_57134_150482# a_34334_141690# a_55210_148592# VDD pfet_06v0 ad=0.242p pd=1.98u as=0.242p ps=1.98u w=0.55u l=1u
X473 VSS VDD VSS VSS nfet_06v0 ad=0.44p pd=2.88u as=0 ps=0 w=1u l=2u
X474 a_62158_171355# a_38886_171239# a_59682_171285# VSS nfet_06v0 ad=1.3p pd=5.52u as=2.2p ps=10.88u w=5u l=1u
X475 a_37974_179979# a_32610_183333# a_41762_184379# VDD pfet_06v0 ad=2.2p pd=10.88u as=1.3p ps=5.52u w=5u l=1u
X476 a_102158_155244# a_105170_179852# VDD VDD pfet_06v0 ad=1.32p pd=6.88u as=1.32p ps=6.88u w=3u l=1u
X477 a_32770_141734# a_32570_141690# a_33502_141734# VSS nfet_06v0 ad=2.2p pd=10.88u as=1.25p ps=5.5u w=5u l=1u
X478 a_99358_141690# a_99658_141690# a_110574_141734# VSS nfet_06v0 ad=2.2p pd=10.88u as=1.25p ps=5.5u w=5u l=1u
X479 a_36310_171285# a_33002_171241# VSS VSS nfet_06v0 ad=1.25p pd=5.5u as=2.2p ps=10.88u w=5u l=1u
X480 a_117170_148592# a_99398_148476# VDD VDD pfet_06v0 ad=2.5p pd=10.5u as=4.4p ps=20.88u w=10u l=1u
X481 a_37774_179863# a_59818_141734# VSS VSS nfet_06v0 ad=0.44p pd=2.88u as=0.44p ps=2.88u w=1u l=1u
X482 a_59382_153925# a_56074_153881# VSS VSS nfet_06v0 ad=1.25p pd=5.5u as=2.2p ps=10.88u w=5u l=1u
X483 a_62158_179979# a_55682_183333# a_63718_184379# VDD pfet_06v0 ad=2.2p pd=10.88u as=1.3p ps=5.52u w=5u l=1u
X484 a_92382_184333# a_92382_184333# a_94018_183333# VDD pfet_06v0 ad=4.4p pd=20.88u as=3.3p ps=10.66u w=10u l=1u
X485 a_61046_179979# a_60846_179863# a_59682_179909# VSS nfet_06v0 ad=1.3p pd=5.52u as=2.2p ps=10.88u w=5u l=1u
X486 VSS VDD VSS VSS nfet_06v0 ad=0.44p pd=2.88u as=0 ps=0 w=1u l=2u
X487 a_32270_117722# a_32610_124508# a_48158_124624# VDD pfet_06v0 ad=4.4p pd=20.88u as=2.5p ps=10.5u w=10u l=1u
X488 a_101622_129750# a_103446_136608# VDD VDD pfet_06v0 ad=2.2p pd=10.88u as=2.2p ps=10.88u w=5u l=1u
X489 a_61046_153995# a_63718_158395# VDD VDD pfet_06v0 ad=1.3p pd=5.52u as=1.3p ps=5.52u w=5u l=1u
X490 a_93582_171285# a_79258_171241# VSS VSS nfet_06v0 ad=1.25p pd=5.5u as=2.2p ps=10.88u w=5u l=1u
X491 a_55170_141734# a_54970_141690# a_55902_141734# VSS nfet_06v0 ad=2.2p pd=10.88u as=1.25p ps=5.5u w=5u l=1u
X492 a_37774_153879# a_37418_117766# VSS VSS nfet_06v0 ad=0.44p pd=2.88u as=0.44p ps=2.88u w=1u l=1u
X493 a_63718_167019# a_55682_165973# a_62158_162619# VDD pfet_06v0 ad=1.3p pd=5.52u as=2.2p ps=10.88u w=5u l=1u
X494 VSS VDD VSS VSS nfet_06v0 ad=7.92p pd=36.88u as=0 ps=0 w=18u l=2u
X495 VDD VSS VDD VDD pfet_06v0 ad=4.29p pd=20.38u as=0 ps=0 w=9.75u l=2u
X496 a_39406_137692# a_32570_129706# a_39614_129750# VSS nfet_06v0 ad=2.2p pd=10.88u as=1.25p ps=5.5u w=5u l=1u
X497 a_85930_136608# a_85730_136492# VDD VDD pfet_06v0 ad=2.5p pd=10.5u as=4.4p ps=20.88u w=10u l=1u
X498 a_69198_166973# a_55342_162505# a_70398_162549# VSS nfet_06v0 ad=2.2p pd=10.88u as=1.25p ps=5.5u w=5u l=1u
X499 a_12580_196913# a_12580_196913# VDD VDD pfet_06v0 ad=0.52p pd=2.52u as=0.52p ps=2.52u w=2u l=1u
X500 a_32770_117766# a_32570_117722# a_33502_117766# VSS nfet_06v0 ad=2.2p pd=10.88u as=1.25p ps=5.5u w=5u l=1u
X501 VDD a_40646_158395# a_39086_153995# VDD pfet_06v0 ad=2.2p pd=10.88u as=1.3p ps=5.52u w=5u l=1u
X502 a_99358_117722# a_99658_117722# a_110574_117766# VSS nfet_06v0 ad=2.2p pd=10.88u as=1.25p ps=5.5u w=5u l=1u
X503 a_63718_175755# a_68734_171241# a_63270_171355# VSS nfet_06v0 ad=1.1p pd=5.88u as=1.1p ps=5.88u w=2.5u l=1u
X504 a_86902_184379# a_91918_179865# a_86454_179979# VSS nfet_06v0 ad=1.1p pd=5.88u as=1.1p ps=5.88u w=2.5u l=1u
X505 a_87566_171355# a_78526_171241# a_84670_174755# VSS nfet_06v0 ad=0.65p pd=3.02u as=1.1p ps=5.88u w=2.5u l=1u
X506 a_77872_122228# a_77298_124508# a_79222_117766# VDD pfet_06v0 ad=4.4p pd=20.88u as=4.4p ps=20.88u w=10u l=1u
X507 VDD VSS VDD VDD pfet_06v0 ad=4.29p pd=20.38u as=0 ps=0 w=9.75u l=2u
X508 a_60846_153879# a_59818_117766# VSS VSS nfet_06v0 ad=0.44p pd=2.88u as=0.44p ps=2.88u w=1u l=1u
X509 a_94626_153925# a_94426_153881# VSS VSS nfet_06v0 ad=1.25p pd=5.5u as=2.2p ps=10.88u w=5u l=1u
X510 a_88018_167019# a_78866_165973# a_84230_162619# VDD pfet_06v0 ad=1.3p pd=5.52u as=2.2p ps=10.88u w=5u l=1u
X511 a_86454_179979# a_78526_179865# a_85786_183379# VSS nfet_06v0 ad=0.65p pd=3.02u as=1.1p ps=5.88u w=2.5u l=1u
X512 a_78566_157349# a_78866_157349# a_81802_157465# VDD pfet_06v0 ad=4.4p pd=20.88u as=2.5p ps=10.5u w=10u l=1u
X513 a_55170_117766# a_54970_117722# a_55902_117766# VSS nfet_06v0 ad=2.2p pd=10.88u as=1.25p ps=5.5u w=5u l=1u
X514 VSS a_49734_153995# a_118422_153912# VSS nfet_06v0 ad=0.44p pd=2.88u as=0.25p ps=1.5u w=1u l=1u
X515 a_54910_124624# a_54710_124508# VDD VDD pfet_06v0 ad=2.5p pd=10.5u as=4.4p ps=20.88u w=10u l=1u
X516 VSS a_41310_162619# a_49734_162619# VSS nfet_06v0 ad=1.3p pd=5.52u as=1.3p ps=5.52u w=5u l=1u
D20 a_34334_117722# VDD diode_pd2nw_06v0 pj=40u area=99.99999p
X517 a_33202_171285# a_33002_171241# VSS VSS nfet_06v0 ad=1.25p pd=5.5u as=2.2p ps=10.88u w=5u l=1u
X518 a_95990_153995# a_88018_158395# VDD VDD pfet_06v0 ad=2.6p pd=10.52u as=4.4p ps=20.88u w=10u l=1u
X519 a_61486_174755# a_63270_171355# VSS VSS nfet_06v0 ad=0.65p pd=3.02u as=0.65p ps=3.02u w=2.5u l=1u
X520 VSS VDD VSS VSS nfet_06v0 ad=7.92p pd=36.88u as=0 ps=0 w=18u l=2u
X521 a_56274_153925# a_56074_153881# VSS VSS nfet_06v0 ad=1.25p pd=5.5u as=2.2p ps=10.88u w=5u l=1u
X522 a_38414_157395# a_49734_153995# cap_mim_2f0_m4m5_noshield c_width=20u c_length=10u
D21 VSS a_50996_204977# diode_nd2ps_06v0 pj=40u area=99.99999p
X523 a_43486_141734# a_32270_141690# VSS VSS nfet_06v0 ad=1.25p pd=5.5u as=2.2p ps=10.88u w=5u l=1u
X524 VSS VDD VSS VSS nfet_06v0 ad=0.44p pd=2.88u as=0 ps=0 w=1u l=2u
X525 a_39086_153995# a_40646_158395# VDD VDD pfet_06v0 ad=1.3p pd=5.52u as=2.2p ps=10.88u w=5u l=1u
D22 a_34334_117722# VDD diode_pd2nw_06v0 pj=40u area=99.99999p
X526 a_99898_124624# a_99698_124508# a_100710_124624# VDD pfet_06v0 ad=4.4p pd=20.88u as=2.5p ps=10.5u w=10u l=1u
X527 VDD VSS VDD VDD pfet_06v0 ad=0.44p pd=2.88u as=0 ps=0 w=1u l=2u
X528 a_72806_153995# a_64382_153995# VSS VSS nfet_06v0 ad=2.2p pd=10.88u as=1.3p ps=5.52u w=5u l=1u
X529 a_95990_171355# a_84230_171355# cap_mim_2f0_m4m5_noshield c_width=20u c_length=10u
X530 a_35266_141734# a_35066_141690# a_32770_141734# VSS nfet_06v0 ad=3.74p pd=17.88u as=3.74p ps=17.88u w=8.5u l=1u
X531 a_105404_175060# a_12580_76961# VSS VSS nfet_05v0 ad=0.5808p pd=3.52u as=0.5808p ps=3.52u w=1.32u l=0.6u
X532 a_77498_148592# a_77298_148476# a_77198_148592# VDD pfet_06v0 ad=4.4p pd=20.88u as=2.5p ps=10.5u w=10u l=1u
X533 a_62602_166019# a_63270_162619# VSS VSS nfet_06v0 ad=0.65p pd=3.02u as=1.1p ps=5.88u w=2.5u l=1u
X534 a_71242_179865# a_55342_179865# a_71442_179909# VSS nfet_06v0 ad=1.65p pd=5.66u as=1.25p ps=5.5u w=5u l=1u
X535 a_37974_171355# a_40646_175755# VDD VDD pfet_06v0 ad=1.3p pd=5.52u as=2.2p ps=10.88u w=5u l=1u
X536 a_37950_141690# a_37950_141690# a_40458_141690# VSS nfet_06v0 ad=2.2p pd=10.88u as=1.65p ps=5.66u w=5u l=1u
X537 a_64834_158395# a_55682_157349# a_61046_153995# VDD pfet_06v0 ad=1.3p pd=5.52u as=2.2p ps=10.88u w=5u l=1u
X538 VSS VDD VSS VSS nfet_06v0 ad=0.44p pd=2.88u as=0 ps=0 w=1u l=2u
X539 a_103182_155360# a_102120_154036# VSS VSS nfet_06v0 ad=0.5456p pd=3.36u as=0.5456p ps=3.36u w=1.24u l=1u
X540 a_95662_157465# a_78566_157349# VDD VDD pfet_06v0 ad=2.5p pd=10.5u as=4.4p ps=20.88u w=10u l=1u
X541 VSS a_72806_162619# a_103270_172604# VSS nfet_06v0 ad=0.44p pd=2.88u as=0.33p ps=1.66u w=1u l=1u
X542 a_39530_166019# a_32270_162505# a_40198_162619# VSS nfet_06v0 ad=1.1p pd=5.88u as=0.65p ps=3.02u w=2.5u l=1u
X543 a_100272_122678# a_115690_123128# VSS ppolyf_u_1k r_width=1u r_length=76.45u
X544 VSS VDD VSS VSS nfet_06v0 ad=7.92p pd=36.88u as=0 ps=0 w=18u l=2u
X545 a_106426_155290# a_12580_196913# VSS VSS nfet_06v0 ad=0.5p pd=2.5u as=0.88p ps=4.88u w=2u l=1u
D23 a_35066_117722# VDD diode_pd2nw_06v0 pj=40u area=99.99999p
X546 a_47762_174709# a_32610_174709# a_47962_174825# VDD pfet_06v0 ad=3.3p pd=10.66u as=2.5p ps=10.5u w=10u l=1u
X547 a_43486_117766# a_32270_117722# VSS VSS nfet_06v0 ad=1.25p pd=5.5u as=2.2p ps=10.88u w=5u l=1u
X548 a_102070_155360# a_102120_154036# VSS VSS nfet_06v0 ad=0.5456p pd=3.36u as=0.5456p ps=3.36u w=1.24u l=1u
X549 VSS a_95990_162619# a_115582_162536# VSS nfet_06v0 ad=0.44p pd=2.88u as=0.25p ps=1.5u w=1u l=1u
X550 a_78766_183449# a_78566_183333# VDD VDD pfet_06v0 ad=2.5p pd=10.5u as=4.4p ps=20.88u w=10u l=1u
X551 a_55382_174709# a_55682_174709# a_57306_171285# VSS nfet_06v0 ad=0.44p pd=2.88u as=0.25p ps=1.5u w=1u l=1u
X552 a_42686_136608# a_32310_136492# VDD VDD pfet_06v0 ad=2.5p pd=10.5u as=4.4p ps=20.88u w=10u l=1u
X553 a_79422_138498# a_80498_129706# VSS VSS nfet_06v0 ad=0.825p pd=3.16u as=1.1p ps=5.88u w=2.5u l=1u
X554 ZN_OUT a_105404_175060# VDD VDD pfet_05v0 ad=0.8052p pd=4.54u as=0.8052p ps=4.54u w=1.83u l=0.5u
X555 a_55902_129750# a_54670_129706# VSS VSS nfet_06v0 ad=1.25p pd=5.5u as=2.2p ps=10.88u w=5u l=1u
X556 a_105038_141690# a_99698_148476# a_109774_148592# VDD pfet_06v0 ad=4.4p pd=20.88u as=2.5p ps=10.5u w=10u l=1u
X557 VSS a_63270_153995# a_62602_157395# VSS nfet_06v0 ad=0.65p pd=3.02u as=0.65p ps=3.02u w=2.5u l=1u
X558 VDD a_78566_174709# a_83558_174825# VDD pfet_06v0 ad=4.4p pd=20.88u as=2.5p ps=10.5u w=10u l=1u
X559 a_35266_117766# a_35066_117722# a_32770_117766# VSS nfet_06v0 ad=3.74p pd=17.88u as=3.74p ps=17.88u w=8.5u l=1u
X560 a_85342_153995# a_86902_158395# VDD VDD pfet_06v0 ad=1.3p pd=5.52u as=2.2p ps=10.88u w=5u l=1u
X561 a_12580_196913# a_103270_155244# a_103182_155360# VSS nfet_06v0 ad=0.6448p pd=3u as=1.0912p ps=5.84u w=2.48u l=1u
X562 a_36670_166089# a_32310_165973# VDD VDD pfet_06v0 ad=2.5p pd=10.5u as=4.4p ps=20.88u w=10u l=1u
X563 VDD a_63718_184379# a_62158_179979# VDD pfet_06v0 ad=1.3p pd=5.52u as=1.3p ps=5.52u w=5u l=1u
X564 a_94018_165973# a_78866_165973# a_94218_166089# VDD pfet_06v0 ad=3.3p pd=10.66u as=2.5p ps=10.5u w=10u l=1u
X565 a_37950_117722# a_37950_117722# a_40458_117722# VSS nfet_06v0 ad=2.2p pd=10.88u as=1.65p ps=5.66u w=5u l=1u
X566 a_37774_171239# a_77872_134212# VDD VDD pfet_06v0 ad=0.44p pd=2.88u as=0.44p ps=2.88u w=1u l=1u
X567 a_103446_124624# a_99698_124508# a_102354_117766# VDD pfet_06v0 ad=4.4p pd=20.88u as=4.4p ps=20.88u w=10u l=1u
X568 a_81046_148592# a_77298_148476# a_79954_141734# VDD pfet_06v0 ad=4.4p pd=20.88u as=4.4p ps=20.88u w=10u l=1u
X569 a_12580_196913# a_12580_196913# a_105026_155360# VSS nfet_06v0 ad=0.52p pd=2.52u as=0.88p ps=4.88u w=2u l=1u
X570 a_94770_124624# a_76998_124508# VDD VDD pfet_06v0 ad=2.5p pd=10.5u as=4.4p ps=20.88u w=10u l=1u
X571 a_41762_184379# a_32610_183333# a_37974_179979# VDD pfet_06v0 ad=1.3p pd=5.52u as=2.2p ps=10.88u w=5u l=1u
X572 a_47046_124624# a_32310_124508# VDD VDD pfet_06v0 ad=2.5p pd=10.5u as=4.4p ps=20.88u w=10u l=1u
X573 a_68734_171241# a_55682_174709# a_72478_174825# VDD pfet_06v0 ad=4.4p pd=20.88u as=2.5p ps=10.5u w=10u l=1u
X574 a_104384_162888# a_102120_162772# a_104084_162888# VSS nfet_06v0 ad=0.175p pd=1.2u as=0.175p ps=1.2u w=0.7u l=1u
X575 VDD VSS VDD VDD pfet_06v0 ad=7.92p pd=36.88u as=0 ps=0 w=18u l=2u
X576 a_103182_164096# a_102120_162772# VSS VSS nfet_06v0 ad=0.5456p pd=3.36u as=0.5456p ps=3.36u w=1.24u l=1u
X577 a_33622_124624# a_32310_124508# VDD VDD pfet_06v0 ad=2.5p pd=10.5u as=4.4p ps=20.88u w=10u l=1u
X578 VDD VSS VDD VDD pfet_06v0 ad=7.92p pd=36.88u as=0 ps=0 w=18u l=2u
X579 a_55382_157349# a_55682_157349# a_58618_157465# VDD pfet_06v0 ad=4.4p pd=20.88u as=2.5p ps=10.5u w=10u l=1u
D24 a_12580_76961# VDD diode_pd2nw_06v0 pj=40u area=99.99999p
X580 a_106426_164026# a_12580_136433# VSS VSS nfet_06v0 ad=0.5p pd=2.5u as=0.88p ps=4.88u w=2u l=1u
X581 a_69446_124624# a_54710_124508# VDD VDD pfet_06v0 ad=2.5p pd=10.5u as=4.4p ps=20.88u w=10u l=1u
X582 a_36610_153925# a_37774_153879# a_37974_153995# VSS nfet_06v0 ad=2.2p pd=10.88u as=1.3p ps=5.52u w=5u l=1u
X583 a_77198_136608# a_76998_136492# VDD VDD pfet_06v0 ad=2.5p pd=10.5u as=4.4p ps=20.88u w=10u l=1u
X584 VDD VSS VDD VDD pfet_06v0 ad=7.92p pd=36.88u as=0 ps=0 w=18u l=2u
X585 VSS VDD VSS VSS nfet_06v0 ad=4.29p pd=20.38u as=0 ps=0 w=9.75u l=2u
X586 VDD a_12580_196913# a_12580_196913# VDD pfet_06v0 ad=0.52p pd=2.52u as=0.52p ps=2.52u w=2u l=1u
X587 VSS a_86454_162619# a_85786_166019# VSS nfet_06v0 ad=1.1p pd=5.88u as=0.65p ps=3.02u w=2.5u l=1u
X588 a_76998_136492# a_77298_136492# a_94770_136608# VDD pfet_06v0 ad=4.4p pd=20.88u as=2.5p ps=10.5u w=10u l=1u
X589 a_59682_179909# a_55342_179865# a_59382_179909# VSS nfet_06v0 ad=1.65p pd=5.66u as=1.25p ps=5.5u w=5u l=1u
X590 a_38886_179863# a_100272_146196# VDD VDD pfet_06v0 ad=0.44p pd=2.88u as=0.44p ps=2.88u w=1u l=1u
X591 a_99358_117722# a_99698_124508# a_115246_124624# VDD pfet_06v0 ad=4.4p pd=20.88u as=2.5p ps=10.5u w=10u l=1u
X592 a_76958_141690# a_77298_148476# a_92846_148592# VDD pfet_06v0 ad=4.4p pd=20.88u as=2.5p ps=10.5u w=10u l=1u
X593 a_32510_174825# a_32310_174709# VDD VDD pfet_06v0 ad=2.5p pd=10.5u as=4.4p ps=20.88u w=10u l=1u
X594 a_56934_117766# a_58758_124624# VDD VDD pfet_06v0 ad=2.2p pd=10.88u as=2.2p ps=10.88u w=5u l=1u
X595 a_99598_136608# a_99398_136492# VDD VDD pfet_06v0 ad=2.5p pd=10.5u as=4.4p ps=20.88u w=10u l=1u
X596 a_32810_136608# a_32610_136492# a_33622_136608# VDD pfet_06v0 ad=4.4p pd=20.88u as=2.5p ps=10.5u w=10u l=1u
X597 a_32770_129750# a_32570_129706# a_32470_129750# VSS nfet_06v0 ad=2.2p pd=10.88u as=1.25p ps=5.5u w=5u l=1u
X598 a_63718_158395# a_55682_157349# a_62158_153995# VDD pfet_06v0 ad=1.3p pd=5.52u as=2.2p ps=10.88u w=5u l=1u
X599 a_106494_137692# a_99658_129706# a_106702_129750# VSS nfet_06v0 ad=2.2p pd=10.88u as=1.25p ps=5.5u w=5u l=1u
X600 a_113830_171272# a_49734_171355# VDD VDD pfet_06v0 ad=1.32p pd=6.88u as=1.32p ps=6.88u w=3u l=1u
X601 a_61486_174755# a_60846_171239# a_60042_174825# VDD pfet_06v0 ad=2.6p pd=10.52u as=4.4p ps=20.88u w=10u l=1u
X602 a_79458_153925# a_79258_153881# VSS VSS nfet_06v0 ad=1.25p pd=5.5u as=2.2p ps=10.88u w=5u l=1u
X603 a_49734_162619# a_41310_162619# VSS VSS nfet_06v0 ad=1.3p pd=5.52u as=2.2p ps=10.88u w=5u l=1u
X604 a_104618_181308# a_95990_179979# a_102158_172604# VDD pfet_06v0 ad=0.75p pd=3.5u as=1.32p ps=6.88u w=3u l=1u
X605 a_32310_183333# a_32610_183333# a_35546_183449# VDD pfet_06v0 ad=4.4p pd=20.88u as=2.5p ps=10.5u w=10u l=1u
X606 a_54970_129706# a_55010_136492# a_69446_136608# VDD pfet_06v0 ad=4.4p pd=20.88u as=2.5p ps=10.5u w=10u l=1u
X607 a_60042_183449# a_55682_183333# a_59742_183449# VDD pfet_06v0 ad=3.3p pd=10.66u as=2.5p ps=10.5u w=10u l=1u
X608 a_55682_174709# a_55682_174709# VDD VDD pfet_06v0 ad=0.88p pd=4.88u as=0.88p ps=4.88u w=2u l=1u
X609 a_102898_129706# a_106494_137692# a_103446_136608# VDD pfet_06v0 ad=1.76p pd=8.88u as=1.76p ps=8.88u w=4u l=1u
X610 a_55210_136608# a_55010_136492# a_56022_136608# VDD pfet_06v0 ad=4.4p pd=20.88u as=2.5p ps=10.5u w=10u l=1u
X611 a_85786_166019# a_86454_162619# VSS VSS nfet_06v0 ad=0.65p pd=3.02u as=1.1p ps=5.88u w=2.5u l=1u
X612 a_94426_179865# a_78526_179865# a_94626_179909# VSS nfet_06v0 ad=1.65p pd=5.66u as=1.25p ps=5.5u w=5u l=1u
X613 a_88018_158395# a_78866_157349# a_84230_153995# VDD pfet_06v0 ad=1.3p pd=5.52u as=2.2p ps=10.88u w=5u l=1u
X614 a_60374_174825# a_55682_174709# a_60042_174825# VDD pfet_06v0 ad=2.5p pd=10.5u as=3.3p ps=10.66u w=10u l=1u
X615 a_85786_174755# a_37774_171239# a_83226_174825# VDD pfet_06v0 ad=2.6p pd=10.52u as=4.4p ps=20.88u w=10u l=1u
X616 a_37774_153879# a_34534_117766# cap_mim_2f0_m4m5_noshield c_width=25u c_length=8u
X617 VSS a_41310_153995# a_49734_153995# VSS nfet_06v0 ad=1.3p pd=5.52u as=1.3p ps=5.52u w=5u l=1u
X618 a_32270_162505# a_32270_162505# VSS VSS nfet_06v0 ad=0.44p pd=2.88u as=0.44p ps=2.88u w=1u l=1u
X619 a_38414_174755# a_49734_171355# cap_mim_2f0_m4m5_noshield c_width=20u c_length=10u
X620 a_109102_163980# a_114650_171228# VDD VDD pfet_06v0 ad=1.32p pd=6.88u as=1.32p ps=6.88u w=3u l=1u
X621 a_79954_129750# a_81046_136608# VDD VDD pfet_06v0 ad=2.2p pd=10.88u as=2.2p ps=10.88u w=5u l=1u
X622 a_33502_141734# a_32270_141690# VSS VSS nfet_06v0 ad=1.25p pd=5.5u as=2.2p ps=10.88u w=5u l=1u
X623 a_32810_148592# a_32610_148476# a_32510_148592# VDD pfet_06v0 ad=4.4p pd=20.88u as=2.5p ps=10.5u w=10u l=1u
X624 a_56074_179865# a_55342_179865# a_56274_179909# VSS nfet_06v0 ad=2.2p pd=10.88u as=1.25p ps=5.5u w=5u l=1u
X625 VSS a_56074_179865# a_60014_179909# VSS nfet_06v0 ad=2.2p pd=10.88u as=1.25p ps=5.5u w=5u l=1u
X626 a_40646_184379# a_32610_183333# a_39086_179979# VDD pfet_06v0 ad=1.3p pd=5.52u as=2.2p ps=10.88u w=5u l=1u
X627 a_60042_183449# a_38886_179863# a_62602_183379# VDD pfet_06v0 ad=4.4p pd=20.88u as=2.6p ps=10.52u w=10u l=1u
X628 a_82638_117722# a_77298_124508# a_87374_124624# VDD pfet_06v0 ad=4.4p pd=20.88u as=2.5p ps=10.5u w=10u l=1u
X629 a_110574_141734# a_99358_141690# VSS VSS nfet_06v0 ad=1.25p pd=5.5u as=2.2p ps=10.88u w=5u l=1u
X630 a_36358_136608# a_32610_136492# a_35266_129750# VDD pfet_06v0 ad=4.4p pd=20.88u as=4.4p ps=20.88u w=10u l=1u
X631 a_32610_148476# a_32610_148476# a_45550_141734# VSS nfet_06v0 ad=0.44p pd=2.88u as=0.25p ps=1.5u w=1u l=1u
X632 a_77872_146196# a_82638_141690# a_82106_141734# VSS nfet_06v0 ad=0.88p pd=4.88u as=0.88p ps=4.88u w=2u l=1u
X633 VSS VDD VSS VSS nfet_06v0 ad=4.29p pd=20.38u as=0 ps=0 w=9.75u l=2u
X634 a_102354_141734# a_35066_117722# a_99858_141734# VSS nfet_06v0 ad=3.74p pd=17.88u as=3.74p ps=17.88u w=8.5u l=1u
X635 VDD a_86902_184379# a_85342_179979# VDD pfet_06v0 ad=1.3p pd=5.52u as=1.3p ps=5.52u w=5u l=1u
X636 a_62602_157395# a_63270_153995# VSS VSS nfet_06v0 ad=0.65p pd=3.02u as=1.1p ps=5.88u w=2.5u l=1u
X637 a_55210_148592# a_55010_148476# a_54910_148592# VDD pfet_06v0 ad=4.4p pd=20.88u as=2.5p ps=10.5u w=10u l=1u
X638 a_58210_129706# a_61806_137692# a_58758_136608# VDD pfet_06v0 ad=1.76p pd=8.88u as=1.76p ps=8.88u w=4u l=1u
X639 a_55010_148476# a_55010_148476# a_67950_141734# VSS nfet_06v0 ad=0.44p pd=2.88u as=0.25p ps=1.5u w=1u l=1u
X640 a_56074_162505# a_55682_165973# a_56694_166089# VDD pfet_06v0 ad=4.4p pd=20.88u as=2.5p ps=10.5u w=10u l=1u
X641 a_39614_129750# a_32270_129706# VSS VSS nfet_06v0 ad=1.25p pd=5.5u as=2.2p ps=10.88u w=5u l=1u
X642 a_39530_157395# a_32270_153881# a_40198_153995# VSS nfet_06v0 ad=1.1p pd=5.88u as=0.65p ps=3.02u w=2.5u l=1u
X643 a_70398_162549# a_56074_162505# VSS VSS nfet_06v0 ad=1.25p pd=5.5u as=2.2p ps=10.88u w=5u l=1u
X644 a_33502_117766# a_32270_117722# VSS VSS nfet_06v0 ad=1.25p pd=5.5u as=2.2p ps=10.88u w=5u l=1u
X645 a_110574_117766# a_99358_117722# VSS VSS nfet_06v0 ad=1.25p pd=5.5u as=2.2p ps=10.88u w=5u l=1u
X646 a_32610_124508# a_32610_124508# a_45550_117766# VSS nfet_06v0 ad=0.44p pd=2.88u as=0.25p ps=1.5u w=1u l=1u
X647 a_42022_129750# a_33184_134212# VDD VDD pfet_06v0 ad=0.44p pd=2.88u as=0.44p ps=2.88u w=1u l=1u
X648 a_77258_129706# a_77258_129706# VSS VSS nfet_06v0 ad=0.44p pd=2.88u as=0.44p ps=2.88u w=1u l=1u
X649 a_77872_122228# a_82638_117722# a_82106_117766# VSS nfet_06v0 ad=0.88p pd=4.88u as=0.88p ps=4.88u w=2u l=1u
X650 a_86902_184379# a_78866_183333# a_85342_179979# VDD pfet_06v0 ad=1.3p pd=5.52u as=2.2p ps=10.88u w=5u l=1u
X651 a_102354_117766# a_31060_204977# a_99858_117766# VSS nfet_06v0 ad=3.74p pd=17.88u as=3.74p ps=17.88u w=8.5u l=1u
X652 a_101822_138498# a_60846_171239# cap_mim_2f0_m4m5_noshield c_width=25u c_length=8u
X653 a_79222_129750# a_12580_36641# a_77458_129750# VSS nfet_06v0 ad=3.3p pd=15.88u as=3.3p ps=15.88u w=7.5u l=1u
X654 a_81802_157465# a_78566_157349# VDD VDD pfet_06v0 ad=2.5p pd=10.5u as=4.4p ps=20.88u w=10u l=1u
X655 VSS a_40198_171355# a_38414_174755# VSS nfet_06v0 ad=0.65p pd=3.02u as=0.65p ps=3.02u w=2.5u l=1u
X656 a_32270_129706# a_32610_136492# a_48158_136608# VDD pfet_06v0 ad=4.4p pd=20.88u as=2.5p ps=10.5u w=10u l=1u
X657 a_118422_153912# a_72806_153995# a_117490_153868# VSS nfet_06v0 ad=0.25p pd=1.5u as=0.44p ps=2.88u w=1u l=1u
X658 a_68734_153881# a_68734_153881# a_71242_153881# VSS nfet_06v0 ad=2.2p pd=10.88u as=1.65p ps=5.66u w=5u l=1u
X659 a_77872_147546# a_60846_179863# VSS ppolyf_u_1k r_width=1u r_length=76.45u
X660 a_55010_124508# a_55010_124508# a_67950_117766# VSS nfet_06v0 ad=0.44p pd=2.88u as=0.25p ps=1.5u w=1u l=1u
X661 a_40458_141690# a_32570_141690# a_40658_141734# VSS nfet_06v0 ad=1.65p pd=5.66u as=1.25p ps=5.5u w=5u l=1u
X662 a_87566_162619# a_92382_166973# a_88018_167019# VDD pfet_06v0 ad=2.2p pd=10.88u as=2.2p ps=10.88u w=5u l=1u
X663 VSS VDD VSS VSS nfet_06v0 ad=4.29p pd=20.38u as=0 ps=0 w=9.75u l=2u
X664 a_33184_134212# a_48602_134212# VSS ppolyf_u_1k r_width=1u r_length=76.45u
X665 a_12580_196913# a_107258_155244# a_107170_155360# VSS nfet_06v0 ad=0.6448p pd=3u as=1.0912p ps=5.84u w=2.48u l=1u
X666 VDD VSS VDD VDD pfet_06v0 ad=4.29p pd=20.38u as=0 ps=0 w=9.75u l=2u
X667 a_114134_124624# a_99398_124508# VDD VDD pfet_06v0 ad=2.5p pd=10.5u as=4.4p ps=20.88u w=10u l=1u
X668 a_54970_141690# a_54970_141690# VSS VSS nfet_06v0 ad=0.44p pd=2.88u as=0.44p ps=2.88u w=1u l=1u
X669 VSS a_40198_179979# a_39530_183379# VSS nfet_06v0 ad=1.1p pd=5.88u as=0.65p ps=3.02u w=2.5u l=1u
X670 a_37418_117766# a_39406_125708# a_33184_122228# VDD pfet_06v0 ad=1.76p pd=8.88u as=1.76p ps=8.88u w=4u l=1u
X671 a_57134_138498# a_12580_36641# a_55210_136608# VDD pfet_06v0 ad=0.242p pd=1.98u as=0.242p ps=1.98u w=0.55u l=1u
X672 a_86902_167019# a_91918_162505# a_86454_162619# VSS nfet_06v0 ad=1.1p pd=5.88u as=1.1p ps=5.88u w=2.5u l=1u
X673 a_100710_124624# a_99398_124508# VDD VDD pfet_06v0 ad=2.5p pd=10.5u as=4.4p ps=20.88u w=10u l=1u
X674 a_56934_141734# a_34334_141690# a_55170_141734# VSS nfet_06v0 ad=3.3p pd=15.88u as=3.3p ps=15.88u w=7.5u l=1u
X675 a_39530_174755# a_40198_171355# VSS VSS nfet_06v0 ad=0.65p pd=3.02u as=0.65p ps=3.02u w=2.5u l=1u
X676 a_62858_141690# a_54970_141690# a_63058_141734# VSS nfet_06v0 ad=1.65p pd=5.66u as=1.25p ps=5.5u w=5u l=1u
X677 a_12580_196913# a_102158_155244# a_102070_155360# VSS nfet_06v0 ad=0.6448p pd=3u as=1.0912p ps=5.84u w=2.48u l=1u
X678 a_77872_134212# a_77298_136492# a_79222_129750# VDD pfet_06v0 ad=4.4p pd=20.88u as=4.4p ps=20.88u w=10u l=1u
X679 a_99858_141734# a_99658_141690# a_99558_141734# VSS nfet_06v0 ad=2.2p pd=10.88u as=1.25p ps=5.5u w=5u l=1u
X680 a_71442_179909# a_71242_179865# VSS VSS nfet_06v0 ad=1.25p pd=5.5u as=2.2p ps=10.88u w=5u l=1u
X681 a_82106_129750# a_77258_129706# a_79422_138498# VSS nfet_06v0 ad=1.1p pd=5.88u as=0.825p ps=3.16u w=2.5u l=1u
X682 a_32610_157349# a_32610_157349# a_35266_153925# VSS nfet_06v0 ad=0.44p pd=2.88u as=0.25p ps=1.5u w=1u l=1u
X683 a_71034_183449# a_70834_183333# VDD VDD pfet_06v0 ad=2.5p pd=10.5u as=4.4p ps=20.88u w=10u l=1u
X684 a_105170_179852# a_49734_179979# VDD VDD pfet_06v0 ad=0.99p pd=3.66u as=1.32p ps=6.88u w=3u l=1u
X685 a_84230_171355# a_86902_175755# VDD VDD pfet_06v0 ad=1.3p pd=5.52u as=1.3p ps=5.52u w=5u l=1u
X686 a_40458_117722# a_32570_117722# a_40658_117766# VSS nfet_06v0 ad=1.65p pd=5.66u as=1.25p ps=5.5u w=5u l=1u
D25 VSS a_35066_141690# diode_nd2ps_06v0 pj=40u area=99.99999p
X687 a_54910_136608# a_54710_136492# VDD VDD pfet_06v0 ad=2.5p pd=10.5u as=4.4p ps=20.88u w=10u l=1u
X688 a_32570_141690# a_32610_148476# a_47046_148592# VDD pfet_06v0 ad=4.4p pd=20.88u as=2.5p ps=10.5u w=10u l=1u
X689 VSS a_86454_153995# a_85786_157395# VSS nfet_06v0 ad=1.1p pd=5.88u as=0.65p ps=3.02u w=2.5u l=1u
X690 a_80498_129706# a_77258_129706# a_80234_138508# VSS nfet_06v0 ad=1.1p pd=5.88u as=0.825p ps=3.16u w=2.5u l=1u
X691 a_54970_117722# a_54970_117722# VSS VSS nfet_06v0 ad=0.44p pd=2.88u as=0.44p ps=2.88u w=1u l=1u
X692 a_84670_166019# a_86454_162619# VSS VSS nfet_06v0 ad=0.65p pd=3.02u as=0.65p ps=3.02u w=2.5u l=1u
X693 a_115582_162536# a_113830_162536# a_114650_162492# VSS nfet_06v0 ad=0.25p pd=1.5u as=0.44p ps=2.88u w=1u l=1u
X694 a_57306_171285# a_55682_174709# VSS VSS nfet_06v0 ad=0.25p pd=1.5u as=0.44p ps=2.88u w=1u l=1u
X695 VSS VDD VSS VSS nfet_06v0 ad=4.29p pd=20.38u as=0 ps=0 w=9.75u l=2u
X696 a_102120_171396# a_102120_171396# VDD VDD pfet_06v0 ad=0.88p pd=4.88u as=0.88p ps=4.88u w=2u l=1u
X697 a_56934_117766# a_34334_141690# a_55170_117766# VSS nfet_06v0 ad=3.3p pd=15.88u as=3.3p ps=15.88u w=7.5u l=1u
X698 a_109774_148592# a_99398_148476# VDD VDD pfet_06v0 ad=2.5p pd=10.5u as=4.4p ps=20.88u w=10u l=1u
X699 a_83558_174825# a_78866_174709# a_83226_174825# VDD pfet_06v0 ad=2.5p pd=10.5u as=3.3p ps=10.66u w=10u l=1u
X700 a_62858_117722# a_54970_117722# a_63058_117766# VSS nfet_06v0 ad=1.65p pd=5.66u as=1.25p ps=5.5u w=5u l=1u
X701 a_99858_117766# a_99658_117722# a_99558_117766# VSS nfet_06v0 ad=2.2p pd=10.88u as=1.25p ps=5.5u w=5u l=1u
X702 a_67950_129750# a_55010_136492# VSS VSS nfet_06v0 ad=0.25p pd=1.5u as=0.44p ps=2.88u w=1u l=1u
X703 a_37774_153879# a_33184_122228# VDD VDD pfet_06v0 ad=0.44p pd=2.88u as=0.44p ps=2.88u w=1u l=1u
X704 a_99898_136608# a_99698_136492# a_100710_136608# VDD pfet_06v0 ad=4.4p pd=20.88u as=2.5p ps=10.5u w=10u l=1u
X705 VSS a_79258_153881# a_83198_153925# VSS nfet_06v0 ad=2.2p pd=10.88u as=1.25p ps=5.5u w=5u l=1u
X706 a_94218_166089# a_94018_165973# VDD VDD pfet_06v0 ad=2.5p pd=10.5u as=4.4p ps=20.88u w=10u l=1u
X707 VDD a_63718_175755# a_62158_171355# VDD pfet_06v0 ad=2.2p pd=10.88u as=1.3p ps=5.52u w=5u l=1u
X708 a_71242_162505# a_55342_162505# a_71442_162549# VSS nfet_06v0 ad=1.65p pd=5.66u as=1.25p ps=5.5u w=5u l=1u
X709 a_49734_153995# a_41310_153995# VSS VSS nfet_06v0 ad=1.3p pd=5.52u as=2.2p ps=10.88u w=5u l=1u
X710 a_36610_179909# a_38886_179863# a_39086_179979# VSS nfet_06v0 ad=2.2p pd=10.88u as=1.3p ps=5.52u w=5u l=1u
X711 a_79258_179865# a_78526_179865# a_79458_179909# VSS nfet_06v0 ad=2.2p pd=10.88u as=1.25p ps=5.5u w=5u l=1u
D26 VSS a_12580_76961# diode_nd2ps_06v0 pj=40u area=99.99999p
X712 VDD VSS VDD VDD pfet_06v0 ad=4.29p pd=20.38u as=0 ps=0 w=9.75u l=2u
X713 a_41042_124508# a_32610_124508# a_41242_124624# VDD pfet_06v0 ad=3.3p pd=10.66u as=2.5p ps=10.5u w=10u l=1u
X714 VSS VDD VSS VSS nfet_06v0 ad=4.29p pd=20.38u as=0 ps=0 w=9.75u l=2u
X715 a_72478_174825# a_55382_174709# VDD VDD pfet_06v0 ad=2.5p pd=10.5u as=4.4p ps=20.88u w=10u l=1u
X716 a_49734_162619# a_41762_167019# VDD VDD pfet_06v0 ad=4.4p pd=20.88u as=2.6p ps=10.52u w=10u l=1u
X717 a_62602_183379# a_38886_179863# a_60042_183449# VDD pfet_06v0 ad=2.6p pd=10.52u as=4.4p ps=20.88u w=10u l=1u
X718 a_36942_171285# a_32270_171241# a_36610_171285# VSS nfet_06v0 ad=1.25p pd=5.5u as=1.65p ps=5.66u w=5u l=1u
X719 a_85786_157395# a_86454_153995# VSS VSS nfet_06v0 ad=0.65p pd=3.02u as=1.1p ps=5.88u w=2.5u l=1u
X720 a_82926_157465# a_78566_157349# VDD VDD pfet_06v0 ad=2.5p pd=10.5u as=4.4p ps=20.88u w=10u l=1u
X721 a_32610_165973# a_32610_165973# VDD VDD pfet_06v0 ad=0.88p pd=4.88u as=0.88p ps=4.88u w=2u l=1u
X722 a_79258_162505# a_78866_165973# a_79878_166089# VDD pfet_06v0 ad=4.4p pd=20.88u as=2.5p ps=10.5u w=10u l=1u
X723 a_60014_179909# a_55342_179865# a_59682_179909# VSS nfet_06v0 ad=1.25p pd=5.5u as=1.65p ps=5.66u w=5u l=1u
X724 a_84670_183379# a_86454_179979# VSS VSS nfet_06v0 ad=0.65p pd=3.02u as=1.1p ps=5.88u w=2.5u l=1u
X725 a_58618_157465# a_55382_157349# VDD VDD pfet_06v0 ad=2.5p pd=10.5u as=4.4p ps=20.88u w=10u l=1u
X726 a_78566_174709# a_78866_174709# a_80490_171285# VSS nfet_06v0 ad=0.44p pd=2.88u as=0.25p ps=1.5u w=1u l=1u
X727 VSS a_63270_171355# a_62602_174755# VSS nfet_06v0 ad=1.1p pd=5.88u as=0.65p ps=3.02u w=2.5u l=1u
X728 a_103446_136608# a_99698_136492# a_102354_129750# VDD pfet_06v0 ad=4.4p pd=20.88u as=4.4p ps=20.88u w=10u l=1u
X729 a_94770_136608# a_76998_136492# VDD VDD pfet_06v0 ad=2.5p pd=10.5u as=4.4p ps=20.88u w=10u l=1u
X730 a_99698_148476# a_99698_148476# VDD VDD pfet_06v0 ad=0.88p pd=4.88u as=0.88p ps=4.88u w=2u l=1u
X731 a_63058_129750# a_62858_129706# VSS VSS nfet_06v0 ad=1.25p pd=5.5u as=2.2p ps=10.88u w=5u l=1u
X732 a_59382_179909# a_56074_179865# VSS VSS nfet_06v0 ad=1.25p pd=5.5u as=2.2p ps=10.88u w=5u l=1u
X733 a_115246_124624# a_99398_124508# VDD VDD pfet_06v0 ad=2.5p pd=10.5u as=4.4p ps=20.88u w=10u l=1u
X734 a_47046_136608# a_32310_136492# VDD VDD pfet_06v0 ad=2.5p pd=10.5u as=4.4p ps=20.88u w=10u l=1u
X735 a_92846_148592# a_76998_148476# VDD VDD pfet_06v0 ad=2.5p pd=10.5u as=4.4p ps=20.88u w=10u l=1u
X736 a_83226_183449# a_78866_183333# a_82926_183449# VDD pfet_06v0 ad=3.3p pd=10.66u as=2.5p ps=10.5u w=10u l=1u
D27 VSS a_34334_117722# diode_nd2ps_06v0 pj=40u area=99.99999p
X737 VSS VDD VSS VSS nfet_06v0 ad=4.29p pd=20.38u as=0 ps=0 w=9.75u l=2u
X738 a_33622_136608# a_32310_136492# VDD VDD pfet_06v0 ad=2.5p pd=10.5u as=4.4p ps=20.88u w=10u l=1u
X739 VDD VSS VDD VDD pfet_06v0 ad=7.92p pd=36.88u as=0 ps=0 w=18u l=2u
X740 a_32470_129750# a_32270_129706# VSS VSS nfet_06v0 ad=1.25p pd=5.5u as=2.2p ps=10.88u w=5u l=1u
X741 a_59682_171285# a_60846_171239# a_61046_171355# VSS nfet_06v0 ad=2.2p pd=10.88u as=1.3p ps=5.52u w=5u l=1u
X742 a_106702_129750# a_99358_129706# VSS VSS nfet_06v0 ad=1.25p pd=5.5u as=2.2p ps=10.88u w=5u l=1u
X743 a_77872_122678# a_93290_122228# VSS ppolyf_u_1k r_width=1u r_length=76.45u
X744 VDD VSS VDD VDD pfet_06v0 ad=7.92p pd=36.88u as=0 ps=0 w=18u l=2u
X745 a_69446_136608# a_54710_136492# VDD VDD pfet_06v0 ad=2.5p pd=10.5u as=4.4p ps=20.88u w=10u l=1u
X746 a_35546_183449# a_32310_183333# VDD VDD pfet_06v0 ad=2.5p pd=10.5u as=4.4p ps=20.88u w=10u l=1u
X747 a_57134_150482# a_37774_179863# cap_mim_2f0_m4m5_noshield c_width=25u c_length=8u
X748 a_95990_162619# a_87566_162619# VSS VSS nfet_06v0 ad=2.2p pd=10.88u as=1.3p ps=5.52u w=5u l=1u
X749 a_59742_183449# a_55382_183333# VDD VDD pfet_06v0 ad=2.5p pd=10.5u as=4.4p ps=20.88u w=10u l=1u
X750 VDD VSS VDD VDD pfet_06v0 ad=7.92p pd=36.88u as=0 ps=0 w=18u l=2u
D28 a_12580_56801# VDD diode_pd2nw_06v0 pj=40u area=99.99999p
X751 a_59682_162549# a_55342_162505# a_59382_162549# VSS nfet_06v0 ad=1.65p pd=5.66u as=1.25p ps=5.5u w=5u l=1u
D29 a_50996_204977# VDD diode_pd2nw_06v0 pj=40u area=99.99999p
X752 a_94626_179909# a_94426_179865# VSS VSS nfet_06v0 ad=1.25p pd=5.5u as=2.2p ps=10.88u w=5u l=1u
X753 a_99358_129706# a_99698_136492# a_115246_136608# VDD pfet_06v0 ad=4.4p pd=20.88u as=2.5p ps=10.5u w=10u l=1u
D30 VSS a_35066_117722# diode_nd2ps_06v0 pj=40u area=99.99999p
X754 a_56934_129750# a_58758_136608# VDD VDD pfet_06v0 ad=2.2p pd=10.88u as=2.2p ps=10.88u w=5u l=1u
X755 a_100272_134212# a_115690_134212# VSS ppolyf_u_1k r_width=1u r_length=76.45u
X756 a_33002_153881# a_32610_157349# a_33622_157465# VDD pfet_06v0 ad=4.4p pd=20.88u as=2.5p ps=10.5u w=10u l=1u
X757 a_57946_126524# a_35066_141690# a_55210_124624# VDD pfet_06v0 ad=0.22p pd=1.88u as=0.22p ps=1.88u w=0.5u l=1u
X758 a_32510_148592# a_32310_148476# VDD VDD pfet_06v0 ad=2.5p pd=10.5u as=4.4p ps=20.88u w=10u l=1u
X759 a_56274_179909# a_56074_179865# VSS VSS nfet_06v0 ad=1.25p pd=5.5u as=2.2p ps=10.88u w=5u l=1u
X760 a_87374_124624# a_76998_124508# VDD VDD pfet_06v0 ad=2.5p pd=10.5u as=4.4p ps=20.88u w=10u l=1u
X761 a_45550_141734# a_32610_148476# VSS VSS nfet_06v0 ad=0.25p pd=1.5u as=0.44p ps=2.88u w=1u l=1u
X762 VSS a_86454_162619# a_84670_166019# VSS nfet_06v0 ad=0.65p pd=3.02u as=0.65p ps=3.02u w=2.5u l=1u
X763 a_76958_141690# a_77258_141690# a_88174_141734# VSS nfet_06v0 ad=2.2p pd=10.88u as=1.25p ps=5.5u w=5u l=1u
D31 VSS a_12580_56801# diode_nd2ps_06v0 pj=40u area=99.99999p
X764 a_49734_179979# a_37974_179979# cap_mim_2f0_m4m5_noshield c_width=20u c_length=10u
X765 a_72806_179979# a_64382_179979# VSS VSS nfet_06v0 ad=2.2p pd=10.88u as=1.3p ps=5.52u w=5u l=1u
X766 a_105038_141690# a_105038_141690# a_107546_141690# VSS nfet_06v0 ad=2.2p pd=10.88u as=1.65p ps=5.66u w=5u l=1u
X767 a_107258_155244# a_117490_153868# VDD VDD pfet_06v0 ad=1.32p pd=6.88u as=1.32p ps=6.88u w=3u l=1u
X768 VDD a_86902_175755# a_85342_171355# VDD pfet_06v0 ad=2.2p pd=10.88u as=1.3p ps=5.52u w=5u l=1u
X769 a_94426_162505# a_78526_162505# a_94626_162549# VSS nfet_06v0 ad=1.65p pd=5.66u as=1.25p ps=5.5u w=5u l=1u
X770 a_41762_158395# a_45662_153881# a_41310_153995# VSS nfet_06v0 ad=1.1p pd=5.88u as=1.1p ps=5.88u w=2.5u l=1u
X771 a_36970_166089# a_38886_162503# a_39530_166019# VDD pfet_06v0 ad=4.4p pd=20.88u as=2.6p ps=10.52u w=10u l=1u
X772 VSS a_114650_171228# a_109102_163980# VSS nfet_06v0 ad=0.44p pd=2.88u as=0.44p ps=2.88u w=1u l=1u
X773 VDD VSS VDD VDD pfet_06v0 ad=7.92p pd=36.88u as=0 ps=0 w=18u l=2u
X774 a_38414_166019# a_40198_162619# VSS VSS nfet_06v0 ad=0.65p pd=3.02u as=1.1p ps=5.88u w=2.5u l=1u
X775 VDD VSS VDD VDD pfet_06v0 ad=4.29p pd=20.38u as=0 ps=0 w=9.75u l=2u
X776 VSS a_64382_171355# a_72806_171355# VSS nfet_06v0 ad=1.3p pd=5.52u as=1.3p ps=5.52u w=5u l=1u
X777 a_56694_166089# a_55382_165973# VDD VDD pfet_06v0 ad=2.5p pd=10.5u as=4.4p ps=20.88u w=10u l=1u
X778 a_49734_162619# a_37974_162619# cap_mim_2f0_m4m5_noshield c_width=20u c_length=10u
X779 VDD VSS VDD VDD pfet_06v0 ad=0.44p pd=2.88u as=0 ps=0 w=1u l=2u
X780 a_78866_174709# a_78866_174709# VDD VDD pfet_06v0 ad=0.88p pd=4.88u as=0.88p ps=4.88u w=2u l=1u
X781 a_35546_138508# a_35810_129706# VSS VSS nfet_06v0 ad=0.825p pd=3.16u as=1.1p ps=5.88u w=2.5u l=1u
X782 a_99658_141690# a_99698_148476# a_114134_148592# VDD pfet_06v0 ad=4.4p pd=20.88u as=2.5p ps=10.5u w=10u l=1u
X783 a_84670_157395# a_86454_153995# VSS VSS nfet_06v0 ad=0.65p pd=3.02u as=0.65p ps=3.02u w=2.5u l=1u
X784 VSS a_56074_162505# a_60014_162549# VSS nfet_06v0 ad=2.2p pd=10.88u as=1.25p ps=5.5u w=5u l=1u
X785 a_56074_162505# a_55342_162505# a_56274_162549# VSS nfet_06v0 ad=2.2p pd=10.88u as=1.25p ps=5.5u w=5u l=1u
X786 a_45550_117766# a_32610_124508# VSS VSS nfet_06v0 ad=0.25p pd=1.5u as=0.44p ps=2.88u w=1u l=1u
X787 VDD a_41762_167019# a_49734_162619# VDD pfet_06v0 ad=2.6p pd=10.52u as=2.6p ps=10.52u w=10u l=1u
X788 a_76958_117722# a_77258_117722# a_88174_117766# VSS nfet_06v0 ad=2.2p pd=10.88u as=1.25p ps=5.5u w=5u l=1u
X789 a_82638_129706# a_77298_136492# a_87374_136608# VDD pfet_06v0 ad=4.4p pd=20.88u as=2.5p ps=10.5u w=10u l=1u
X790 VSS a_63270_179979# a_62602_183379# VSS nfet_06v0 ad=0.65p pd=3.02u as=0.65p ps=3.02u w=2.5u l=1u
X791 a_105038_117722# a_105038_117722# a_107546_117722# VSS nfet_06v0 ad=2.2p pd=10.88u as=1.65p ps=5.66u w=5u l=1u
X792 a_37774_162503# a_100272_122228# VDD VDD pfet_06v0 ad=0.44p pd=2.88u as=0.44p ps=2.88u w=1u l=1u
X793 a_57946_138508# a_58210_129706# VSS VSS nfet_06v0 ad=0.825p pd=3.16u as=1.1p ps=5.88u w=2.5u l=1u
X794 a_40198_179979# a_46126_184333# a_40646_184379# VDD pfet_06v0 ad=2.2p pd=10.88u as=2.2p ps=10.88u w=5u l=1u
X795 a_37774_179863# a_55584_146196# VDD VDD pfet_06v0 ad=0.44p pd=2.88u as=0.44p ps=2.88u w=1u l=1u
X796 a_91918_162505# a_78866_165973# a_95662_166089# VDD pfet_06v0 ad=4.4p pd=20.88u as=2.5p ps=10.5u w=10u l=1u
X797 a_40658_141734# a_40458_141690# VSS VSS nfet_06v0 ad=1.25p pd=5.5u as=2.2p ps=10.88u w=5u l=1u
X798 a_77158_141734# a_76958_141690# VSS VSS nfet_06v0 ad=1.25p pd=5.5u as=2.2p ps=10.88u w=5u l=1u
X799 a_102320_162888# a_102120_162772# VSS VSS nfet_06v0 ad=0.5456p pd=3.36u as=0.5456p ps=3.36u w=1.24u l=1u
D32 VSS a_35066_141690# diode_nd2ps_06v0 pj=40u area=99.99999p
X800 a_49734_153995# a_41762_158395# VDD VDD pfet_06v0 ad=4.4p pd=20.88u as=2.6p ps=10.52u w=10u l=1u
X801 VDD VSS VDD VDD pfet_06v0 ad=4.29p pd=20.38u as=0 ps=0 w=9.75u l=2u
X802 a_99558_141734# a_99358_141690# VSS VSS nfet_06v0 ad=1.25p pd=5.5u as=2.2p ps=10.88u w=5u l=1u
X803 a_77498_124624# a_77298_124508# a_78310_124624# VDD pfet_06v0 ad=4.4p pd=20.88u as=2.5p ps=10.5u w=10u l=1u
X804 a_82866_171285# a_60846_171239# a_84230_171355# VSS nfet_06v0 ad=2.2p pd=10.88u as=1.3p ps=5.52u w=5u l=1u
X805 a_84094_149676# a_84094_149676# a_85730_148476# VDD pfet_06v0 ad=4.4p pd=20.88u as=3.3p ps=10.66u w=10u l=1u
X806 a_99858_141734# a_99658_141690# a_100590_141734# VSS nfet_06v0 ad=2.2p pd=10.88u as=1.25p ps=5.5u w=5u l=1u
X807 a_35266_153925# a_32610_157349# VSS VSS nfet_06v0 ad=0.25p pd=1.5u as=0.44p ps=2.88u w=1u l=1u
X808 a_114650_171228# a_95990_171355# VDD VDD pfet_06v0 ad=0.99p pd=3.66u as=1.32p ps=6.88u w=3u l=1u
X809 a_36610_179909# a_37774_179863# a_37974_179979# VSS nfet_06v0 ad=2.2p pd=10.88u as=1.3p ps=5.52u w=5u l=1u
D33 a_12580_36641# VDD diode_pd2nw_06v0 pj=40u area=99.99999p
X810 a_40658_117766# a_40458_117722# VSS VSS nfet_06v0 ad=1.25p pd=5.5u as=2.2p ps=10.88u w=5u l=1u
X811 a_77158_117766# a_76958_117722# VSS VSS nfet_06v0 ad=1.25p pd=5.5u as=2.2p ps=10.88u w=5u l=1u
X812 a_88174_129750# a_76958_129706# VSS VSS nfet_06v0 ad=1.25p pd=5.5u as=2.2p ps=10.88u w=5u l=1u
X813 a_95990_171355# a_88018_175755# VDD VDD pfet_06v0 ad=4.4p pd=20.88u as=2.6p ps=10.52u w=10u l=1u
D34 a_50996_204977# VDD diode_pd2nw_06v0 pj=40u area=99.99999p
X814 a_99698_136492# a_99698_136492# a_112638_129750# VSS nfet_06v0 ad=0.44p pd=2.88u as=0.25p ps=1.5u w=1u l=1u
X815 a_37974_171355# a_37774_171239# a_36610_171285# VSS nfet_06v0 ad=1.3p pd=5.52u as=2.2p ps=10.88u w=5u l=1u
X816 VSS a_87566_162619# a_95990_162619# VSS nfet_06v0 ad=1.3p pd=5.52u as=1.3p ps=5.52u w=5u l=1u
X817 a_36358_136608# a_37950_129706# a_35810_129706# VSS nfet_06v0 ad=0.88p pd=4.88u as=0.88p ps=4.88u w=2u l=1u
X818 VSS a_63270_162619# a_61486_166019# VSS nfet_06v0 ad=0.65p pd=3.02u as=0.65p ps=3.02u w=2.5u l=1u
X819 a_77872_122678# a_93290_123128# VSS ppolyf_u_1k r_width=1u r_length=76.45u
D35 a_12580_136433# VDD diode_pd2nw_06v0 pj=40u area=99.99999p
X820 a_79954_129750# a_12580_56801# a_77458_129750# VSS nfet_06v0 ad=3.74p pd=17.88u as=3.74p ps=17.88u w=8.5u l=1u
X821 a_114134_136608# a_99398_136492# VDD VDD pfet_06v0 ad=2.5p pd=10.5u as=4.4p ps=20.88u w=10u l=1u
X822 a_39086_171355# a_40646_175755# VDD VDD pfet_06v0 ad=1.3p pd=5.52u as=1.3p ps=5.52u w=5u l=1u
X823 a_37418_129750# a_39406_137692# a_33184_134212# VDD pfet_06v0 ad=1.76p pd=8.88u as=1.76p ps=8.88u w=4u l=1u
X824 a_12580_196913# VDD a_105128_154152# VSS nfet_06v0 ad=0.6448p pd=3u as=1.0912p ps=5.84u w=2.48u l=1u
X825 a_99558_117766# a_99358_117722# VSS VSS nfet_06v0 ad=1.25p pd=5.5u as=2.2p ps=10.88u w=5u l=1u
X826 a_55584_135562# a_71002_135112# VSS ppolyf_u_1k r_width=1u r_length=76.45u
X827 VSS VDD VSS VSS nfet_06v0 ad=7.92p pd=36.88u as=0 ps=0 w=18u l=2u
X828 a_100710_136608# a_99398_136492# VDD VDD pfet_06v0 ad=2.5p pd=10.5u as=4.4p ps=20.88u w=10u l=1u
X829 a_36970_166089# a_37774_162503# a_38414_166019# VDD pfet_06v0 ad=4.4p pd=20.88u as=2.6p ps=10.52u w=10u l=1u
D36 a_34334_117722# VDD diode_pd2nw_06v0 pj=40u area=99.99999p
X830 a_99858_117766# a_99658_117722# a_100590_117766# VSS nfet_06v0 ad=2.2p pd=10.88u as=1.25p ps=5.5u w=5u l=1u
D37 VSS a_12580_36641# diode_nd2ps_06v0 pj=40u area=99.99999p
X831 a_71442_162549# a_71242_162505# VSS VSS nfet_06v0 ad=1.25p pd=5.5u as=2.2p ps=10.88u w=5u l=1u
X832 VDD a_40646_167019# a_37974_162619# VDD pfet_06v0 ad=2.2p pd=10.88u as=1.3p ps=5.52u w=5u l=1u
X833 a_79458_179909# a_79258_179865# VSS VSS nfet_06v0 ad=1.25p pd=5.5u as=2.2p ps=10.88u w=5u l=1u
X834 a_69198_166973# a_69198_166973# a_70834_165973# VDD pfet_06v0 ad=4.4p pd=20.88u as=3.3p ps=10.66u w=10u l=1u
X835 a_95990_153995# a_87566_153995# VSS VSS nfet_06v0 ad=2.2p pd=10.88u as=1.3p ps=5.52u w=5u l=1u
X836 a_62602_166019# a_63270_162619# VSS VSS nfet_06v0 ad=0.65p pd=3.02u as=0.65p ps=3.02u w=2.5u l=1u
X837 a_59682_162549# a_38886_162503# a_62158_162619# VSS nfet_06v0 ad=2.2p pd=10.88u as=1.3p ps=5.52u w=5u l=1u
X838 a_41242_124624# a_41042_124508# VDD VDD pfet_06v0 ad=2.5p pd=10.5u as=4.4p ps=20.88u w=10u l=1u
X839 a_39086_171355# a_32610_174709# a_40646_175755# VDD pfet_06v0 ad=2.2p pd=10.88u as=1.3p ps=5.52u w=5u l=1u
X840 VSS VDD VSS VSS nfet_06v0 ad=7.92p pd=36.88u as=0 ps=0 w=18u l=2u
X841 VDD VSS VDD VDD pfet_06v0 ad=0.44p pd=2.88u as=0 ps=0 w=1u l=2u
X842 a_32610_124508# a_32610_124508# VDD VDD pfet_06v0 ad=0.88p pd=4.88u as=0.88p ps=4.88u w=2u l=1u
X843 a_54670_117722# a_55010_124508# a_70558_124624# VDD pfet_06v0 ad=4.4p pd=20.88u as=2.5p ps=10.5u w=10u l=1u
X844 a_32270_179865# a_32610_183333# a_32510_183449# VDD pfet_06v0 ad=4.4p pd=20.88u as=2.5p ps=10.5u w=10u l=1u
X845 a_85342_171355# a_86902_175755# VDD VDD pfet_06v0 ad=1.3p pd=5.52u as=1.3p ps=5.52u w=5u l=1u
X846 a_79878_166089# a_78566_165973# VDD VDD pfet_06v0 ad=2.5p pd=10.5u as=4.4p ps=20.88u w=10u l=1u
X847 VDD a_40646_184379# a_37974_179979# VDD pfet_06v0 ad=1.3p pd=5.52u as=1.3p ps=5.52u w=5u l=1u
X848 VSS a_41310_179979# a_49734_179979# VSS nfet_06v0 ad=1.3p pd=5.52u as=1.3p ps=5.52u w=5u l=1u
X849 a_39530_166019# a_38886_162503# a_36970_166089# VDD pfet_06v0 ad=2.6p pd=10.52u as=4.4p ps=20.88u w=10u l=1u
X850 a_60846_179863# a_82106_141734# VSS VSS nfet_06v0 ad=0.44p pd=2.88u as=0.44p ps=2.88u w=1u l=1u
X851 a_42022_129750# a_33184_134212# VDD VDD pfet_06v0 ad=0.44p pd=2.88u as=0.44p ps=2.88u w=1u l=1u
X852 a_79258_162505# a_78526_162505# a_79458_162549# VSS nfet_06v0 ad=2.2p pd=10.88u as=1.25p ps=5.5u w=5u l=1u
X853 a_80490_171285# a_78866_174709# VSS VSS nfet_06v0 ad=0.25p pd=1.5u as=0.44p ps=2.88u w=1u l=1u
X854 VSS a_86454_153995# a_84670_157395# VSS nfet_06v0 ad=0.65p pd=3.02u as=0.65p ps=3.02u w=2.5u l=1u
X855 a_41042_136492# a_32610_136492# a_41242_136608# VDD pfet_06v0 ad=3.3p pd=10.66u as=2.5p ps=10.5u w=10u l=1u
X856 a_38414_174755# a_32270_171241# a_41310_171355# VSS nfet_06v0 ad=1.1p pd=5.88u as=0.65p ps=3.02u w=2.5u l=1u
X857 a_36610_153925# a_32270_153881# a_36310_153925# VSS nfet_06v0 ad=1.65p pd=5.66u as=1.25p ps=5.5u w=5u l=1u
X858 a_62602_183379# a_63270_179979# VSS VSS nfet_06v0 ad=0.65p pd=3.02u as=1.1p ps=5.88u w=2.5u l=1u
X859 a_60846_179863# a_77872_146196# VDD VDD pfet_06v0 ad=0.44p pd=2.88u as=0.44p ps=2.88u w=1u l=1u
X860 a_36970_157465# a_38886_153879# a_39530_157395# VDD pfet_06v0 ad=4.4p pd=20.88u as=2.6p ps=10.52u w=10u l=1u
X861 ZP_OUT ZN_OUT VSS VSS nfet_05v0 ad=0.5808p pd=3.52u as=0.5808p ps=3.52u w=1.32u l=0.6u
X862 a_38414_157395# a_40198_153995# VSS VSS nfet_06v0 ad=0.65p pd=3.02u as=1.1p ps=5.88u w=2.5u l=1u
X863 a_60014_162549# a_55342_162505# a_59682_162549# VSS nfet_06v0 ad=1.25p pd=5.5u as=1.65p ps=5.66u w=5u l=1u
X864 VDD a_55382_183333# a_60374_183449# VDD pfet_06v0 ad=4.4p pd=20.88u as=2.5p ps=10.5u w=10u l=1u
X865 a_77298_124508# a_77298_124508# VDD VDD pfet_06v0 ad=0.88p pd=4.88u as=0.88p ps=4.88u w=2u l=1u
X866 a_38886_153879# a_82106_117766# VSS VSS nfet_06v0 ad=0.44p pd=2.88u as=0.44p ps=2.88u w=1u l=1u
X867 a_34734_126514# a_34334_117722# a_32810_124624# VDD pfet_06v0 ad=0.242p pd=1.98u as=0.242p ps=1.98u w=0.55u l=1u
X868 VSS VDD VSS VSS nfet_06v0 ad=7.92p pd=36.88u as=0 ps=0 w=18u l=2u
X869 a_39530_183379# a_32270_179865# a_40198_179979# VSS nfet_06v0 ad=1.1p pd=5.88u as=0.65p ps=3.02u w=2.5u l=1u
X870 a_92382_158349# a_78526_153881# a_93582_153925# VSS nfet_06v0 ad=2.2p pd=10.88u as=1.25p ps=5.5u w=5u l=1u
X871 a_60846_171239# a_101622_129750# cap_mim_2f0_m4m5_noshield c_width=25u c_length=8u
X872 VDD VSS VDD VDD pfet_06v0 ad=4.29p pd=20.38u as=0 ps=0 w=9.75u l=2u
X873 VDD a_41762_158395# a_49734_153995# VDD pfet_06v0 ad=2.6p pd=10.52u as=2.6p ps=10.52u w=10u l=1u
X874 a_59382_162549# a_56074_162505# VSS VSS nfet_06v0 ad=1.25p pd=5.5u as=2.2p ps=10.88u w=5u l=1u
X875 a_116938_155324# a_95990_153995# a_107258_172604# VDD pfet_06v0 ad=0.75p pd=3.5u as=1.32p ps=6.88u w=3u l=1u
X876 VDD a_32310_157349# a_37302_157465# VDD pfet_06v0 ad=4.4p pd=20.88u as=2.5p ps=10.5u w=10u l=1u
X877 VSS VDD VSS VSS nfet_06v0 ad=7.92p pd=36.88u as=0 ps=0 w=18u l=2u
X878 a_115246_136608# a_99398_136492# VDD VDD pfet_06v0 ad=2.5p pd=10.5u as=4.4p ps=20.88u w=10u l=1u
X879 a_68734_179865# a_68734_179865# a_71242_179865# VSS nfet_06v0 ad=2.2p pd=10.88u as=1.65p ps=5.66u w=5u l=1u
X880 a_84230_171355# a_60846_171239# a_82866_171285# VSS nfet_06v0 ad=1.3p pd=5.52u as=2.2p ps=10.88u w=5u l=1u
X881 a_64382_171355# a_69198_175709# a_64834_175755# VDD pfet_06v0 ad=2.2p pd=10.88u as=2.2p ps=10.88u w=5u l=1u
X882 a_33622_157465# a_32310_157349# VDD VDD pfet_06v0 ad=2.5p pd=10.5u as=4.4p ps=20.88u w=10u l=1u
X883 a_41310_171355# a_46126_175709# a_41762_175755# VDD pfet_06v0 ad=2.2p pd=10.88u as=2.2p ps=10.88u w=5u l=1u
X884 VDD a_86902_167019# a_84230_162619# VDD pfet_06v0 ad=1.3p pd=5.52u as=1.3p ps=5.52u w=5u l=1u
X885 a_60846_153879# a_56934_117766# cap_mim_2f0_m4m5_noshield c_width=25u c_length=8u
X886 a_33002_153881# a_32270_153881# a_33202_153925# VSS nfet_06v0 ad=2.2p pd=10.88u as=1.25p ps=5.5u w=5u l=1u
X887 a_61486_166019# a_63270_162619# VSS VSS nfet_06v0 ad=0.65p pd=3.02u as=1.1p ps=5.88u w=2.5u l=1u
X888 a_46126_175709# a_46126_175709# a_47762_174709# VDD pfet_06v0 ad=4.4p pd=20.88u as=3.3p ps=10.66u w=10u l=1u
X889 a_94626_162549# a_94426_162505# VSS VSS nfet_06v0 ad=1.25p pd=5.5u as=2.2p ps=10.88u w=5u l=1u
X890 a_35266_117766# a_36358_124624# VDD VDD pfet_06v0 ad=2.2p pd=10.88u as=2.2p ps=10.88u w=5u l=1u
X891 a_32610_183333# a_32610_183333# a_35266_179909# VSS nfet_06v0 ad=0.44p pd=2.88u as=0.25p ps=1.5u w=1u l=1u
X892 a_78566_165973# a_78866_165973# a_81802_166089# VDD pfet_06v0 ad=4.4p pd=20.88u as=2.5p ps=10.5u w=10u l=1u
X893 a_38414_166019# a_37774_162503# a_36970_166089# VDD pfet_06v0 ad=2.6p pd=10.52u as=4.4p ps=20.88u w=10u l=1u
X894 VDD VSS VDD VDD pfet_06v0 ad=7.92p pd=36.88u as=0 ps=0 w=18u l=2u
X895 VSS a_49734_162619# a_118422_162536# VSS nfet_06v0 ad=0.44p pd=2.88u as=0.25p ps=1.5u w=1u l=1u
X896 a_37974_162619# a_40646_167019# VDD VDD pfet_06v0 ad=1.3p pd=5.52u as=1.3p ps=5.52u w=5u l=1u
X897 a_55584_135562# a_38886_162503# VSS ppolyf_u_1k r_width=1u r_length=76.45u
X898 a_82866_162549# a_37774_162503# a_85342_162619# VSS nfet_06v0 ad=2.2p pd=10.88u as=1.3p ps=5.52u w=5u l=1u
X899 VSS a_86454_179979# a_85786_183379# VSS nfet_06v0 ad=1.1p pd=5.88u as=0.65p ps=3.02u w=2.5u l=1u
X900 VSS a_87566_153995# a_95990_153995# VSS nfet_06v0 ad=1.3p pd=5.52u as=1.3p ps=5.52u w=5u l=1u
X901 a_79422_150482# a_60846_179863# cap_mim_2f0_m4m5_noshield c_width=25u c_length=8u
X902 a_57946_138508# a_12580_56801# a_55210_136608# VDD pfet_06v0 ad=0.22p pd=1.88u as=0.22p ps=1.88u w=0.5u l=1u
X903 VSS a_63270_153995# a_61486_157395# VSS nfet_06v0 ad=0.65p pd=3.02u as=0.65p ps=3.02u w=2.5u l=1u
X904 a_56274_162549# a_56074_162505# VSS VSS nfet_06v0 ad=1.25p pd=5.5u as=2.2p ps=10.88u w=5u l=1u
X905 a_33184_123578# a_48602_123128# VSS ppolyf_u_1k r_width=1u r_length=76.45u
X906 a_47962_157465# a_47762_157349# VDD VDD pfet_06v0 ad=2.5p pd=10.5u as=4.4p ps=20.88u w=10u l=1u
X907 a_39086_162619# a_38886_162503# a_36610_162549# VSS nfet_06v0 ad=1.3p pd=5.52u as=2.2p ps=10.88u w=5u l=1u
X908 a_32310_124508# a_32610_124508# a_50082_124624# VDD pfet_06v0 ad=4.4p pd=20.88u as=2.5p ps=10.5u w=10u l=1u
X909 a_87374_136608# a_76998_136492# VDD VDD pfet_06v0 ad=2.5p pd=10.5u as=4.4p ps=20.88u w=10u l=1u
X910 a_36970_157465# a_37774_153879# a_38414_157395# VDD pfet_06v0 ad=4.4p pd=20.88u as=2.6p ps=10.52u w=10u l=1u
X911 VSS a_79258_179865# a_83198_179909# VSS nfet_06v0 ad=2.2p pd=10.88u as=1.25p ps=5.5u w=5u l=1u
X912 VDD a_40646_158395# a_37974_153995# VDD pfet_06v0 ad=2.2p pd=10.88u as=1.3p ps=5.52u w=5u l=1u
X913 a_37974_179979# a_40646_184379# VDD VDD pfet_06v0 ad=1.3p pd=5.52u as=2.2p ps=10.88u w=5u l=1u
X914 a_81046_148592# a_82638_141690# a_80498_141690# VSS nfet_06v0 ad=0.88p pd=4.88u as=0.88p ps=4.88u w=2u l=1u
X915 a_49734_179979# a_41310_179979# VSS VSS nfet_06v0 ad=1.3p pd=5.52u as=2.2p ps=10.88u w=5u l=1u
X916 a_46126_175709# a_32270_171241# a_47326_171285# VSS nfet_06v0 ad=2.2p pd=10.88u as=1.25p ps=5.5u w=5u l=1u
X917 a_95662_166089# a_78566_165973# VDD VDD pfet_06v0 ad=2.5p pd=10.5u as=4.4p ps=20.88u w=10u l=1u
X918 a_101510_179896# a_49734_179979# VDD VDD pfet_06v0 ad=1.32p pd=6.88u as=1.32p ps=6.88u w=3u l=1u
X919 a_62602_157395# a_63270_153995# VSS VSS nfet_06v0 ad=0.65p pd=3.02u as=0.65p ps=3.02u w=2.5u l=1u
X920 a_59682_153925# a_38886_153879# a_62158_153995# VSS nfet_06v0 ad=2.2p pd=10.88u as=1.3p ps=5.52u w=5u l=1u
X921 a_86454_153995# a_92382_158349# a_86902_158395# VDD pfet_06v0 ad=2.2p pd=10.88u as=2.2p ps=10.88u w=5u l=1u
X922 VDD a_113830_171272# a_114650_171228# VDD pfet_06v0 ad=1.32p pd=6.88u as=0.99p ps=3.66u w=3u l=1u
X923 VSS a_49734_179979# a_101510_179896# VSS nfet_06v0 ad=0.44p pd=2.88u as=0.44p ps=2.88u w=1u l=1u
D38 VSS a_12580_76961# diode_nd2ps_06v0 pj=40u area=99.99999p
X924 a_106102_179896# a_72806_179979# a_105170_179852# VSS nfet_06v0 ad=0.25p pd=1.5u as=0.44p ps=2.88u w=1u l=1u
X925 a_61806_149676# a_54970_141690# a_62014_141734# VSS nfet_06v0 ad=2.2p pd=10.88u as=1.25p ps=5.5u w=5u l=1u
X926 a_47762_183333# a_32610_183333# a_47962_183449# VDD pfet_06v0 ad=3.3p pd=10.66u as=2.5p ps=10.5u w=10u l=1u
X927 a_85786_183379# a_86454_179979# VSS VSS nfet_06v0 ad=0.65p pd=3.02u as=1.1p ps=5.88u w=2.5u l=1u
X928 a_102120_171396# a_102120_171396# a_104384_171512# VSS nfet_06v0 ad=0.308p pd=2.28u as=0.175p ps=1.2u w=0.7u l=1u
X929 a_41310_171355# a_32270_171241# a_38414_174755# VSS nfet_06v0 ad=0.65p pd=3.02u as=1.1p ps=5.88u w=2.5u l=1u
X930 VDD VSS VDD VDD pfet_06v0 ad=7.92p pd=36.88u as=0 ps=0 w=18u l=2u
X931 a_65086_148592# a_54710_148476# VDD VDD pfet_06v0 ad=2.5p pd=10.5u as=4.4p ps=20.88u w=10u l=1u
X932 VDD a_78566_183333# a_83558_183449# VDD pfet_06v0 ad=4.4p pd=20.88u as=2.5p ps=10.5u w=10u l=1u
X933 a_78310_124624# a_76998_124508# VDD VDD pfet_06v0 ad=2.5p pd=10.5u as=4.4p ps=20.88u w=10u l=1u
X934 a_102158_172604# a_95990_179979# VSS VSS nfet_06v0 ad=0.33p pd=1.66u as=0.44p ps=2.88u w=1u l=1u
X935 a_39530_157395# a_38886_153879# a_36970_157465# VDD pfet_06v0 ad=2.6p pd=10.52u as=4.4p ps=20.88u w=10u l=1u
D39 VSS a_50996_204977# diode_nd2ps_06v0 pj=40u area=99.99999p
X936 a_100590_141734# a_99358_141690# VSS VSS nfet_06v0 ad=1.25p pd=5.5u as=2.2p ps=10.88u w=5u l=1u
X937 a_81046_124624# a_82638_117722# a_80498_117722# VSS nfet_06v0 ad=0.88p pd=4.88u as=0.88p ps=4.88u w=2u l=1u
X938 a_60846_171239# a_100272_134212# VDD VDD pfet_06v0 ad=0.44p pd=2.88u as=0.44p ps=2.88u w=1u l=1u
X939 a_105128_171512# a_102120_171396# VSS VSS nfet_06v0 ad=0.5456p pd=3.36u as=0.5456p ps=3.36u w=1.24u l=1u
X940 VDD VSS VDD VDD pfet_06v0 ad=4.29p pd=20.38u as=0 ps=0 w=9.75u l=2u
X941 a_38886_171239# a_33184_146196# VDD VDD pfet_06v0 ad=0.44p pd=2.88u as=0.44p ps=2.88u w=1u l=1u
X942 a_102158_163980# a_102330_179852# VDD VDD pfet_06v0 ad=1.32p pd=6.88u as=1.32p ps=6.88u w=3u l=1u
X943 VDD a_63718_167019# a_61046_162619# VDD pfet_06v0 ad=1.3p pd=5.52u as=1.3p ps=5.52u w=5u l=1u
X944 a_36970_174825# a_32610_174709# a_36670_174825# VDD pfet_06v0 ad=3.3p pd=10.66u as=2.5p ps=10.5u w=10u l=1u
X945 a_112638_129750# a_99698_136492# VSS VSS nfet_06v0 ad=0.25p pd=1.5u as=0.44p ps=2.88u w=1u l=1u
X946 a_68734_179865# a_55682_183333# a_72478_183449# VDD pfet_06v0 ad=4.4p pd=20.88u as=2.5p ps=10.5u w=10u l=1u
X947 a_61806_125708# a_54970_117722# a_62014_117766# VSS nfet_06v0 ad=2.2p pd=10.88u as=1.25p ps=5.5u w=5u l=1u
X948 a_117490_153868# a_49734_153995# VDD VDD pfet_06v0 ad=0.99p pd=3.66u as=1.32p ps=6.88u w=3u l=1u
X949 a_104506_141734# a_106494_149676# a_100272_146196# VDD pfet_06v0 ad=1.76p pd=8.88u as=1.76p ps=8.88u w=4u l=1u
X950 VSS a_40198_162619# a_39530_166019# VSS nfet_06v0 ad=0.65p pd=3.02u as=0.65p ps=3.02u w=2.5u l=1u
X951 a_100590_117766# a_99358_117722# VSS VSS nfet_06v0 ad=1.25p pd=5.5u as=2.2p ps=10.88u w=5u l=1u
X952 a_102070_164096# a_102120_162772# VSS VSS nfet_06v0 ad=0.5456p pd=3.36u as=0.5456p ps=3.36u w=1.24u l=1u
X953 a_55382_165973# a_55682_165973# a_58618_166089# VDD pfet_06v0 ad=4.4p pd=20.88u as=2.5p ps=10.5u w=10u l=1u
D40 a_31060_204977# VDD diode_pd2nw_06v0 pj=40u area=99.99999p
X954 VSS VDD VSS VSS nfet_06v0 ad=4.29p pd=20.38u as=0 ps=0 w=9.75u l=2u
X955 a_101822_126514# a_50996_204977# a_99898_124624# VDD pfet_06v0 ad=0.242p pd=1.98u as=0.242p ps=1.98u w=0.55u l=1u
X956 a_77498_136608# a_77298_136492# a_78310_136608# VDD pfet_06v0 ad=4.4p pd=20.88u as=2.5p ps=10.5u w=10u l=1u
X957 a_45662_153881# a_32610_157349# a_49406_157465# VDD pfet_06v0 ad=4.4p pd=20.88u as=2.5p ps=10.5u w=10u l=1u
X958 a_37774_171239# a_79222_129750# cap_mim_2f0_m4m5_noshield c_width=25u c_length=8u
X959 VSS VDD VSS VSS nfet_06v0 ad=4.29p pd=20.38u as=0 ps=0 w=9.75u l=2u
D41 VSS a_31060_204977# diode_nd2ps_06v0 pj=40u area=99.99999p
X960 VSS VDD VSS VSS nfet_06v0 ad=0.44p pd=2.88u as=0 ps=0 w=1u l=2u
X961 VSS VDD VSS VSS nfet_06v0 ad=0.44p pd=2.88u as=0 ps=0 w=1u l=2u
X962 a_32510_183449# a_32310_183333# VDD VDD pfet_06v0 ad=2.5p pd=10.5u as=4.4p ps=20.88u w=10u l=1u
X963 a_70558_124624# a_54710_124508# VDD VDD pfet_06v0 ad=2.5p pd=10.5u as=4.4p ps=20.88u w=10u l=1u
X964 a_84230_171355# a_78866_174709# a_88018_175755# VDD pfet_06v0 ad=2.2p pd=10.88u as=1.3p ps=5.52u w=5u l=1u
X965 a_55170_141734# a_54970_141690# a_54870_141734# VSS nfet_06v0 ad=2.2p pd=10.88u as=1.25p ps=5.5u w=5u l=1u
X966 a_55584_147546# a_71002_147096# VSS ppolyf_u_1k r_width=1u r_length=76.45u
X967 a_85342_162619# a_37774_162503# a_82866_162549# VSS nfet_06v0 ad=1.3p pd=5.52u as=2.2p ps=10.88u w=5u l=1u
X968 a_61486_183379# a_60846_179863# a_60042_183449# VDD pfet_06v0 ad=2.6p pd=10.52u as=4.4p ps=20.88u w=10u l=1u
X969 a_60846_153879# a_55584_122228# VDD VDD pfet_06v0 ad=0.44p pd=2.88u as=0.44p ps=2.88u w=1u l=1u
X970 a_62014_129750# a_54670_129706# VSS VSS nfet_06v0 ad=1.25p pd=5.5u as=2.2p ps=10.88u w=5u l=1u
X971 VDD a_86902_158395# a_84230_153995# VDD pfet_06v0 ad=1.3p pd=5.52u as=1.3p ps=5.52u w=5u l=1u
X972 a_79458_162549# a_79258_162505# VSS VSS nfet_06v0 ad=1.25p pd=5.5u as=2.2p ps=10.88u w=5u l=1u
X973 a_63270_153995# a_69198_158349# a_63718_158395# VDD pfet_06v0 ad=2.2p pd=10.88u as=2.2p ps=10.88u w=5u l=1u
X974 a_103182_164096# a_103270_163980# a_12580_136433# VSS nfet_06v0 ad=1.0912p pd=5.84u as=0.6448p ps=3u w=2.48u l=1u
X975 VSS a_105170_179852# a_102158_155244# VSS nfet_06v0 ad=0.44p pd=2.88u as=0.44p ps=2.88u w=1u l=1u
X976 a_61486_157395# a_63270_153995# VSS VSS nfet_06v0 ad=0.65p pd=3.02u as=1.1p ps=5.88u w=2.5u l=1u
X977 a_55682_183333# a_55682_183333# VDD VDD pfet_06v0 ad=0.88p pd=4.88u as=0.88p ps=4.88u w=2u l=1u
X978 a_34734_138498# a_35810_129706# VSS VSS nfet_06v0 ad=0.825p pd=3.16u as=1.1p ps=5.88u w=2.5u l=1u
X979 a_41242_136608# a_41042_136492# VDD VDD pfet_06v0 ad=2.5p pd=10.5u as=4.4p ps=20.88u w=10u l=1u
X980 VDD a_72806_171355# a_116938_172684# VDD pfet_06v0 ad=1.32p pd=6.88u as=0.75p ps=3.5u w=3u l=1u
X981 a_36310_153925# a_33002_153881# VSS VSS nfet_06v0 ad=1.25p pd=5.5u as=2.2p ps=10.88u w=5u l=1u
X982 a_105026_164096# a_12580_136433# a_12580_136433# VSS nfet_06v0 ad=0.88p pd=4.88u as=0.52p ps=2.52u w=2u l=1u
X983 a_55342_171241# a_55342_171241# VSS VSS nfet_06v0 ad=0.44p pd=2.88u as=0.44p ps=2.88u w=1u l=1u
X984 a_33184_123578# a_37774_153879# VSS ppolyf_u_1k r_width=1u r_length=76.45u
X985 a_108130_148476# a_99698_148476# a_108330_148592# VDD pfet_06v0 ad=3.3p pd=10.66u as=2.5p ps=10.5u w=10u l=1u
X986 a_41762_184379# a_45662_179865# a_41310_179979# VSS nfet_06v0 ad=1.1p pd=5.88u as=1.1p ps=5.88u w=2.5u l=1u
X987 a_102354_117766# a_103446_124624# VDD VDD pfet_06v0 ad=2.2p pd=10.88u as=2.2p ps=10.88u w=5u l=1u
D42 VSS a_12580_56801# diode_nd2ps_06v0 pj=40u area=99.99999p
X988 a_38414_157395# a_37774_153879# a_36970_157465# VDD pfet_06v0 ad=2.6p pd=10.52u as=4.4p ps=20.88u w=10u l=1u
X989 a_55170_117766# a_54970_117722# a_54870_117766# VSS nfet_06v0 ad=2.2p pd=10.88u as=1.25p ps=5.5u w=5u l=1u
X990 a_55584_146646# a_71002_147096# VSS ppolyf_u_1k r_width=1u r_length=76.45u
X991 a_37974_153995# a_40646_158395# VDD VDD pfet_06v0 ad=1.3p pd=5.52u as=1.3p ps=5.52u w=5u l=1u
X992 a_60374_183449# a_55682_183333# a_60042_183449# VDD pfet_06v0 ad=2.5p pd=10.5u as=3.3p ps=10.66u w=10u l=1u
X993 a_85786_183379# a_37774_179863# a_83226_183449# VDD pfet_06v0 ad=2.6p pd=10.52u as=4.4p ps=20.88u w=10u l=1u
X994 a_54670_129706# a_55010_136492# a_70558_136608# VDD pfet_06v0 ad=4.4p pd=20.88u as=2.5p ps=10.5u w=10u l=1u
X995 a_32610_136492# a_32610_136492# VDD VDD pfet_06v0 ad=0.88p pd=4.88u as=0.88p ps=4.88u w=2u l=1u
X996 a_82866_153925# a_37774_153879# a_85342_153995# VSS nfet_06v0 ad=2.2p pd=10.88u as=1.3p ps=5.52u w=5u l=1u
X997 a_72806_171355# a_61046_171355# cap_mim_2f0_m4m5_noshield c_width=20u c_length=10u
X998 a_50082_124624# a_32310_124508# VDD VDD pfet_06v0 ad=2.5p pd=10.5u as=4.4p ps=20.88u w=10u l=1u
X999 a_57134_138498# a_58210_129706# VSS VSS nfet_06v0 ad=0.825p pd=3.16u as=1.1p ps=5.88u w=2.5u l=1u
X1000 a_93582_153925# a_79258_153881# VSS VSS nfet_06v0 ad=1.25p pd=5.5u as=2.2p ps=10.88u w=5u l=1u
X1001 a_84670_183379# a_86454_179979# VSS VSS nfet_06v0 ad=0.65p pd=3.02u as=0.65p ps=3.02u w=2.5u l=1u
X1002 VSS VDD VSS VSS nfet_06v0 ad=7.92p pd=36.88u as=0 ps=0 w=18u l=2u
X1003 a_100272_123578# a_115690_123128# VSS ppolyf_u_1k r_width=1u r_length=76.45u
X1004 a_39086_153995# a_38886_153879# a_36610_153925# VSS nfet_06v0 ad=1.3p pd=5.52u as=2.2p ps=10.88u w=5u l=1u
X1005 a_70834_174709# a_55682_174709# a_71034_174825# VDD pfet_06v0 ad=3.3p pd=10.66u as=2.5p ps=10.5u w=10u l=1u
X1006 VSS VDD VSS VSS nfet_06v0 ad=4.29p pd=20.38u as=0 ps=0 w=9.75u l=2u
X1007 a_37302_157465# a_32610_157349# a_36970_157465# VDD pfet_06v0 ad=2.5p pd=10.5u as=3.3p ps=10.66u w=10u l=1u
X1008 a_58758_148592# a_55010_148476# a_57666_141734# VDD pfet_06v0 ad=4.4p pd=20.88u as=4.4p ps=20.88u w=10u l=1u
X1009 a_63718_158395# a_68734_153881# a_63270_153995# VSS nfet_06v0 ad=1.1p pd=5.88u as=1.1p ps=5.88u w=2.5u l=1u
X1010 VDD VSS VDD VDD pfet_06v0 ad=0.44p pd=2.88u as=0 ps=0 w=1u l=2u
X1011 VSS VDD VSS VSS nfet_06v0 ad=0.44p pd=2.88u as=0 ps=0 w=1u l=2u
X1012 VSS VDD VSS VSS nfet_06v0 ad=7.92p pd=36.88u as=0 ps=0 w=18u l=2u
X1013 VDD a_72806_179979# a_105170_179852# VDD pfet_06v0 ad=1.32p pd=6.88u as=0.99p ps=3.66u w=3u l=1u
X1014 a_85146_141690# a_77258_141690# a_85346_141734# VSS nfet_06v0 ad=1.65p pd=5.66u as=1.25p ps=5.5u w=5u l=1u
X1015 a_33184_146196# a_32610_148476# a_34534_141734# VDD pfet_06v0 ad=4.4p pd=20.88u as=4.4p ps=20.88u w=10u l=1u
D43 a_34334_141690# VDD diode_pd2nw_06v0 pj=40u area=99.99999p
X1016 a_77872_134212# a_93290_134212# VSS ppolyf_u_1k r_width=1u r_length=76.45u
X1017 a_77298_136492# a_77298_136492# VDD VDD pfet_06v0 ad=0.88p pd=4.88u as=0.88p ps=4.88u w=2u l=1u
X1018 a_61046_162619# a_63718_167019# VDD VDD pfet_06v0 ad=1.3p pd=5.52u as=2.2p ps=10.88u w=5u l=1u
X1019 a_33202_153925# a_33002_153881# VSS VSS nfet_06v0 ad=1.25p pd=5.5u as=2.2p ps=10.88u w=5u l=1u
X1020 a_55584_146196# a_55010_148476# a_56934_141734# VDD pfet_06v0 ad=4.4p pd=20.88u as=4.4p ps=20.88u w=10u l=1u
X1021 VDD a_40646_167019# a_39086_162619# VDD pfet_06v0 ad=1.3p pd=5.52u as=1.3p ps=5.52u w=5u l=1u
X1022 a_35266_179909# a_32610_183333# VSS VSS nfet_06v0 ad=0.25p pd=1.5u as=0.44p ps=2.88u w=1u l=1u
X1023 a_85342_171355# a_78866_174709# a_86902_175755# VDD pfet_06v0 ad=2.2p pd=10.88u as=1.3p ps=5.52u w=5u l=1u
X1024 a_81802_166089# a_78566_165973# VDD VDD pfet_06v0 ad=2.5p pd=10.5u as=4.4p ps=20.88u w=10u l=1u
X1025 a_39530_166019# a_40198_162619# VSS VSS nfet_06v0 ad=0.65p pd=3.02u as=1.1p ps=5.88u w=2.5u l=1u
X1026 a_118422_162536# a_72806_162619# a_117490_162492# VSS nfet_06v0 ad=0.25p pd=1.5u as=0.44p ps=2.88u w=1u l=1u
X1027 a_68734_162505# a_68734_162505# a_71242_162505# VSS nfet_06v0 ad=2.2p pd=10.88u as=1.65p ps=5.66u w=5u l=1u
X1028 a_55342_153881# a_55682_157349# a_55582_157465# VDD pfet_06v0 ad=4.4p pd=20.88u as=2.5p ps=10.5u w=10u l=1u
X1029 VSS VDD VSS VSS nfet_06v0 ad=4.29p pd=20.38u as=0 ps=0 w=9.75u l=2u
X1030 a_85146_117722# a_77258_117722# a_85346_117766# VSS nfet_06v0 ad=1.65p pd=5.66u as=1.25p ps=5.5u w=5u l=1u
X1031 a_55584_134212# a_60350_129706# a_59818_129750# VSS nfet_06v0 ad=0.88p pd=4.88u as=0.88p ps=4.88u w=2u l=1u
X1032 VDD a_63718_158395# a_61046_153995# VDD pfet_06v0 ad=1.3p pd=5.52u as=1.3p ps=5.52u w=5u l=1u
X1033 a_49734_153995# a_37974_153995# cap_mim_2f0_m4m5_noshield c_width=20u c_length=10u
X1034 a_39406_125708# a_39406_125708# a_41042_124508# VDD pfet_06v0 ad=4.4p pd=20.88u as=3.3p ps=10.66u w=10u l=1u
X1035 a_103270_155244# a_117490_162492# VDD VDD pfet_06v0 ad=1.32p pd=6.88u as=1.32p ps=6.88u w=3u l=1u
X1036 VSS a_40198_153995# a_39530_157395# VSS nfet_06v0 ad=0.65p pd=3.02u as=0.65p ps=3.02u w=2.5u l=1u
X1037 a_55382_157349# a_55682_157349# a_57306_153925# VSS nfet_06v0 ad=0.44p pd=2.88u as=0.25p ps=1.5u w=1u l=1u
X1038 a_32310_148476# a_32610_148476# a_44518_141734# VSS nfet_06v0 ad=0.44p pd=2.88u as=0.25p ps=1.5u w=1u l=1u
X1039 XN_OUT a_105404_157700# VDD VDD pfet_05v0 ad=0.8052p pd=4.54u as=0.8052p ps=4.54u w=1.83u l=0.5u
X1040 VDD VSS VDD VDD pfet_06v0 ad=4.29p pd=20.38u as=0 ps=0 w=9.75u l=2u
X1041 a_38886_153879# a_77872_122228# VDD VDD pfet_06v0 ad=0.44p pd=2.88u as=0.44p ps=2.88u w=1u l=1u
X1042 a_47326_171285# a_33002_171241# VSS VSS nfet_06v0 ad=1.25p pd=5.5u as=2.2p ps=10.88u w=5u l=1u
X1043 a_32610_165973# a_32610_165973# a_35266_162549# VSS nfet_06v0 ad=0.44p pd=2.88u as=0.25p ps=1.5u w=1u l=1u
X1044 a_61806_125708# a_61806_125708# a_63442_124508# VDD pfet_06v0 ad=4.4p pd=20.88u as=3.3p ps=10.66u w=10u l=1u
X1045 a_84230_179979# a_86902_184379# VDD VDD pfet_06v0 ad=1.3p pd=5.52u as=1.3p ps=5.52u w=5u l=1u
X1046 a_55584_122228# a_71002_122228# VSS ppolyf_u_1k r_width=1u r_length=76.45u
X1047 a_35266_129750# a_36358_136608# VDD VDD pfet_06v0 ad=2.2p pd=10.88u as=2.2p ps=10.88u w=5u l=1u
X1048 a_95990_179979# a_87566_179979# VSS VSS nfet_06v0 ad=2.2p pd=10.88u as=1.3p ps=5.52u w=5u l=1u
X1049 a_72806_162619# a_64382_162619# VSS VSS nfet_06v0 ad=1.3p pd=5.52u as=2.2p ps=10.88u w=5u l=1u
D44 VSS a_12580_36641# diode_nd2ps_06v0 pj=40u area=99.99999p
X1050 VDD VSS VDD VDD pfet_06v0 ad=7.92p pd=36.88u as=0 ps=0 w=18u l=2u
X1051 VSS a_49734_171355# a_113830_171272# VSS nfet_06v0 ad=0.44p pd=2.88u as=0.44p ps=2.88u w=1u l=1u
X1052 a_33184_146196# a_37950_141690# a_37418_141734# VSS nfet_06v0 ad=0.88p pd=4.88u as=0.88p ps=4.88u w=2u l=1u
X1053 a_85730_124508# a_77298_124508# a_85930_124624# VDD pfet_06v0 ad=3.3p pd=10.66u as=2.5p ps=10.5u w=10u l=1u
X1054 a_12580_136433# a_103270_163980# a_103182_164096# VSS nfet_06v0 ad=0.6448p pd=3u as=1.0912p ps=5.84u w=2.48u l=1u
X1055 a_54710_148476# a_55010_148476# a_66918_141734# VSS nfet_06v0 ad=0.44p pd=2.88u as=0.25p ps=1.5u w=1u l=1u
X1056 a_78526_171241# a_78526_171241# VSS VSS nfet_06v0 ad=0.44p pd=2.88u as=0.44p ps=2.88u w=1u l=1u
X1057 a_104384_171512# a_102120_171396# a_104084_171512# VSS nfet_06v0 ad=0.175p pd=1.2u as=0.175p ps=1.2u w=0.7u l=1u
X1058 a_83558_183449# a_78866_183333# a_83226_183449# VDD pfet_06v0 ad=2.5p pd=10.5u as=3.3p ps=10.66u w=10u l=1u
X1059 a_32310_136492# a_32610_136492# a_50082_136608# VDD pfet_06v0 ad=4.4p pd=20.88u as=2.5p ps=10.5u w=10u l=1u
X1060 a_12580_136433# a_12580_136433# a_105026_164096# VSS nfet_06v0 ad=0.52p pd=2.52u as=0.88p ps=4.88u w=2u l=1u
X1061 a_32310_124508# a_32610_124508# a_44518_117766# VSS nfet_06v0 ad=0.44p pd=2.88u as=0.25p ps=1.5u w=1u l=1u
X1062 VSS a_79258_162505# a_83198_162549# VSS nfet_06v0 ad=2.2p pd=10.88u as=1.25p ps=5.5u w=5u l=1u
X1063 VDD a_63718_184379# a_62158_179979# VDD pfet_06v0 ad=2.2p pd=10.88u as=1.3p ps=5.52u w=5u l=1u
X1064 a_91918_171241# a_91918_171241# a_94426_171241# VSS nfet_06v0 ad=2.2p pd=10.88u as=1.65p ps=5.66u w=5u l=1u
D45 a_35066_141690# VDD diode_pd2nw_06v0 pj=40u area=99.99999p
X1065 a_85342_153995# a_37774_153879# a_82866_153925# VSS nfet_06v0 ad=1.3p pd=5.52u as=2.2p ps=10.88u w=5u l=1u
X1066 a_77458_141734# a_77258_141690# a_78190_141734# VSS nfet_06v0 ad=2.2p pd=10.88u as=1.25p ps=5.5u w=5u l=1u
X1067 VDD VSS VDD VDD pfet_06v0 ad=4.29p pd=20.38u as=0 ps=0 w=9.75u l=2u
X1068 ZP_OUT ZN_OUT VDD VDD pfet_05v0 ad=0.8052p pd=4.54u as=0.8052p ps=4.54u w=1.83u l=0.5u
X1069 VSS a_86454_179979# a_84670_183379# VSS nfet_06v0 ad=0.65p pd=3.02u as=0.65p ps=3.02u w=2.5u l=1u
X1070 a_36670_174825# a_32310_174709# VDD VDD pfet_06v0 ad=2.5p pd=10.5u as=4.4p ps=20.88u w=10u l=1u
X1071 a_94018_174709# a_78866_174709# a_94218_174825# VDD pfet_06v0 ad=3.3p pd=10.66u as=2.5p ps=10.5u w=10u l=1u
X1072 a_62158_162619# a_63718_167019# VDD VDD pfet_06v0 ad=1.3p pd=5.52u as=1.3p ps=5.52u w=5u l=1u
X1073 VDD VSS VDD VDD pfet_06v0 ad=0.44p pd=2.88u as=0 ps=0 w=1u l=2u
X1074 VSS VDD VSS VSS nfet_06v0 ad=4.29p pd=20.38u as=0 ps=0 w=9.75u l=2u
X1075 a_33184_122228# a_37950_117722# a_37418_117766# VSS nfet_06v0 ad=0.88p pd=4.88u as=0.88p ps=4.88u w=2u l=1u
X1076 a_72478_183449# a_55382_183333# VDD VDD pfet_06v0 ad=2.5p pd=10.5u as=4.4p ps=20.88u w=10u l=1u
X1077 a_101822_138498# a_102898_129706# VSS VSS nfet_06v0 ad=0.825p pd=3.16u as=1.1p ps=5.88u w=2.5u l=1u
X1078 a_103446_136608# a_105038_129706# a_102898_129706# VSS nfet_06v0 ad=0.88p pd=4.88u as=0.88p ps=4.88u w=2u l=1u
X1079 a_54710_124508# a_55010_124508# a_66918_117766# VSS nfet_06v0 ad=0.44p pd=2.88u as=0.25p ps=1.5u w=1u l=1u
X1080 a_36610_179909# a_32270_179865# a_36310_179909# VSS nfet_06v0 ad=1.65p pd=5.66u as=1.25p ps=5.5u w=5u l=1u
X1081 a_100272_123578# a_37774_162503# VSS ppolyf_u_1k r_width=1u r_length=76.45u
X1082 a_82926_166089# a_78566_165973# VDD VDD pfet_06v0 ad=2.5p pd=10.5u as=4.4p ps=20.88u w=10u l=1u
X1083 a_38414_183379# a_40198_179979# VSS VSS nfet_06v0 ad=0.65p pd=3.02u as=1.1p ps=5.88u w=2.5u l=1u
X1084 a_37974_162619# a_32610_165973# a_41762_167019# VDD pfet_06v0 ad=2.2p pd=10.88u as=1.3p ps=5.52u w=5u l=1u
X1085 a_85786_174755# a_86454_171355# VSS VSS nfet_06v0 ad=0.65p pd=3.02u as=0.65p ps=3.02u w=2.5u l=1u
D46 a_34334_141690# VDD diode_pd2nw_06v0 pj=40u area=99.99999p
X1086 a_58618_166089# a_55382_165973# VDD VDD pfet_06v0 ad=2.5p pd=10.5u as=4.4p ps=20.88u w=10u l=1u
X1087 VDD VSS VDD VDD pfet_06v0 ad=7.92p pd=36.88u as=0 ps=0 w=18u l=2u
X1088 a_78310_136608# a_76998_136492# VDD VDD pfet_06v0 ad=2.5p pd=10.5u as=4.4p ps=20.88u w=10u l=1u
X1089 a_117170_124624# a_99398_124508# VDD VDD pfet_06v0 ad=2.5p pd=10.5u as=4.4p ps=20.88u w=10u l=1u
X1090 a_77458_117766# a_77258_117722# a_78190_117766# VSS nfet_06v0 ad=2.2p pd=10.88u as=1.25p ps=5.5u w=5u l=1u
X1091 a_49406_157465# a_32310_157349# VDD VDD pfet_06v0 ad=2.5p pd=10.5u as=4.4p ps=20.88u w=10u l=1u
D47 a_12580_196913# VDD diode_pd2nw_06v0 pj=40u area=99.99999p
X1092 a_92382_184333# a_78526_179865# a_93582_179909# VSS nfet_06v0 ad=2.2p pd=10.88u as=1.25p ps=5.5u w=5u l=1u
X1093 a_62158_162619# a_55682_165973# a_63718_167019# VDD pfet_06v0 ad=2.2p pd=10.88u as=1.3p ps=5.52u w=5u l=1u
X1094 VDD a_12580_196913# a_12580_196913# VDD pfet_06v0 ad=0.88p pd=4.88u as=0.52p ps=2.52u w=2u l=1u
X1095 a_80234_150492# a_80498_141690# VSS VSS nfet_06v0 ad=0.825p pd=3.16u as=1.1p ps=5.88u w=2.5u l=1u
X1096 a_84670_174755# a_78526_171241# a_87566_171355# VSS nfet_06v0 ad=1.1p pd=5.88u as=0.65p ps=3.02u w=2.5u l=1u
D48 VSS a_34334_141690# diode_nd2ps_06v0 pj=40u area=99.99999p
X1097 VDD VSS VDD VDD pfet_06v0 ad=7.92p pd=36.88u as=0 ps=0 w=18u l=2u
X1098 a_54870_141734# a_54670_141690# VSS VSS nfet_06v0 ad=1.25p pd=5.5u as=2.2p ps=10.88u w=5u l=1u
X1099 a_78526_153881# a_78866_157349# a_78766_157465# VDD pfet_06v0 ad=4.4p pd=20.88u as=2.5p ps=10.5u w=10u l=1u
X1100 a_82866_171285# a_78526_171241# a_82566_171285# VSS nfet_06v0 ad=1.65p pd=5.66u as=1.25p ps=5.5u w=5u l=1u
X1101 a_56022_148592# a_54710_148476# VDD VDD pfet_06v0 ad=2.5p pd=10.5u as=4.4p ps=20.88u w=10u l=1u
X1102 a_66918_129750# a_55010_136492# VSS VSS nfet_06v0 ad=0.25p pd=1.5u as=0.44p ps=2.88u w=1u l=1u
X1103 a_33184_134662# a_48602_134212# VSS ppolyf_u_1k r_width=1u r_length=76.45u
X1104 a_61046_153995# a_63718_158395# VDD VDD pfet_06v0 ad=1.3p pd=5.52u as=2.2p ps=10.88u w=5u l=1u
X1105 a_33002_179865# a_32270_179865# a_33202_179909# VSS nfet_06v0 ad=2.2p pd=10.88u as=1.25p ps=5.5u w=5u l=1u
X1106 a_59818_129750# a_54970_129706# a_57134_138498# VSS nfet_06v0 ad=1.1p pd=5.88u as=0.825p ps=3.16u w=2.5u l=1u
X1107 a_80234_126524# a_80498_117722# VSS VSS nfet_06v0 ad=0.825p pd=3.16u as=1.1p ps=5.88u w=2.5u l=1u
D49 VSS a_12580_136433# diode_nd2ps_06v0 pj=40u area=99.99999p
X1108 a_108330_148592# a_108130_148476# VDD VDD pfet_06v0 ad=2.5p pd=10.5u as=4.4p ps=20.88u w=10u l=1u
X1109 a_12580_196913# a_12580_196913# VDD VDD pfet_06v0 ad=0.52p pd=2.52u as=0.52p ps=2.52u w=2u l=1u
X1110 VDD a_40646_158395# a_39086_153995# VDD pfet_06v0 ad=1.3p pd=5.52u as=1.3p ps=5.52u w=5u l=1u
X1111 VDD VSS VDD VDD pfet_06v0 ad=4.29p pd=20.38u as=0 ps=0 w=9.75u l=2u
X1112 a_78190_129750# a_76958_129706# VSS VSS nfet_06v0 ad=1.25p pd=5.5u as=2.2p ps=10.88u w=5u l=1u
X1113 a_54870_117766# a_54670_117722# VSS VSS nfet_06v0 ad=1.25p pd=5.5u as=2.2p ps=10.88u w=5u l=1u
X1114 a_58210_129706# a_54970_129706# a_57946_138508# VSS nfet_06v0 ad=1.1p pd=5.88u as=0.825p ps=3.16u w=2.5u l=1u
X1115 a_39530_157395# a_40198_153995# VSS VSS nfet_06v0 ad=0.65p pd=3.02u as=1.1p ps=5.88u w=2.5u l=1u
X1116 a_12580_136433# a_12580_136433# VDD VDD pfet_06v0 ad=0.52p pd=2.52u as=0.52p ps=2.52u w=2u l=1u
X1117 a_102330_179852# a_95990_179979# VDD VDD pfet_06v0 ad=0.99p pd=3.66u as=1.32p ps=6.88u w=3u l=1u
X1118 a_70558_136608# a_54710_136492# VDD VDD pfet_06v0 ad=2.5p pd=10.5u as=4.4p ps=20.88u w=10u l=1u
X1119 a_33002_162505# a_32610_165973# a_33622_166089# VDD pfet_06v0 ad=4.4p pd=20.88u as=2.5p ps=10.5u w=10u l=1u
X1120 VSS a_87566_179979# a_95990_179979# VSS nfet_06v0 ad=1.3p pd=5.52u as=1.3p ps=5.52u w=5u l=1u
X1121 VSS a_63270_179979# a_61486_183379# VSS nfet_06v0 ad=0.65p pd=3.02u as=0.65p ps=3.02u w=2.5u l=1u
X1122 a_38886_162503# a_55584_134212# VDD VDD pfet_06v0 ad=0.44p pd=2.88u as=0.44p ps=2.88u w=1u l=1u
X1123 a_77498_124624# a_77298_124508# a_77198_124624# VDD pfet_06v0 ad=4.4p pd=20.88u as=2.5p ps=10.5u w=10u l=1u
X1124 a_34734_138498# a_42022_129750# cap_mim_2f0_m4m5_noshield c_width=25u c_length=8u
X1125 a_95990_171355# a_87566_171355# VSS VSS nfet_06v0 ad=1.3p pd=5.52u as=2.2p ps=10.88u w=5u l=1u
X1126 a_62602_174755# a_55342_171241# a_63270_171355# VSS nfet_06v0 ad=1.1p pd=5.88u as=0.65p ps=3.02u w=2.5u l=1u
X1127 VDD a_86902_184379# a_85342_179979# VDD pfet_06v0 ad=2.2p pd=10.88u as=1.3p ps=5.52u w=5u l=1u
X1128 a_101822_150482# a_38886_179863# cap_mim_2f0_m4m5_noshield c_width=25u c_length=8u
X1129 a_99398_148476# a_99698_148476# a_111606_141734# VSS nfet_06v0 ad=0.44p pd=2.88u as=0.25p ps=1.5u w=1u l=1u
X1130 a_38886_171239# a_33184_146196# VDD VDD pfet_06v0 ad=0.44p pd=2.88u as=0.44p ps=2.88u w=1u l=1u
X1131 a_41762_167019# a_45662_162505# a_41310_162619# VSS nfet_06v0 ad=1.1p pd=5.88u as=1.1p ps=5.88u w=2.5u l=1u
X1132 VDD VSS VDD VDD pfet_06v0 ad=4.29p pd=20.38u as=0 ps=0 w=9.75u l=2u
X1133 a_102354_129750# a_103446_136608# VDD VDD pfet_06v0 ad=2.2p pd=10.88u as=2.2p ps=10.88u w=5u l=1u
X1134 a_62602_183379# a_63270_179979# VSS VSS nfet_06v0 ad=0.65p pd=3.02u as=0.65p ps=3.02u w=2.5u l=1u
X1135 a_80234_126524# a_31060_204977# a_77498_124624# VDD pfet_06v0 ad=0.22p pd=1.88u as=0.22p ps=1.88u w=0.5u l=1u
D50 a_12580_76961# VDD diode_pd2nw_06v0 pj=40u area=99.99999p
X1136 a_72806_153995# a_64382_153995# VSS VSS nfet_06v0 ad=1.3p pd=5.52u as=2.2p ps=10.88u w=5u l=1u
X1137 a_59682_179909# a_38886_179863# a_62158_179979# VSS nfet_06v0 ad=2.2p pd=10.88u as=1.3p ps=5.52u w=5u l=1u
X1138 a_85346_141734# a_85146_141690# VSS VSS nfet_06v0 ad=1.25p pd=5.5u as=2.2p ps=10.88u w=5u l=1u
X1139 VDD VSS VDD VDD pfet_06v0 ad=4.29p pd=20.38u as=0 ps=0 w=9.75u l=2u
X1140 a_105038_117722# a_99698_124508# a_109774_124624# VDD pfet_06v0 ad=4.4p pd=20.88u as=2.5p ps=10.5u w=10u l=1u
X1141 a_78866_183333# a_78866_183333# VDD VDD pfet_06v0 ad=0.88p pd=4.88u as=0.88p ps=4.88u w=2u l=1u
X1142 a_100272_146196# a_105038_141690# a_104506_141734# VSS nfet_06v0 ad=0.88p pd=4.88u as=0.88p ps=4.88u w=2u l=1u
X1143 a_50082_136608# a_32310_136492# VDD VDD pfet_06v0 ad=2.5p pd=10.5u as=4.4p ps=20.88u w=10u l=1u
D51 VSS a_35066_117722# diode_nd2ps_06v0 pj=40u area=99.99999p
X1144 a_105404_175060# a_12580_76961# VDD VDD pfet_05v0 ad=0.8052p pd=4.54u as=0.8052p ps=4.54u w=1.83u l=0.5u
X1145 VDD a_63718_167019# a_62158_162619# VDD pfet_06v0 ad=1.3p pd=5.52u as=1.3p ps=5.52u w=5u l=1u
X1146 a_56074_171241# a_55682_174709# a_56694_174825# VDD pfet_06v0 ad=4.4p pd=20.88u as=2.5p ps=10.5u w=10u l=1u
X1147 a_116938_163948# a_95990_162619# a_103270_172604# VDD pfet_06v0 ad=0.75p pd=3.5u as=1.32p ps=6.88u w=3u l=1u
X1148 a_32270_129706# a_32570_129706# a_43486_129750# VSS nfet_06v0 ad=2.2p pd=10.88u as=1.25p ps=5.5u w=5u l=1u
X1149 a_48158_148592# a_32310_148476# VDD VDD pfet_06v0 ad=2.5p pd=10.5u as=4.4p ps=20.88u w=10u l=1u
X1150 a_49734_162619# a_41310_162619# VSS VSS nfet_06v0 ad=2.2p pd=10.88u as=1.3p ps=5.52u w=5u l=1u
X1151 a_81046_124624# a_77298_124508# a_79954_117766# VDD pfet_06v0 ad=4.4p pd=20.88u as=4.4p ps=20.88u w=10u l=1u
X1152 VDD VSS VDD VDD pfet_06v0 ad=0.44p pd=2.88u as=0 ps=0 w=1u l=2u
X1153 a_37774_153879# a_33184_122228# VDD VDD pfet_06v0 ad=0.44p pd=2.88u as=0.44p ps=2.88u w=1u l=1u
X1154 a_99398_124508# a_99698_124508# a_111606_117766# VSS nfet_06v0 ad=0.44p pd=2.88u as=0.25p ps=1.5u w=1u l=1u
X1155 a_12580_136433# a_107258_163980# a_107170_164096# VSS nfet_06v0 ad=0.6448p pd=3u as=1.0912p ps=5.84u w=2.48u l=1u
X1156 a_41762_167019# a_32610_165973# a_37974_162619# VDD pfet_06v0 ad=1.3p pd=5.52u as=2.2p ps=10.88u w=5u l=1u
X1157 VSS a_40198_171355# a_38414_174755# VSS nfet_06v0 ad=1.1p pd=5.88u as=0.65p ps=3.02u w=2.5u l=1u
X1158 a_55582_157465# a_55382_157349# VDD VDD pfet_06v0 ad=2.5p pd=10.5u as=4.4p ps=20.88u w=10u l=1u
X1159 a_85346_117766# a_85146_117722# VSS VSS nfet_06v0 ad=1.25p pd=5.5u as=2.2p ps=10.88u w=5u l=1u
X1160 a_62158_153995# a_63718_158395# VDD VDD pfet_06v0 ad=1.3p pd=5.52u as=1.3p ps=5.52u w=5u l=1u
X1161 a_99658_129706# a_99658_129706# VSS VSS nfet_06v0 ad=0.44p pd=2.88u as=0.44p ps=2.88u w=1u l=1u
X1162 a_100272_122228# a_105038_117722# a_104506_117766# VSS nfet_06v0 ad=0.88p pd=4.88u as=0.88p ps=4.88u w=2u l=1u
X1163 a_12580_136433# a_102158_163980# a_102070_164096# VSS nfet_06v0 ad=0.6448p pd=3u as=1.0912p ps=5.84u w=2.48u l=1u
X1164 a_87566_171355# a_92382_175709# a_88018_175755# VDD pfet_06v0 ad=2.2p pd=10.88u as=2.2p ps=10.88u w=5u l=1u
X1165 a_49734_171355# a_41762_175755# VDD VDD pfet_06v0 ad=2.6p pd=10.52u as=4.4p ps=20.88u w=10u l=1u
X1166 a_37974_153995# a_32610_157349# a_41762_158395# VDD pfet_06v0 ad=2.2p pd=10.88u as=1.3p ps=5.52u w=5u l=1u
X1167 a_55010_124508# a_55010_124508# VDD VDD pfet_06v0 ad=0.88p pd=4.88u as=0.88p ps=4.88u w=2u l=1u
X1168 a_57306_153925# a_55682_157349# VSS VSS nfet_06v0 ad=0.25p pd=1.5u as=0.44p ps=2.88u w=1u l=1u
D52 a_12580_136433# VDD diode_pd2nw_06v0 pj=40u area=99.99999p
X1169 a_44518_141734# a_32610_148476# VSS VSS nfet_06v0 ad=0.25p pd=1.5u as=0.44p ps=2.88u w=1u l=1u
X1170 VSS VDD VSS VSS nfet_06v0 ad=7.92p pd=36.88u as=0 ps=0 w=18u l=2u
X1171 a_95990_179979# a_84230_179979# cap_mim_2f0_m4m5_noshield c_width=20u c_length=10u
X1172 a_35266_162549# a_32610_165973# VSS VSS nfet_06v0 ad=0.25p pd=1.5u as=0.44p ps=2.88u w=1u l=1u
X1173 a_79222_141734# a_81046_148592# VDD VDD pfet_06v0 ad=2.2p pd=10.88u as=2.2p ps=10.88u w=5u l=1u
X1174 a_62158_153995# a_55682_157349# a_63718_158395# VDD pfet_06v0 ad=2.2p pd=10.88u as=1.3p ps=5.52u w=5u l=1u
X1175 a_37418_141734# a_32570_141690# a_34734_150482# VSS nfet_06v0 ad=1.1p pd=5.88u as=0.825p ps=3.16u w=2.5u l=1u
X1176 a_92382_158349# a_92382_158349# a_94018_157349# VDD pfet_06v0 ad=4.4p pd=20.88u as=3.3p ps=10.66u w=10u l=1u
X1177 a_76958_117722# a_77298_124508# a_92846_124624# VDD pfet_06v0 ad=4.4p pd=20.88u as=2.5p ps=10.5u w=10u l=1u
X1178 a_95990_179979# a_88018_184379# VDD VDD pfet_06v0 ad=4.4p pd=20.88u as=2.6p ps=10.52u w=10u l=1u
X1179 a_60042_174825# a_60846_171239# a_61486_174755# VDD pfet_06v0 ad=4.4p pd=20.88u as=2.6p ps=10.52u w=10u l=1u
X1180 a_95990_162619# a_84230_162619# cap_mim_2f0_m4m5_noshield c_width=20u c_length=10u
X1181 a_33184_134662# a_48602_135112# VSS ppolyf_u_1k r_width=1u r_length=76.45u
X1182 a_35810_141690# a_32570_141690# a_35546_150492# VSS nfet_06v0 ad=1.1p pd=5.88u as=0.825p ps=3.16u w=2.5u l=1u
X1183 a_113830_153912# a_49734_153995# VDD VDD pfet_06v0 ad=1.32p pd=6.88u as=1.32p ps=6.88u w=3u l=1u
X1184 a_39086_179979# a_40646_184379# VDD VDD pfet_06v0 ad=1.3p pd=5.52u as=1.3p ps=5.52u w=5u l=1u
X1185 a_39406_137692# a_39406_137692# a_41042_136492# VDD pfet_06v0 ad=4.4p pd=20.88u as=3.3p ps=10.66u w=10u l=1u
X1186 a_72806_171355# a_64834_175755# VDD VDD pfet_06v0 ad=4.4p pd=20.88u as=2.6p ps=10.52u w=10u l=1u
X1187 a_36942_153925# a_32270_153881# a_36610_153925# VSS nfet_06v0 ad=1.25p pd=5.5u as=1.65p ps=5.66u w=5u l=1u
X1188 VDD a_12580_196913# a_12580_196913# VDD pfet_06v0 ad=0.52p pd=2.52u as=0.52p ps=2.52u w=2u l=1u
X1189 VSS a_86454_162619# a_85786_166019# VSS nfet_06v0 ad=0.65p pd=3.02u as=0.65p ps=3.02u w=2.5u l=1u
X1190 a_44518_117766# a_32610_124508# VSS VSS nfet_06v0 ad=0.25p pd=1.5u as=0.44p ps=2.88u w=1u l=1u
X1191 a_59818_141734# a_61806_149676# a_55584_146196# VDD pfet_06v0 ad=1.76p pd=8.88u as=1.76p ps=8.88u w=4u l=1u
X1192 a_99398_148476# a_99698_148476# a_117170_148592# VDD pfet_06v0 ad=4.4p pd=20.88u as=2.5p ps=10.5u w=10u l=1u
X1193 VDD a_12580_136433# a_12580_136433# VDD pfet_06v0 ad=0.52p pd=2.52u as=0.52p ps=2.52u w=2u l=1u
X1194 a_83226_174825# a_37774_171239# a_85786_174755# VDD pfet_06v0 ad=4.4p pd=20.88u as=2.6p ps=10.52u w=10u l=1u
X1195 a_57946_150492# a_35066_141690# a_55210_148592# VDD pfet_06v0 ad=0.22p pd=1.88u as=0.22p ps=1.88u w=0.5u l=1u
X1196 a_37418_117766# a_32570_117722# a_34734_126514# VSS nfet_06v0 ad=1.1p pd=5.88u as=0.825p ps=3.16u w=2.5u l=1u
X1197 a_100272_134662# a_115690_134212# VSS ppolyf_u_1k r_width=1u r_length=76.45u
X1198 a_37774_171239# a_77872_134212# VDD VDD pfet_06v0 ad=0.44p pd=2.88u as=0.44p ps=2.88u w=1u l=1u
X1199 a_61806_137692# a_61806_137692# a_63442_136492# VDD pfet_06v0 ad=4.4p pd=20.88u as=3.3p ps=10.66u w=10u l=1u
X1200 VSS VDD VSS VSS nfet_06v0 ad=0.44p pd=2.88u as=0 ps=0 w=1u l=2u
X1201 a_94218_174825# a_94018_174709# VDD VDD pfet_06v0 ad=2.5p pd=10.5u as=4.4p ps=20.88u w=10u l=1u
X1202 a_61486_183379# a_63270_179979# VSS VSS nfet_06v0 ad=0.65p pd=3.02u as=1.1p ps=5.88u w=2.5u l=1u
X1203 a_39086_179979# a_32610_183333# a_40646_184379# VDD pfet_06v0 ad=2.2p pd=10.88u as=1.3p ps=5.52u w=5u l=1u
X1204 a_78566_157349# a_78866_157349# a_80490_153925# VSS nfet_06v0 ad=0.44p pd=2.88u as=0.25p ps=1.5u w=1u l=1u
X1205 a_85786_174755# a_78526_171241# a_86454_171355# VSS nfet_06v0 ad=1.1p pd=5.88u as=0.65p ps=3.02u w=2.5u l=1u
X1206 a_35810_117722# a_32570_117722# a_35546_126524# VSS nfet_06v0 ad=1.1p pd=5.88u as=0.825p ps=3.16u w=2.5u l=1u
X1207 a_107258_163980# a_114650_153868# VDD VDD pfet_06v0 ad=1.32p pd=6.88u as=1.32p ps=6.88u w=3u l=1u
X1208 a_36310_179909# a_33002_179865# VSS VSS nfet_06v0 ad=1.25p pd=5.5u as=2.2p ps=10.88u w=5u l=1u
X1209 a_85730_136492# a_77298_136492# a_85930_136608# VDD pfet_06v0 ad=3.3p pd=10.66u as=2.5p ps=10.5u w=10u l=1u
D53 VSS a_34334_141690# diode_nd2ps_06v0 pj=40u area=99.99999p
X1210 a_63270_171355# a_55342_171241# a_62602_174755# VSS nfet_06v0 ad=0.65p pd=3.02u as=1.1p ps=5.88u w=2.5u l=1u
X1211 a_85342_179979# a_86902_184379# VDD VDD pfet_06v0 ad=1.3p pd=5.52u as=1.3p ps=5.52u w=5u l=1u
X1212 a_32810_124624# a_32610_124508# a_32510_124624# VDD pfet_06v0 ad=4.4p pd=20.88u as=2.5p ps=10.5u w=10u l=1u
X1213 a_60042_166089# a_38886_162503# a_62602_166019# VDD pfet_06v0 ad=4.4p pd=20.88u as=2.6p ps=10.52u w=10u l=1u
X1214 a_40646_167019# a_32610_165973# a_39086_162619# VDD pfet_06v0 ad=1.3p pd=5.52u as=2.2p ps=10.88u w=5u l=1u
X1215 a_82866_179909# a_37774_179863# a_85342_179979# VSS nfet_06v0 ad=2.2p pd=10.88u as=1.3p ps=5.52u w=5u l=1u
X1216 a_40198_171355# a_32270_171241# a_39530_174755# VSS nfet_06v0 ad=0.65p pd=3.02u as=1.1p ps=5.88u w=2.5u l=1u
X1217 a_12580_136433# VDD a_105128_162888# VSS nfet_06v0 ad=0.6448p pd=3u as=1.0912p ps=5.84u w=2.48u l=1u
X1218 a_93582_179909# a_79258_179865# VSS VSS nfet_06v0 ad=1.25p pd=5.5u as=2.2p ps=10.88u w=5u l=1u
X1219 VSS VDD VSS VSS nfet_06v0 ad=7.92p pd=36.88u as=0 ps=0 w=18u l=2u
X1220 a_79422_126514# a_50996_204977# a_77498_124624# VDD pfet_06v0 ad=0.242p pd=1.98u as=0.242p ps=1.98u w=0.55u l=1u
X1221 a_79258_171241# a_78866_174709# a_79878_174825# VDD pfet_06v0 ad=4.4p pd=20.88u as=2.5p ps=10.5u w=10u l=1u
X1222 VDD a_86902_167019# a_85342_162619# VDD pfet_06v0 ad=1.3p pd=5.52u as=1.3p ps=5.52u w=5u l=1u
X1223 a_40646_175755# a_45662_171241# a_40198_171355# VSS nfet_06v0 ad=1.1p pd=5.88u as=1.1p ps=5.88u w=2.5u l=1u
X1224 a_117490_162492# a_49734_162619# VDD VDD pfet_06v0 ad=0.99p pd=3.66u as=1.32p ps=6.88u w=3u l=1u
X1225 a_39086_179979# a_38886_179863# a_36610_179909# VSS nfet_06v0 ad=1.3p pd=5.52u as=2.2p ps=10.88u w=5u l=1u
X1226 a_55210_124624# a_55010_124508# a_54910_124624# VDD pfet_06v0 ad=4.4p pd=20.88u as=2.5p ps=10.5u w=10u l=1u
X1227 VSS a_86454_171355# a_84670_174755# VSS nfet_06v0 ad=1.1p pd=5.88u as=0.65p ps=3.02u w=2.5u l=1u
X1228 a_61486_183379# a_72806_179979# cap_mim_2f0_m4m5_noshield c_width=20u c_length=10u
X1229 XN_OUT a_105404_157700# VSS VSS nfet_05v0 ad=0.5808p pd=3.52u as=0.5808p ps=3.52u w=1.32u l=0.6u
X1230 a_63718_184379# a_68734_179865# a_63270_179979# VSS nfet_06v0 ad=1.1p pd=5.88u as=1.1p ps=5.88u w=2.5u l=1u
X1231 a_58758_148592# a_60350_141690# a_58210_141690# VSS nfet_06v0 ad=0.88p pd=4.88u as=0.88p ps=4.88u w=2u l=1u
X1232 a_38886_179863# a_100272_146196# VDD VDD pfet_06v0 ad=0.44p pd=2.88u as=0.44p ps=2.88u w=1u l=1u
X1233 a_36610_162549# a_32270_162505# a_36310_162549# VSS nfet_06v0 ad=1.65p pd=5.66u as=1.25p ps=5.5u w=5u l=1u
X1234 a_63442_148476# a_55010_148476# a_63642_148592# VDD pfet_06v0 ad=3.3p pd=10.66u as=2.5p ps=10.5u w=10u l=1u
X1235 a_61486_166019# a_55342_162505# a_64382_162619# VSS nfet_06v0 ad=1.1p pd=5.88u as=0.65p ps=3.02u w=2.5u l=1u
X1236 a_78766_157465# a_78566_157349# VDD VDD pfet_06v0 ad=2.5p pd=10.5u as=4.4p ps=20.88u w=10u l=1u
X1237 a_82566_171285# a_79258_171241# VSS VSS nfet_06v0 ad=1.25p pd=5.5u as=2.2p ps=10.88u w=5u l=1u
X1238 a_86902_167019# a_78866_165973# a_85342_162619# VDD pfet_06v0 ad=1.3p pd=5.52u as=2.2p ps=10.88u w=5u l=1u
X1239 a_38414_174755# a_40198_171355# VSS VSS nfet_06v0 ad=0.65p pd=3.02u as=0.65p ps=3.02u w=2.5u l=1u
X1240 a_57134_126514# a_60846_153879# cap_mim_2f0_m4m5_noshield c_width=25u c_length=8u
X1241 a_61486_166019# a_72806_162619# cap_mim_2f0_m4m5_noshield c_width=20u c_length=10u
X1242 a_42022_129750# a_37418_129750# VSS VSS nfet_06v0 ad=0.44p pd=2.88u as=0.44p ps=2.88u w=1u l=1u
X1243 a_92382_166973# a_78526_162505# a_93582_162549# VSS nfet_06v0 ad=2.2p pd=10.88u as=1.25p ps=5.5u w=5u l=1u
D54 a_31060_204977# VDD diode_pd2nw_06v0 pj=40u area=99.99999p
X1244 a_117170_136608# a_99398_136492# VDD VDD pfet_06v0 ad=2.5p pd=10.5u as=4.4p ps=20.88u w=10u l=1u
X1245 VDD a_101510_179896# a_102330_179852# VDD pfet_06v0 ad=1.32p pd=6.88u as=0.99p ps=3.66u w=3u l=1u
X1246 a_107170_155360# a_107258_155244# a_12580_196913# VSS nfet_06v0 ad=1.0912p pd=5.84u as=0.6448p ps=3u w=2.48u l=1u
X1247 VDD a_63718_158395# a_62158_153995# VDD pfet_06v0 ad=1.3p pd=5.52u as=1.3p ps=5.52u w=5u l=1u
X1248 a_33202_179909# a_33002_179865# VSS VSS nfet_06v0 ad=1.25p pd=5.5u as=2.2p ps=10.88u w=5u l=1u
X1249 a_32770_129750# a_32570_129706# a_33502_129750# VSS nfet_06v0 ad=2.2p pd=10.88u as=1.25p ps=5.5u w=5u l=1u
X1250 VSS VDD VSS VSS nfet_06v0 ad=0.44p pd=2.88u as=0 ps=0 w=1u l=2u
X1251 a_99358_129706# a_99658_129706# a_110574_129750# VSS nfet_06v0 ad=2.2p pd=10.88u as=1.25p ps=5.5u w=5u l=1u
X1252 a_49734_153995# a_41310_153995# VSS VSS nfet_06v0 ad=2.2p pd=10.88u as=1.3p ps=5.52u w=5u l=1u
X1253 a_35066_117722# S2N VDD ppolyf_u r_width=40u r_length=10u
X1254 a_102320_154152# a_109102_155244# a_12580_196913# VSS nfet_06v0 ad=1.0912p pd=5.84u as=0.6448p ps=3u w=2.48u l=1u
X1255 VDD a_32310_165973# a_37302_166089# VDD pfet_06v0 ad=4.4p pd=20.88u as=2.5p ps=10.5u w=10u l=1u
X1256 a_37774_162503# a_100272_122228# VDD VDD pfet_06v0 ad=0.44p pd=2.88u as=0.44p ps=2.88u w=1u l=1u
X1257 a_58758_124624# a_60350_117722# a_58210_117722# VSS nfet_06v0 ad=0.88p pd=4.88u as=0.88p ps=4.88u w=2u l=1u
X1258 a_38886_162503# a_59818_129750# VSS VSS nfet_06v0 ad=0.44p pd=2.88u as=0.44p ps=2.88u w=1u l=1u
X1259 a_41762_158395# a_32610_157349# a_37974_153995# VDD pfet_06v0 ad=1.3p pd=5.52u as=2.2p ps=10.88u w=5u l=1u
X1260 a_102070_155360# a_102158_155244# a_12580_196913# VSS nfet_06v0 ad=1.0912p pd=5.84u as=0.6448p ps=3u w=2.48u l=1u
X1261 a_12580_36641# S4P VDD ppolyf_u r_width=40u r_length=10u
X1262 a_64382_179979# a_69198_184333# a_64834_184379# VDD pfet_06v0 ad=2.2p pd=10.88u as=2.2p ps=10.88u w=5u l=1u
X1263 VDD VSS VDD VDD pfet_06v0 ad=7.92p pd=36.88u as=0 ps=0 w=18u l=2u
X1264 a_83226_174825# a_60846_171239# a_84670_174755# VDD pfet_06v0 ad=4.4p pd=20.88u as=2.6p ps=10.52u w=10u l=1u
D55 a_12580_56801# VDD diode_pd2nw_06v0 pj=40u area=99.99999p
X1265 a_55170_129750# a_54970_129706# a_55902_129750# VSS nfet_06v0 ad=2.2p pd=10.88u as=1.25p ps=5.5u w=5u l=1u
X1266 a_33622_166089# a_32310_165973# VDD VDD pfet_06v0 ad=2.5p pd=10.5u as=4.4p ps=20.88u w=10u l=1u
X1267 VSS a_114650_153868# a_107258_163980# VSS nfet_06v0 ad=0.44p pd=2.88u as=0.44p ps=2.88u w=1u l=1u
X1268 a_41310_179979# a_46126_184333# a_41762_184379# VDD pfet_06v0 ad=2.2p pd=10.88u as=2.2p ps=10.88u w=5u l=1u
X1269 VDD a_86902_175755# a_84230_171355# VDD pfet_06v0 ad=2.2p pd=10.88u as=1.3p ps=5.52u w=5u l=1u
X1270 a_32310_174709# a_32610_174709# a_34234_171285# VSS nfet_06v0 ad=0.44p pd=2.88u as=0.25p ps=1.5u w=1u l=1u
X1271 a_61046_171355# a_60846_171239# a_59682_171285# VSS nfet_06v0 ad=1.3p pd=5.52u as=2.2p ps=10.88u w=5u l=1u
X1272 a_33184_146646# a_48602_146196# VSS ppolyf_u_1k r_width=1u r_length=76.45u
X1273 a_77872_123578# a_93290_123128# VSS ppolyf_u_1k r_width=1u r_length=76.45u
X1274 a_33002_162505# a_32270_162505# a_33202_162549# VSS nfet_06v0 ad=2.2p pd=10.88u as=1.25p ps=5.5u w=5u l=1u
X1275 a_46126_184333# a_46126_184333# a_47762_183333# VDD pfet_06v0 ad=4.4p pd=20.88u as=3.3p ps=10.66u w=10u l=1u
X1276 VSS a_40198_179979# a_39530_183379# VSS nfet_06v0 ad=0.65p pd=3.02u as=0.65p ps=3.02u w=2.5u l=1u
X1277 VDD a_64834_175755# a_72806_171355# VDD pfet_06v0 ad=2.6p pd=10.52u as=2.6p ps=10.52u w=10u l=1u
X1278 a_55382_183333# a_55682_183333# a_57306_179909# VSS nfet_06v0 ad=0.44p pd=2.88u as=0.25p ps=1.5u w=1u l=1u
X1279 a_111606_141734# a_99698_148476# VSS VSS nfet_06v0 ad=0.25p pd=1.5u as=0.44p ps=2.88u w=1u l=1u
X1280 a_32570_117722# a_32610_124508# a_47046_124624# VDD pfet_06v0 ad=4.4p pd=20.88u as=2.5p ps=10.5u w=10u l=1u
X1281 a_12580_196913# a_12580_196913# VDD VDD pfet_06v0 ad=0.52p pd=2.52u as=0.88p ps=4.88u w=2u l=1u
X1282 VSS a_72806_179979# a_102158_172604# VSS nfet_06v0 ad=0.44p pd=2.88u as=0.33p ps=1.66u w=1u l=1u
X1283 a_84094_149676# a_77258_141690# a_84302_141734# VSS nfet_06v0 ad=2.2p pd=10.88u as=1.25p ps=5.5u w=5u l=1u
X1284 a_104506_141734# a_99658_141690# a_101822_150482# VSS nfet_06v0 ad=1.1p pd=5.88u as=0.825p ps=3.16u w=2.5u l=1u
X1285 a_102320_171512# a_102120_171396# VSS VSS nfet_06v0 ad=0.5456p pd=3.36u as=0.5456p ps=3.36u w=1.24u l=1u
X1286 a_109774_124624# a_99398_124508# VDD VDD pfet_06v0 ad=2.5p pd=10.5u as=4.4p ps=20.88u w=10u l=1u
X1287 a_100272_146196# a_99698_148476# a_101622_141734# VDD pfet_06v0 ad=4.4p pd=20.88u as=4.4p ps=20.88u w=10u l=1u
X1288 a_33184_146196# a_48602_146196# VSS ppolyf_u_1k r_width=1u r_length=76.45u
X1289 VSS a_95990_179979# a_103262_179896# VSS nfet_06v0 ad=0.44p pd=2.88u as=0.25p ps=1.5u w=1u l=1u
X1290 a_56694_174825# a_55382_174709# VDD VDD pfet_06v0 ad=2.5p pd=10.5u as=4.4p ps=20.88u w=10u l=1u
X1291 a_84230_171355# a_86902_175755# VDD VDD pfet_06v0 ad=1.3p pd=5.52u as=2.2p ps=10.88u w=5u l=1u
X1292 a_100272_134662# a_115690_135112# VSS ppolyf_u_1k r_width=1u r_length=76.45u
X1293 a_102898_141690# a_99658_141690# a_102634_150492# VSS nfet_06v0 ad=1.1p pd=5.88u as=0.825p ps=3.16u w=2.5u l=1u
D56 VSS a_34334_141690# diode_nd2ps_06v0 pj=40u area=99.99999p
X1294 a_47962_166089# a_47762_165973# VDD VDD pfet_06v0 ad=2.5p pd=10.5u as=4.4p ps=20.88u w=10u l=1u
X1295 a_43486_129750# a_32270_129706# VSS VSS nfet_06v0 ad=1.25p pd=5.5u as=2.2p ps=10.88u w=5u l=1u
X1296 a_109102_172604# a_95990_171355# VSS VSS nfet_06v0 ad=0.33p pd=1.66u as=0.44p ps=2.88u w=1u l=1u
X1297 a_86454_171355# a_78526_171241# a_85786_174755# VSS nfet_06v0 ad=0.65p pd=3.02u as=1.1p ps=5.88u w=2.5u l=1u
X1298 a_77498_136608# a_77298_136492# a_77198_136608# VDD pfet_06v0 ad=4.4p pd=20.88u as=2.5p ps=10.5u w=10u l=1u
X1299 a_12580_56801# S4N VDD ppolyf_u r_width=40u r_length=10u
X1300 VDD VSS VDD VDD pfet_06v0 ad=0.44p pd=2.88u as=0 ps=0 w=1u l=2u
X1301 a_80498_141690# a_84094_149676# a_81046_148592# VDD pfet_06v0 ad=1.76p pd=8.88u as=1.76p ps=8.88u w=4u l=1u
X1302 a_32610_148476# a_32610_148476# VDD VDD pfet_06v0 ad=0.88p pd=4.88u as=0.88p ps=4.88u w=2u l=1u
X1303 VSS a_86454_153995# a_85786_157395# VSS nfet_06v0 ad=0.65p pd=3.02u as=0.65p ps=3.02u w=2.5u l=1u
X1304 a_32310_157349# a_32610_157349# a_35546_157465# VDD pfet_06v0 ad=4.4p pd=20.88u as=2.5p ps=10.5u w=10u l=1u
X1305 a_111606_117766# a_99698_124508# VSS VSS nfet_06v0 ad=0.25p pd=1.5u as=0.44p ps=2.88u w=1u l=1u
X1306 a_84094_125708# a_77258_117722# a_84302_117766# VSS nfet_06v0 ad=2.2p pd=10.88u as=1.25p ps=5.5u w=5u l=1u
X1307 a_35266_129750# a_35066_117722# a_32770_129750# VSS nfet_06v0 ad=3.74p pd=17.88u as=3.74p ps=17.88u w=8.5u l=1u
X1308 a_60042_157465# a_55682_157349# a_59742_157465# VDD pfet_06v0 ad=3.3p pd=10.66u as=2.5p ps=10.5u w=10u l=1u
X1309 a_62602_166019# a_38886_162503# a_60042_166089# VDD pfet_06v0 ad=2.6p pd=10.52u as=4.4p ps=20.88u w=10u l=1u
X1310 a_85342_179979# a_37774_179863# a_82866_179909# VSS nfet_06v0 ad=1.3p pd=5.52u as=2.2p ps=10.88u w=5u l=1u
X1311 a_104506_117766# a_99658_117722# a_101822_126514# VSS nfet_06v0 ad=1.1p pd=5.88u as=0.825p ps=3.16u w=2.5u l=1u
X1312 a_37950_129706# a_37950_129706# a_40458_129706# VSS nfet_06v0 ad=2.2p pd=10.88u as=1.65p ps=5.66u w=5u l=1u
X1313 VSS VDD VSS VSS nfet_06v0 ad=4.29p pd=20.38u as=0 ps=0 w=9.75u l=2u
X1314 a_80234_138508# a_12580_56801# a_77498_136608# VDD pfet_06v0 ad=0.22p pd=1.88u as=0.22p ps=1.88u w=0.5u l=1u
X1315 a_86454_162619# a_92382_166973# a_86902_167019# VDD pfet_06v0 ad=2.2p pd=10.88u as=2.2p ps=10.88u w=5u l=1u
X1316 a_105038_129706# a_99698_136492# a_109774_136608# VDD pfet_06v0 ad=4.4p pd=20.88u as=2.5p ps=10.5u w=10u l=1u
X1317 a_91918_171241# a_78866_174709# a_95662_174825# VDD pfet_06v0 ad=4.4p pd=20.88u as=2.5p ps=10.5u w=10u l=1u
X1318 a_102898_117722# a_99658_117722# a_102634_126524# VSS nfet_06v0 ad=1.1p pd=5.88u as=0.825p ps=3.16u w=2.5u l=1u
D57 VSS a_50996_204977# diode_nd2ps_06v0 pj=40u area=99.99999p
D58 VSS a_12580_76961# diode_nd2ps_06v0 pj=40u area=99.99999p
X1319 a_107170_155360# a_102120_154036# VSS VSS nfet_06v0 ad=0.5456p pd=3.36u as=0.5456p ps=3.36u w=1.24u l=1u
X1320 a_60042_157465# a_38886_153879# a_62602_157395# VDD pfet_06v0 ad=4.4p pd=20.88u as=2.6p ps=10.52u w=10u l=1u
X1321 a_40646_158395# a_32610_157349# a_39086_153995# VDD pfet_06v0 ad=1.3p pd=5.52u as=2.2p ps=10.88u w=5u l=1u
X1322 a_105026_172720# a_12580_76961# a_106426_172650# VSS nfet_06v0 ad=0.88p pd=4.88u as=0.5p ps=2.5u w=2u l=1u
X1323 VDD a_72806_171355# a_117490_171228# VDD pfet_06v0 ad=1.32p pd=6.88u as=0.99p ps=3.66u w=3u l=1u
X1324 a_81046_136608# a_77298_136492# a_79954_129750# VDD pfet_06v0 ad=4.4p pd=20.88u as=4.4p ps=20.88u w=10u l=1u
X1325 a_77298_148476# a_77298_148476# VDD VDD pfet_06v0 ad=0.88p pd=4.88u as=0.88p ps=4.88u w=2u l=1u
X1326 a_64382_162619# a_55342_162505# a_61486_166019# VSS nfet_06v0 ad=0.65p pd=3.02u as=1.1p ps=5.88u w=2.5u l=1u
X1327 a_42022_129750# a_33184_134212# VDD VDD pfet_06v0 ad=0.44p pd=2.88u as=0.44p ps=2.88u w=1u l=1u
X1328 a_34734_150482# a_34334_141690# a_32810_148592# VDD pfet_06v0 ad=0.242p pd=1.98u as=0.242p ps=1.98u w=0.55u l=1u
D59 a_34334_141690# VDD diode_pd2nw_06v0 pj=40u area=99.99999p
X1329 VDD a_86902_158395# a_85342_153995# VDD pfet_06v0 ad=1.3p pd=5.52u as=1.3p ps=5.52u w=5u l=1u
X1330 VDD a_63718_175755# a_61046_171355# VDD pfet_06v0 ad=2.2p pd=10.88u as=1.3p ps=5.52u w=5u l=1u
X1331 a_92846_124624# a_76998_124508# VDD VDD pfet_06v0 ad=2.5p pd=10.5u as=4.4p ps=20.88u w=10u l=1u
D60 VSS a_34334_117722# diode_nd2ps_06v0 pj=40u area=99.99999p
X1332 a_36970_183449# a_32610_183333# a_36670_183449# VDD pfet_06v0 ad=3.3p pd=10.66u as=2.5p ps=10.5u w=10u l=1u
X1333 a_32610_174709# a_32610_174709# VDD VDD pfet_06v0 ad=0.88p pd=4.88u as=0.88p ps=4.88u w=2u l=1u
X1334 a_48170_171241# a_32270_171241# a_48370_171285# VSS nfet_06v0 ad=1.65p pd=5.66u as=1.25p ps=5.5u w=5u l=1u
D61 a_12580_36641# VDD diode_pd2nw_06v0 pj=40u area=99.99999p
X1335 VSS a_63270_162619# a_61486_166019# VSS nfet_06v0 ad=1.1p pd=5.88u as=0.65p ps=3.02u w=2.5u l=1u
X1336 a_38886_153879# a_77872_122228# VDD VDD pfet_06v0 ad=0.44p pd=2.88u as=0.44p ps=2.88u w=1u l=1u
X1337 a_12580_196913# a_109102_155244# a_102320_154152# VSS nfet_06v0 ad=0.6448p pd=3u as=1.0912p ps=5.84u w=2.48u l=1u
X1338 a_106494_149676# a_106494_149676# a_108130_148476# VDD pfet_06v0 ad=4.4p pd=20.88u as=3.3p ps=10.66u w=10u l=1u
X1339 a_61486_157395# a_55342_153881# a_64382_153995# VSS nfet_06v0 ad=1.1p pd=5.88u as=0.65p ps=3.02u w=2.5u l=1u
X1340 VSS VDD VSS VSS nfet_06v0 ad=4.29p pd=20.38u as=0 ps=0 w=9.75u l=2u
X1341 a_86902_158395# a_78866_157349# a_85342_153995# VDD pfet_06v0 ad=1.3p pd=5.52u as=2.2p ps=10.88u w=5u l=1u
X1342 a_55010_136492# a_55010_136492# VDD VDD pfet_06v0 ad=0.88p pd=4.88u as=0.88p ps=4.88u w=2u l=1u
X1343 VSS a_117490_171228# a_109102_155244# VSS nfet_06v0 ad=0.44p pd=2.88u as=0.44p ps=2.88u w=1u l=1u
X1344 a_84670_174755# a_60846_171239# a_83226_174825# VDD pfet_06v0 ad=2.6p pd=10.52u as=4.4p ps=20.88u w=10u l=1u
X1345 a_45662_162505# a_32610_165973# a_49406_166089# VDD pfet_06v0 ad=4.4p pd=20.88u as=2.5p ps=10.5u w=10u l=1u
X1346 a_107170_164096# a_102120_162772# VSS VSS nfet_06v0 ad=0.5456p pd=3.36u as=0.5456p ps=3.36u w=1.24u l=1u
X1347 VSS VDD VSS VSS nfet_06v0 ad=4.29p pd=20.38u as=0 ps=0 w=9.75u l=2u
X1348 a_76958_129706# a_77298_136492# a_92846_136608# VDD pfet_06v0 ad=4.4p pd=20.88u as=2.5p ps=10.5u w=10u l=1u
X1349 a_80490_153925# a_78866_157349# VSS VSS nfet_06v0 ad=0.25p pd=1.5u as=0.44p ps=2.88u w=1u l=1u
X1350 a_69198_175709# a_69198_175709# a_70834_174709# VDD pfet_06v0 ad=4.4p pd=20.88u as=3.3p ps=10.66u w=10u l=1u
X1351 VDD a_88018_175755# a_95990_171355# VDD pfet_06v0 ad=2.6p pd=10.52u as=2.6p ps=10.52u w=10u l=1u
X1352 a_39530_183379# a_40198_179979# VSS VSS nfet_06v0 ad=0.65p pd=3.02u as=1.1p ps=5.88u w=2.5u l=1u
X1353 a_32510_124624# a_32310_124508# VDD VDD pfet_06v0 ad=2.5p pd=10.5u as=4.4p ps=20.88u w=10u l=1u
X1354 a_77872_123578# a_38886_153879# VSS ppolyf_u_1k r_width=1u r_length=76.45u
X1355 a_72806_171355# a_64834_175755# VDD VDD pfet_06v0 ad=2.6p pd=10.52u as=4.4p ps=20.88u w=10u l=1u
X1356 a_84230_179979# a_78866_183333# a_88018_184379# VDD pfet_06v0 ad=2.2p pd=10.88u as=1.3p ps=5.52u w=5u l=1u
X1357 a_79878_174825# a_78566_174709# VDD VDD pfet_06v0 ad=2.5p pd=10.5u as=4.4p ps=20.88u w=10u l=1u
X1358 a_82638_141690# a_82638_141690# a_85146_141690# VSS nfet_06v0 ad=2.2p pd=10.88u as=1.65p ps=5.66u w=5u l=1u
X1359 a_63270_162619# a_69198_166973# a_63718_167019# VDD pfet_06v0 ad=2.2p pd=10.88u as=2.2p ps=10.88u w=5u l=1u
X1360 a_61046_171355# a_55682_174709# a_64834_175755# VDD pfet_06v0 ad=2.2p pd=10.88u as=1.3p ps=5.52u w=5u l=1u
X1361 a_38886_179863# a_101622_141734# cap_mim_2f0_m4m5_noshield c_width=25u c_length=8u
X1362 a_100272_146646# a_115690_146196# VSS ppolyf_u_1k r_width=1u r_length=76.45u
X1363 a_71034_157465# a_70834_157349# VDD VDD pfet_06v0 ad=2.5p pd=10.5u as=4.4p ps=20.88u w=10u l=1u
X1364 a_62158_162619# a_38886_162503# a_59682_162549# VSS nfet_06v0 ad=1.3p pd=5.52u as=2.2p ps=10.88u w=5u l=1u
D62 a_12580_136433# VDD diode_pd2nw_06v0 pj=40u area=99.99999p
X1365 VDD VSS VDD VDD pfet_06v0 ad=0.44p pd=2.88u as=0 ps=0 w=1u l=2u
X1366 a_36310_162549# a_33002_162505# VSS VSS nfet_06v0 ad=1.25p pd=5.5u as=2.2p ps=10.88u w=5u l=1u
X1367 a_78866_174709# a_78866_174709# a_81522_171285# VSS nfet_06v0 ad=0.44p pd=2.88u as=0.25p ps=1.5u w=1u l=1u
X1368 a_99658_117722# a_99698_124508# a_114134_124624# VDD pfet_06v0 ad=4.4p pd=20.88u as=2.5p ps=10.5u w=10u l=1u
X1369 a_77258_141690# a_77298_148476# a_91734_148592# VDD pfet_06v0 ad=4.4p pd=20.88u as=2.5p ps=10.5u w=10u l=1u
X1370 a_63642_148592# a_63442_148476# VDD VDD pfet_06v0 ad=2.5p pd=10.5u as=4.4p ps=20.88u w=10u l=1u
D63 a_35066_141690# VDD diode_pd2nw_06v0 pj=40u area=99.99999p
X1371 a_38886_179863# a_104506_141734# VSS VSS nfet_06v0 ad=0.44p pd=2.88u as=0.44p ps=2.88u w=1u l=1u
X1372 a_72806_179979# a_64382_179979# VSS VSS nfet_06v0 ad=1.3p pd=5.52u as=2.2p ps=10.88u w=5u l=1u
D64 VSS a_12580_56801# diode_nd2ps_06v0 pj=40u area=99.99999p
X1373 a_32810_136608# a_32610_136492# a_32510_136608# VDD pfet_06v0 ad=4.4p pd=20.88u as=2.5p ps=10.5u w=10u l=1u
X1374 a_103182_172720# a_103270_172604# a_12580_76961# VSS nfet_06v0 ad=1.0912p pd=5.84u as=0.6448p ps=3u w=2.48u l=1u
X1375 a_82638_117722# a_82638_117722# a_85146_117722# VSS nfet_06v0 ad=2.2p pd=10.88u as=1.65p ps=5.66u w=5u l=1u
X1376 a_100272_146196# a_115690_146196# VSS ppolyf_u_1k r_width=1u r_length=76.45u
X1377 a_93582_162549# a_79258_162505# VSS VSS nfet_06v0 ad=1.25p pd=5.5u as=2.2p ps=10.88u w=5u l=1u
X1378 a_62158_171355# a_63718_175755# VDD VDD pfet_06v0 ad=1.3p pd=5.52u as=2.2p ps=10.88u w=5u l=1u
X1379 a_33502_129750# a_32270_129706# VSS VSS nfet_06v0 ad=1.25p pd=5.5u as=2.2p ps=10.88u w=5u l=1u
X1380 a_110574_129750# a_99358_129706# VSS VSS nfet_06v0 ad=1.25p pd=5.5u as=2.2p ps=10.88u w=5u l=1u
X1381 a_105026_172720# a_12580_76961# a_12580_76961# VSS nfet_06v0 ad=0.88p pd=4.88u as=0.52p ps=2.52u w=2u l=1u
X1382 a_70834_183333# a_55682_183333# a_71034_183449# VDD pfet_06v0 ad=3.3p pd=10.66u as=2.5p ps=10.5u w=10u l=1u
X1383 a_77872_134212# a_82638_129706# a_82106_129750# VSS nfet_06v0 ad=0.88p pd=4.88u as=0.88p ps=4.88u w=2u l=1u
X1384 a_32610_136492# a_32610_136492# a_45550_129750# VSS nfet_06v0 ad=0.44p pd=2.88u as=0.25p ps=1.5u w=1u l=1u
D65 a_34334_141690# VDD diode_pd2nw_06v0 pj=40u area=99.99999p
X1385 a_55210_136608# a_55010_136492# a_54910_136608# VDD pfet_06v0 ad=4.4p pd=20.88u as=2.5p ps=10.5u w=10u l=1u
X1386 a_37302_166089# a_32610_165973# a_36970_166089# VDD pfet_06v0 ad=2.5p pd=10.5u as=3.3p ps=10.66u w=10u l=1u
X1387 a_63718_167019# a_68734_162505# a_63270_162619# VSS nfet_06v0 ad=1.1p pd=5.88u as=1.1p ps=5.88u w=2.5u l=1u
X1388 a_87566_162619# a_78526_162505# a_84670_166019# VSS nfet_06v0 ad=0.65p pd=3.02u as=1.1p ps=5.88u w=2.5u l=1u
X1389 a_102354_129750# a_31060_204977# a_99858_129750# VSS nfet_06v0 ad=3.74p pd=17.88u as=3.74p ps=17.88u w=8.5u l=1u
X1390 a_37774_162503# a_104506_117766# VSS VSS nfet_06v0 ad=0.44p pd=2.88u as=0.44p ps=2.88u w=1u l=1u
X1391 a_62602_157395# a_38886_153879# a_60042_157465# VDD pfet_06v0 ad=2.6p pd=10.52u as=4.4p ps=20.88u w=10u l=1u
X1392 a_55010_136492# a_55010_136492# a_67950_129750# VSS nfet_06v0 ad=0.44p pd=2.88u as=0.25p ps=1.5u w=1u l=1u
X1393 a_61046_171355# a_63718_175755# VDD VDD pfet_06v0 ad=1.3p pd=5.52u as=1.3p ps=5.52u w=5u l=1u
X1394 a_34234_171285# a_32610_174709# VSS VSS nfet_06v0 ad=0.25p pd=1.5u as=0.44p ps=2.88u w=1u l=1u
D66 VSS a_12580_196913# diode_nd2ps_06v0 pj=40u area=99.99999p
X1395 a_114650_153868# a_95990_153995# VDD VDD pfet_06v0 ad=0.99p pd=3.66u as=1.32p ps=6.88u w=3u l=1u
X1396 a_33202_162549# a_33002_162505# VSS VSS nfet_06v0 ad=1.25p pd=5.5u as=2.2p ps=10.88u w=5u l=1u
X1397 a_84094_125708# a_84094_125708# a_85730_124508# VDD pfet_06v0 ad=4.4p pd=20.88u as=3.3p ps=10.66u w=10u l=1u
X1398 a_61486_166019# a_63270_162619# VSS VSS nfet_06v0 ad=0.65p pd=3.02u as=0.65p ps=3.02u w=2.5u l=1u
X1399 a_57306_179909# a_55682_183333# VSS VSS nfet_06v0 ad=0.25p pd=1.5u as=0.44p ps=2.88u w=1u l=1u
X1400 VDD a_40646_175755# a_39086_171355# VDD pfet_06v0 ad=2.2p pd=10.88u as=1.3p ps=5.52u w=5u l=1u
X1401 a_12580_76961# a_12580_76961# VDD VDD pfet_06v0 ad=0.52p pd=2.52u as=0.52p ps=2.52u w=2u l=1u
X1402 a_105128_154152# VDD a_12580_196913# VSS nfet_06v0 ad=1.0912p pd=5.84u as=0.6448p ps=3u w=2.48u l=1u
X1403 a_85342_179979# a_78866_183333# a_86902_184379# VDD pfet_06v0 ad=2.2p pd=10.88u as=1.3p ps=5.52u w=5u l=1u
X1404 VSS a_33002_171241# a_36942_171285# VSS nfet_06v0 ad=2.2p pd=10.88u as=1.25p ps=5.5u w=5u l=1u
X1405 a_84302_141734# a_76958_141690# VSS VSS nfet_06v0 ad=1.25p pd=5.5u as=2.2p ps=10.88u w=5u l=1u
X1406 a_64382_153995# a_55342_153881# a_61486_157395# VSS nfet_06v0 ad=0.65p pd=3.02u as=1.1p ps=5.88u w=2.5u l=1u
X1407 VDD VSS VDD VDD pfet_06v0 ad=4.29p pd=20.38u as=0 ps=0 w=9.75u l=2u
X1408 a_60846_171239# a_100272_134212# VDD VDD pfet_06v0 ad=0.44p pd=2.88u as=0.44p ps=2.88u w=1u l=1u
X1409 a_76998_148476# a_77298_148476# a_89206_141734# VSS nfet_06v0 ad=0.44p pd=2.88u as=0.25p ps=1.5u w=1u l=1u
X1410 a_101822_150482# a_34334_117722# a_99898_148592# VDD pfet_06v0 ad=0.242p pd=1.98u as=0.242p ps=1.98u w=0.55u l=1u
X1411 a_61486_157395# a_72806_153995# cap_mim_2f0_m4m5_noshield c_width=20u c_length=10u
X1412 a_83226_157465# a_78866_157349# a_82926_157465# VDD pfet_06v0 ad=3.3p pd=10.66u as=2.5p ps=10.5u w=10u l=1u
X1413 a_55342_162505# a_55682_165973# a_55582_166089# VDD pfet_06v0 ad=4.4p pd=20.88u as=2.5p ps=10.5u w=10u l=1u
X1414 a_79422_126514# a_38886_153879# cap_mim_2f0_m4m5_noshield c_width=25u c_length=8u
X1415 a_40458_129706# a_32570_129706# a_40658_129750# VSS nfet_06v0 ad=1.65p pd=5.66u as=1.25p ps=5.5u w=5u l=1u
X1416 a_103262_179896# a_101510_179896# a_102330_179852# VSS nfet_06v0 ad=0.25p pd=1.5u as=0.44p ps=2.88u w=1u l=1u
X1417 a_78566_174709# a_78866_174709# a_81802_174825# VDD pfet_06v0 ad=4.4p pd=20.88u as=2.5p ps=10.5u w=10u l=1u
X1418 a_46126_158349# a_32270_153881# a_47326_153925# VSS nfet_06v0 ad=2.2p pd=10.88u as=1.25p ps=5.5u w=5u l=1u
X1419 VSS a_63270_153995# a_61486_157395# VSS nfet_06v0 ad=1.1p pd=5.88u as=0.65p ps=3.02u w=2.5u l=1u
X1420 a_54970_129706# a_54970_129706# VSS VSS nfet_06v0 ad=0.44p pd=2.88u as=0.44p ps=2.88u w=1u l=1u
X1421 a_104084_154152# a_102120_154036# a_103784_154152# VSS nfet_06v0 ad=0.175p pd=1.2u as=0.175p ps=1.2u w=0.7u l=1u
X1422 a_95990_171355# a_88018_175755# VDD VDD pfet_06v0 ad=2.6p pd=10.52u as=4.4p ps=20.88u w=10u l=1u
X1423 a_36942_179909# a_32270_179865# a_36610_179909# VSS nfet_06v0 ad=1.25p pd=5.5u as=1.65p ps=5.66u w=5u l=1u
X1424 a_55682_174709# a_55682_174709# a_58338_171285# VSS nfet_06v0 ad=0.44p pd=2.88u as=0.25p ps=1.5u w=1u l=1u
X1425 a_35546_157465# a_32310_157349# VDD VDD pfet_06v0 ad=2.5p pd=10.5u as=4.4p ps=20.88u w=10u l=1u
X1426 a_56934_129750# a_12580_36641# a_55170_129750# VSS nfet_06v0 ad=3.3p pd=15.88u as=3.3p ps=15.88u w=7.5u l=1u
X1427 a_62858_129706# a_54970_129706# a_63058_129750# VSS nfet_06v0 ad=1.65p pd=5.66u as=1.25p ps=5.5u w=5u l=1u
X1428 a_55382_165973# a_55682_165973# a_57306_162549# VSS nfet_06v0 ad=0.44p pd=2.88u as=0.25p ps=1.5u w=1u l=1u
X1429 a_99858_129750# a_99658_129706# a_99558_129750# VSS nfet_06v0 ad=2.2p pd=10.88u as=1.25p ps=5.5u w=5u l=1u
X1430 a_84302_117766# a_76958_117722# VSS VSS nfet_06v0 ad=1.25p pd=5.5u as=2.2p ps=10.88u w=5u l=1u
X1431 a_59742_157465# a_55382_157349# VDD VDD pfet_06v0 ad=2.5p pd=10.5u as=4.4p ps=20.88u w=10u l=1u
X1432 VDD VSS VDD VDD pfet_06v0 ad=4.29p pd=20.38u as=0 ps=0 w=9.75u l=2u
X1433 a_39086_171355# a_40646_175755# VDD VDD pfet_06v0 ad=1.3p pd=5.52u as=2.2p ps=10.88u w=5u l=1u
X1434 a_76998_124508# a_77298_124508# a_89206_117766# VSS nfet_06v0 ad=0.44p pd=2.88u as=0.25p ps=1.5u w=1u l=1u
X1435 a_55584_147546# a_37774_179863# VSS ppolyf_u_1k r_width=1u r_length=76.45u
X1436 VSS a_40198_171355# a_39530_174755# VSS nfet_06v0 ad=1.1p pd=5.88u as=0.65p ps=3.02u w=2.5u l=1u
X1437 a_32570_129706# a_32610_136492# a_47046_136608# VDD pfet_06v0 ad=4.4p pd=20.88u as=2.5p ps=10.5u w=10u l=1u
X1438 a_37774_179863# a_55584_146196# VDD VDD pfet_06v0 ad=0.44p pd=2.88u as=0.44p ps=2.88u w=1u l=1u
X1439 VDD VSS VDD VDD pfet_06v0 ad=0.44p pd=2.88u as=0 ps=0 w=1u l=2u
X1440 VDD a_40646_167019# a_37974_162619# VDD pfet_06v0 ad=1.3p pd=5.52u as=1.3p ps=5.52u w=5u l=1u
X1441 a_64834_175755# a_55682_174709# a_61046_171355# VDD pfet_06v0 ad=1.3p pd=5.52u as=2.2p ps=10.88u w=5u l=1u
X1442 a_109774_136608# a_99398_136492# VDD VDD pfet_06v0 ad=2.5p pd=10.5u as=4.4p ps=20.88u w=10u l=1u
X1443 a_103182_172720# a_102120_171396# VSS VSS nfet_06v0 ad=0.5456p pd=3.36u as=0.5456p ps=3.36u w=1.24u l=1u
X1444 a_78566_183333# a_78866_183333# a_80490_179909# VSS nfet_06v0 ad=0.44p pd=2.88u as=0.25p ps=1.5u w=1u l=1u
X1445 a_95662_174825# a_78566_174709# VDD VDD pfet_06v0 ad=2.5p pd=10.5u as=4.4p ps=20.88u w=10u l=1u
D67 VSS a_12580_36641# diode_nd2ps_06v0 pj=40u area=99.99999p
X1446 VDD VSS VDD VDD pfet_06v0 ad=7.92p pd=36.88u as=0 ps=0 w=18u l=2u
X1447 a_106426_172650# a_12580_76961# VSS VSS nfet_06v0 ad=0.5p pd=2.5u as=0.88p ps=4.88u w=2u l=1u
X1448 a_45662_171241# a_45662_171241# a_48170_171241# VSS nfet_06v0 ad=2.2p pd=10.88u as=1.65p ps=5.66u w=5u l=1u
X1449 a_102070_172720# a_102120_171396# VSS VSS nfet_06v0 ad=0.5456p pd=3.36u as=0.5456p ps=3.36u w=1.24u l=1u
X1450 a_54710_148476# a_55010_148476# a_72482_148592# VDD pfet_06v0 ad=4.4p pd=20.88u as=2.5p ps=10.5u w=10u l=1u
X1451 a_83198_171285# a_78526_171241# a_82866_171285# VSS nfet_06v0 ad=1.25p pd=5.5u as=1.65p ps=5.66u w=5u l=1u
X1452 a_85342_171355# a_86902_175755# VDD VDD pfet_06v0 ad=1.3p pd=5.52u as=2.2p ps=10.88u w=5u l=1u
X1453 a_60846_179863# a_79222_141734# cap_mim_2f0_m4m5_noshield c_width=25u c_length=8u
X1454 VDD VSS VDD VDD pfet_06v0 ad=7.92p pd=36.88u as=0 ps=0 w=18u l=2u
X1455 a_12580_76961# a_103270_172604# a_103182_172720# VSS nfet_06v0 ad=0.6448p pd=3u as=1.0912p ps=5.84u w=2.48u l=1u
X1456 a_36670_183449# a_32310_183333# VDD VDD pfet_06v0 ad=2.5p pd=10.5u as=4.4p ps=20.88u w=10u l=1u
X1457 a_94018_183333# a_78866_183333# a_94218_183449# VDD pfet_06v0 ad=3.3p pd=10.66u as=2.5p ps=10.5u w=10u l=1u
X1458 a_48370_171285# a_48170_171241# VSS VSS nfet_06v0 ad=1.25p pd=5.5u as=2.2p ps=10.88u w=5u l=1u
X1459 a_62158_153995# a_38886_153879# a_59682_153925# VSS nfet_06v0 ad=1.3p pd=5.52u as=2.2p ps=10.88u w=5u l=1u
D68 a_12580_196913# VDD diode_pd2nw_06v0 pj=40u area=99.99999p
X1460 a_12580_76961# a_12580_76961# a_105026_172720# VSS nfet_06v0 ad=0.52p pd=2.52u as=0.88p ps=4.88u w=2u l=1u
X1461 a_88018_175755# a_91918_171241# a_87566_171355# VSS nfet_06v0 ad=1.1p pd=5.88u as=1.1p ps=5.88u w=2.5u l=1u
X1462 a_95990_153995# a_84230_153995# cap_mim_2f0_m4m5_noshield c_width=20u c_length=10u
X1463 a_36610_171285# a_38886_171239# a_39086_171355# VSS nfet_06v0 ad=2.2p pd=10.88u as=1.3p ps=5.52u w=5u l=1u
X1464 a_35066_141690# S3N VDD ppolyf_u r_width=40u r_length=10u
X1465 a_49406_166089# a_32310_165973# VDD VDD pfet_06v0 ad=2.5p pd=10.5u as=4.4p ps=20.88u w=10u l=1u
X1466 VSS VDD VSS VSS nfet_06v0 ad=0.44p pd=2.88u as=0 ps=0 w=1u l=2u
X1467 a_77872_134662# a_93290_134212# VSS ppolyf_u_1k r_width=1u r_length=76.45u
X1468 a_40198_153995# a_46126_158349# a_40646_158395# VDD pfet_06v0 ad=2.2p pd=10.88u as=2.2p ps=10.88u w=5u l=1u
X1469 a_55382_174709# a_55682_174709# a_58618_174825# VDD pfet_06v0 ad=4.4p pd=20.88u as=2.5p ps=10.5u w=10u l=1u
X1470 a_113830_162536# a_49734_162619# VDD VDD pfet_06v0 ad=1.32p pd=6.88u as=1.32p ps=6.88u w=3u l=1u
X1471 VSS VDD VSS VSS nfet_06v0 ad=0.44p pd=2.88u as=0 ps=0 w=1u l=2u
X1472 a_49734_179979# a_41310_179979# VSS VSS nfet_06v0 ad=2.2p pd=10.88u as=1.3p ps=5.52u w=5u l=1u
X1473 a_92846_136608# a_76998_136492# VDD VDD pfet_06v0 ad=2.5p pd=10.5u as=4.4p ps=20.88u w=10u l=1u
X1474 a_84670_174755# a_86454_171355# VSS VSS nfet_06v0 ad=0.65p pd=3.02u as=1.1p ps=5.88u w=2.5u l=1u
X1475 a_87566_153995# a_78526_153881# a_84670_157395# VSS nfet_06v0 ad=0.65p pd=3.02u as=1.1p ps=5.88u w=2.5u l=1u
X1476 a_57666_141734# a_58758_148592# VDD VDD pfet_06v0 ad=2.2p pd=10.88u as=2.2p ps=10.88u w=5u l=1u
X1477 VDD a_12580_76961# a_12580_76961# VDD pfet_06v0 ad=0.52p pd=2.52u as=0.52p ps=2.52u w=2u l=1u
X1478 a_37774_171239# a_77872_134212# VDD VDD pfet_06v0 ad=0.44p pd=2.88u as=0.44p ps=2.88u w=1u l=1u
X1479 a_78526_162505# a_78866_165973# a_78766_166089# VDD pfet_06v0 ad=4.4p pd=20.88u as=2.5p ps=10.5u w=10u l=1u
X1480 a_55342_153881# a_55342_153881# VSS VSS nfet_06v0 ad=0.44p pd=2.88u as=0.44p ps=2.88u w=1u l=1u
X1481 a_32570_141690# a_32570_141690# VSS VSS nfet_06v0 ad=0.44p pd=2.88u as=0.44p ps=2.88u w=1u l=1u
X1482 a_77298_148476# a_77298_148476# a_90238_141734# VSS nfet_06v0 ad=0.44p pd=2.88u as=0.25p ps=1.5u w=1u l=1u
X1483 a_34734_138498# a_34334_117722# a_32810_136608# VDD pfet_06v0 ad=0.242p pd=1.98u as=0.242p ps=1.98u w=0.55u l=1u
X1484 a_63718_175755# a_55682_174709# a_62158_171355# VDD pfet_06v0 ad=1.3p pd=5.52u as=2.2p ps=10.88u w=5u l=1u
X1485 a_34534_141734# a_34334_141690# a_32770_141734# VSS nfet_06v0 ad=3.3p pd=15.88u as=3.3p ps=15.88u w=7.5u l=1u
X1486 a_61486_157395# a_63270_153995# VSS VSS nfet_06v0 ad=0.65p pd=3.02u as=0.65p ps=3.02u w=2.5u l=1u
X1487 a_103270_163980# a_114650_162492# VDD VDD pfet_06v0 ad=1.32p pd=6.88u as=1.32p ps=6.88u w=3u l=1u
X1488 a_77458_141734# a_77258_141690# a_77158_141734# VSS nfet_06v0 ad=2.2p pd=10.88u as=1.25p ps=5.5u w=5u l=1u
X1489 a_81522_171285# a_78866_174709# VSS VSS nfet_06v0 ad=0.25p pd=1.5u as=0.44p ps=2.88u w=1u l=1u
X1490 VDD VSS VDD VDD pfet_06v0 ad=4.29p pd=20.38u as=0 ps=0 w=9.75u l=2u
X1491 a_61486_174755# a_72806_171355# cap_mim_2f0_m4m5_noshield c_width=20u c_length=10u
X1492 a_91734_148592# a_76998_148476# VDD VDD pfet_06v0 ad=2.5p pd=10.5u as=4.4p ps=20.88u w=10u l=1u
X1493 a_60846_179863# a_77872_146196# VDD VDD pfet_06v0 ad=0.44p pd=2.88u as=0.44p ps=2.88u w=1u l=1u
X1494 a_35810_141690# a_39406_149676# a_36358_148592# VDD pfet_06v0 ad=1.76p pd=8.88u as=1.76p ps=8.88u w=4u l=1u
D69 VSS a_34334_117722# diode_nd2ps_06v0 pj=40u area=99.99999p
X1495 VDD VSS VDD VDD pfet_06v0 ad=7.92p pd=36.88u as=0 ps=0 w=18u l=2u
X1496 a_32510_136608# a_32310_136492# VDD VDD pfet_06v0 ad=2.5p pd=10.5u as=4.4p ps=20.88u w=10u l=1u
X1497 a_32570_117722# a_32570_117722# VSS VSS nfet_06v0 ad=0.44p pd=2.88u as=0.44p ps=2.88u w=1u l=1u
X1498 a_55584_122678# a_71002_122228# VSS ppolyf_u_1k r_width=1u r_length=76.45u
X1499 a_77298_124508# a_77298_124508# a_90238_117766# VSS nfet_06v0 ad=0.44p pd=2.88u as=0.25p ps=1.5u w=1u l=1u
X1500 a_88018_175755# a_78866_174709# a_84230_171355# VDD pfet_06v0 ad=1.3p pd=5.52u as=2.2p ps=10.88u w=5u l=1u
X1501 a_37974_162619# a_40646_167019# VDD VDD pfet_06v0 ad=1.3p pd=5.52u as=2.2p ps=10.88u w=5u l=1u
X1502 a_34534_117766# a_34334_117722# a_32770_117766# VSS nfet_06v0 ad=3.3p pd=15.88u as=3.3p ps=15.88u w=7.5u l=1u
X1503 VDD VSS VDD VDD pfet_06v0 ad=0.44p pd=2.88u as=0 ps=0 w=1u l=2u
X1504 a_77458_117766# a_77258_117722# a_77158_117766# VSS nfet_06v0 ad=2.2p pd=10.88u as=1.25p ps=5.5u w=5u l=1u
X1505 a_45550_129750# a_32610_136492# VSS VSS nfet_06v0 ad=0.25p pd=1.5u as=0.44p ps=2.88u w=1u l=1u
X1506 VSS VDD VSS VSS nfet_06v0 ad=0.44p pd=2.88u as=0 ps=0 w=1u l=2u
X1507 a_64834_175755# a_68734_171241# a_64382_171355# VSS nfet_06v0 ad=1.1p pd=5.88u as=1.1p ps=5.88u w=2.5u l=1u
X1508 VSS a_86454_179979# a_85786_183379# VSS nfet_06v0 ad=0.65p pd=3.02u as=0.65p ps=3.02u w=2.5u l=1u
X1509 a_76958_129706# a_77258_129706# a_88174_129750# VSS nfet_06v0 ad=2.2p pd=10.88u as=1.25p ps=5.5u w=5u l=1u
X1510 VDD a_113830_153912# a_114650_153868# VDD pfet_06v0 ad=1.32p pd=6.88u as=0.99p ps=3.66u w=3u l=1u
X1511 a_105038_129706# a_105038_129706# a_107546_129706# VSS nfet_06v0 ad=2.2p pd=10.88u as=1.65p ps=5.66u w=5u l=1u
X1512 a_99658_129706# a_99698_136492# a_114134_136608# VDD pfet_06v0 ad=4.4p pd=20.88u as=2.5p ps=10.5u w=10u l=1u
X1513 a_12580_136433# Y VDD ppolyf_u r_width=40u r_length=10u
X1514 a_32270_153881# a_32610_157349# a_32510_157465# VDD pfet_06v0 ad=4.4p pd=20.88u as=2.5p ps=10.5u w=10u l=1u
X1515 VSS a_40198_162619# a_38414_166019# VSS nfet_06v0 ad=0.65p pd=3.02u as=0.65p ps=3.02u w=2.5u l=1u
X1516 VDD a_40646_158395# a_37974_153995# VDD pfet_06v0 ad=1.3p pd=5.52u as=1.3p ps=5.52u w=5u l=1u
X1517 a_65086_124624# a_54710_124508# VDD VDD pfet_06v0 ad=2.5p pd=10.5u as=4.4p ps=20.88u w=10u l=1u
X1518 a_72806_171355# a_64382_171355# VSS VSS nfet_06v0 ad=2.2p pd=10.88u as=1.3p ps=5.52u w=5u l=1u
X1519 a_56074_179865# a_55682_183333# a_56694_183449# VDD pfet_06v0 ad=4.4p pd=20.88u as=2.5p ps=10.5u w=10u l=1u
X1520 a_54670_141690# a_54970_141690# a_65886_141734# VSS nfet_06v0 ad=2.2p pd=10.88u as=1.25p ps=5.5u w=5u l=1u
X1521 VDD VSS VDD VDD pfet_06v0 ad=0.44p pd=2.88u as=0 ps=0 w=1u l=2u
X1522 a_89206_141734# a_77298_148476# VSS VSS nfet_06v0 ad=0.25p pd=1.5u as=0.44p ps=2.88u w=1u l=1u
X1523 a_39530_166019# a_40198_162619# VSS VSS nfet_06v0 ad=0.65p pd=3.02u as=0.65p ps=3.02u w=2.5u l=1u
X1524 a_107546_141690# a_99658_141690# a_107746_141734# VSS nfet_06v0 ad=1.65p pd=5.66u as=1.25p ps=5.5u w=5u l=1u
D70 a_31060_204977# VDD diode_pd2nw_06v0 pj=40u area=99.99999p
X1525 a_55582_166089# a_55382_165973# VDD VDD pfet_06v0 ad=2.5p pd=10.5u as=4.4p ps=20.88u w=10u l=1u
X1526 a_77158_129750# a_76958_129706# VSS VSS nfet_06v0 ad=1.25p pd=5.5u as=2.2p ps=10.88u w=5u l=1u
X1527 a_40658_129750# a_40458_129706# VSS VSS nfet_06v0 ad=1.25p pd=5.5u as=2.2p ps=10.88u w=5u l=1u
X1528 a_81802_174825# a_78566_174709# VDD VDD pfet_06v0 ad=2.5p pd=10.5u as=4.4p ps=20.88u w=10u l=1u
X1529 a_104506_117766# a_106494_125708# a_100272_122228# VDD pfet_06v0 ad=1.76p pd=8.88u as=1.76p ps=8.88u w=4u l=1u
X1530 a_47326_153925# a_33002_153881# VSS VSS nfet_06v0 ad=1.25p pd=5.5u as=2.2p ps=10.88u w=5u l=1u
X1531 VSS a_63270_171355# a_62602_174755# VSS nfet_06v0 ad=0.65p pd=3.02u as=0.65p ps=3.02u w=2.5u l=1u
X1532 a_82106_141734# a_84094_149676# a_77872_146196# VDD pfet_06v0 ad=1.76p pd=8.88u as=1.76p ps=8.88u w=4u l=1u
X1533 VDD a_55382_157349# a_60374_157465# VDD pfet_06v0 ad=4.4p pd=20.88u as=2.5p ps=10.5u w=10u l=1u
X1534 a_87566_179979# a_92382_184333# a_88018_184379# VDD pfet_06v0 ad=2.2p pd=10.88u as=2.2p ps=10.88u w=5u l=1u
X1535 a_54670_117722# a_54970_117722# a_65886_117766# VSS nfet_06v0 ad=2.2p pd=10.88u as=1.25p ps=5.5u w=5u l=1u
X1536 YN_OUT a_105404_166436# VDD VDD pfet_05v0 ad=0.8052p pd=4.54u as=0.8052p ps=4.54u w=1.83u l=0.5u
X1537 a_77872_134662# a_93290_135112# VSS ppolyf_u_1k r_width=1u r_length=76.45u
X1538 VSS a_49734_153995# a_113830_153912# VSS nfet_06v0 ad=0.44p pd=2.88u as=0.44p ps=2.88u w=1u l=1u
X1539 a_103784_154152# a_102120_154036# VSS VSS nfet_06v0 ad=0.175p pd=1.2u as=0.308p ps=2.28u w=0.7u l=1u
X1540 VDD VSS VDD VDD pfet_06v0 ad=4.29p pd=20.38u as=0 ps=0 w=9.75u l=2u
X1541 a_12580_76961# a_107258_172604# a_107170_172720# VSS nfet_06v0 ad=0.6448p pd=3u as=1.0912p ps=5.84u w=2.48u l=1u
X1542 a_58338_171285# a_55682_174709# VSS VSS nfet_06v0 ad=0.25p pd=1.5u as=0.44p ps=2.88u w=1u l=1u
X1543 a_84094_137692# a_84094_137692# a_85730_136492# VDD pfet_06v0 ad=4.4p pd=20.88u as=3.3p ps=10.66u w=10u l=1u
X1544 a_49734_179979# a_41762_184379# VDD VDD pfet_06v0 ad=2.6p pd=10.52u as=4.4p ps=20.88u w=10u l=1u
X1545 a_61486_183379# a_55342_179865# a_64382_179979# VSS nfet_06v0 ad=1.1p pd=5.88u as=0.65p ps=3.02u w=2.5u l=1u
X1546 a_57306_162549# a_55682_165973# VSS VSS nfet_06v0 ad=0.25p pd=1.5u as=0.44p ps=2.88u w=1u l=1u
X1547 a_78526_153881# a_78526_153881# VSS VSS nfet_06v0 ad=0.44p pd=2.88u as=0.44p ps=2.88u w=1u l=1u
X1548 a_99558_129750# a_99358_129706# VSS VSS nfet_06v0 ad=1.25p pd=5.5u as=2.2p ps=10.88u w=5u l=1u
X1549 a_89206_117766# a_77298_124508# VSS VSS nfet_06v0 ad=0.25p pd=1.5u as=0.44p ps=2.88u w=1u l=1u
X1550 VSS VDD VSS VSS nfet_06v0 ad=7.92p pd=36.88u as=0 ps=0 w=18u l=2u
X1551 a_99858_129750# a_99658_129706# a_100590_129750# VSS nfet_06v0 ad=2.2p pd=10.88u as=1.25p ps=5.5u w=5u l=1u
X1552 a_107546_117722# a_99658_117722# a_107746_117766# VSS nfet_06v0 ad=1.65p pd=5.66u as=1.25p ps=5.5u w=5u l=1u
X1553 a_92382_166973# a_92382_166973# a_94018_165973# VDD pfet_06v0 ad=4.4p pd=20.88u as=3.3p ps=10.66u w=10u l=1u
X1554 a_12580_76961# a_102158_172604# a_102070_172720# VSS nfet_06v0 ad=0.6448p pd=3u as=1.0912p ps=5.84u w=2.48u l=1u
X1555 a_91918_153881# a_91918_153881# a_94426_153881# VSS nfet_06v0 ad=2.2p pd=10.88u as=1.65p ps=5.66u w=5u l=1u
X1556 a_60042_183449# a_60846_179863# a_61486_183379# VDD pfet_06v0 ad=4.4p pd=20.88u as=2.6p ps=10.52u w=10u l=1u
X1557 a_80490_179909# a_78866_183333# VSS VSS nfet_06v0 ad=0.25p pd=1.5u as=0.44p ps=2.88u w=1u l=1u
X1558 XP_OUT XN_OUT VDD VDD pfet_05v0 ad=0.8052p pd=4.54u as=0.8052p ps=4.54u w=1.83u l=0.5u
X1559 VSS VDD VSS VSS nfet_06v0 ad=7.92p pd=36.88u as=0 ps=0 w=18u l=2u
X1560 a_36610_171285# a_37774_171239# a_37974_171355# VSS nfet_06v0 ad=2.2p pd=10.88u as=1.3p ps=5.52u w=5u l=1u
X1561 a_61486_166019# a_42022_129750# a_60042_166089# VDD pfet_06v0 ad=2.6p pd=10.52u as=4.4p ps=20.88u w=10u l=1u
X1562 a_72806_179979# a_64834_184379# VDD VDD pfet_06v0 ad=4.4p pd=20.88u as=2.6p ps=10.52u w=10u l=1u
X1563 a_36942_162549# a_32270_162505# a_36610_162549# VSS nfet_06v0 ad=1.25p pd=5.5u as=1.65p ps=5.66u w=5u l=1u
X1564 a_42022_129750# a_34534_129750# cap_mim_2f0_m4m5_noshield c_width=25u c_length=8u
X1565 a_35546_126524# a_35066_117722# a_32810_124624# VDD pfet_06v0 ad=0.22p pd=1.88u as=0.22p ps=1.88u w=0.5u l=1u
X1566 VSS VDD VSS VSS nfet_06v0 ad=7.92p pd=36.88u as=0 ps=0 w=18u l=2u
X1567 a_72482_148592# a_54710_148476# VDD VDD pfet_06v0 ad=2.5p pd=10.5u as=4.4p ps=20.88u w=10u l=1u
X1568 VDD a_72806_153995# a_116938_155324# VDD pfet_06v0 ad=1.32p pd=6.88u as=0.75p ps=3.5u w=3u l=1u
X1569 a_83226_183449# a_37774_179863# a_85786_183379# VDD pfet_06v0 ad=4.4p pd=20.88u as=2.6p ps=10.52u w=10u l=1u
X1570 a_101822_138498# a_50996_204977# a_99898_136608# VDD pfet_06v0 ad=0.242p pd=1.98u as=0.242p ps=1.98u w=0.55u l=1u
X1571 a_108130_124508# a_99698_124508# a_108330_124624# VDD pfet_06v0 ad=3.3p pd=10.66u as=2.5p ps=10.5u w=10u l=1u
X1572 a_94218_183449# a_94018_183333# VDD VDD pfet_06v0 ad=2.5p pd=10.5u as=4.4p ps=20.88u w=10u l=1u
X1573 a_101622_141734# a_34334_117722# a_99858_141734# VSS nfet_06v0 ad=3.3p pd=15.88u as=3.3p ps=15.88u w=7.5u l=1u
X1574 a_55584_122678# a_71002_123128# VSS ppolyf_u_1k r_width=1u r_length=76.45u
X1575 a_85786_166019# a_37774_162503# a_83226_166089# VDD pfet_06v0 ad=2.6p pd=10.52u as=4.4p ps=20.88u w=10u l=1u
X1576 a_78566_165973# a_78866_165973# a_80490_162549# VSS nfet_06v0 ad=0.44p pd=2.88u as=0.25p ps=1.5u w=1u l=1u
X1577 VSS a_63270_162619# a_62602_166019# VSS nfet_06v0 ad=1.1p pd=5.88u as=0.65p ps=3.02u w=2.5u l=1u
X1578 VSS VDD VSS VSS nfet_06v0 ad=7.92p pd=36.88u as=0 ps=0 w=18u l=2u
X1579 a_69198_175709# a_55342_171241# a_70398_171285# VSS nfet_06v0 ad=2.2p pd=10.88u as=1.25p ps=5.5u w=5u l=1u
X1580 a_80234_150492# a_12580_56801# a_77498_148592# VDD pfet_06v0 ad=0.22p pd=1.88u as=0.22p ps=1.88u w=0.5u l=1u
X1581 a_82926_174825# a_78566_174709# VDD VDD pfet_06v0 ad=2.5p pd=10.5u as=4.4p ps=20.88u w=10u l=1u
X1582 a_105404_157700# a_12580_196913# VSS VSS nfet_05v0 ad=0.5808p pd=3.52u as=0.5808p ps=3.52u w=1.32u l=0.6u
X1583 a_37774_171239# a_82106_129750# VSS VSS nfet_06v0 ad=0.44p pd=2.88u as=0.44p ps=2.88u w=1u l=1u
X1584 VSS VDD VSS VSS nfet_06v0 ad=7.92p pd=36.88u as=0 ps=0 w=18u l=2u
X1585 a_79258_179865# a_78866_183333# a_79878_183449# VDD pfet_06v0 ad=4.4p pd=20.88u as=2.5p ps=10.5u w=10u l=1u
X1586 a_58758_124624# a_55010_124508# a_57666_117766# VDD pfet_06v0 ad=4.4p pd=20.88u as=4.4p ps=20.88u w=10u l=1u
X1587 a_82866_153925# a_78526_153881# a_82566_153925# VSS nfet_06v0 ad=1.65p pd=5.66u as=1.25p ps=5.5u w=5u l=1u
X1588 a_58618_174825# a_55382_174709# VDD VDD pfet_06v0 ad=2.5p pd=10.5u as=4.4p ps=20.88u w=10u l=1u
X1589 a_37974_153995# a_40646_158395# VDD VDD pfet_06v0 ad=1.3p pd=5.52u as=2.2p ps=10.88u w=5u l=1u
X1590 a_101622_117766# a_50996_204977# a_99858_117766# VSS nfet_06v0 ad=3.3p pd=15.88u as=3.3p ps=15.88u w=7.5u l=1u
X1591 a_59682_162549# a_42022_129750# a_61046_162619# VSS nfet_06v0 ad=2.2p pd=10.88u as=1.3p ps=5.52u w=5u l=1u
X1592 VSS a_41310_171355# a_49734_171355# VSS nfet_06v0 ad=1.3p pd=5.52u as=1.3p ps=5.52u w=5u l=1u
D71 a_31060_204977# VDD diode_pd2nw_06v0 pj=40u area=99.99999p
X1593 a_33184_122228# a_32610_124508# a_34534_117766# VDD pfet_06v0 ad=4.4p pd=20.88u as=4.4p ps=20.88u w=10u l=1u
X1594 a_38886_171239# a_33184_146196# VDD VDD pfet_06v0 ad=0.44p pd=2.88u as=0.44p ps=2.88u w=1u l=1u
D72 a_12580_56801# VDD diode_pd2nw_06v0 pj=40u area=99.99999p
X1595 VSS VDD VSS VSS nfet_06v0 ad=7.92p pd=36.88u as=0 ps=0 w=18u l=2u
X1596 a_47762_157349# a_32610_157349# a_47962_157465# VDD pfet_06v0 ad=3.3p pd=10.66u as=2.5p ps=10.5u w=10u l=1u
X1597 a_78766_166089# a_78566_165973# VDD VDD pfet_06v0 ad=2.5p pd=10.5u as=4.4p ps=20.88u w=10u l=1u
X1598 a_34534_141734# a_36358_148592# VDD VDD pfet_06v0 ad=2.2p pd=10.88u as=2.2p ps=10.88u w=5u l=1u
X1599 a_90238_141734# a_77298_148476# VSS VSS nfet_06v0 ad=0.25p pd=1.5u as=0.44p ps=2.88u w=1u l=1u
X1600 VSS a_40198_153995# a_38414_157395# VSS nfet_06v0 ad=0.65p pd=3.02u as=0.65p ps=3.02u w=2.5u l=1u
X1601 VSS VDD VSS VSS nfet_06v0 ad=7.92p pd=36.88u as=0 ps=0 w=18u l=2u
X1602 VDD a_78566_157349# a_83558_157465# VDD pfet_06v0 ad=4.4p pd=20.88u as=2.5p ps=10.5u w=10u l=1u
X1603 a_55584_122228# a_55010_124508# a_56934_117766# VDD pfet_06v0 ad=4.4p pd=20.88u as=4.4p ps=20.88u w=10u l=1u
X1604 a_60846_153879# a_55584_122228# VDD VDD pfet_06v0 ad=0.44p pd=2.88u as=0.44p ps=2.88u w=1u l=1u
X1605 a_102634_150492# a_102898_141690# VSS VSS nfet_06v0 ad=0.825p pd=3.16u as=1.1p ps=5.88u w=2.5u l=1u
X1606 a_62602_174755# a_63270_171355# VSS VSS nfet_06v0 ad=0.65p pd=3.02u as=1.1p ps=5.88u w=2.5u l=1u
X1607 a_77872_146646# a_93290_146196# VSS ppolyf_u_1k r_width=1u r_length=76.45u
X1608 a_37950_141690# a_32610_148476# a_42686_148592# VDD pfet_06v0 ad=4.4p pd=20.88u as=2.5p ps=10.5u w=10u l=1u
X1609 a_34734_150482# a_38886_171239# cap_mim_2f0_m4m5_noshield c_width=25u c_length=8u
X1610 VSS a_72806_171355# a_109102_172604# VSS nfet_06v0 ad=0.44p pd=2.88u as=0.33p ps=1.66u w=1u l=1u
X1611 a_55010_148476# a_55010_148476# VDD VDD pfet_06v0 ad=0.88p pd=4.88u as=0.88p ps=4.88u w=2u l=1u
X1612 a_39530_174755# a_32270_171241# a_40198_171355# VSS nfet_06v0 ad=1.1p pd=5.88u as=0.65p ps=3.02u w=2.5u l=1u
X1613 a_64382_179979# a_55342_179865# a_61486_183379# VSS nfet_06v0 ad=0.65p pd=3.02u as=1.1p ps=5.88u w=2.5u l=1u
X1614 VSS VDD VSS VSS nfet_06v0 ad=7.92p pd=36.88u as=0 ps=0 w=18u l=2u
X1615 a_68734_153881# a_55682_157349# a_72478_157465# VDD pfet_06v0 ad=4.4p pd=20.88u as=2.5p ps=10.5u w=10u l=1u
X1616 VSS a_49734_179979# a_106102_179896# VSS nfet_06v0 ad=0.44p pd=2.88u as=0.25p ps=1.5u w=1u l=1u
X1617 a_39530_157395# a_40198_153995# VSS VSS nfet_06v0 ad=0.65p pd=3.02u as=0.65p ps=3.02u w=2.5u l=1u
X1618 VSS a_95990_171355# a_115582_171272# VSS nfet_06v0 ad=0.44p pd=2.88u as=0.25p ps=1.5u w=1u l=1u
X1619 YN_OUT a_105404_166436# VSS VSS nfet_05v0 ad=0.5808p pd=3.52u as=0.5808p ps=3.52u w=1.32u l=0.6u
X1620 a_83226_183449# a_60846_179863# a_84670_183379# VDD pfet_06v0 ad=4.4p pd=20.88u as=2.6p ps=10.52u w=10u l=1u
X1621 a_90238_117766# a_77298_124508# VSS VSS nfet_06v0 ad=0.25p pd=1.5u as=0.44p ps=2.88u w=1u l=1u
X1622 VSS a_114650_162492# a_103270_163980# VSS nfet_06v0 ad=0.44p pd=2.88u as=0.44p ps=2.88u w=1u l=1u
X1623 VDD a_86902_184379# a_84230_179979# VDD pfet_06v0 ad=2.2p pd=10.88u as=1.3p ps=5.52u w=5u l=1u
X1624 a_60350_141690# a_55010_148476# a_65086_148592# VDD pfet_06v0 ad=4.4p pd=20.88u as=2.5p ps=10.5u w=10u l=1u
D73 a_12580_196913# VDD diode_pd2nw_06v0 pj=40u area=99.99999p
X1625 a_46126_184333# a_32270_179865# a_47326_179909# VSS nfet_06v0 ad=2.2p pd=10.88u as=1.25p ps=5.5u w=5u l=1u
X1626 a_72806_179979# a_61046_179979# cap_mim_2f0_m4m5_noshield c_width=20u c_length=10u
X1627 VSS a_64382_162619# a_72806_162619# VSS nfet_06v0 ad=1.3p pd=5.52u as=1.3p ps=5.52u w=5u l=1u
X1628 VSS a_63270_179979# a_61486_183379# VSS nfet_06v0 ad=1.1p pd=5.88u as=0.65p ps=3.02u w=2.5u l=1u
X1629 a_102634_126524# a_102898_117722# VSS VSS nfet_06v0 ad=0.825p pd=3.16u as=1.1p ps=5.88u w=2.5u l=1u
X1630 a_77872_146196# a_93290_146196# VSS ppolyf_u_1k r_width=1u r_length=76.45u
X1631 VDD VSS VDD VDD pfet_06v0 ad=0.44p pd=2.88u as=0 ps=0 w=1u l=2u
X1632 a_33002_171241# a_32610_174709# a_33622_174825# VDD pfet_06v0 ad=4.4p pd=20.88u as=2.5p ps=10.5u w=10u l=1u
X1633 VSS VDD VSS VSS nfet_06v0 ad=0.44p pd=2.88u as=0 ps=0 w=1u l=2u
X1634 a_33184_135562# a_48602_135112# VSS ppolyf_u_1k r_width=1u r_length=76.45u
X1635 a_84230_162619# a_86902_167019# VDD VDD pfet_06v0 ad=1.3p pd=5.52u as=1.3p ps=5.52u w=5u l=1u
X1636 a_101822_126514# a_37774_162503# cap_mim_2f0_m4m5_noshield c_width=25u c_length=8u
X1637 a_105404_157700# a_12580_196913# VDD VDD pfet_05v0 ad=0.8052p pd=4.54u as=0.8052p ps=4.54u w=1.83u l=0.5u
X1638 VDD a_64834_184379# a_72806_179979# VDD pfet_06v0 ad=2.6p pd=10.52u as=2.6p ps=10.52u w=10u l=1u
X1639 VSS VDD VSS VSS nfet_06v0 ad=4.29p pd=20.38u as=0 ps=0 w=9.75u l=2u
X1640 a_72806_162619# a_61046_162619# cap_mim_2f0_m4m5_noshield c_width=20u c_length=10u
X1641 a_102120_154036# a_102120_154036# VDD VDD pfet_06v0 ad=0.88p pd=4.88u as=0.88p ps=4.88u w=2u l=1u
D74 a_35066_141690# VDD diode_pd2nw_06v0 pj=40u area=99.99999p
X1642 a_32510_157465# a_32310_157349# VDD VDD pfet_06v0 ad=2.5p pd=10.5u as=4.4p ps=20.88u w=10u l=1u
X1643 VDD VSS VDD VDD pfet_06v0 ad=7.92p pd=36.88u as=0 ps=0 w=18u l=2u
X1644 a_56694_183449# a_55382_183333# VDD VDD pfet_06v0 ad=2.5p pd=10.5u as=4.4p ps=20.88u w=10u l=1u
X1645 VDD a_63718_167019# a_62158_162619# VDD pfet_06v0 ad=2.2p pd=10.88u as=1.3p ps=5.52u w=5u l=1u
X1646 a_84230_179979# a_86902_184379# VDD VDD pfet_06v0 ad=1.3p pd=5.52u as=2.2p ps=10.88u w=5u l=1u
X1647 a_65886_141734# a_54670_141690# VSS VSS nfet_06v0 ad=1.25p pd=5.5u as=2.2p ps=10.88u w=5u l=1u
D75 a_12580_76961# VDD diode_pd2nw_06v0 pj=40u area=99.99999p
X1648 a_61486_157395# a_60846_153879# a_60042_157465# VDD pfet_06v0 ad=2.6p pd=10.52u as=4.4p ps=20.88u w=10u l=1u
D76 a_35066_141690# VDD diode_pd2nw_06v0 pj=40u area=99.99999p
X1649 a_32310_165973# a_32610_165973# a_35546_166089# VDD pfet_06v0 ad=4.4p pd=20.88u as=2.5p ps=10.5u w=10u l=1u
X1650 a_57666_141734# a_35066_141690# a_55170_141734# VSS nfet_06v0 ad=3.74p pd=17.88u as=3.74p ps=17.88u w=8.5u l=1u
X1651 a_102634_126524# a_31060_204977# a_99898_124624# VDD pfet_06v0 ad=0.22p pd=1.88u as=0.22p ps=1.88u w=0.5u l=1u
X1652 a_99898_148592# a_99698_148476# a_99598_148592# VDD pfet_06v0 ad=4.4p pd=20.88u as=2.5p ps=10.5u w=10u l=1u
X1653 a_55682_157349# a_55682_157349# VDD VDD pfet_06v0 ad=0.88p pd=4.88u as=0.88p ps=4.88u w=2u l=1u
X1654 a_60042_166089# a_55682_165973# a_59742_166089# VDD pfet_06v0 ad=3.3p pd=10.66u as=2.5p ps=10.5u w=10u l=1u
X1655 VSS a_86454_171355# a_85786_174755# VSS nfet_06v0 ad=1.1p pd=5.88u as=0.65p ps=3.02u w=2.5u l=1u
X1656 a_107746_141734# a_107546_141690# VSS VSS nfet_06v0 ad=1.25p pd=5.5u as=2.2p ps=10.88u w=5u l=1u
X1657 a_60350_141690# a_60350_141690# a_62858_141690# VSS nfet_06v0 ad=2.2p pd=10.88u as=1.65p ps=5.66u w=5u l=1u
X1658 a_81046_136608# a_82638_129706# a_80498_129706# VSS nfet_06v0 ad=0.88p pd=4.88u as=0.88p ps=4.88u w=2u l=1u
X1659 a_79422_150482# a_12580_36641# a_77498_148592# VDD pfet_06v0 ad=0.242p pd=1.98u as=0.242p ps=1.98u w=0.55u l=1u
X1660 VSS VDD VSS VSS nfet_06v0 ad=4.29p pd=20.38u as=0 ps=0 w=9.75u l=2u
X1661 a_82866_162549# a_42022_129750# a_84230_162619# VSS nfet_06v0 ad=2.2p pd=10.88u as=1.3p ps=5.52u w=5u l=1u
D77 a_12580_36641# VDD diode_pd2nw_06v0 pj=40u area=99.99999p
X1662 a_114650_162492# a_95990_162619# VDD VDD pfet_06v0 ad=0.99p pd=3.66u as=1.32p ps=6.88u w=3u l=1u
X1663 a_85786_157395# a_37774_153879# a_83226_157465# VDD pfet_06v0 ad=2.6p pd=10.52u as=4.4p ps=20.88u w=10u l=1u
X1664 a_60374_157465# a_55682_157349# a_60042_157465# VDD pfet_06v0 ad=2.5p pd=10.5u as=3.3p ps=10.66u w=10u l=1u
X1665 a_62158_179979# a_38886_179863# a_59682_179909# VSS nfet_06v0 ad=1.3p pd=5.52u as=2.2p ps=10.88u w=5u l=1u
X1666 VSS a_63270_153995# a_62602_157395# VSS nfet_06v0 ad=1.1p pd=5.88u as=0.65p ps=3.02u w=2.5u l=1u
X1667 a_91918_179865# a_78866_183333# a_95662_183449# VDD pfet_06v0 ad=4.4p pd=20.88u as=2.5p ps=10.5u w=10u l=1u
X1668 a_65886_117766# a_54670_117722# VSS VSS nfet_06v0 ad=1.25p pd=5.5u as=2.2p ps=10.88u w=5u l=1u
X1669 a_65086_136608# a_54710_136492# VDD VDD pfet_06v0 ad=2.5p pd=10.5u as=4.4p ps=20.88u w=10u l=1u
X1670 a_61806_137692# a_54970_129706# a_62014_129750# VSS nfet_06v0 ad=2.2p pd=10.88u as=1.25p ps=5.5u w=5u l=1u
X1671 a_37974_162619# a_37774_162503# a_36610_162549# VSS nfet_06v0 ad=1.3p pd=5.52u as=2.2p ps=10.88u w=5u l=1u
X1672 a_49734_171355# a_41310_171355# VSS VSS nfet_06v0 ad=1.3p pd=5.52u as=2.2p ps=10.88u w=5u l=1u
X1673 a_49734_171355# a_41762_175755# VDD VDD pfet_06v0 ad=4.4p pd=20.88u as=2.6p ps=10.52u w=10u l=1u
X1674 a_57666_117766# a_35066_141690# a_55170_117766# VSS nfet_06v0 ad=3.74p pd=17.88u as=3.74p ps=17.88u w=8.5u l=1u
X1675 a_60350_117722# a_60350_117722# a_62858_117722# VSS nfet_06v0 ad=2.2p pd=10.88u as=1.65p ps=5.66u w=5u l=1u
X1676 VSS VDD VSS VSS nfet_06v0 ad=4.29p pd=20.38u as=0 ps=0 w=9.75u l=2u
X1677 a_100590_129750# a_99358_129706# VSS VSS nfet_06v0 ad=1.25p pd=5.5u as=2.2p ps=10.88u w=5u l=1u
X1678 a_107746_117766# a_107546_117722# VSS VSS nfet_06v0 ad=1.25p pd=5.5u as=2.2p ps=10.88u w=5u l=1u
X1679 a_12580_76961# Z VDD ppolyf_u r_width=40u r_length=10u
X1680 VDD a_63718_184379# a_61046_179979# VDD pfet_06v0 ad=2.2p pd=10.88u as=1.3p ps=5.52u w=5u l=1u
X1681 a_85786_174755# a_86454_171355# VSS VSS nfet_06v0 ad=0.65p pd=3.02u as=1.1p ps=5.88u w=2.5u l=1u
X1682 a_59682_153925# a_60846_153879# a_61046_153995# VSS nfet_06v0 ad=2.2p pd=10.88u as=1.3p ps=5.52u w=5u l=1u
X1683 a_32610_183333# a_32610_183333# VDD VDD pfet_06v0 ad=0.88p pd=4.88u as=0.88p ps=4.88u w=2u l=1u
X1684 a_104506_129750# a_106494_137692# a_100272_134212# VDD pfet_06v0 ad=1.76p pd=8.88u as=1.76p ps=8.88u w=4u l=1u
X1685 a_32270_171241# a_32270_171241# VSS VSS nfet_06v0 ad=0.44p pd=2.88u as=0.44p ps=2.88u w=1u l=1u
X1686 a_87566_179979# a_78526_179865# a_84670_183379# VSS nfet_06v0 ad=0.65p pd=3.02u as=1.1p ps=5.88u w=2.5u l=1u
X1687 a_38886_179863# a_100272_146196# VDD VDD pfet_06v0 ad=0.44p pd=2.88u as=0.44p ps=2.88u w=1u l=1u
X1688 VSS VDD VSS VSS nfet_06v0 ad=7.92p pd=36.88u as=0 ps=0 w=18u l=2u
X1689 a_56022_124624# a_54710_124508# VDD VDD pfet_06v0 ad=2.5p pd=10.5u as=4.4p ps=20.88u w=10u l=1u
X1690 a_39406_149676# a_32570_141690# a_39614_141734# VSS nfet_06v0 ad=2.2p pd=10.88u as=1.25p ps=5.5u w=5u l=1u
X1691 a_55342_179865# a_55342_179865# VSS VSS nfet_06v0 ad=0.44p pd=2.88u as=0.44p ps=2.88u w=1u l=1u
X1692 a_101622_141734# a_103446_148592# VDD VDD pfet_06v0 ad=2.2p pd=10.88u as=2.2p ps=10.88u w=5u l=1u
X1693 VDD a_12580_136433# a_12580_136433# VDD pfet_06v0 ad=0.88p pd=4.88u as=0.52p ps=2.52u w=2u l=1u
D78 VSS a_50996_204977# diode_nd2ps_06v0 pj=40u area=99.99999p
X1694 a_12580_76961# VDD a_105128_171512# VSS nfet_06v0 ad=0.6448p pd=3u as=1.0912p ps=5.84u w=2.48u l=1u
X1695 a_84670_183379# a_60846_179863# a_83226_183449# VDD pfet_06v0 ad=2.6p pd=10.52u as=4.4p ps=20.88u w=10u l=1u
X1696 a_108330_124624# a_108130_124508# VDD VDD pfet_06v0 ad=2.5p pd=10.5u as=4.4p ps=20.88u w=10u l=1u
X1697 a_85930_148592# a_85730_148476# VDD VDD pfet_06v0 ad=2.5p pd=10.5u as=4.4p ps=20.88u w=10u l=1u
X1698 VSS VDD VSS VSS nfet_06v0 ad=4.29p pd=20.38u as=0 ps=0 w=9.75u l=2u
X1699 a_61486_183379# a_63270_179979# VSS VSS nfet_06v0 ad=0.65p pd=3.02u as=0.65p ps=3.02u w=2.5u l=1u
X1700 a_40646_158395# a_45662_153881# a_40198_153995# VSS nfet_06v0 ad=1.1p pd=5.88u as=1.1p ps=5.88u w=2.5u l=1u
X1701 a_80490_162549# a_78866_165973# VSS VSS nfet_06v0 ad=0.25p pd=1.5u as=0.44p ps=2.88u w=1u l=1u
X1702 a_69198_184333# a_69198_184333# a_70834_183333# VDD pfet_06v0 ad=4.4p pd=20.88u as=3.3p ps=10.66u w=10u l=1u
X1703 VDD a_88018_184379# a_95990_179979# VDD pfet_06v0 ad=2.6p pd=10.52u as=2.6p ps=10.52u w=10u l=1u
X1704 VSS VDD VSS VSS nfet_06v0 ad=4.29p pd=20.38u as=0 ps=0 w=9.75u l=2u
X1705 a_70398_171285# a_56074_171241# VSS VSS nfet_06v0 ad=1.25p pd=5.5u as=2.2p ps=10.88u w=5u l=1u
X1706 a_72806_179979# a_64834_184379# VDD VDD pfet_06v0 ad=2.6p pd=10.52u as=4.4p ps=20.88u w=10u l=1u
X1707 a_39406_125708# a_32570_117722# a_39614_117766# VSS nfet_06v0 ad=2.2p pd=10.88u as=1.25p ps=5.5u w=5u l=1u
X1708 a_33184_135562# a_42022_129750# VSS ppolyf_u_1k r_width=1u r_length=76.45u
X1709 VDD VSS VDD VDD pfet_06v0 ad=0.44p pd=2.88u as=0 ps=0 w=1u l=2u
D79 a_12580_136433# VDD diode_pd2nw_06v0 pj=40u area=99.99999p
X1710 a_38414_166019# a_32270_162505# a_41310_162619# VSS nfet_06v0 ad=1.1p pd=5.88u as=0.65p ps=3.02u w=2.5u l=1u
X1711 a_55170_129750# a_54970_129706# a_54870_129750# VSS nfet_06v0 ad=2.2p pd=10.88u as=1.25p ps=5.5u w=5u l=1u
X1712 a_35546_138508# a_35066_117722# a_32810_136608# VDD pfet_06v0 ad=0.22p pd=1.88u as=0.22p ps=1.88u w=0.5u l=1u
X1713 a_79878_183449# a_78566_183333# VDD VDD pfet_06v0 ad=2.5p pd=10.5u as=4.4p ps=20.88u w=10u l=1u
X1714 a_82566_153925# a_79258_153881# VSS VSS nfet_06v0 ad=1.25p pd=5.5u as=2.2p ps=10.88u w=5u l=1u
X1715 VSS a_64382_153995# a_72806_153995# VSS nfet_06v0 ad=1.3p pd=5.52u as=1.3p ps=5.52u w=5u l=1u
X1716 VDD a_86902_167019# a_85342_162619# VDD pfet_06v0 ad=2.2p pd=10.88u as=1.3p ps=5.52u w=5u l=1u
X1717 a_12580_136433# a_12580_136433# VDD VDD pfet_06v0 ad=0.52p pd=2.52u as=0.52p ps=2.52u w=2u l=1u
X1718 a_61046_179979# a_55682_183333# a_64834_184379# VDD pfet_06v0 ad=2.2p pd=10.88u as=1.3p ps=5.52u w=5u l=1u
X1719 VSS VDD VSS VSS nfet_06v0 ad=7.92p pd=36.88u as=0 ps=0 w=18u l=2u
X1720 a_100272_135562# a_115690_135112# VSS ppolyf_u_1k r_width=1u r_length=76.45u
X1721 a_108130_136492# a_99698_136492# a_108330_136608# VDD pfet_06v0 ad=3.3p pd=10.66u as=2.5p ps=10.5u w=10u l=1u
X1722 a_84230_153995# a_86902_158395# VDD VDD pfet_06v0 ad=1.3p pd=5.52u as=1.3p ps=5.52u w=5u l=1u
X1723 a_71034_166089# a_70834_165973# VDD VDD pfet_06v0 ad=2.5p pd=10.5u as=4.4p ps=20.88u w=10u l=1u
D80 VSS a_31060_204977# diode_nd2ps_06v0 pj=40u area=99.99999p
X1724 a_107170_164096# a_107258_163980# a_12580_136433# VSS nfet_06v0 ad=1.0912p pd=5.84u as=0.6448p ps=3u w=2.48u l=1u
X1725 VSS VDD VSS VSS nfet_06v0 ad=7.92p pd=36.88u as=0 ps=0 w=18u l=2u
X1726 a_86902_175755# a_91918_171241# a_86454_171355# VSS nfet_06v0 ad=1.1p pd=5.88u as=1.1p ps=5.88u w=2.5u l=1u
X1727 a_36970_174825# a_38886_171239# a_39530_174755# VDD pfet_06v0 ad=4.4p pd=20.88u as=2.6p ps=10.52u w=10u l=1u
X1728 a_48158_124624# a_32310_124508# VDD VDD pfet_06v0 ad=2.5p pd=10.5u as=4.4p ps=20.88u w=10u l=1u
X1729 VSS VDD VSS VSS nfet_06v0 ad=7.92p pd=36.88u as=0 ps=0 w=18u l=2u
X1730 a_83558_157465# a_78866_157349# a_83226_157465# VDD pfet_06v0 ad=2.5p pd=10.5u as=3.3p ps=10.66u w=10u l=1u
X1731 a_84230_162619# a_42022_129750# a_82866_162549# VSS nfet_06v0 ad=1.3p pd=5.52u as=2.2p ps=10.88u w=5u l=1u
X1732 a_79422_150482# a_80498_141690# VSS VSS nfet_06v0 ad=0.825p pd=3.16u as=1.1p ps=5.88u w=2.5u l=1u
X1733 a_102320_162888# a_109102_163980# a_12580_136433# VSS nfet_06v0 ad=1.0912p pd=5.84u as=0.6448p ps=3u w=2.48u l=1u
X1734 a_55902_141734# a_54670_141690# VSS VSS nfet_06v0 ad=1.25p pd=5.5u as=2.2p ps=10.88u w=5u l=1u
X1735 VDD a_63718_158395# a_62158_153995# VDD pfet_06v0 ad=2.2p pd=10.88u as=1.3p ps=5.52u w=5u l=1u
X1736 a_62158_179979# a_63718_184379# VDD VDD pfet_06v0 ad=1.3p pd=5.52u as=2.2p ps=10.88u w=5u l=1u
X1737 VSS VDD VSS VSS nfet_06v0 ad=7.92p pd=36.88u as=0 ps=0 w=18u l=2u
X1738 a_58758_136608# a_55010_136492# a_57666_129750# VDD pfet_06v0 ad=4.4p pd=20.88u as=4.4p ps=20.88u w=10u l=1u
X1739 a_102070_164096# a_102158_163980# a_12580_136433# VSS nfet_06v0 ad=1.0912p pd=5.84u as=0.6448p ps=3u w=2.48u l=1u
X1740 a_42686_148592# a_32310_148476# VDD VDD pfet_06v0 ad=2.5p pd=10.5u as=4.4p ps=20.88u w=10u l=1u
X1741 VDD VSS VDD VDD pfet_06v0 ad=4.29p pd=20.38u as=0 ps=0 w=9.75u l=2u
X1742 a_32310_157349# a_32610_157349# a_34234_153925# VSS nfet_06v0 ad=0.44p pd=2.88u as=0.25p ps=1.5u w=1u l=1u
X1743 VDD VSS VDD VDD pfet_06v0 ad=4.29p pd=20.38u as=0 ps=0 w=9.75u l=2u
X1744 VSS VDD VSS VSS nfet_06v0 ad=4.29p pd=20.38u as=0 ps=0 w=9.75u l=2u
X1745 VDD a_41762_175755# a_49734_171355# VDD pfet_06v0 ad=2.6p pd=10.52u as=2.6p ps=10.52u w=10u l=1u
X1746 a_72478_157465# a_55382_157349# VDD VDD pfet_06v0 ad=2.5p pd=10.5u as=4.4p ps=20.88u w=10u l=1u
X1747 a_84670_174755# a_86454_171355# VSS VSS nfet_06v0 ad=0.65p pd=3.02u as=0.65p ps=3.02u w=2.5u l=1u
X1748 a_33184_134212# a_32610_136492# a_34534_129750# VDD pfet_06v0 ad=4.4p pd=20.88u as=4.4p ps=20.88u w=10u l=1u
X1749 a_115582_171272# a_113830_171272# a_114650_171228# VSS nfet_06v0 ad=0.25p pd=1.5u as=0.44p ps=2.88u w=1u l=1u
X1750 VDD a_32310_174709# a_37302_174825# VDD pfet_06v0 ad=4.4p pd=20.88u as=2.5p ps=10.5u w=10u l=1u
X1751 a_82866_153925# a_60846_153879# a_84230_153995# VSS nfet_06v0 ad=2.2p pd=10.88u as=1.3p ps=5.52u w=5u l=1u
X1752 a_47326_179909# a_33002_179865# VSS VSS nfet_06v0 ad=1.25p pd=5.5u as=2.2p ps=10.88u w=5u l=1u
X1753 VSS VDD VSS VSS nfet_06v0 ad=7.92p pd=36.88u as=0 ps=0 w=18u l=2u
X1754 a_61046_179979# a_63718_184379# VDD VDD pfet_06v0 ad=1.3p pd=5.52u as=1.3p ps=5.52u w=5u l=1u
X1755 a_85146_129706# a_77258_129706# a_85346_129750# VSS nfet_06v0 ad=1.65p pd=5.66u as=1.25p ps=5.5u w=5u l=1u
X1756 a_79422_126514# a_80498_117722# VSS VSS nfet_06v0 ad=0.825p pd=3.16u as=1.1p ps=5.88u w=2.5u l=1u
X1757 a_55902_117766# a_54670_117722# VSS VSS nfet_06v0 ad=1.25p pd=5.5u as=2.2p ps=10.88u w=5u l=1u
X1758 a_38886_162503# a_55584_134212# VDD VDD pfet_06v0 ad=0.44p pd=2.88u as=0.44p ps=2.88u w=1u l=1u
X1759 a_33622_174825# a_32310_174709# VDD VDD pfet_06v0 ad=2.5p pd=10.5u as=4.4p ps=20.88u w=10u l=1u
X1760 a_55584_134212# a_55010_136492# a_56934_129750# VDD pfet_06v0 ad=4.4p pd=20.88u as=4.4p ps=20.88u w=10u l=1u
X1761 a_60846_179863# a_77872_146196# VDD VDD pfet_06v0 ad=0.44p pd=2.88u as=0.44p ps=2.88u w=1u l=1u
X1762 a_71242_171241# a_55342_171241# a_71442_171285# VSS nfet_06v0 ad=1.65p pd=5.66u as=1.25p ps=5.5u w=5u l=1u
X1763 a_37974_153995# a_37774_153879# a_36610_153925# VSS nfet_06v0 ad=1.3p pd=5.52u as=2.2p ps=10.88u w=5u l=1u
X1764 a_79222_117766# a_81046_124624# VDD VDD pfet_06v0 ad=2.2p pd=10.88u as=2.2p ps=10.88u w=5u l=1u
X1765 VDD a_40646_184379# a_39086_179979# VDD pfet_06v0 ad=2.2p pd=10.88u as=1.3p ps=5.52u w=5u l=1u
X1766 a_78526_179865# a_78526_179865# VSS VSS nfet_06v0 ad=0.44p pd=2.88u as=0.44p ps=2.88u w=1u l=1u
X1767 a_95990_162619# a_88018_167019# VDD VDD pfet_06v0 ad=4.4p pd=20.88u as=2.6p ps=10.52u w=10u l=1u
X1768 a_107258_172604# a_95990_153995# VSS VSS nfet_06v0 ad=0.33p pd=1.66u as=0.44p ps=2.88u w=1u l=1u
X1769 VDD VSS VDD VDD pfet_06v0 ad=4.29p pd=20.38u as=0 ps=0 w=9.75u l=2u
X1770 VDD VSS VDD VDD pfet_06v0 ad=0.44p pd=2.88u as=0 ps=0 w=1u l=2u
D81 VSS a_35066_141690# diode_nd2ps_06v0 pj=40u area=99.99999p
X1771 a_83226_166089# a_78866_165973# a_82926_166089# VDD pfet_06v0 ad=3.3p pd=10.66u as=2.5p ps=10.5u w=10u l=1u
X1772 a_39086_162619# a_40646_167019# VDD VDD pfet_06v0 ad=1.3p pd=5.52u as=1.3p ps=5.52u w=5u l=1u
X1773 a_91918_179865# a_91918_179865# a_94426_179865# VSS nfet_06v0 ad=2.2p pd=10.88u as=1.65p ps=5.66u w=5u l=1u
X1774 a_55584_134212# a_71002_134212# VSS ppolyf_u_1k r_width=1u r_length=76.45u
X1775 a_77198_148592# a_76998_148476# VDD VDD pfet_06v0 ad=2.5p pd=10.5u as=4.4p ps=20.88u w=10u l=1u
X1776 a_78566_183333# a_78866_183333# a_81802_183449# VDD pfet_06v0 ad=4.4p pd=20.88u as=2.5p ps=10.5u w=10u l=1u
X1777 a_46126_166973# a_32270_162505# a_47326_162549# VSS nfet_06v0 ad=2.2p pd=10.88u as=1.25p ps=5.5u w=5u l=1u
X1778 VDD VSS VDD VDD pfet_06v0 ad=7.92p pd=36.88u as=0 ps=0 w=18u l=2u
X1779 a_59818_117766# a_61806_125708# a_55584_122228# VDD pfet_06v0 ad=1.76p pd=8.88u as=1.76p ps=8.88u w=4u l=1u
X1780 a_99398_124508# a_99698_124508# a_117170_124624# VDD pfet_06v0 ad=4.4p pd=20.88u as=2.5p ps=10.5u w=10u l=1u
X1781 a_76998_148476# a_77298_148476# a_94770_148592# VDD pfet_06v0 ad=4.4p pd=20.88u as=2.5p ps=10.5u w=10u l=1u
X1782 VDD a_113830_162536# a_114650_162492# VDD pfet_06v0 ad=1.32p pd=6.88u as=0.99p ps=3.66u w=3u l=1u
X1783 a_95990_179979# a_88018_184379# VDD VDD pfet_06v0 ad=2.6p pd=10.52u as=4.4p ps=20.88u w=10u l=1u
X1784 VDD VSS VDD VDD pfet_06v0 ad=7.92p pd=36.88u as=0 ps=0 w=18u l=2u
X1785 a_32770_141734# a_32570_141690# a_32470_141734# VSS nfet_06v0 ad=2.2p pd=10.88u as=1.25p ps=5.5u w=5u l=1u
X1786 a_35546_166089# a_32310_165973# VDD VDD pfet_06v0 ad=2.5p pd=10.5u as=4.4p ps=20.88u w=10u l=1u
X1787 a_106494_149676# a_99658_141690# a_106702_141734# VSS nfet_06v0 ad=2.2p pd=10.88u as=1.25p ps=5.5u w=5u l=1u
X1788 a_33184_147546# a_48602_147096# VSS ppolyf_u_1k r_width=1u r_length=76.45u
X1789 a_47962_174825# a_47762_174709# VDD VDD pfet_06v0 ad=2.5p pd=10.5u as=4.4p ps=20.88u w=10u l=1u
X1790 a_99598_148592# a_99398_148476# VDD VDD pfet_06v0 ad=2.5p pd=10.5u as=4.4p ps=20.88u w=10u l=1u
X1791 a_37774_153879# a_33184_122228# VDD VDD pfet_06v0 ad=0.44p pd=2.88u as=0.44p ps=2.88u w=1u l=1u
X1792 a_59742_166089# a_55382_165973# VDD VDD pfet_06v0 ad=2.5p pd=10.5u as=4.4p ps=20.88u w=10u l=1u
X1793 a_32810_148592# a_32610_148476# a_33622_148592# VDD pfet_06v0 ad=4.4p pd=20.88u as=2.5p ps=10.5u w=10u l=1u
X1794 a_39086_162619# a_32610_165973# a_40646_167019# VDD pfet_06v0 ad=2.2p pd=10.88u as=1.3p ps=5.52u w=5u l=1u
X1795 a_39086_179979# a_40646_184379# VDD VDD pfet_06v0 ad=1.3p pd=5.52u as=2.2p ps=10.88u w=5u l=1u
X1796 VDD VSS VDD VDD pfet_06v0 ad=7.92p pd=36.88u as=0 ps=0 w=18u l=2u
X1797 a_32310_136492# a_32610_136492# a_44518_129750# VSS nfet_06v0 ad=0.44p pd=2.88u as=0.25p ps=1.5u w=1u l=1u
X1798 a_41310_162619# a_32270_162505# a_38414_166019# VSS nfet_06v0 ad=0.65p pd=3.02u as=1.1p ps=5.88u w=2.5u l=1u
X1799 a_36970_174825# a_37774_171239# a_38414_174755# VDD pfet_06v0 ad=4.4p pd=20.88u as=2.6p ps=10.52u w=10u l=1u
X1800 a_105128_162888# VDD a_12580_136433# VSS nfet_06v0 ad=1.0912p pd=5.84u as=0.6448p ps=3u w=2.48u l=1u
X1801 a_50996_204977# S1P VDD ppolyf_u r_width=40u r_length=10u
X1802 VDD a_40646_175755# a_37974_171355# VDD pfet_06v0 ad=2.2p pd=10.88u as=1.3p ps=5.52u w=5u l=1u
X1803 a_85342_162619# a_86902_167019# VDD VDD pfet_06v0 ad=1.3p pd=5.52u as=1.3p ps=5.52u w=5u l=1u
D82 VSS a_31060_204977# diode_nd2ps_06v0 pj=40u area=99.99999p
X1804 a_54970_141690# a_55010_148476# a_69446_148592# VDD pfet_06v0 ad=4.4p pd=20.88u as=2.5p ps=10.5u w=10u l=1u
X1805 VDD a_12580_136433# a_12580_136433# VDD pfet_06v0 ad=0.52p pd=2.52u as=0.52p ps=2.52u w=2u l=1u
X1806 a_64834_184379# a_55682_183333# a_61046_179979# VDD pfet_06v0 ad=1.3p pd=5.52u as=2.2p ps=10.88u w=5u l=1u
X1807 a_95662_183449# a_78566_183333# VDD VDD pfet_06v0 ad=2.5p pd=10.5u as=4.4p ps=20.88u w=10u l=1u
X1808 a_33184_134212# a_37950_129706# a_37418_129750# VSS nfet_06v0 ad=0.88p pd=4.88u as=0.88p ps=4.88u w=2u l=1u
X1809 a_102898_141690# a_106494_149676# a_103446_148592# VDD pfet_06v0 ad=1.76p pd=8.88u as=1.76p ps=8.88u w=4u l=1u
X1810 a_86454_171355# a_92382_175709# a_86902_175755# VDD pfet_06v0 ad=2.2p pd=10.88u as=2.2p ps=10.88u w=5u l=1u
X1811 a_54710_136492# a_55010_136492# a_66918_129750# VSS nfet_06v0 ad=0.44p pd=2.88u as=0.25p ps=1.5u w=1u l=1u
X1812 a_55210_148592# a_55010_148476# a_56022_148592# VDD pfet_06v0 ad=4.4p pd=20.88u as=2.5p ps=10.5u w=10u l=1u
X1813 a_32770_117766# a_32570_117722# a_32470_117766# VSS nfet_06v0 ad=2.2p pd=10.88u as=1.25p ps=5.5u w=5u l=1u
X1814 a_33184_146646# a_48602_147096# VSS ppolyf_u_1k r_width=1u r_length=76.45u
X1815 a_48170_153881# a_32270_153881# a_48370_153925# VSS nfet_06v0 ad=1.65p pd=5.66u as=1.25p ps=5.5u w=5u l=1u
X1816 a_106494_125708# a_99658_117722# a_106702_117766# VSS nfet_06v0 ad=2.2p pd=10.88u as=1.25p ps=5.5u w=5u l=1u
X1817 a_100272_135562# a_60846_171239# VSS ppolyf_u_1k r_width=1u r_length=76.45u
X1818 a_95990_171355# a_87566_171355# VSS VSS nfet_06v0 ad=2.2p pd=10.88u as=1.3p ps=5.52u w=5u l=1u
X1819 a_34334_117722# S2P VDD ppolyf_u r_width=40u r_length=10u
X1820 a_60846_153879# a_55584_122228# VDD VDD pfet_06v0 ad=0.44p pd=2.88u as=0.44p ps=2.88u w=1u l=1u
X1821 a_38414_157395# a_32270_153881# a_41310_153995# VSS nfet_06v0 ad=1.1p pd=5.88u as=0.65p ps=3.02u w=2.5u l=1u
X1822 a_104084_162888# a_102120_162772# a_103784_162888# VSS nfet_06v0 ad=0.175p pd=1.2u as=0.175p ps=1.2u w=0.7u l=1u
X1823 a_102634_138508# a_31060_204977# a_99898_136608# VDD pfet_06v0 ad=0.22p pd=1.88u as=0.22p ps=1.88u w=0.5u l=1u
X1824 a_59682_171285# a_55342_171241# a_59382_171285# VSS nfet_06v0 ad=1.65p pd=5.66u as=1.25p ps=5.5u w=5u l=1u
X1825 VDD a_86902_158395# a_85342_153995# VDD pfet_06v0 ad=2.2p pd=10.88u as=1.3p ps=5.52u w=5u l=1u
X1826 a_85342_179979# a_86902_184379# VDD VDD pfet_06v0 ad=1.3p pd=5.52u as=2.2p ps=10.88u w=5u l=1u
X1827 a_82866_179909# a_78526_179865# a_82566_179909# VSS nfet_06v0 ad=1.65p pd=5.66u as=1.25p ps=5.5u w=5u l=1u
X1828 a_77458_129750# a_77258_129706# a_78190_129750# VSS nfet_06v0 ad=2.2p pd=10.88u as=1.25p ps=5.5u w=5u l=1u
X1829 a_79954_141734# a_81046_148592# VDD VDD pfet_06v0 ad=2.2p pd=10.88u as=2.2p ps=10.88u w=5u l=1u
X1830 a_39530_174755# a_38886_171239# a_36970_174825# VDD pfet_06v0 ad=2.6p pd=10.52u as=4.4p ps=20.88u w=10u l=1u
X1831 VDD VSS VDD VDD pfet_06v0 ad=4.29p pd=20.38u as=0 ps=0 w=9.75u l=2u
X1832 a_12580_136433# a_109102_163980# a_102320_162888# VSS nfet_06v0 ad=0.6448p pd=3u as=1.0912p ps=5.84u w=2.48u l=1u
X1833 a_63442_124508# a_55010_124508# a_63642_124624# VDD pfet_06v0 ad=3.3p pd=10.66u as=2.5p ps=10.5u w=10u l=1u
X1834 VSS a_117490_153868# a_107258_155244# VSS nfet_06v0 ad=0.44p pd=2.88u as=0.44p ps=2.88u w=1u l=1u
X1835 a_36358_148592# a_32610_148476# a_35266_141734# VDD pfet_06v0 ad=4.4p pd=20.88u as=4.4p ps=20.88u w=10u l=1u
X1836 a_78866_157349# a_78866_157349# VDD VDD pfet_06v0 ad=0.88p pd=4.88u as=0.88p ps=4.88u w=2u l=1u
X1837 a_39614_141734# a_32270_141690# VSS VSS nfet_06v0 ad=1.25p pd=5.5u as=2.2p ps=10.88u w=5u l=1u
X1838 VSS a_86454_171355# a_84670_174755# VSS nfet_06v0 ad=0.65p pd=3.02u as=0.65p ps=3.02u w=2.5u l=1u
X1839 a_58210_141690# a_61806_149676# a_58758_148592# VDD pfet_06v0 ad=1.76p pd=8.88u as=1.76p ps=8.88u w=4u l=1u
X1840 VSS a_40198_179979# a_38414_183379# VSS nfet_06v0 ad=0.65p pd=3.02u as=0.65p ps=3.02u w=2.5u l=1u
X1841 a_77258_141690# a_77258_141690# VSS VSS nfet_06v0 ad=0.44p pd=2.88u as=0.44p ps=2.88u w=1u l=1u
X1842 a_84230_153995# a_60846_153879# a_82866_153925# VSS nfet_06v0 ad=1.3p pd=5.52u as=2.2p ps=10.88u w=5u l=1u
X1843 a_38886_153879# a_77872_122228# VDD VDD pfet_06v0 ad=0.44p pd=2.88u as=0.44p ps=2.88u w=1u l=1u
X1844 a_79422_138498# a_12580_36641# a_77498_136608# VDD pfet_06v0 ad=0.242p pd=1.98u as=0.242p ps=1.98u w=0.55u l=1u
X1845 a_40198_162619# a_46126_166973# a_40646_167019# VDD pfet_06v0 ad=2.2p pd=10.88u as=2.2p ps=10.88u w=5u l=1u
X1846 a_94426_171241# a_78526_171241# a_94626_171285# VSS nfet_06v0 ad=1.65p pd=5.66u as=1.25p ps=5.5u w=5u l=1u
X1847 a_55382_183333# a_55682_183333# a_58618_183449# VDD pfet_06v0 ad=4.4p pd=20.88u as=2.5p ps=10.5u w=10u l=1u
X1848 a_38414_174755# a_40198_171355# VSS VSS nfet_06v0 ad=0.65p pd=3.02u as=1.1p ps=5.88u w=2.5u l=1u
X1849 a_38886_162503# a_56934_129750# cap_mim_2f0_m4m5_noshield c_width=25u c_length=8u
X1850 a_79222_141734# a_12580_36641# a_77458_141734# VSS nfet_06v0 ad=3.3p pd=15.88u as=3.3p ps=15.88u w=7.5u l=1u
X1851 a_45662_171241# a_32610_174709# a_49406_174825# VDD pfet_06v0 ad=4.4p pd=20.88u as=2.5p ps=10.5u w=10u l=1u
D83 a_50996_204977# VDD diode_pd2nw_06v0 pj=40u area=99.99999p
X1852 a_80234_138508# a_80498_129706# VSS VSS nfet_06v0 ad=0.825p pd=3.16u as=1.1p ps=5.88u w=2.5u l=1u
D84 VSS a_35066_141690# diode_nd2ps_06v0 pj=40u area=99.99999p
X1853 a_39530_183379# a_40198_179979# VSS VSS nfet_06v0 ad=0.65p pd=3.02u as=0.65p ps=3.02u w=2.5u l=1u
X1854 a_39614_117766# a_32270_117722# VSS VSS nfet_06v0 ad=1.25p pd=5.5u as=2.2p ps=10.88u w=5u l=1u
X1855 VDD a_72806_162619# a_116938_163948# VDD pfet_06v0 ad=1.32p pd=6.88u as=0.75p ps=3.5u w=3u l=1u
X1856 a_56074_171241# a_55342_171241# a_56274_171285# VSS nfet_06v0 ad=2.2p pd=10.88u as=1.25p ps=5.5u w=5u l=1u
X1857 VSS a_56074_171241# a_60014_171285# VSS nfet_06v0 ad=2.2p pd=10.88u as=1.25p ps=5.5u w=5u l=1u
X1858 a_56022_136608# a_54710_136492# VDD VDD pfet_06v0 ad=2.5p pd=10.5u as=4.4p ps=20.88u w=10u l=1u
X1859 a_78866_157349# a_78866_157349# a_81522_153925# VSS nfet_06v0 ad=0.44p pd=2.88u as=0.25p ps=1.5u w=1u l=1u
X1860 a_54870_129750# a_54670_129706# VSS VSS nfet_06v0 ad=1.25p pd=5.5u as=2.2p ps=10.88u w=5u l=1u
X1861 a_32270_141690# a_32610_148476# a_48158_148592# VDD pfet_06v0 ad=4.4p pd=20.88u as=2.5p ps=10.5u w=10u l=1u
X1862 a_55342_162505# a_55342_162505# VSS VSS nfet_06v0 ad=0.44p pd=2.88u as=0.44p ps=2.88u w=1u l=1u
X1863 a_77258_117722# a_77258_117722# VSS VSS nfet_06v0 ad=0.44p pd=2.88u as=0.44p ps=2.88u w=1u l=1u
X1864 a_37774_162503# a_101622_117766# cap_mim_2f0_m4m5_noshield c_width=25u c_length=8u
X1865 a_63718_184379# a_55682_183333# a_62158_179979# VDD pfet_06v0 ad=1.3p pd=5.52u as=2.2p ps=10.88u w=5u l=1u
X1866 a_108330_136608# a_108130_136492# VDD VDD pfet_06v0 ad=2.5p pd=10.5u as=4.4p ps=20.88u w=10u l=1u
X1867 a_79222_117766# a_50996_204977# a_77458_117766# VSS nfet_06v0 ad=3.3p pd=15.88u as=3.3p ps=15.88u w=7.5u l=1u
X1868 VDD a_86902_175755# a_84230_171355# VDD pfet_06v0 ad=1.3p pd=5.52u as=1.3p ps=5.52u w=5u l=1u
X1869 a_63270_171355# a_69198_175709# a_63718_175755# VDD pfet_06v0 ad=2.2p pd=10.88u as=2.2p ps=10.88u w=5u l=1u
X1870 a_82106_141734# a_77258_141690# a_79422_150482# VSS nfet_06v0 ad=1.1p pd=5.88u as=0.825p ps=3.16u w=2.5u l=1u
X1871 a_95990_153995# a_88018_158395# VDD VDD pfet_06v0 ad=4.4p pd=20.88u as=2.6p ps=10.52u w=10u l=1u
X1872 a_100272_122228# a_99698_124508# a_101622_117766# VDD pfet_06v0 ad=4.4p pd=20.88u as=4.4p ps=20.88u w=10u l=1u
X1873 a_77872_146196# a_77298_148476# a_79222_141734# VDD pfet_06v0 ad=4.4p pd=20.88u as=4.4p ps=20.88u w=10u l=1u
X1874 a_33184_122228# a_48602_122228# VSS ppolyf_u_1k r_width=1u r_length=76.45u
X1875 a_80498_141690# a_77258_141690# a_80234_150492# VSS nfet_06v0 ad=1.1p pd=5.88u as=0.825p ps=3.16u w=2.5u l=1u
X1876 a_39086_153995# a_40646_158395# VDD VDD pfet_06v0 ad=1.3p pd=5.52u as=1.3p ps=5.52u w=5u l=1u
X1877 a_88018_184379# a_78866_183333# a_84230_179979# VDD pfet_06v0 ad=1.3p pd=5.52u as=2.2p ps=10.88u w=5u l=1u
X1878 a_38414_174755# a_37774_171239# a_36970_174825# VDD pfet_06v0 ad=2.6p pd=10.52u as=4.4p ps=20.88u w=10u l=1u
X1879 a_80498_117722# a_84094_125708# a_81046_124624# VDD pfet_06v0 ad=1.76p pd=8.88u as=1.76p ps=8.88u w=4u l=1u
X1880 a_54910_148592# a_54710_148476# VDD VDD pfet_06v0 ad=2.5p pd=10.5u as=4.4p ps=20.88u w=10u l=1u
X1881 a_37974_171355# a_40646_175755# VDD VDD pfet_06v0 ad=1.3p pd=5.52u as=1.3p ps=5.52u w=5u l=1u
X1882 a_67950_141734# a_55010_148476# VSS VSS nfet_06v0 ad=0.25p pd=1.5u as=0.44p ps=2.88u w=1u l=1u
X1883 a_12580_136433# a_12580_136433# VDD VDD pfet_06v0 ad=0.52p pd=2.52u as=0.88p ps=4.88u w=2u l=1u
X1884 a_34234_153925# a_32610_157349# VSS VSS nfet_06v0 ad=0.25p pd=1.5u as=0.44p ps=2.88u w=1u l=1u
X1885 a_82106_117766# a_77258_117722# a_79422_126514# VSS nfet_06v0 ad=1.1p pd=5.88u as=0.825p ps=3.16u w=2.5u l=1u
X1886 a_100272_147546# a_115690_147096# VSS ppolyf_u_1k r_width=1u r_length=76.45u
X1887 a_37774_162503# a_100272_122228# VDD VDD pfet_06v0 ad=0.44p pd=2.88u as=0.44p ps=2.88u w=1u l=1u
X1888 a_99898_148592# a_99698_148476# a_100710_148592# VDD pfet_06v0 ad=4.4p pd=20.88u as=2.5p ps=10.5u w=10u l=1u
X1889 a_39086_153995# a_32610_157349# a_40646_158395# VDD pfet_06v0 ad=2.2p pd=10.88u as=1.3p ps=5.52u w=5u l=1u
X1890 VSS a_87566_171355# a_95990_171355# VSS nfet_06v0 ad=1.3p pd=5.52u as=1.3p ps=5.52u w=5u l=1u
X1891 a_99398_136492# a_99698_136492# a_111606_129750# VSS nfet_06v0 ad=0.44p pd=2.88u as=0.25p ps=1.5u w=1u l=1u
X1892 VSS a_63270_171355# a_61486_174755# VSS nfet_06v0 ad=0.65p pd=3.02u as=0.65p ps=3.02u w=2.5u l=1u
X1893 a_12580_196913# X VDD ppolyf_u r_width=40u r_length=10u
X1894 a_41310_153995# a_32270_153881# a_38414_157395# VSS nfet_06v0 ad=0.65p pd=3.02u as=1.1p ps=5.88u w=2.5u l=1u
X1895 a_37302_174825# a_32610_174709# a_36970_174825# VDD pfet_06v0 ad=2.5p pd=10.5u as=3.3p ps=10.66u w=10u l=1u
X1896 a_80498_117722# a_77258_117722# a_80234_126524# VSS nfet_06v0 ad=1.1p pd=5.88u as=0.825p ps=3.16u w=2.5u l=1u
X1897 VSS a_33002_153881# a_36942_153925# VSS nfet_06v0 ad=2.2p pd=10.88u as=1.25p ps=5.5u w=5u l=1u
X1898 a_32270_162505# a_32610_165973# a_32510_166089# VDD pfet_06v0 ad=4.4p pd=20.88u as=2.5p ps=10.5u w=10u l=1u
X1899 a_85342_153995# a_86902_158395# VDD VDD pfet_06v0 ad=1.3p pd=5.52u as=1.3p ps=5.52u w=5u l=1u
X1900 a_85346_129750# a_85146_129706# VSS VSS nfet_06v0 ad=1.25p pd=5.5u as=2.2p ps=10.88u w=5u l=1u
X1901 VDD a_72806_153995# a_117490_153868# VDD pfet_06v0 ad=1.32p pd=6.88u as=0.99p ps=3.66u w=3u l=1u
X1902 a_48158_136608# a_32310_136492# VDD VDD pfet_06v0 ad=2.5p pd=10.5u as=4.4p ps=20.88u w=10u l=1u
X1903 VSS a_63270_179979# a_62602_183379# VSS nfet_06v0 ad=1.1p pd=5.88u as=0.65p ps=3.02u w=2.5u l=1u
X1904 a_100272_134212# a_105038_129706# a_104506_129750# VSS nfet_06v0 ad=0.88p pd=4.88u as=0.88p ps=4.88u w=2u l=1u
X1905 a_67950_117766# a_55010_124508# VSS VSS nfet_06v0 ad=0.25p pd=1.5u as=0.44p ps=2.88u w=1u l=1u
X1906 a_71442_171285# a_71242_171241# VSS VSS nfet_06v0 ad=1.25p pd=5.5u as=2.2p ps=10.88u w=5u l=1u
X1907 a_100272_146646# a_115690_147096# VSS ppolyf_u_1k r_width=1u r_length=76.45u
D85 a_35066_117722# VDD diode_pd2nw_06v0 pj=40u area=99.99999p
X1908 a_62602_174755# a_63270_171355# VSS VSS nfet_06v0 ad=0.65p pd=3.02u as=0.65p ps=3.02u w=2.5u l=1u
X1909 a_59682_171285# a_38886_171239# a_62158_171355# VSS nfet_06v0 ad=2.2p pd=10.88u as=1.3p ps=5.52u w=5u l=1u
X1910 a_72806_153995# a_61046_153995# cap_mim_2f0_m4m5_noshield c_width=20u c_length=10u
X1911 a_55682_157349# a_55682_157349# a_58338_153925# VSS nfet_06v0 ad=0.44p pd=2.88u as=0.25p ps=1.5u w=1u l=1u
X1912 VSS VDD VSS VSS nfet_06v0 ad=7.92p pd=36.88u as=0 ps=0 w=18u l=2u
X1913 a_63058_141734# a_62858_141690# VSS VSS nfet_06v0 ad=1.25p pd=5.5u as=2.2p ps=10.88u w=5u l=1u
X1914 XP_OUT XN_OUT VSS VSS nfet_05v0 ad=0.5808p pd=3.52u as=0.5808p ps=3.52u w=1.32u l=0.6u
X1915 a_59682_179909# a_60846_179863# a_61046_179979# VSS nfet_06v0 ad=2.2p pd=10.88u as=1.3p ps=5.52u w=5u l=1u
X1916 a_47326_162549# a_33002_162505# VSS VSS nfet_06v0 ad=1.25p pd=5.5u as=2.2p ps=10.88u w=5u l=1u
X1917 a_81802_183449# a_78566_183333# VDD VDD pfet_06v0 ad=2.5p pd=10.5u as=4.4p ps=20.88u w=10u l=1u
X1918 a_106494_125708# a_106494_125708# a_108130_124508# VDD pfet_06v0 ad=4.4p pd=20.88u as=3.3p ps=10.66u w=10u l=1u
D86 VSS a_31060_204977# diode_nd2ps_06v0 pj=40u area=99.99999p
X1919 a_103446_148592# a_99698_148476# a_102354_141734# VDD pfet_06v0 ad=4.4p pd=20.88u as=4.4p ps=20.88u w=10u l=1u
X1920 VDD a_55382_165973# a_60374_166089# VDD pfet_06v0 ad=4.4p pd=20.88u as=2.5p ps=10.5u w=10u l=1u
X1921 a_94770_148592# a_76998_148476# VDD VDD pfet_06v0 ad=2.5p pd=10.5u as=4.4p ps=20.88u w=10u l=1u
X1922 a_55342_171241# a_55682_174709# a_55582_174825# VDD pfet_06v0 ad=4.4p pd=20.88u as=2.5p ps=10.5u w=10u l=1u
D87 VSS a_35066_117722# diode_nd2ps_06v0 pj=40u area=99.99999p
X1923 VDD a_63718_175755# a_61046_171355# VDD pfet_06v0 ad=1.3p pd=5.52u as=1.3p ps=5.52u w=5u l=1u
X1924 VSS VDD VSS VSS nfet_06v0 ad=4.29p pd=20.38u as=0 ps=0 w=9.75u l=2u
X1925 VSS a_49734_162619# a_113830_162536# VSS nfet_06v0 ad=0.44p pd=2.88u as=0.44p ps=2.88u w=1u l=1u
X1926 VDD VSS VDD VDD pfet_06v0 ad=4.29p pd=20.38u as=0 ps=0 w=9.75u l=2u
X1927 a_32470_141734# a_32270_141690# VSS VSS nfet_06v0 ad=1.25p pd=5.5u as=2.2p ps=10.88u w=5u l=1u
X1928 a_106702_141734# a_99358_141690# VSS VSS nfet_06v0 ad=1.25p pd=5.5u as=2.2p ps=10.88u w=5u l=1u
X1929 a_47046_148592# a_32310_148476# VDD VDD pfet_06v0 ad=2.5p pd=10.5u as=4.4p ps=20.88u w=10u l=1u
X1930 a_79258_171241# a_78526_171241# a_79458_171285# VSS nfet_06v0 ad=2.2p pd=10.88u as=1.25p ps=5.5u w=5u l=1u
X1931 a_78526_162505# a_78526_162505# VSS VSS nfet_06v0 ad=0.44p pd=2.88u as=0.44p ps=2.88u w=1u l=1u
X1932 a_79222_129750# a_81046_136608# VDD VDD pfet_06v0 ad=2.2p pd=10.88u as=2.2p ps=10.88u w=5u l=1u
X1933 a_33622_148592# a_32310_148476# VDD VDD pfet_06v0 ad=2.5p pd=10.5u as=4.4p ps=20.88u w=10u l=1u
X1934 VSS VDD VSS VSS nfet_06v0 ad=7.92p pd=36.88u as=0 ps=0 w=18u l=2u
X1935 a_44518_129750# a_32610_136492# VSS VSS nfet_06v0 ad=0.25p pd=1.5u as=0.44p ps=2.88u w=1u l=1u
X1936 a_45662_153881# a_45662_153881# a_48170_153881# VSS nfet_06v0 ad=2.2p pd=10.88u as=1.65p ps=5.66u w=5u l=1u
X1937 a_63058_117766# a_62858_117722# VSS VSS nfet_06v0 ad=1.25p pd=5.5u as=2.2p ps=10.88u w=5u l=1u
X1938 a_91918_162505# a_91918_162505# a_94426_162505# VSS nfet_06v0 ad=2.2p pd=10.88u as=1.65p ps=5.66u w=5u l=1u
X1939 a_37418_129750# a_32570_129706# a_34734_138498# VSS nfet_06v0 ad=1.1p pd=5.88u as=0.825p ps=3.16u w=2.5u l=1u
X1940 a_83198_153925# a_78526_153881# a_82866_153925# VSS nfet_06v0 ad=1.25p pd=5.5u as=1.65p ps=5.66u w=5u l=1u
X1941 a_69446_148592# a_54710_148476# VDD VDD pfet_06v0 ad=2.5p pd=10.5u as=4.4p ps=20.88u w=10u l=1u
X1942 a_64382_153995# a_69198_158349# a_64834_158395# VDD pfet_06v0 ad=2.2p pd=10.88u as=2.2p ps=10.88u w=5u l=1u
X1943 a_84230_162619# a_78866_165973# a_88018_167019# VDD pfet_06v0 ad=2.2p pd=10.88u as=1.3p ps=5.52u w=5u l=1u
X1944 a_40646_184379# a_45662_179865# a_40198_179979# VSS nfet_06v0 ad=1.1p pd=5.88u as=1.1p ps=5.88u w=2.5u l=1u
X1945 a_60014_171285# a_55342_171241# a_59682_171285# VSS nfet_06v0 ad=1.25p pd=5.5u as=1.65p ps=5.66u w=5u l=1u
X1946 a_41310_153995# a_46126_158349# a_41762_158395# VDD pfet_06v0 ad=2.2p pd=10.88u as=2.2p ps=10.88u w=5u l=1u
X1947 a_59818_129750# a_61806_137692# a_55584_134212# VDD pfet_06v0 ad=1.76p pd=8.88u as=1.76p ps=8.88u w=4u l=1u
X1948 a_32470_117766# a_32270_117722# VSS VSS nfet_06v0 ad=1.25p pd=5.5u as=2.2p ps=10.88u w=5u l=1u
X1949 a_35810_129706# a_32570_129706# a_35546_138508# VSS nfet_06v0 ad=1.1p pd=5.88u as=0.825p ps=3.16u w=2.5u l=1u
X1950 a_99398_136492# a_99698_136492# a_117170_136608# VDD pfet_06v0 ad=4.4p pd=20.88u as=2.5p ps=10.5u w=10u l=1u
X1951 a_48370_153925# a_48170_153881# VSS VSS nfet_06v0 ad=1.25p pd=5.5u as=2.2p ps=10.88u w=5u l=1u
X1952 a_55682_165973# a_55682_165973# VDD VDD pfet_06v0 ad=0.88p pd=4.88u as=0.88p ps=4.88u w=2u l=1u
X1953 a_106702_117766# a_99358_117722# VSS VSS nfet_06v0 ad=1.25p pd=5.5u as=2.2p ps=10.88u w=5u l=1u
X1954 a_88018_158395# a_91918_153881# a_87566_153995# VSS nfet_06v0 ad=1.1p pd=5.88u as=1.1p ps=5.88u w=2.5u l=1u
X1955 a_99358_141690# a_99698_148476# a_115246_148592# VDD pfet_06v0 ad=4.4p pd=20.88u as=2.5p ps=10.5u w=10u l=1u
X1956 a_46126_158349# a_46126_158349# a_47762_157349# VDD pfet_06v0 ad=4.4p pd=20.88u as=3.3p ps=10.66u w=10u l=1u
X1957 a_38886_153879# a_79222_117766# cap_mim_2f0_m4m5_noshield c_width=25u c_length=8u
X1958 a_103784_162888# a_102120_162772# VSS VSS nfet_06v0 ad=0.175p pd=1.2u as=0.308p ps=2.28u w=0.7u l=1u
X1959 a_56934_141734# a_58758_148592# VDD VDD pfet_06v0 ad=2.2p pd=10.88u as=2.2p ps=10.88u w=5u l=1u
X1960 a_85786_166019# a_86454_162619# VSS VSS nfet_06v0 ad=0.65p pd=3.02u as=0.65p ps=3.02u w=2.5u l=1u
X1961 VSS a_64382_179979# a_72806_179979# VSS nfet_06v0 ad=1.3p pd=5.52u as=1.3p ps=5.52u w=5u l=1u
X1962 a_59382_171285# a_56074_171241# VSS VSS nfet_06v0 ad=1.25p pd=5.5u as=2.2p ps=10.88u w=5u l=1u
X1963 a_42022_129750# a_33184_134212# VDD VDD pfet_06v0 ad=0.44p pd=2.88u as=0.44p ps=2.88u w=1u l=1u
X1964 a_82566_179909# a_79258_179865# VSS VSS nfet_06v0 ad=1.25p pd=5.5u as=2.2p ps=10.88u w=5u l=1u
X1965 VSS VDD VSS VSS nfet_06v0 ad=7.92p pd=36.88u as=0 ps=0 w=18u l=2u
X1966 a_77258_117722# a_77298_124508# a_91734_124624# VDD pfet_06v0 ad=4.4p pd=20.88u as=2.5p ps=10.5u w=10u l=1u
X1967 a_63642_124624# a_63442_124508# VDD VDD pfet_06v0 ad=2.5p pd=10.5u as=4.4p ps=20.88u w=10u l=1u
X1968 a_100272_122228# a_115690_122228# VSS ppolyf_u_1k r_width=1u r_length=76.45u
X1969 VSS VDD VSS VSS nfet_06v0 ad=4.29p pd=20.38u as=0 ps=0 w=9.75u l=2u
X1970 a_35546_150492# a_35810_141690# VSS VSS nfet_06v0 ad=0.825p pd=3.16u as=1.1p ps=5.88u w=2.5u l=1u
X1971 a_84670_166019# a_78526_162505# a_87566_162619# VSS nfet_06v0 ad=1.1p pd=5.88u as=0.65p ps=3.02u w=2.5u l=1u
X1972 a_61486_174755# a_63270_171355# VSS VSS nfet_06v0 ad=0.65p pd=3.02u as=1.1p ps=5.88u w=2.5u l=1u
X1973 a_38886_162503# a_55584_134212# VDD VDD pfet_06v0 ad=0.44p pd=2.88u as=0.44p ps=2.88u w=1u l=1u
X1974 a_82926_183449# a_78566_183333# VDD VDD pfet_06v0 ad=2.5p pd=10.5u as=4.4p ps=20.88u w=10u l=1u
X1975 a_82866_162549# a_78526_162505# a_82566_162549# VSS nfet_06v0 ad=1.65p pd=5.66u as=1.25p ps=5.5u w=5u l=1u
X1976 a_94626_171285# a_94426_171241# VSS VSS nfet_06v0 ad=1.25p pd=5.5u as=2.2p ps=10.88u w=5u l=1u
X1977 a_58618_183449# a_55382_183333# VDD VDD pfet_06v0 ad=2.5p pd=10.5u as=4.4p ps=20.88u w=10u l=1u
X1978 VSS VDD VSS VSS nfet_06v0 ad=7.92p pd=36.88u as=0 ps=0 w=18u l=2u
.ends
