* netlist plana generada por flatten_spice.py (top: GRADIENT_NAV)
* 1341 MOSFETs; nets fusionadas por V=0: x5_net11->VSS, x5_net12->VSS, x5_net10->VSS, x5_net13->VSS, x6_net11->VSS, x6_net12->VSS, x6_net10->VSS, x6_net13->VSS, x7_net11->VSS, x7_net12->VSS, x7_net10->VSS, x7_net13->VSS
* nombres: los del esquematico; solo llevan la ruta de instancias (Mx1_M4) los 1341 que chocaban
* m -> fingers: Mx5_XM2: m=6 nf=1 -> nf=6; Mx5_XM3: m=2 nf=1 -> nf=2; Mx5_XM5: m=2 nf=1 -> nf=2; Mx5_XM1: m=2 nf=1 -> nf=2; Mx5_XM9: m=2 nf=1 -> nf=2; Mx5_XM11: m=2 nf=1 -> nf=2; Mx6_XM2: m=6 nf=1 -> nf=6; Mx6_XM3: m=2 nf=1 -> nf=2; Mx6_XM5: m=2 nf=1 -> nf=2; Mx6_XM1: m=2 nf=1 -> nf=2; Mx6_XM9: m=2 nf=1 -> nf=2; Mx6_XM11: m=2 nf=1 -> nf=2; Mx7_XM2: m=6 nf=1 -> nf=6; Mx7_XM3: m=2 nf=1 -> nf=2; Mx7_XM5: m=2 nf=1 -> nf=2; Mx7_XM1: m=2 nf=1 -> nf=2; Mx7_XM9: m=2 nf=1 -> nf=2; Mx7_XM11: m=2 nf=1 -> nf=2
* para LVS: cada dedo, un transistor en paralelo
.subckt GRADIENT_NAV S1N VDD XN VSS S1P S2N S2P S3N S3P S4N S4P XP YN YP ZN ZP X Y Z
Mx1_x1_XM11 x1_x1_net5 x1_x1_net1 VDD VDD pfet_06v0 L=1.0u W=10.0u
Mx1_x1_XM12 x1_x1_net11 x1_x1_net6 x1_x1_net5 VDD pfet_06v0 L=1.0u W=10.0u
Mx1_x1_XM13 x1_x1_net23 x1_x1_net1 VDD VDD pfet_06v0 L=1.0u W=10.0u
Mx1_x1_XM14 x1_x1_net11 x1_x1_net6 x1_x1_net23 VDD pfet_06v0 L=1.0u W=10.0u
Mx1_x1_XM15 x1_x1_net9 S1P x1_x1_net11 VDD pfet_06v0 L=1.0u W=10.0u
Mx1_x1_XM16 x1_x1_net8 S1N x1_x1_net11 VDD pfet_06v0 L=1.0u W=10.0u
Mx1_x1_XM17 x1_x1_net12 x1_x1_net4 x1_x1_net2 VSS nfet_06v0 L=1.0u W=5.0u
Mx1_x1_XM18 x1_x1_net2 x1_x1_net3 VSS VSS nfet_06v0 L=1.0u W=5.0u
Mx1_x1_XM19 x1_x1_net12 x1_x1_net4 x1_x1_net24 VSS nfet_06v0 L=1.0u W=5.0u
Mx1_x1_XM20 x1_x1_net24 x1_x1_net3 VSS VSS nfet_06v0 L=1.0u W=5.0u
Mx1_x1_XM21 x1_x1_net10 S1P x1_x1_net12 VSS nfet_06v0 L=1.0u W=5u
Mx1_x1_XM22 x1_x1_net7 S1N x1_x1_net12 VSS nfet_06v0 L=1.0u W=5u
Mx1_x1_XM29 x1_x1_net13 x1_x1_net6 x1_x1_net7 VDD pfet_06v0 L=1.0u W=5u
Mx1_x1_XM30 x1_x1_net16 x1_x1_net6 x1_x1_net10 VDD pfet_06v0 L=1.0u W=5u
Mx1_x1_XM31 x1_x1_net7 x1_x1_net13 VDD VDD pfet_06v0 L=1.0u W=5u
Mx1_x1_XM35 x1_x1_net10 x1_x1_net13 VDD VDD pfet_06v0 L=1.0u W=5u
Mx1_x1_XM32 x1_x1_net14 x1_x1_net25 x1_x1_net13 VDD pfet_06v0 L=1.0u W=5.0u
Mx1_x1_XM33 x1_x1_net26 x1_x1_net25 x1_x1_net16 VDD pfet_06v0 L=1.0u W=5.0u
Mx1_x1_XM23 x1_x1_net14 x1_x1_net4 x1_x1_net8 VSS nfet_06v0 L=1.0u W=2.5u
Mx1_x1_XM24 x1_x1_net26 x1_x1_net4 x1_x1_net9 VSS nfet_06v0 L=1.0u W=2.5u
Mx1_x1_XM25 x1_x1_net8 x1_x1_net14 VSS VSS nfet_06v0 L=1.0u W=2.5u
Mx1_x1_XM26 x1_x1_net9 x1_x1_net14 VSS VSS nfet_06v0 L=1.0u W=2.5u
Mx1_x1_XM27 x1_x1_net13 x1_x1_net15 x1_x1_net14 VSS nfet_06v0 L=1.0u W=2.5u
Mx1_x1_XM28 x1_x1_net16 x1_x1_net15 x1_x1_net26 VSS nfet_06v0 L=1.0u W=2.5u
Mx1_x1_XM34 x1_x1_net17 x1_x1_net18 VDD VDD pfet_06v0 L=1.0u W=10.0u
Mx1_x1_XM36 x1_x1_net18 x1_x1_net6 x1_x1_net17 VDD pfet_06v0 L=1.0u W=10.0u
Mx1_x1_XM37 x1_x1_net25 x1_x1_net25 x1_x1_net18 VDD pfet_06v0 L=1.0u W=10.0u
Mx1_x1_XM38 x1_x1_net25 x1_x1_net4 x1_x1_net19 VSS nfet_06v0 L=1.0u W=5.0u
Mx1_x1_XM39 x1_x1_net19 x1_x1_net3 VSS VSS nfet_06v0 L=1.0u W=5.0u
Mx1_x1_XM45 x1_x1_net20 x1_x1_net1 VDD VDD pfet_06v0 L=1.0u W=10.0u
Mx1_x1_XM46 x1_x1_net15 x1_x1_net6 x1_x1_net20 VDD pfet_06v0 L=1.0u W=10.0u
Mx1_x1_XM40 x1_x1_net15 x1_x1_net15 x1_x1_net22 VSS nfet_06v0 L=1.0u W=5.0u
Mx1_x1_XM41 x1_x1_net22 x1_x1_net4 x1_x1_net21 VSS nfet_06v0 L=1.0u W=5.0u
Mx1_x1_XM42 x1_x1_net21 x1_x1_net22 VSS VSS nfet_06v0 L=1.0u W=5.0u
Mx1_x1_XM43 x1_SX x1_x1_net16 VDD VDD pfet_06v0 L=20.0u W=0.7u
Mx1_x1_XM44 x1_SX x1_x1_net26 VSS VSS nfet_06v0 L=1.0u W=1.0u
Mx1_x1_XM4 x1_x1_net29 x1_x1_net1 VDD VDD pfet_06v0 L=1.0u W=10.0u
Mx1_x1_XM5 x1_x1_net4 x1_x1_net6 x1_x1_net29 VDD pfet_06v0 L=1.0u W=10.0u
Mx1_x1_XM6 x1_x1_net4 x1_x1_net4 VSS VSS nfet_06v0 L=1.0u W=1.0u
Mx1_x1_XM7 x1_x1_net28 x1_x1_net1 VDD VDD pfet_06v0 L=1.0u W=10.0u
Mx1_x1_XM8 x1_x1_net3 x1_x1_net6 x1_x1_net28 VDD pfet_06v0 L=1.0u W=10.0u
Mx1_x1_XM9 x1_x1_net3 x1_x1_net4 x1_x1_net27 VSS nfet_06v0 L=1.0u W=5.0u
Mx1_x1_XM10 x1_x1_net27 x1_x1_net3 VSS VSS nfet_06v0 L=1.0u W=5.0u
Mx1_x1_XM1 x1_x1_net6 x1_x1_net6 VDD VDD pfet_06v0 L=1.0u W=2u
Mx1_x1_XM2 x1_x1_net30 x1_x1_net1 VDD VDD pfet_06v0 L=1.0u W=10.0u
Mx1_x1_XM3 x1_x1_net1 x1_x1_net6 x1_x1_net30 VDD pfet_06v0 L=1.0u W=10.0u
Mx1_x1_XM47 x1_x1_net31 x1_x1_net6 VSS VSS nfet_06v0 L=1.0u W=1.0u
Mx1_x1_XM48 x1_x1_net32 x1_x1_net6 VSS VSS nfet_06v0 L=1.0u W=1.0u
Mx1_x1_XM49 x1_x1_net6 x1_x1_net6 x1_x1_net32 VSS nfet_06v0 L=1.0u W=1.0u
Mx1_x1_XM50 x1_x1_net1 x1_x1_net6 x1_x1_net31 VSS nfet_06v0 L=1.0u W=1.0u
Mx1_x2_XM11 x1_x2_net5 x1_x2_net1 VDD VDD pfet_06v0 L=1.0u W=10.0u
Mx1_x2_XM12 x1_x2_net11 x1_x2_net6 x1_x2_net5 VDD pfet_06v0 L=1.0u W=10.0u
Mx1_x2_XM13 x1_x2_net23 x1_x2_net1 VDD VDD pfet_06v0 L=1.0u W=10.0u
Mx1_x2_XM14 x1_x2_net11 x1_x2_net6 x1_x2_net23 VDD pfet_06v0 L=1.0u W=10.0u
Mx1_x2_XM15 x1_x2_net9 S2P x1_x2_net11 VDD pfet_06v0 L=1.0u W=10.0u
Mx1_x2_XM16 x1_x2_net8 S2N x1_x2_net11 VDD pfet_06v0 L=1.0u W=10.0u
Mx1_x2_XM17 x1_x2_net12 x1_x2_net4 x1_x2_net2 VSS nfet_06v0 L=1.0u W=5.0u
Mx1_x2_XM18 x1_x2_net2 x1_x2_net3 VSS VSS nfet_06v0 L=1.0u W=5.0u
Mx1_x2_XM19 x1_x2_net12 x1_x2_net4 x1_x2_net24 VSS nfet_06v0 L=1.0u W=5.0u
Mx1_x2_XM20 x1_x2_net24 x1_x2_net3 VSS VSS nfet_06v0 L=1.0u W=5.0u
Mx1_x2_XM21 x1_x2_net10 S2P x1_x2_net12 VSS nfet_06v0 L=1.0u W=5u
Mx1_x2_XM22 x1_x2_net7 S2N x1_x2_net12 VSS nfet_06v0 L=1.0u W=5u
Mx1_x2_XM29 x1_x2_net13 x1_x2_net6 x1_x2_net7 VDD pfet_06v0 L=1.0u W=5u
Mx1_x2_XM30 x1_x2_net16 x1_x2_net6 x1_x2_net10 VDD pfet_06v0 L=1.0u W=5u
Mx1_x2_XM31 x1_x2_net7 x1_x2_net13 VDD VDD pfet_06v0 L=1.0u W=5u
Mx1_x2_XM35 x1_x2_net10 x1_x2_net13 VDD VDD pfet_06v0 L=1.0u W=5u
Mx1_x2_XM32 x1_x2_net14 x1_x2_net25 x1_x2_net13 VDD pfet_06v0 L=1.0u W=5.0u
Mx1_x2_XM33 x1_x2_net26 x1_x2_net25 x1_x2_net16 VDD pfet_06v0 L=1.0u W=5.0u
Mx1_x2_XM23 x1_x2_net14 x1_x2_net4 x1_x2_net8 VSS nfet_06v0 L=1.0u W=2.5u
Mx1_x2_XM24 x1_x2_net26 x1_x2_net4 x1_x2_net9 VSS nfet_06v0 L=1.0u W=2.5u
Mx1_x2_XM25 x1_x2_net8 x1_x2_net14 VSS VSS nfet_06v0 L=1.0u W=2.5u
Mx1_x2_XM26 x1_x2_net9 x1_x2_net14 VSS VSS nfet_06v0 L=1.0u W=2.5u
Mx1_x2_XM27 x1_x2_net13 x1_x2_net15 x1_x2_net14 VSS nfet_06v0 L=1.0u W=2.5u
Mx1_x2_XM28 x1_x2_net16 x1_x2_net15 x1_x2_net26 VSS nfet_06v0 L=1.0u W=2.5u
Mx1_x2_XM34 x1_x2_net17 x1_x2_net18 VDD VDD pfet_06v0 L=1.0u W=10.0u
Mx1_x2_XM36 x1_x2_net18 x1_x2_net6 x1_x2_net17 VDD pfet_06v0 L=1.0u W=10.0u
Mx1_x2_XM37 x1_x2_net25 x1_x2_net25 x1_x2_net18 VDD pfet_06v0 L=1.0u W=10.0u
Mx1_x2_XM38 x1_x2_net25 x1_x2_net4 x1_x2_net19 VSS nfet_06v0 L=1.0u W=5.0u
Mx1_x2_XM39 x1_x2_net19 x1_x2_net3 VSS VSS nfet_06v0 L=1.0u W=5.0u
Mx1_x2_XM45 x1_x2_net20 x1_x2_net1 VDD VDD pfet_06v0 L=1.0u W=10.0u
Mx1_x2_XM46 x1_x2_net15 x1_x2_net6 x1_x2_net20 VDD pfet_06v0 L=1.0u W=10.0u
Mx1_x2_XM40 x1_x2_net15 x1_x2_net15 x1_x2_net22 VSS nfet_06v0 L=1.0u W=5.0u
Mx1_x2_XM41 x1_x2_net22 x1_x2_net4 x1_x2_net21 VSS nfet_06v0 L=1.0u W=5.0u
Mx1_x2_XM42 x1_x2_net21 x1_x2_net22 VSS VSS nfet_06v0 L=1.0u W=5.0u
Mx1_x2_XM43 x1_SY x1_x2_net16 VDD VDD pfet_06v0 L=20.0u W=0.7u
Mx1_x2_XM44 x1_SY x1_x2_net26 VSS VSS nfet_06v0 L=1.0u W=1.0u
Mx1_x2_XM4 x1_x2_net29 x1_x2_net1 VDD VDD pfet_06v0 L=1.0u W=10.0u
Mx1_x2_XM5 x1_x2_net4 x1_x2_net6 x1_x2_net29 VDD pfet_06v0 L=1.0u W=10.0u
Mx1_x2_XM6 x1_x2_net4 x1_x2_net4 VSS VSS nfet_06v0 L=1.0u W=1.0u
Mx1_x2_XM7 x1_x2_net28 x1_x2_net1 VDD VDD pfet_06v0 L=1.0u W=10.0u
Mx1_x2_XM8 x1_x2_net3 x1_x2_net6 x1_x2_net28 VDD pfet_06v0 L=1.0u W=10.0u
Mx1_x2_XM9 x1_x2_net3 x1_x2_net4 x1_x2_net27 VSS nfet_06v0 L=1.0u W=5.0u
Mx1_x2_XM10 x1_x2_net27 x1_x2_net3 VSS VSS nfet_06v0 L=1.0u W=5.0u
Mx1_x2_XM1 x1_x2_net6 x1_x2_net6 VDD VDD pfet_06v0 L=1.0u W=2u
Mx1_x2_XM2 x1_x2_net30 x1_x2_net1 VDD VDD pfet_06v0 L=1.0u W=10.0u
Mx1_x2_XM3 x1_x2_net1 x1_x2_net6 x1_x2_net30 VDD pfet_06v0 L=1.0u W=10.0u
Mx1_x2_XM47 x1_x2_net31 x1_x2_net6 VSS VSS nfet_06v0 L=1.0u W=1.0u
Mx1_x2_XM48 x1_x2_net32 x1_x2_net6 VSS VSS nfet_06v0 L=1.0u W=1.0u
Mx1_x2_XM49 x1_x2_net6 x1_x2_net6 x1_x2_net32 VSS nfet_06v0 L=1.0u W=1.0u
Mx1_x2_XM50 x1_x2_net1 x1_x2_net6 x1_x2_net31 VSS nfet_06v0 L=1.0u W=1.0u
Mx1_x3_XM11 x1_x3_net5 x1_x3_net1 VDD VDD pfet_06v0 L=1.0u W=10.0u
Mx1_x3_XM12 x1_x3_net11 x1_x3_net6 x1_x3_net5 VDD pfet_06v0 L=1.0u W=10.0u
Mx1_x3_XM13 x1_x3_net23 x1_x3_net1 VDD VDD pfet_06v0 L=1.0u W=10.0u
Mx1_x3_XM14 x1_x3_net11 x1_x3_net6 x1_x3_net23 VDD pfet_06v0 L=1.0u W=10.0u
Mx1_x3_XM15 x1_x3_net9 S3P x1_x3_net11 VDD pfet_06v0 L=1.0u W=10.0u
Mx1_x3_XM16 x1_x3_net8 S3N x1_x3_net11 VDD pfet_06v0 L=1.0u W=10.0u
Mx1_x3_XM17 x1_x3_net12 x1_x3_net4 x1_x3_net2 VSS nfet_06v0 L=1.0u W=5.0u
Mx1_x3_XM18 x1_x3_net2 x1_x3_net3 VSS VSS nfet_06v0 L=1.0u W=5.0u
Mx1_x3_XM19 x1_x3_net12 x1_x3_net4 x1_x3_net24 VSS nfet_06v0 L=1.0u W=5.0u
Mx1_x3_XM20 x1_x3_net24 x1_x3_net3 VSS VSS nfet_06v0 L=1.0u W=5.0u
Mx1_x3_XM21 x1_x3_net10 S3P x1_x3_net12 VSS nfet_06v0 L=1.0u W=5u
Mx1_x3_XM22 x1_x3_net7 S3N x1_x3_net12 VSS nfet_06v0 L=1.0u W=5u
Mx1_x3_XM29 x1_x3_net13 x1_x3_net6 x1_x3_net7 VDD pfet_06v0 L=1.0u W=5u
Mx1_x3_XM30 x1_x3_net16 x1_x3_net6 x1_x3_net10 VDD pfet_06v0 L=1.0u W=5u
Mx1_x3_XM31 x1_x3_net7 x1_x3_net13 VDD VDD pfet_06v0 L=1.0u W=5u
Mx1_x3_XM35 x1_x3_net10 x1_x3_net13 VDD VDD pfet_06v0 L=1.0u W=5u
Mx1_x3_XM32 x1_x3_net14 x1_x3_net25 x1_x3_net13 VDD pfet_06v0 L=1.0u W=5.0u
Mx1_x3_XM33 x1_x3_net26 x1_x3_net25 x1_x3_net16 VDD pfet_06v0 L=1.0u W=5.0u
Mx1_x3_XM23 x1_x3_net14 x1_x3_net4 x1_x3_net8 VSS nfet_06v0 L=1.0u W=2.5u
Mx1_x3_XM24 x1_x3_net26 x1_x3_net4 x1_x3_net9 VSS nfet_06v0 L=1.0u W=2.5u
Mx1_x3_XM25 x1_x3_net8 x1_x3_net14 VSS VSS nfet_06v0 L=1.0u W=2.5u
Mx1_x3_XM26 x1_x3_net9 x1_x3_net14 VSS VSS nfet_06v0 L=1.0u W=2.5u
Mx1_x3_XM27 x1_x3_net13 x1_x3_net15 x1_x3_net14 VSS nfet_06v0 L=1.0u W=2.5u
Mx1_x3_XM28 x1_x3_net16 x1_x3_net15 x1_x3_net26 VSS nfet_06v0 L=1.0u W=2.5u
Mx1_x3_XM34 x1_x3_net17 x1_x3_net18 VDD VDD pfet_06v0 L=1.0u W=10.0u
Mx1_x3_XM36 x1_x3_net18 x1_x3_net6 x1_x3_net17 VDD pfet_06v0 L=1.0u W=10.0u
Mx1_x3_XM37 x1_x3_net25 x1_x3_net25 x1_x3_net18 VDD pfet_06v0 L=1.0u W=10.0u
Mx1_x3_XM38 x1_x3_net25 x1_x3_net4 x1_x3_net19 VSS nfet_06v0 L=1.0u W=5.0u
Mx1_x3_XM39 x1_x3_net19 x1_x3_net3 VSS VSS nfet_06v0 L=1.0u W=5.0u
Mx1_x3_XM45 x1_x3_net20 x1_x3_net1 VDD VDD pfet_06v0 L=1.0u W=10.0u
Mx1_x3_XM46 x1_x3_net15 x1_x3_net6 x1_x3_net20 VDD pfet_06v0 L=1.0u W=10.0u
Mx1_x3_XM40 x1_x3_net15 x1_x3_net15 x1_x3_net22 VSS nfet_06v0 L=1.0u W=5.0u
Mx1_x3_XM41 x1_x3_net22 x1_x3_net4 x1_x3_net21 VSS nfet_06v0 L=1.0u W=5.0u
Mx1_x3_XM42 x1_x3_net21 x1_x3_net22 VSS VSS nfet_06v0 L=1.0u W=5.0u
Mx1_x3_XM43 x1_SZ x1_x3_net16 VDD VDD pfet_06v0 L=20.0u W=0.7u
Mx1_x3_XM44 x1_SZ x1_x3_net26 VSS VSS nfet_06v0 L=1.0u W=1.0u
Mx1_x3_XM4 x1_x3_net29 x1_x3_net1 VDD VDD pfet_06v0 L=1.0u W=10.0u
Mx1_x3_XM5 x1_x3_net4 x1_x3_net6 x1_x3_net29 VDD pfet_06v0 L=1.0u W=10.0u
Mx1_x3_XM6 x1_x3_net4 x1_x3_net4 VSS VSS nfet_06v0 L=1.0u W=1.0u
Mx1_x3_XM7 x1_x3_net28 x1_x3_net1 VDD VDD pfet_06v0 L=1.0u W=10.0u
Mx1_x3_XM8 x1_x3_net3 x1_x3_net6 x1_x3_net28 VDD pfet_06v0 L=1.0u W=10.0u
Mx1_x3_XM9 x1_x3_net3 x1_x3_net4 x1_x3_net27 VSS nfet_06v0 L=1.0u W=5.0u
Mx1_x3_XM10 x1_x3_net27 x1_x3_net3 VSS VSS nfet_06v0 L=1.0u W=5.0u
Mx1_x3_XM1 x1_x3_net6 x1_x3_net6 VDD VDD pfet_06v0 L=1.0u W=2u
Mx1_x3_XM2 x1_x3_net30 x1_x3_net1 VDD VDD pfet_06v0 L=1.0u W=10.0u
Mx1_x3_XM3 x1_x3_net1 x1_x3_net6 x1_x3_net30 VDD pfet_06v0 L=1.0u W=10.0u
Mx1_x3_XM47 x1_x3_net31 x1_x3_net6 VSS VSS nfet_06v0 L=1.0u W=1.0u
Mx1_x3_XM48 x1_x3_net32 x1_x3_net6 VSS VSS nfet_06v0 L=1.0u W=1.0u
Mx1_x3_XM49 x1_x3_net6 x1_x3_net6 x1_x3_net32 VSS nfet_06v0 L=1.0u W=1.0u
Mx1_x3_XM50 x1_x3_net1 x1_x3_net6 x1_x3_net31 VSS nfet_06v0 L=1.0u W=1.0u
Mx1_x4_x1_XM4 x1_x4_x1_net3 x1_x4_net4 VDD VDD pfet_06v0 L=1.0u W=10.0u
Mx1_x4_x1_XM5 x1_x4_net2 x1_x4_net3 x1_x4_x1_net3 VDD pfet_06v0 L=1.0u W=10.0u
Mx1_x4_x1_XM6 x1_x4_net2 x1_x4_net2 VSS VSS nfet_06v0 L=1.0u W=1.0u
Mx1_x4_x1_XM7 x1_x4_x1_net2 x1_x4_net4 VDD VDD pfet_06v0 L=1.0u W=10.0u
Mx1_x4_x1_XM8 x1_x4_net1 x1_x4_net3 x1_x4_x1_net2 VDD pfet_06v0 L=1.0u W=10.0u
Mx1_x4_x1_XM9 x1_x4_net1 x1_x4_net2 x1_x4_x1_net1 VSS nfet_06v0 L=1.0u W=5.0u
Mx1_x4_x1_XM10 x1_x4_x1_net1 x1_x4_net1 VSS VSS nfet_06v0 L=1.0u W=5.0u
Mx1_x4_x1_XM1 x1_x4_net3 x1_x4_net3 VDD VDD pfet_06v0 L=1.0u W=2u
Mx1_x4_x1_XM2 x1_x4_x1_net4 x1_x4_net4 VDD VDD pfet_06v0 L=1.0u W=10.0u
Mx1_x4_x1_XM3 x1_x4_net4 x1_x4_net3 x1_x4_x1_net4 VDD pfet_06v0 L=1.0u W=10.0u
Mx1_x4_x1_XM47 x1_x4_x1_net5 x1_x4_net3 VSS VSS nfet_06v0 L=1.0u W=1.0u
Mx1_x4_x1_XM48 x1_x4_x1_net6 x1_x4_net3 VSS VSS nfet_06v0 L=1.0u W=1.0u
Mx1_x4_x1_XM49 x1_x4_net3 x1_x4_net3 x1_x4_x1_net6 VSS nfet_06v0 L=1.0u W=1.0u
Mx1_x4_x1_XM50 x1_x4_net4 x1_x4_net3 x1_x4_x1_net5 VSS nfet_06v0 L=1.0u W=1.0u
Mx1_x4_x2_XM11 x1_x4_x2_net2 x1_x4_net4 VDD VDD pfet_06v0 L=1.0u W=10.0u
Mx1_x4_x2_XM12 x1_x4_x2_net7 x1_x4_net3 x1_x4_x2_net2 VDD pfet_06v0 L=1.0u W=10.0u
Mx1_x4_x2_XM13 x1_x4_x2_net19 x1_x4_net4 VDD VDD pfet_06v0 L=1.0u W=10.0u
Mx1_x4_x2_XM14 x1_x4_x2_net7 x1_x4_net3 x1_x4_x2_net19 VDD pfet_06v0 L=1.0u W=10.0u
Mx1_x4_x2_XM15_f1 x1_x4_x2_net5 x1_SY x1_x4_x2_net7 VDD pfet_06v0 L=1.0u W=20.0u
Mx1_x4_x2_XM15_f2 x1_x4_x2_net5 x1_SY x1_x4_x2_net7 VDD pfet_06v0 L=1.0u W=20.0u
Mx1_x4_x2_XM16_f1 x1_x4_x2_net4 x1_SX x1_x4_x2_net7 VDD pfet_06v0 L=1.0u W=20.0u
Mx1_x4_x2_XM16_f2 x1_x4_x2_net4 x1_SX x1_x4_x2_net7 VDD pfet_06v0 L=1.0u W=20.0u
Mx1_x4_x2_XM17 x1_x4_x2_net8 x1_x4_net2 x1_x4_x2_net1 VSS nfet_06v0 L=1.0u W=5.0u
Mx1_x4_x2_XM18 x1_x4_x2_net1 x1_x4_net1 VSS VSS nfet_06v0 L=1.0u W=5.0u
Mx1_x4_x2_XM19 x1_x4_x2_net8 x1_x4_net2 x1_x4_x2_net20 VSS nfet_06v0 L=1.0u W=5.0u
Mx1_x4_x2_XM20 x1_x4_x2_net20 x1_x4_net1 VSS VSS nfet_06v0 L=1.0u W=5.0u
Mx1_x4_x2_XM21_f1 x1_x4_x2_net6 x1_SY x1_x4_x2_net8 VSS nfet_06v0 L=1.0u W=10u
Mx1_x4_x2_XM21_f2 x1_x4_x2_net6 x1_SY x1_x4_x2_net8 VSS nfet_06v0 L=1.0u W=10u
Mx1_x4_x2_XM22_f1 x1_x4_x2_net3 x1_SX x1_x4_x2_net8 VSS nfet_06v0 L=1.0u W=10u
Mx1_x4_x2_XM22_f2 x1_x4_x2_net3 x1_SX x1_x4_x2_net8 VSS nfet_06v0 L=1.0u W=10u
Mx1_x4_x2_XM29_f1 x1_x4_x2_net9 x1_x4_net3 x1_x4_x2_net3 VDD pfet_06v0 L=1.0u W=10u
Mx1_x4_x2_XM29_f2 x1_x4_x2_net9 x1_x4_net3 x1_x4_x2_net3 VDD pfet_06v0 L=1.0u W=10u
Mx1_x4_x2_XM30_f1 x1_x4_x2_net12 x1_x4_net3 x1_x4_x2_net6 VDD pfet_06v0 L=1.0u W=10.0u
Mx1_x4_x2_XM30_f2 x1_x4_x2_net12 x1_x4_net3 x1_x4_x2_net6 VDD pfet_06v0 L=1.0u W=10.0u
Mx1_x4_x2_XM31_f1 x1_x4_x2_net3 x1_x4_x2_net9 VDD VDD pfet_06v0 L=1.0u W=20u
Mx1_x4_x2_XM31_f2 x1_x4_x2_net3 x1_x4_x2_net9 VDD VDD pfet_06v0 L=1.0u W=20u
Mx1_x4_x2_XM31_f3 x1_x4_x2_net3 x1_x4_x2_net9 VDD VDD pfet_06v0 L=1.0u W=20u
Mx1_x4_x2_XM31_f4 x1_x4_x2_net3 x1_x4_x2_net9 VDD VDD pfet_06v0 L=1.0u W=20u
Mx1_x4_x2_XM35_f1 x1_x4_x2_net6 x1_x4_x2_net9 VDD VDD pfet_06v0 L=1.0u W=20.0u
Mx1_x4_x2_XM35_f2 x1_x4_x2_net6 x1_x4_x2_net9 VDD VDD pfet_06v0 L=1.0u W=20.0u
Mx1_x4_x2_XM35_f3 x1_x4_x2_net6 x1_x4_x2_net9 VDD VDD pfet_06v0 L=1.0u W=20.0u
Mx1_x4_x2_XM35_f4 x1_x4_x2_net6 x1_x4_x2_net9 VDD VDD pfet_06v0 L=1.0u W=20.0u
Mx1_x4_x2_XM32 x1_x4_x2_net10 x1_x4_x2_net21 x1_x4_x2_net9 VDD pfet_06v0 L=1.0u W=5u
Mx1_x4_x2_XM33 x1_x4_x2_net22 x1_x4_x2_net21 x1_x4_x2_net12 VDD pfet_06v0 L=1.0u W=5.0u
Mx1_x4_x2_XM23_f1 x1_x4_x2_net10 x1_x4_net2 x1_x4_x2_net4 VSS nfet_06v0 L=1.0u W=5u
Mx1_x4_x2_XM23_f2 x1_x4_x2_net10 x1_x4_net2 x1_x4_x2_net4 VSS nfet_06v0 L=1.0u W=5u
Mx1_x4_x2_XM24_f1 x1_x4_x2_net22 x1_x4_net2 x1_x4_x2_net5 VSS nfet_06v0 L=1.0u W=5u
Mx1_x4_x2_XM24_f2 x1_x4_x2_net22 x1_x4_net2 x1_x4_x2_net5 VSS nfet_06v0 L=1.0u W=5u
Mx1_x4_x2_XM25_f1 x1_x4_x2_net4 x1_x4_x2_net10 VSS VSS nfet_06v0 L=1.0u W=10u
Mx1_x4_x2_XM25_f2 x1_x4_x2_net4 x1_x4_x2_net10 VSS VSS nfet_06v0 L=1.0u W=10u
Mx1_x4_x2_XM25_f3 x1_x4_x2_net4 x1_x4_x2_net10 VSS VSS nfet_06v0 L=1.0u W=10u
Mx1_x4_x2_XM25_f4 x1_x4_x2_net4 x1_x4_x2_net10 VSS VSS nfet_06v0 L=1.0u W=10u
Mx1_x4_x2_XM26_f1 x1_x4_x2_net5 x1_x4_x2_net10 VSS VSS nfet_06v0 L=1.0u W=10u
Mx1_x4_x2_XM26_f2 x1_x4_x2_net5 x1_x4_x2_net10 VSS VSS nfet_06v0 L=1.0u W=10u
Mx1_x4_x2_XM26_f3 x1_x4_x2_net5 x1_x4_x2_net10 VSS VSS nfet_06v0 L=1.0u W=10u
Mx1_x4_x2_XM26_f4 x1_x4_x2_net5 x1_x4_x2_net10 VSS VSS nfet_06v0 L=1.0u W=10u
Mx1_x4_x2_XM27 x1_x4_x2_net9 x1_x4_x2_net11 x1_x4_x2_net10 VSS nfet_06v0 L=1.0u W=2.5u
Mx1_x4_x2_XM28 x1_x4_x2_net12 x1_x4_x2_net11 x1_x4_x2_net22 VSS nfet_06v0 L=1.0u W=2.5u
Mx1_x4_x2_XM34 x1_x4_x2_net13 x1_x4_x2_net14 VDD VDD pfet_06v0 L=1.0u W=10.0u
Mx1_x4_x2_XM36 x1_x4_x2_net14 x1_x4_net3 x1_x4_x2_net13 VDD pfet_06v0 L=1.0u W=10.0u
Mx1_x4_x2_XM37 x1_x4_x2_net21 x1_x4_x2_net21 x1_x4_x2_net14 VDD pfet_06v0 L=1.0u W=10.0u
Mx1_x4_x2_XM38 x1_x4_x2_net21 x1_x4_net2 x1_x4_x2_net15 VSS nfet_06v0 L=1.0u W=5.0u
Mx1_x4_x2_XM39 x1_x4_x2_net15 x1_x4_net1 VSS VSS nfet_06v0 L=1.0u W=5.0u
Mx1_x4_x2_XM45 x1_x4_x2_net16 x1_x4_net4 VDD VDD pfet_06v0 L=1.0u W=10.0u
Mx1_x4_x2_XM46 x1_x4_x2_net11 x1_x4_net3 x1_x4_x2_net16 VDD pfet_06v0 L=1.0u W=10.0u
Mx1_x4_x2_XM40 x1_x4_x2_net11 x1_x4_x2_net11 x1_x4_x2_net18 VSS nfet_06v0 L=1.0u W=5.0u
Mx1_x4_x2_XM41 x1_x4_x2_net18 x1_x4_net2 x1_x4_x2_net17 VSS nfet_06v0 L=1.0u W=5.0u
Mx1_x4_x2_XM42 x1_x4_x2_net17 x1_x4_x2_net18 VSS VSS nfet_06v0 L=1.0u W=5.0u
Mx1_x4_x2_XM43_f1 x1_net1 x1_x4_x2_net12 VDD VDD pfet_06v0 L=1.0u W=30u
Mx1_x4_x2_XM43_f2 x1_net1 x1_x4_x2_net12 VDD VDD pfet_06v0 L=1.0u W=30u
Mx1_x4_x2_XM43_f3 x1_net1 x1_x4_x2_net12 VDD VDD pfet_06v0 L=1.0u W=30u
Mx1_x4_x2_XM44_f1 x1_net1 x1_x4_x2_net22 VSS VSS nfet_06v0 L=1.0u W=15u
Mx1_x4_x2_XM44_f2 x1_net1 x1_x4_x2_net22 VSS VSS nfet_06v0 L=1.0u W=15u
Mx1_x4_x2_XM44_f3 x1_net1 x1_x4_x2_net22 VSS VSS nfet_06v0 L=1.0u W=15u
Mx1_x5_x1_XM4 x1_x5_x1_net3 x1_x5_net4 VDD VDD pfet_06v0 L=1.0u W=10.0u
Mx1_x5_x1_XM5 x1_x5_net2 x1_x5_net3 x1_x5_x1_net3 VDD pfet_06v0 L=1.0u W=10.0u
Mx1_x5_x1_XM6 x1_x5_net2 x1_x5_net2 VSS VSS nfet_06v0 L=1.0u W=1.0u
Mx1_x5_x1_XM7 x1_x5_x1_net2 x1_x5_net4 VDD VDD pfet_06v0 L=1.0u W=10.0u
Mx1_x5_x1_XM8 x1_x5_net1 x1_x5_net3 x1_x5_x1_net2 VDD pfet_06v0 L=1.0u W=10.0u
Mx1_x5_x1_XM9 x1_x5_net1 x1_x5_net2 x1_x5_x1_net1 VSS nfet_06v0 L=1.0u W=5.0u
Mx1_x5_x1_XM10 x1_x5_x1_net1 x1_x5_net1 VSS VSS nfet_06v0 L=1.0u W=5.0u
Mx1_x5_x1_XM1 x1_x5_net3 x1_x5_net3 VDD VDD pfet_06v0 L=1.0u W=2u
Mx1_x5_x1_XM2 x1_x5_x1_net4 x1_x5_net4 VDD VDD pfet_06v0 L=1.0u W=10.0u
Mx1_x5_x1_XM3 x1_x5_net4 x1_x5_net3 x1_x5_x1_net4 VDD pfet_06v0 L=1.0u W=10.0u
Mx1_x5_x1_XM47 x1_x5_x1_net5 x1_x5_net3 VSS VSS nfet_06v0 L=1.0u W=1.0u
Mx1_x5_x1_XM48 x1_x5_x1_net6 x1_x5_net3 VSS VSS nfet_06v0 L=1.0u W=1.0u
Mx1_x5_x1_XM49 x1_x5_net3 x1_x5_net3 x1_x5_x1_net6 VSS nfet_06v0 L=1.0u W=1.0u
Mx1_x5_x1_XM50 x1_x5_net4 x1_x5_net3 x1_x5_x1_net5 VSS nfet_06v0 L=1.0u W=1.0u
Mx1_x5_x2_XM11 x1_x5_x2_net2 x1_x5_net4 VDD VDD pfet_06v0 L=1.0u W=10.0u
Mx1_x5_x2_XM12 x1_x5_x2_net7 x1_x5_net3 x1_x5_x2_net2 VDD pfet_06v0 L=1.0u W=10.0u
Mx1_x5_x2_XM13 x1_x5_x2_net19 x1_x5_net4 VDD VDD pfet_06v0 L=1.0u W=10.0u
Mx1_x5_x2_XM14 x1_x5_x2_net7 x1_x5_net3 x1_x5_x2_net19 VDD pfet_06v0 L=1.0u W=10.0u
Mx1_x5_x2_XM15_f1 x1_x5_x2_net5 x1_SZ x1_x5_x2_net7 VDD pfet_06v0 L=1.0u W=20.0u
Mx1_x5_x2_XM15_f2 x1_x5_x2_net5 x1_SZ x1_x5_x2_net7 VDD pfet_06v0 L=1.0u W=20.0u
Mx1_x5_x2_XM16_f1 x1_x5_x2_net4 x1_SX x1_x5_x2_net7 VDD pfet_06v0 L=1.0u W=20.0u
Mx1_x5_x2_XM16_f2 x1_x5_x2_net4 x1_SX x1_x5_x2_net7 VDD pfet_06v0 L=1.0u W=20.0u
Mx1_x5_x2_XM17 x1_x5_x2_net8 x1_x5_net2 x1_x5_x2_net1 VSS nfet_06v0 L=1.0u W=5.0u
Mx1_x5_x2_XM18 x1_x5_x2_net1 x1_x5_net1 VSS VSS nfet_06v0 L=1.0u W=5.0u
Mx1_x5_x2_XM19 x1_x5_x2_net8 x1_x5_net2 x1_x5_x2_net20 VSS nfet_06v0 L=1.0u W=5.0u
Mx1_x5_x2_XM20 x1_x5_x2_net20 x1_x5_net1 VSS VSS nfet_06v0 L=1.0u W=5.0u
Mx1_x5_x2_XM21_f1 x1_x5_x2_net6 x1_SZ x1_x5_x2_net8 VSS nfet_06v0 L=1.0u W=10u
Mx1_x5_x2_XM21_f2 x1_x5_x2_net6 x1_SZ x1_x5_x2_net8 VSS nfet_06v0 L=1.0u W=10u
Mx1_x5_x2_XM22_f1 x1_x5_x2_net3 x1_SX x1_x5_x2_net8 VSS nfet_06v0 L=1.0u W=10u
Mx1_x5_x2_XM22_f2 x1_x5_x2_net3 x1_SX x1_x5_x2_net8 VSS nfet_06v0 L=1.0u W=10u
Mx1_x5_x2_XM29_f1 x1_x5_x2_net9 x1_x5_net3 x1_x5_x2_net3 VDD pfet_06v0 L=1.0u W=10u
Mx1_x5_x2_XM29_f2 x1_x5_x2_net9 x1_x5_net3 x1_x5_x2_net3 VDD pfet_06v0 L=1.0u W=10u
Mx1_x5_x2_XM30_f1 x1_x5_x2_net12 x1_x5_net3 x1_x5_x2_net6 VDD pfet_06v0 L=1.0u W=10.0u
Mx1_x5_x2_XM30_f2 x1_x5_x2_net12 x1_x5_net3 x1_x5_x2_net6 VDD pfet_06v0 L=1.0u W=10.0u
Mx1_x5_x2_XM31_f1 x1_x5_x2_net3 x1_x5_x2_net9 VDD VDD pfet_06v0 L=1.0u W=20u
Mx1_x5_x2_XM31_f2 x1_x5_x2_net3 x1_x5_x2_net9 VDD VDD pfet_06v0 L=1.0u W=20u
Mx1_x5_x2_XM31_f3 x1_x5_x2_net3 x1_x5_x2_net9 VDD VDD pfet_06v0 L=1.0u W=20u
Mx1_x5_x2_XM31_f4 x1_x5_x2_net3 x1_x5_x2_net9 VDD VDD pfet_06v0 L=1.0u W=20u
Mx1_x5_x2_XM35_f1 x1_x5_x2_net6 x1_x5_x2_net9 VDD VDD pfet_06v0 L=1.0u W=20.0u
Mx1_x5_x2_XM35_f2 x1_x5_x2_net6 x1_x5_x2_net9 VDD VDD pfet_06v0 L=1.0u W=20.0u
Mx1_x5_x2_XM35_f3 x1_x5_x2_net6 x1_x5_x2_net9 VDD VDD pfet_06v0 L=1.0u W=20.0u
Mx1_x5_x2_XM35_f4 x1_x5_x2_net6 x1_x5_x2_net9 VDD VDD pfet_06v0 L=1.0u W=20.0u
Mx1_x5_x2_XM32 x1_x5_x2_net10 x1_x5_x2_net21 x1_x5_x2_net9 VDD pfet_06v0 L=1.0u W=5u
Mx1_x5_x2_XM33 x1_x5_x2_net22 x1_x5_x2_net21 x1_x5_x2_net12 VDD pfet_06v0 L=1.0u W=5.0u
Mx1_x5_x2_XM23_f1 x1_x5_x2_net10 x1_x5_net2 x1_x5_x2_net4 VSS nfet_06v0 L=1.0u W=5u
Mx1_x5_x2_XM23_f2 x1_x5_x2_net10 x1_x5_net2 x1_x5_x2_net4 VSS nfet_06v0 L=1.0u W=5u
Mx1_x5_x2_XM24_f1 x1_x5_x2_net22 x1_x5_net2 x1_x5_x2_net5 VSS nfet_06v0 L=1.0u W=5u
Mx1_x5_x2_XM24_f2 x1_x5_x2_net22 x1_x5_net2 x1_x5_x2_net5 VSS nfet_06v0 L=1.0u W=5u
Mx1_x5_x2_XM25_f1 x1_x5_x2_net4 x1_x5_x2_net10 VSS VSS nfet_06v0 L=1.0u W=10u
Mx1_x5_x2_XM25_f2 x1_x5_x2_net4 x1_x5_x2_net10 VSS VSS nfet_06v0 L=1.0u W=10u
Mx1_x5_x2_XM25_f3 x1_x5_x2_net4 x1_x5_x2_net10 VSS VSS nfet_06v0 L=1.0u W=10u
Mx1_x5_x2_XM25_f4 x1_x5_x2_net4 x1_x5_x2_net10 VSS VSS nfet_06v0 L=1.0u W=10u
Mx1_x5_x2_XM26_f1 x1_x5_x2_net5 x1_x5_x2_net10 VSS VSS nfet_06v0 L=1.0u W=10u
Mx1_x5_x2_XM26_f2 x1_x5_x2_net5 x1_x5_x2_net10 VSS VSS nfet_06v0 L=1.0u W=10u
Mx1_x5_x2_XM26_f3 x1_x5_x2_net5 x1_x5_x2_net10 VSS VSS nfet_06v0 L=1.0u W=10u
Mx1_x5_x2_XM26_f4 x1_x5_x2_net5 x1_x5_x2_net10 VSS VSS nfet_06v0 L=1.0u W=10u
Mx1_x5_x2_XM27 x1_x5_x2_net9 x1_x5_x2_net11 x1_x5_x2_net10 VSS nfet_06v0 L=1.0u W=2.5u
Mx1_x5_x2_XM28 x1_x5_x2_net12 x1_x5_x2_net11 x1_x5_x2_net22 VSS nfet_06v0 L=1.0u W=2.5u
Mx1_x5_x2_XM34 x1_x5_x2_net13 x1_x5_x2_net14 VDD VDD pfet_06v0 L=1.0u W=10.0u
Mx1_x5_x2_XM36 x1_x5_x2_net14 x1_x5_net3 x1_x5_x2_net13 VDD pfet_06v0 L=1.0u W=10.0u
Mx1_x5_x2_XM37 x1_x5_x2_net21 x1_x5_x2_net21 x1_x5_x2_net14 VDD pfet_06v0 L=1.0u W=10.0u
Mx1_x5_x2_XM38 x1_x5_x2_net21 x1_x5_net2 x1_x5_x2_net15 VSS nfet_06v0 L=1.0u W=5.0u
Mx1_x5_x2_XM39 x1_x5_x2_net15 x1_x5_net1 VSS VSS nfet_06v0 L=1.0u W=5.0u
Mx1_x5_x2_XM45 x1_x5_x2_net16 x1_x5_net4 VDD VDD pfet_06v0 L=1.0u W=10.0u
Mx1_x5_x2_XM46 x1_x5_x2_net11 x1_x5_net3 x1_x5_x2_net16 VDD pfet_06v0 L=1.0u W=10.0u
Mx1_x5_x2_XM40 x1_x5_x2_net11 x1_x5_x2_net11 x1_x5_x2_net18 VSS nfet_06v0 L=1.0u W=5.0u
Mx1_x5_x2_XM41 x1_x5_x2_net18 x1_x5_net2 x1_x5_x2_net17 VSS nfet_06v0 L=1.0u W=5.0u
Mx1_x5_x2_XM42 x1_x5_x2_net17 x1_x5_x2_net18 VSS VSS nfet_06v0 L=1.0u W=5.0u
Mx1_x5_x2_XM43_f1 x1_net2 x1_x5_x2_net12 VDD VDD pfet_06v0 L=1.0u W=30u
Mx1_x5_x2_XM43_f2 x1_net2 x1_x5_x2_net12 VDD VDD pfet_06v0 L=1.0u W=30u
Mx1_x5_x2_XM43_f3 x1_net2 x1_x5_x2_net12 VDD VDD pfet_06v0 L=1.0u W=30u
Mx1_x5_x2_XM44_f1 x1_net2 x1_x5_x2_net22 VSS VSS nfet_06v0 L=1.0u W=15u
Mx1_x5_x2_XM44_f2 x1_net2 x1_x5_x2_net22 VSS VSS nfet_06v0 L=1.0u W=15u
Mx1_x5_x2_XM44_f3 x1_net2 x1_x5_x2_net22 VSS VSS nfet_06v0 L=1.0u W=15u
Mx1_x6_x1_XM4 x1_x6_x1_net3 x1_x6_net4 VDD VDD pfet_06v0 L=1.0u W=10.0u
Mx1_x6_x1_XM5 x1_x6_net2 x1_x6_net3 x1_x6_x1_net3 VDD pfet_06v0 L=1.0u W=10.0u
Mx1_x6_x1_XM6 x1_x6_net2 x1_x6_net2 VSS VSS nfet_06v0 L=1.0u W=1.0u
Mx1_x6_x1_XM7 x1_x6_x1_net2 x1_x6_net4 VDD VDD pfet_06v0 L=1.0u W=10.0u
Mx1_x6_x1_XM8 x1_x6_net1 x1_x6_net3 x1_x6_x1_net2 VDD pfet_06v0 L=1.0u W=10.0u
Mx1_x6_x1_XM9 x1_x6_net1 x1_x6_net2 x1_x6_x1_net1 VSS nfet_06v0 L=1.0u W=5.0u
Mx1_x6_x1_XM10 x1_x6_x1_net1 x1_x6_net1 VSS VSS nfet_06v0 L=1.0u W=5.0u
Mx1_x6_x1_XM1 x1_x6_net3 x1_x6_net3 VDD VDD pfet_06v0 L=1.0u W=2u
Mx1_x6_x1_XM2 x1_x6_x1_net4 x1_x6_net4 VDD VDD pfet_06v0 L=1.0u W=10.0u
Mx1_x6_x1_XM3 x1_x6_net4 x1_x6_net3 x1_x6_x1_net4 VDD pfet_06v0 L=1.0u W=10.0u
Mx1_x6_x1_XM47 x1_x6_x1_net5 x1_x6_net3 VSS VSS nfet_06v0 L=1.0u W=1.0u
Mx1_x6_x1_XM48 x1_x6_x1_net6 x1_x6_net3 VSS VSS nfet_06v0 L=1.0u W=1.0u
Mx1_x6_x1_XM49 x1_x6_net3 x1_x6_net3 x1_x6_x1_net6 VSS nfet_06v0 L=1.0u W=1.0u
Mx1_x6_x1_XM50 x1_x6_net4 x1_x6_net3 x1_x6_x1_net5 VSS nfet_06v0 L=1.0u W=1.0u
Mx1_x6_x2_XM11 x1_x6_x2_net2 x1_x6_net4 VDD VDD pfet_06v0 L=1.0u W=10.0u
Mx1_x6_x2_XM12 x1_x6_x2_net7 x1_x6_net3 x1_x6_x2_net2 VDD pfet_06v0 L=1.0u W=10.0u
Mx1_x6_x2_XM13 x1_x6_x2_net19 x1_x6_net4 VDD VDD pfet_06v0 L=1.0u W=10.0u
Mx1_x6_x2_XM14 x1_x6_x2_net7 x1_x6_net3 x1_x6_x2_net19 VDD pfet_06v0 L=1.0u W=10.0u
Mx1_x6_x2_XM15_f1 x1_x6_x2_net5 x1_SZ x1_x6_x2_net7 VDD pfet_06v0 L=1.0u W=20.0u
Mx1_x6_x2_XM15_f2 x1_x6_x2_net5 x1_SZ x1_x6_x2_net7 VDD pfet_06v0 L=1.0u W=20.0u
Mx1_x6_x2_XM16_f1 x1_x6_x2_net4 x1_SY x1_x6_x2_net7 VDD pfet_06v0 L=1.0u W=20.0u
Mx1_x6_x2_XM16_f2 x1_x6_x2_net4 x1_SY x1_x6_x2_net7 VDD pfet_06v0 L=1.0u W=20.0u
Mx1_x6_x2_XM17 x1_x6_x2_net8 x1_x6_net2 x1_x6_x2_net1 VSS nfet_06v0 L=1.0u W=5.0u
Mx1_x6_x2_XM18 x1_x6_x2_net1 x1_x6_net1 VSS VSS nfet_06v0 L=1.0u W=5.0u
Mx1_x6_x2_XM19 x1_x6_x2_net8 x1_x6_net2 x1_x6_x2_net20 VSS nfet_06v0 L=1.0u W=5.0u
Mx1_x6_x2_XM20 x1_x6_x2_net20 x1_x6_net1 VSS VSS nfet_06v0 L=1.0u W=5.0u
Mx1_x6_x2_XM21_f1 x1_x6_x2_net6 x1_SZ x1_x6_x2_net8 VSS nfet_06v0 L=1.0u W=10u
Mx1_x6_x2_XM21_f2 x1_x6_x2_net6 x1_SZ x1_x6_x2_net8 VSS nfet_06v0 L=1.0u W=10u
Mx1_x6_x2_XM22_f1 x1_x6_x2_net3 x1_SY x1_x6_x2_net8 VSS nfet_06v0 L=1.0u W=10u
Mx1_x6_x2_XM22_f2 x1_x6_x2_net3 x1_SY x1_x6_x2_net8 VSS nfet_06v0 L=1.0u W=10u
Mx1_x6_x2_XM29_f1 x1_x6_x2_net9 x1_x6_net3 x1_x6_x2_net3 VDD pfet_06v0 L=1.0u W=10u
Mx1_x6_x2_XM29_f2 x1_x6_x2_net9 x1_x6_net3 x1_x6_x2_net3 VDD pfet_06v0 L=1.0u W=10u
Mx1_x6_x2_XM30_f1 x1_x6_x2_net12 x1_x6_net3 x1_x6_x2_net6 VDD pfet_06v0 L=1.0u W=10.0u
Mx1_x6_x2_XM30_f2 x1_x6_x2_net12 x1_x6_net3 x1_x6_x2_net6 VDD pfet_06v0 L=1.0u W=10.0u
Mx1_x6_x2_XM31_f1 x1_x6_x2_net3 x1_x6_x2_net9 VDD VDD pfet_06v0 L=1.0u W=20u
Mx1_x6_x2_XM31_f2 x1_x6_x2_net3 x1_x6_x2_net9 VDD VDD pfet_06v0 L=1.0u W=20u
Mx1_x6_x2_XM31_f3 x1_x6_x2_net3 x1_x6_x2_net9 VDD VDD pfet_06v0 L=1.0u W=20u
Mx1_x6_x2_XM31_f4 x1_x6_x2_net3 x1_x6_x2_net9 VDD VDD pfet_06v0 L=1.0u W=20u
Mx1_x6_x2_XM35_f1 x1_x6_x2_net6 x1_x6_x2_net9 VDD VDD pfet_06v0 L=1.0u W=20.0u
Mx1_x6_x2_XM35_f2 x1_x6_x2_net6 x1_x6_x2_net9 VDD VDD pfet_06v0 L=1.0u W=20.0u
Mx1_x6_x2_XM35_f3 x1_x6_x2_net6 x1_x6_x2_net9 VDD VDD pfet_06v0 L=1.0u W=20.0u
Mx1_x6_x2_XM35_f4 x1_x6_x2_net6 x1_x6_x2_net9 VDD VDD pfet_06v0 L=1.0u W=20.0u
Mx1_x6_x2_XM32 x1_x6_x2_net10 x1_x6_x2_net21 x1_x6_x2_net9 VDD pfet_06v0 L=1.0u W=5u
Mx1_x6_x2_XM33 x1_x6_x2_net22 x1_x6_x2_net21 x1_x6_x2_net12 VDD pfet_06v0 L=1.0u W=5.0u
Mx1_x6_x2_XM23_f1 x1_x6_x2_net10 x1_x6_net2 x1_x6_x2_net4 VSS nfet_06v0 L=1.0u W=5u
Mx1_x6_x2_XM23_f2 x1_x6_x2_net10 x1_x6_net2 x1_x6_x2_net4 VSS nfet_06v0 L=1.0u W=5u
Mx1_x6_x2_XM24_f1 x1_x6_x2_net22 x1_x6_net2 x1_x6_x2_net5 VSS nfet_06v0 L=1.0u W=5u
Mx1_x6_x2_XM24_f2 x1_x6_x2_net22 x1_x6_net2 x1_x6_x2_net5 VSS nfet_06v0 L=1.0u W=5u
Mx1_x6_x2_XM25_f1 x1_x6_x2_net4 x1_x6_x2_net10 VSS VSS nfet_06v0 L=1.0u W=10u
Mx1_x6_x2_XM25_f2 x1_x6_x2_net4 x1_x6_x2_net10 VSS VSS nfet_06v0 L=1.0u W=10u
Mx1_x6_x2_XM25_f3 x1_x6_x2_net4 x1_x6_x2_net10 VSS VSS nfet_06v0 L=1.0u W=10u
Mx1_x6_x2_XM25_f4 x1_x6_x2_net4 x1_x6_x2_net10 VSS VSS nfet_06v0 L=1.0u W=10u
Mx1_x6_x2_XM26_f1 x1_x6_x2_net5 x1_x6_x2_net10 VSS VSS nfet_06v0 L=1.0u W=10u
Mx1_x6_x2_XM26_f2 x1_x6_x2_net5 x1_x6_x2_net10 VSS VSS nfet_06v0 L=1.0u W=10u
Mx1_x6_x2_XM26_f3 x1_x6_x2_net5 x1_x6_x2_net10 VSS VSS nfet_06v0 L=1.0u W=10u
Mx1_x6_x2_XM26_f4 x1_x6_x2_net5 x1_x6_x2_net10 VSS VSS nfet_06v0 L=1.0u W=10u
Mx1_x6_x2_XM27 x1_x6_x2_net9 x1_x6_x2_net11 x1_x6_x2_net10 VSS nfet_06v0 L=1.0u W=2.5u
Mx1_x6_x2_XM28 x1_x6_x2_net12 x1_x6_x2_net11 x1_x6_x2_net22 VSS nfet_06v0 L=1.0u W=2.5u
Mx1_x6_x2_XM34 x1_x6_x2_net13 x1_x6_x2_net14 VDD VDD pfet_06v0 L=1.0u W=10.0u
Mx1_x6_x2_XM36 x1_x6_x2_net14 x1_x6_net3 x1_x6_x2_net13 VDD pfet_06v0 L=1.0u W=10.0u
Mx1_x6_x2_XM37 x1_x6_x2_net21 x1_x6_x2_net21 x1_x6_x2_net14 VDD pfet_06v0 L=1.0u W=10.0u
Mx1_x6_x2_XM38 x1_x6_x2_net21 x1_x6_net2 x1_x6_x2_net15 VSS nfet_06v0 L=1.0u W=5.0u
Mx1_x6_x2_XM39 x1_x6_x2_net15 x1_x6_net1 VSS VSS nfet_06v0 L=1.0u W=5.0u
Mx1_x6_x2_XM45 x1_x6_x2_net16 x1_x6_net4 VDD VDD pfet_06v0 L=1.0u W=10.0u
Mx1_x6_x2_XM46 x1_x6_x2_net11 x1_x6_net3 x1_x6_x2_net16 VDD pfet_06v0 L=1.0u W=10.0u
Mx1_x6_x2_XM40 x1_x6_x2_net11 x1_x6_x2_net11 x1_x6_x2_net18 VSS nfet_06v0 L=1.0u W=5.0u
Mx1_x6_x2_XM41 x1_x6_x2_net18 x1_x6_net2 x1_x6_x2_net17 VSS nfet_06v0 L=1.0u W=5.0u
Mx1_x6_x2_XM42 x1_x6_x2_net17 x1_x6_x2_net18 VSS VSS nfet_06v0 L=1.0u W=5.0u
Mx1_x6_x2_XM43_f1 x1_net3 x1_x6_x2_net12 VDD VDD pfet_06v0 L=1.0u W=30u
Mx1_x6_x2_XM43_f2 x1_net3 x1_x6_x2_net12 VDD VDD pfet_06v0 L=1.0u W=30u
Mx1_x6_x2_XM43_f3 x1_net3 x1_x6_x2_net12 VDD VDD pfet_06v0 L=1.0u W=30u
Mx1_x6_x2_XM44_f1 x1_net3 x1_x6_x2_net22 VSS VSS nfet_06v0 L=1.0u W=15u
Mx1_x6_x2_XM44_f2 x1_net3 x1_x6_x2_net22 VSS VSS nfet_06v0 L=1.0u W=15u
Mx1_x6_x2_XM44_f3 x1_net3 x1_x6_x2_net22 VSS VSS nfet_06v0 L=1.0u W=15u
Mx1_x7_x1_XM4 x1_x7_x1_net1 x1_net3 Z1 VDD pfet_06v0 L=1.0u W=3.0u
Mx1_x7_x1_XM5 VDD x1_net2 x1_x7_x1_net1 VDD pfet_06v0 L=1.0u W=3.0u
Mx1_x7_x1_XM7 VSS x1_net3 Z1 VSS nfet_06v0 L=1u W=1u
Mx1_x7_x1_XM1 VSS x1_net2 Z1 VSS nfet_06v0 L=1u W=1u
Mx1_x7_x2_x2_XM4 x1_x7_x2_net1 x1_net1 VDD VDD pfet_06v0 L=1.0u W=3.0u
Mx1_x7_x2_x2_XM5 VSS x1_net1 x1_x7_x2_net1 VSS nfet_06v0 L=1u W=1u
Mx1_x7_x2_x3_XM4 Y1 x1_x7_x2_x3_net1 VDD VDD pfet_06v0 L=1.0u W=3.0u
Mx1_x7_x2_x3_XM5 VSS x1_x7_x2_x3_net1 Y1 VSS nfet_06v0 L=1u W=1u
Mx1_x7_x2_x3_XM2 VDD x1_net3 x1_x7_x2_x3_net1 VDD pfet_06v0 L=1.0u W=3.0u
Mx1_x7_x2_x3_XM1 VDD x1_x7_x2_net1 x1_x7_x2_x3_net1 VDD pfet_06v0 L=1.0u W=3.0u
Mx1_x7_x2_x3_XM3 VSS x1_net3 x1_x7_x2_x3_net2 VSS nfet_06v0 L=1u W=1u
Mx1_x7_x2_x3_XM6 x1_x7_x2_x3_net2 x1_x7_x2_net1 x1_x7_x2_x3_net1 VSS nfet_06v0 L=1u W=1u
Mx1_x7_x3_x2_XM4 X1 x1_x7_x3_x2_net1 VDD VDD pfet_06v0 L=1.0u W=3.0u
Mx1_x7_x3_x2_XM5 VSS x1_x7_x3_x2_net1 X1 VSS nfet_06v0 L=1u W=1u
Mx1_x7_x3_x2_XM2 VDD x1_net1 x1_x7_x3_x2_net1 VDD pfet_06v0 L=1.0u W=3.0u
Mx1_x7_x3_x2_XM1 VDD x1_net2 x1_x7_x3_x2_net1 VDD pfet_06v0 L=1.0u W=3.0u
Mx1_x7_x3_x2_XM3 VSS x1_net1 x1_x7_x3_x2_net2 VSS nfet_06v0 L=1u W=1u
Mx1_x7_x3_x2_XM6 x1_x7_x3_x2_net2 x1_net2 x1_x7_x3_x2_net1 VSS nfet_06v0 L=1u W=1u
Mx2_x1_XM11 x2_x1_net5 x2_x1_net1 VDD VDD pfet_06v0 L=1.0u W=10.0u
Mx2_x1_XM12 x2_x1_net11 x2_x1_net6 x2_x1_net5 VDD pfet_06v0 L=1.0u W=10.0u
Mx2_x1_XM13 x2_x1_net23 x2_x1_net1 VDD VDD pfet_06v0 L=1.0u W=10.0u
Mx2_x1_XM14 x2_x1_net11 x2_x1_net6 x2_x1_net23 VDD pfet_06v0 L=1.0u W=10.0u
Mx2_x1_XM15 x2_x1_net9 S1P x2_x1_net11 VDD pfet_06v0 L=1.0u W=10.0u
Mx2_x1_XM16 x2_x1_net8 S1N x2_x1_net11 VDD pfet_06v0 L=1.0u W=10.0u
Mx2_x1_XM17 x2_x1_net12 x2_x1_net4 x2_x1_net2 VSS nfet_06v0 L=1.0u W=5.0u
Mx2_x1_XM18 x2_x1_net2 x2_x1_net3 VSS VSS nfet_06v0 L=1.0u W=5.0u
Mx2_x1_XM19 x2_x1_net12 x2_x1_net4 x2_x1_net24 VSS nfet_06v0 L=1.0u W=5.0u
Mx2_x1_XM20 x2_x1_net24 x2_x1_net3 VSS VSS nfet_06v0 L=1.0u W=5.0u
Mx2_x1_XM21 x2_x1_net10 S1P x2_x1_net12 VSS nfet_06v0 L=1.0u W=5u
Mx2_x1_XM22 x2_x1_net7 S1N x2_x1_net12 VSS nfet_06v0 L=1.0u W=5u
Mx2_x1_XM29 x2_x1_net13 x2_x1_net6 x2_x1_net7 VDD pfet_06v0 L=1.0u W=5u
Mx2_x1_XM30 x2_x1_net16 x2_x1_net6 x2_x1_net10 VDD pfet_06v0 L=1.0u W=5u
Mx2_x1_XM31 x2_x1_net7 x2_x1_net13 VDD VDD pfet_06v0 L=1.0u W=5u
Mx2_x1_XM35 x2_x1_net10 x2_x1_net13 VDD VDD pfet_06v0 L=1.0u W=5u
Mx2_x1_XM32 x2_x1_net14 x2_x1_net25 x2_x1_net13 VDD pfet_06v0 L=1.0u W=5.0u
Mx2_x1_XM33 x2_x1_net26 x2_x1_net25 x2_x1_net16 VDD pfet_06v0 L=1.0u W=5.0u
Mx2_x1_XM23 x2_x1_net14 x2_x1_net4 x2_x1_net8 VSS nfet_06v0 L=1.0u W=2.5u
Mx2_x1_XM24 x2_x1_net26 x2_x1_net4 x2_x1_net9 VSS nfet_06v0 L=1.0u W=2.5u
Mx2_x1_XM25 x2_x1_net8 x2_x1_net14 VSS VSS nfet_06v0 L=1.0u W=2.5u
Mx2_x1_XM26 x2_x1_net9 x2_x1_net14 VSS VSS nfet_06v0 L=1.0u W=2.5u
Mx2_x1_XM27 x2_x1_net13 x2_x1_net15 x2_x1_net14 VSS nfet_06v0 L=1.0u W=2.5u
Mx2_x1_XM28 x2_x1_net16 x2_x1_net15 x2_x1_net26 VSS nfet_06v0 L=1.0u W=2.5u
Mx2_x1_XM34 x2_x1_net17 x2_x1_net18 VDD VDD pfet_06v0 L=1.0u W=10.0u
Mx2_x1_XM36 x2_x1_net18 x2_x1_net6 x2_x1_net17 VDD pfet_06v0 L=1.0u W=10.0u
Mx2_x1_XM37 x2_x1_net25 x2_x1_net25 x2_x1_net18 VDD pfet_06v0 L=1.0u W=10.0u
Mx2_x1_XM38 x2_x1_net25 x2_x1_net4 x2_x1_net19 VSS nfet_06v0 L=1.0u W=5.0u
Mx2_x1_XM39 x2_x1_net19 x2_x1_net3 VSS VSS nfet_06v0 L=1.0u W=5.0u
Mx2_x1_XM45 x2_x1_net20 x2_x1_net1 VDD VDD pfet_06v0 L=1.0u W=10.0u
Mx2_x1_XM46 x2_x1_net15 x2_x1_net6 x2_x1_net20 VDD pfet_06v0 L=1.0u W=10.0u
Mx2_x1_XM40 x2_x1_net15 x2_x1_net15 x2_x1_net22 VSS nfet_06v0 L=1.0u W=5.0u
Mx2_x1_XM41 x2_x1_net22 x2_x1_net4 x2_x1_net21 VSS nfet_06v0 L=1.0u W=5.0u
Mx2_x1_XM42 x2_x1_net21 x2_x1_net22 VSS VSS nfet_06v0 L=1.0u W=5.0u
Mx2_x1_XM43 x2_SX x2_x1_net16 VDD VDD pfet_06v0 L=20.0u W=0.7u
Mx2_x1_XM44 x2_SX x2_x1_net26 VSS VSS nfet_06v0 L=1.0u W=1.0u
Mx2_x1_XM4 x2_x1_net29 x2_x1_net1 VDD VDD pfet_06v0 L=1.0u W=10.0u
Mx2_x1_XM5 x2_x1_net4 x2_x1_net6 x2_x1_net29 VDD pfet_06v0 L=1.0u W=10.0u
Mx2_x1_XM6 x2_x1_net4 x2_x1_net4 VSS VSS nfet_06v0 L=1.0u W=1.0u
Mx2_x1_XM7 x2_x1_net28 x2_x1_net1 VDD VDD pfet_06v0 L=1.0u W=10.0u
Mx2_x1_XM8 x2_x1_net3 x2_x1_net6 x2_x1_net28 VDD pfet_06v0 L=1.0u W=10.0u
Mx2_x1_XM9 x2_x1_net3 x2_x1_net4 x2_x1_net27 VSS nfet_06v0 L=1.0u W=5.0u
Mx2_x1_XM10 x2_x1_net27 x2_x1_net3 VSS VSS nfet_06v0 L=1.0u W=5.0u
Mx2_x1_XM1 x2_x1_net6 x2_x1_net6 VDD VDD pfet_06v0 L=1.0u W=2u
Mx2_x1_XM2 x2_x1_net30 x2_x1_net1 VDD VDD pfet_06v0 L=1.0u W=10.0u
Mx2_x1_XM3 x2_x1_net1 x2_x1_net6 x2_x1_net30 VDD pfet_06v0 L=1.0u W=10.0u
Mx2_x1_XM47 x2_x1_net31 x2_x1_net6 VSS VSS nfet_06v0 L=1.0u W=1.0u
Mx2_x1_XM48 x2_x1_net32 x2_x1_net6 VSS VSS nfet_06v0 L=1.0u W=1.0u
Mx2_x1_XM49 x2_x1_net6 x2_x1_net6 x2_x1_net32 VSS nfet_06v0 L=1.0u W=1.0u
Mx2_x1_XM50 x2_x1_net1 x2_x1_net6 x2_x1_net31 VSS nfet_06v0 L=1.0u W=1.0u
Mx2_x2_XM11 x2_x2_net5 x2_x2_net1 VDD VDD pfet_06v0 L=1.0u W=10.0u
Mx2_x2_XM12 x2_x2_net11 x2_x2_net6 x2_x2_net5 VDD pfet_06v0 L=1.0u W=10.0u
Mx2_x2_XM13 x2_x2_net23 x2_x2_net1 VDD VDD pfet_06v0 L=1.0u W=10.0u
Mx2_x2_XM14 x2_x2_net11 x2_x2_net6 x2_x2_net23 VDD pfet_06v0 L=1.0u W=10.0u
Mx2_x2_XM15 x2_x2_net9 S2P x2_x2_net11 VDD pfet_06v0 L=1.0u W=10.0u
Mx2_x2_XM16 x2_x2_net8 S2N x2_x2_net11 VDD pfet_06v0 L=1.0u W=10.0u
Mx2_x2_XM17 x2_x2_net12 x2_x2_net4 x2_x2_net2 VSS nfet_06v0 L=1.0u W=5.0u
Mx2_x2_XM18 x2_x2_net2 x2_x2_net3 VSS VSS nfet_06v0 L=1.0u W=5.0u
Mx2_x2_XM19 x2_x2_net12 x2_x2_net4 x2_x2_net24 VSS nfet_06v0 L=1.0u W=5.0u
Mx2_x2_XM20 x2_x2_net24 x2_x2_net3 VSS VSS nfet_06v0 L=1.0u W=5.0u
Mx2_x2_XM21 x2_x2_net10 S2P x2_x2_net12 VSS nfet_06v0 L=1.0u W=5u
Mx2_x2_XM22 x2_x2_net7 S2N x2_x2_net12 VSS nfet_06v0 L=1.0u W=5u
Mx2_x2_XM29 x2_x2_net13 x2_x2_net6 x2_x2_net7 VDD pfet_06v0 L=1.0u W=5u
Mx2_x2_XM30 x2_x2_net16 x2_x2_net6 x2_x2_net10 VDD pfet_06v0 L=1.0u W=5u
Mx2_x2_XM31 x2_x2_net7 x2_x2_net13 VDD VDD pfet_06v0 L=1.0u W=5u
Mx2_x2_XM35 x2_x2_net10 x2_x2_net13 VDD VDD pfet_06v0 L=1.0u W=5u
Mx2_x2_XM32 x2_x2_net14 x2_x2_net25 x2_x2_net13 VDD pfet_06v0 L=1.0u W=5.0u
Mx2_x2_XM33 x2_x2_net26 x2_x2_net25 x2_x2_net16 VDD pfet_06v0 L=1.0u W=5.0u
Mx2_x2_XM23 x2_x2_net14 x2_x2_net4 x2_x2_net8 VSS nfet_06v0 L=1.0u W=2.5u
Mx2_x2_XM24 x2_x2_net26 x2_x2_net4 x2_x2_net9 VSS nfet_06v0 L=1.0u W=2.5u
Mx2_x2_XM25 x2_x2_net8 x2_x2_net14 VSS VSS nfet_06v0 L=1.0u W=2.5u
Mx2_x2_XM26 x2_x2_net9 x2_x2_net14 VSS VSS nfet_06v0 L=1.0u W=2.5u
Mx2_x2_XM27 x2_x2_net13 x2_x2_net15 x2_x2_net14 VSS nfet_06v0 L=1.0u W=2.5u
Mx2_x2_XM28 x2_x2_net16 x2_x2_net15 x2_x2_net26 VSS nfet_06v0 L=1.0u W=2.5u
Mx2_x2_XM34 x2_x2_net17 x2_x2_net18 VDD VDD pfet_06v0 L=1.0u W=10.0u
Mx2_x2_XM36 x2_x2_net18 x2_x2_net6 x2_x2_net17 VDD pfet_06v0 L=1.0u W=10.0u
Mx2_x2_XM37 x2_x2_net25 x2_x2_net25 x2_x2_net18 VDD pfet_06v0 L=1.0u W=10.0u
Mx2_x2_XM38 x2_x2_net25 x2_x2_net4 x2_x2_net19 VSS nfet_06v0 L=1.0u W=5.0u
Mx2_x2_XM39 x2_x2_net19 x2_x2_net3 VSS VSS nfet_06v0 L=1.0u W=5.0u
Mx2_x2_XM45 x2_x2_net20 x2_x2_net1 VDD VDD pfet_06v0 L=1.0u W=10.0u
Mx2_x2_XM46 x2_x2_net15 x2_x2_net6 x2_x2_net20 VDD pfet_06v0 L=1.0u W=10.0u
Mx2_x2_XM40 x2_x2_net15 x2_x2_net15 x2_x2_net22 VSS nfet_06v0 L=1.0u W=5.0u
Mx2_x2_XM41 x2_x2_net22 x2_x2_net4 x2_x2_net21 VSS nfet_06v0 L=1.0u W=5.0u
Mx2_x2_XM42 x2_x2_net21 x2_x2_net22 VSS VSS nfet_06v0 L=1.0u W=5.0u
Mx2_x2_XM43 x2_SY x2_x2_net16 VDD VDD pfet_06v0 L=20.0u W=0.7u
Mx2_x2_XM44 x2_SY x2_x2_net26 VSS VSS nfet_06v0 L=1.0u W=1.0u
Mx2_x2_XM4 x2_x2_net29 x2_x2_net1 VDD VDD pfet_06v0 L=1.0u W=10.0u
Mx2_x2_XM5 x2_x2_net4 x2_x2_net6 x2_x2_net29 VDD pfet_06v0 L=1.0u W=10.0u
Mx2_x2_XM6 x2_x2_net4 x2_x2_net4 VSS VSS nfet_06v0 L=1.0u W=1.0u
Mx2_x2_XM7 x2_x2_net28 x2_x2_net1 VDD VDD pfet_06v0 L=1.0u W=10.0u
Mx2_x2_XM8 x2_x2_net3 x2_x2_net6 x2_x2_net28 VDD pfet_06v0 L=1.0u W=10.0u
Mx2_x2_XM9 x2_x2_net3 x2_x2_net4 x2_x2_net27 VSS nfet_06v0 L=1.0u W=5.0u
Mx2_x2_XM10 x2_x2_net27 x2_x2_net3 VSS VSS nfet_06v0 L=1.0u W=5.0u
Mx2_x2_XM1 x2_x2_net6 x2_x2_net6 VDD VDD pfet_06v0 L=1.0u W=2u
Mx2_x2_XM2 x2_x2_net30 x2_x2_net1 VDD VDD pfet_06v0 L=1.0u W=10.0u
Mx2_x2_XM3 x2_x2_net1 x2_x2_net6 x2_x2_net30 VDD pfet_06v0 L=1.0u W=10.0u
Mx2_x2_XM47 x2_x2_net31 x2_x2_net6 VSS VSS nfet_06v0 L=1.0u W=1.0u
Mx2_x2_XM48 x2_x2_net32 x2_x2_net6 VSS VSS nfet_06v0 L=1.0u W=1.0u
Mx2_x2_XM49 x2_x2_net6 x2_x2_net6 x2_x2_net32 VSS nfet_06v0 L=1.0u W=1.0u
Mx2_x2_XM50 x2_x2_net1 x2_x2_net6 x2_x2_net31 VSS nfet_06v0 L=1.0u W=1.0u
Mx2_x3_XM11 x2_x3_net5 x2_x3_net1 VDD VDD pfet_06v0 L=1.0u W=10.0u
Mx2_x3_XM12 x2_x3_net11 x2_x3_net6 x2_x3_net5 VDD pfet_06v0 L=1.0u W=10.0u
Mx2_x3_XM13 x2_x3_net23 x2_x3_net1 VDD VDD pfet_06v0 L=1.0u W=10.0u
Mx2_x3_XM14 x2_x3_net11 x2_x3_net6 x2_x3_net23 VDD pfet_06v0 L=1.0u W=10.0u
Mx2_x3_XM15 x2_x3_net9 S4P x2_x3_net11 VDD pfet_06v0 L=1.0u W=10.0u
Mx2_x3_XM16 x2_x3_net8 S4N x2_x3_net11 VDD pfet_06v0 L=1.0u W=10.0u
Mx2_x3_XM17 x2_x3_net12 x2_x3_net4 x2_x3_net2 VSS nfet_06v0 L=1.0u W=5.0u
Mx2_x3_XM18 x2_x3_net2 x2_x3_net3 VSS VSS nfet_06v0 L=1.0u W=5.0u
Mx2_x3_XM19 x2_x3_net12 x2_x3_net4 x2_x3_net24 VSS nfet_06v0 L=1.0u W=5.0u
Mx2_x3_XM20 x2_x3_net24 x2_x3_net3 VSS VSS nfet_06v0 L=1.0u W=5.0u
Mx2_x3_XM21 x2_x3_net10 S4P x2_x3_net12 VSS nfet_06v0 L=1.0u W=5u
Mx2_x3_XM22 x2_x3_net7 S4N x2_x3_net12 VSS nfet_06v0 L=1.0u W=5u
Mx2_x3_XM29 x2_x3_net13 x2_x3_net6 x2_x3_net7 VDD pfet_06v0 L=1.0u W=5u
Mx2_x3_XM30 x2_x3_net16 x2_x3_net6 x2_x3_net10 VDD pfet_06v0 L=1.0u W=5u
Mx2_x3_XM31 x2_x3_net7 x2_x3_net13 VDD VDD pfet_06v0 L=1.0u W=5u
Mx2_x3_XM35 x2_x3_net10 x2_x3_net13 VDD VDD pfet_06v0 L=1.0u W=5u
Mx2_x3_XM32 x2_x3_net14 x2_x3_net25 x2_x3_net13 VDD pfet_06v0 L=1.0u W=5.0u
Mx2_x3_XM33 x2_x3_net26 x2_x3_net25 x2_x3_net16 VDD pfet_06v0 L=1.0u W=5.0u
Mx2_x3_XM23 x2_x3_net14 x2_x3_net4 x2_x3_net8 VSS nfet_06v0 L=1.0u W=2.5u
Mx2_x3_XM24 x2_x3_net26 x2_x3_net4 x2_x3_net9 VSS nfet_06v0 L=1.0u W=2.5u
Mx2_x3_XM25 x2_x3_net8 x2_x3_net14 VSS VSS nfet_06v0 L=1.0u W=2.5u
Mx2_x3_XM26 x2_x3_net9 x2_x3_net14 VSS VSS nfet_06v0 L=1.0u W=2.5u
Mx2_x3_XM27 x2_x3_net13 x2_x3_net15 x2_x3_net14 VSS nfet_06v0 L=1.0u W=2.5u
Mx2_x3_XM28 x2_x3_net16 x2_x3_net15 x2_x3_net26 VSS nfet_06v0 L=1.0u W=2.5u
Mx2_x3_XM34 x2_x3_net17 x2_x3_net18 VDD VDD pfet_06v0 L=1.0u W=10.0u
Mx2_x3_XM36 x2_x3_net18 x2_x3_net6 x2_x3_net17 VDD pfet_06v0 L=1.0u W=10.0u
Mx2_x3_XM37 x2_x3_net25 x2_x3_net25 x2_x3_net18 VDD pfet_06v0 L=1.0u W=10.0u
Mx2_x3_XM38 x2_x3_net25 x2_x3_net4 x2_x3_net19 VSS nfet_06v0 L=1.0u W=5.0u
Mx2_x3_XM39 x2_x3_net19 x2_x3_net3 VSS VSS nfet_06v0 L=1.0u W=5.0u
Mx2_x3_XM45 x2_x3_net20 x2_x3_net1 VDD VDD pfet_06v0 L=1.0u W=10.0u
Mx2_x3_XM46 x2_x3_net15 x2_x3_net6 x2_x3_net20 VDD pfet_06v0 L=1.0u W=10.0u
Mx2_x3_XM40 x2_x3_net15 x2_x3_net15 x2_x3_net22 VSS nfet_06v0 L=1.0u W=5.0u
Mx2_x3_XM41 x2_x3_net22 x2_x3_net4 x2_x3_net21 VSS nfet_06v0 L=1.0u W=5.0u
Mx2_x3_XM42 x2_x3_net21 x2_x3_net22 VSS VSS nfet_06v0 L=1.0u W=5.0u
Mx2_x3_XM43 x2_SZ x2_x3_net16 VDD VDD pfet_06v0 L=20.0u W=0.7u
Mx2_x3_XM44 x2_SZ x2_x3_net26 VSS VSS nfet_06v0 L=1.0u W=1.0u
Mx2_x3_XM4 x2_x3_net29 x2_x3_net1 VDD VDD pfet_06v0 L=1.0u W=10.0u
Mx2_x3_XM5 x2_x3_net4 x2_x3_net6 x2_x3_net29 VDD pfet_06v0 L=1.0u W=10.0u
Mx2_x3_XM6 x2_x3_net4 x2_x3_net4 VSS VSS nfet_06v0 L=1.0u W=1.0u
Mx2_x3_XM7 x2_x3_net28 x2_x3_net1 VDD VDD pfet_06v0 L=1.0u W=10.0u
Mx2_x3_XM8 x2_x3_net3 x2_x3_net6 x2_x3_net28 VDD pfet_06v0 L=1.0u W=10.0u
Mx2_x3_XM9 x2_x3_net3 x2_x3_net4 x2_x3_net27 VSS nfet_06v0 L=1.0u W=5.0u
Mx2_x3_XM10 x2_x3_net27 x2_x3_net3 VSS VSS nfet_06v0 L=1.0u W=5.0u
Mx2_x3_XM1 x2_x3_net6 x2_x3_net6 VDD VDD pfet_06v0 L=1.0u W=2u
Mx2_x3_XM2 x2_x3_net30 x2_x3_net1 VDD VDD pfet_06v0 L=1.0u W=10.0u
Mx2_x3_XM3 x2_x3_net1 x2_x3_net6 x2_x3_net30 VDD pfet_06v0 L=1.0u W=10.0u
Mx2_x3_XM47 x2_x3_net31 x2_x3_net6 VSS VSS nfet_06v0 L=1.0u W=1.0u
Mx2_x3_XM48 x2_x3_net32 x2_x3_net6 VSS VSS nfet_06v0 L=1.0u W=1.0u
Mx2_x3_XM49 x2_x3_net6 x2_x3_net6 x2_x3_net32 VSS nfet_06v0 L=1.0u W=1.0u
Mx2_x3_XM50 x2_x3_net1 x2_x3_net6 x2_x3_net31 VSS nfet_06v0 L=1.0u W=1.0u
Mx2_x4_x1_XM4 x2_x4_x1_net3 x2_x4_net4 VDD VDD pfet_06v0 L=1.0u W=10.0u
Mx2_x4_x1_XM5 x2_x4_net2 x2_x4_net3 x2_x4_x1_net3 VDD pfet_06v0 L=1.0u W=10.0u
Mx2_x4_x1_XM6 x2_x4_net2 x2_x4_net2 VSS VSS nfet_06v0 L=1.0u W=1.0u
Mx2_x4_x1_XM7 x2_x4_x1_net2 x2_x4_net4 VDD VDD pfet_06v0 L=1.0u W=10.0u
Mx2_x4_x1_XM8 x2_x4_net1 x2_x4_net3 x2_x4_x1_net2 VDD pfet_06v0 L=1.0u W=10.0u
Mx2_x4_x1_XM9 x2_x4_net1 x2_x4_net2 x2_x4_x1_net1 VSS nfet_06v0 L=1.0u W=5.0u
Mx2_x4_x1_XM10 x2_x4_x1_net1 x2_x4_net1 VSS VSS nfet_06v0 L=1.0u W=5.0u
Mx2_x4_x1_XM1 x2_x4_net3 x2_x4_net3 VDD VDD pfet_06v0 L=1.0u W=2u
Mx2_x4_x1_XM2 x2_x4_x1_net4 x2_x4_net4 VDD VDD pfet_06v0 L=1.0u W=10.0u
Mx2_x4_x1_XM3 x2_x4_net4 x2_x4_net3 x2_x4_x1_net4 VDD pfet_06v0 L=1.0u W=10.0u
Mx2_x4_x1_XM47 x2_x4_x1_net5 x2_x4_net3 VSS VSS nfet_06v0 L=1.0u W=1.0u
Mx2_x4_x1_XM48 x2_x4_x1_net6 x2_x4_net3 VSS VSS nfet_06v0 L=1.0u W=1.0u
Mx2_x4_x1_XM49 x2_x4_net3 x2_x4_net3 x2_x4_x1_net6 VSS nfet_06v0 L=1.0u W=1.0u
Mx2_x4_x1_XM50 x2_x4_net4 x2_x4_net3 x2_x4_x1_net5 VSS nfet_06v0 L=1.0u W=1.0u
Mx2_x4_x2_XM11 x2_x4_x2_net2 x2_x4_net4 VDD VDD pfet_06v0 L=1.0u W=10.0u
Mx2_x4_x2_XM12 x2_x4_x2_net7 x2_x4_net3 x2_x4_x2_net2 VDD pfet_06v0 L=1.0u W=10.0u
Mx2_x4_x2_XM13 x2_x4_x2_net19 x2_x4_net4 VDD VDD pfet_06v0 L=1.0u W=10.0u
Mx2_x4_x2_XM14 x2_x4_x2_net7 x2_x4_net3 x2_x4_x2_net19 VDD pfet_06v0 L=1.0u W=10.0u
Mx2_x4_x2_XM15_f1 x2_x4_x2_net5 x2_SY x2_x4_x2_net7 VDD pfet_06v0 L=1.0u W=20.0u
Mx2_x4_x2_XM15_f2 x2_x4_x2_net5 x2_SY x2_x4_x2_net7 VDD pfet_06v0 L=1.0u W=20.0u
Mx2_x4_x2_XM16_f1 x2_x4_x2_net4 x2_SX x2_x4_x2_net7 VDD pfet_06v0 L=1.0u W=20.0u
Mx2_x4_x2_XM16_f2 x2_x4_x2_net4 x2_SX x2_x4_x2_net7 VDD pfet_06v0 L=1.0u W=20.0u
Mx2_x4_x2_XM17 x2_x4_x2_net8 x2_x4_net2 x2_x4_x2_net1 VSS nfet_06v0 L=1.0u W=5.0u
Mx2_x4_x2_XM18 x2_x4_x2_net1 x2_x4_net1 VSS VSS nfet_06v0 L=1.0u W=5.0u
Mx2_x4_x2_XM19 x2_x4_x2_net8 x2_x4_net2 x2_x4_x2_net20 VSS nfet_06v0 L=1.0u W=5.0u
Mx2_x4_x2_XM20 x2_x4_x2_net20 x2_x4_net1 VSS VSS nfet_06v0 L=1.0u W=5.0u
Mx2_x4_x2_XM21_f1 x2_x4_x2_net6 x2_SY x2_x4_x2_net8 VSS nfet_06v0 L=1.0u W=10u
Mx2_x4_x2_XM21_f2 x2_x4_x2_net6 x2_SY x2_x4_x2_net8 VSS nfet_06v0 L=1.0u W=10u
Mx2_x4_x2_XM22_f1 x2_x4_x2_net3 x2_SX x2_x4_x2_net8 VSS nfet_06v0 L=1.0u W=10u
Mx2_x4_x2_XM22_f2 x2_x4_x2_net3 x2_SX x2_x4_x2_net8 VSS nfet_06v0 L=1.0u W=10u
Mx2_x4_x2_XM29_f1 x2_x4_x2_net9 x2_x4_net3 x2_x4_x2_net3 VDD pfet_06v0 L=1.0u W=10u
Mx2_x4_x2_XM29_f2 x2_x4_x2_net9 x2_x4_net3 x2_x4_x2_net3 VDD pfet_06v0 L=1.0u W=10u
Mx2_x4_x2_XM30_f1 x2_x4_x2_net12 x2_x4_net3 x2_x4_x2_net6 VDD pfet_06v0 L=1.0u W=10.0u
Mx2_x4_x2_XM30_f2 x2_x4_x2_net12 x2_x4_net3 x2_x4_x2_net6 VDD pfet_06v0 L=1.0u W=10.0u
Mx2_x4_x2_XM31_f1 x2_x4_x2_net3 x2_x4_x2_net9 VDD VDD pfet_06v0 L=1.0u W=20u
Mx2_x4_x2_XM31_f2 x2_x4_x2_net3 x2_x4_x2_net9 VDD VDD pfet_06v0 L=1.0u W=20u
Mx2_x4_x2_XM31_f3 x2_x4_x2_net3 x2_x4_x2_net9 VDD VDD pfet_06v0 L=1.0u W=20u
Mx2_x4_x2_XM31_f4 x2_x4_x2_net3 x2_x4_x2_net9 VDD VDD pfet_06v0 L=1.0u W=20u
Mx2_x4_x2_XM35_f1 x2_x4_x2_net6 x2_x4_x2_net9 VDD VDD pfet_06v0 L=1.0u W=20.0u
Mx2_x4_x2_XM35_f2 x2_x4_x2_net6 x2_x4_x2_net9 VDD VDD pfet_06v0 L=1.0u W=20.0u
Mx2_x4_x2_XM35_f3 x2_x4_x2_net6 x2_x4_x2_net9 VDD VDD pfet_06v0 L=1.0u W=20.0u
Mx2_x4_x2_XM35_f4 x2_x4_x2_net6 x2_x4_x2_net9 VDD VDD pfet_06v0 L=1.0u W=20.0u
Mx2_x4_x2_XM32 x2_x4_x2_net10 x2_x4_x2_net21 x2_x4_x2_net9 VDD pfet_06v0 L=1.0u W=5u
Mx2_x4_x2_XM33 x2_x4_x2_net22 x2_x4_x2_net21 x2_x4_x2_net12 VDD pfet_06v0 L=1.0u W=5.0u
Mx2_x4_x2_XM23_f1 x2_x4_x2_net10 x2_x4_net2 x2_x4_x2_net4 VSS nfet_06v0 L=1.0u W=5u
Mx2_x4_x2_XM23_f2 x2_x4_x2_net10 x2_x4_net2 x2_x4_x2_net4 VSS nfet_06v0 L=1.0u W=5u
Mx2_x4_x2_XM24_f1 x2_x4_x2_net22 x2_x4_net2 x2_x4_x2_net5 VSS nfet_06v0 L=1.0u W=5u
Mx2_x4_x2_XM24_f2 x2_x4_x2_net22 x2_x4_net2 x2_x4_x2_net5 VSS nfet_06v0 L=1.0u W=5u
Mx2_x4_x2_XM25_f1 x2_x4_x2_net4 x2_x4_x2_net10 VSS VSS nfet_06v0 L=1.0u W=10u
Mx2_x4_x2_XM25_f2 x2_x4_x2_net4 x2_x4_x2_net10 VSS VSS nfet_06v0 L=1.0u W=10u
Mx2_x4_x2_XM25_f3 x2_x4_x2_net4 x2_x4_x2_net10 VSS VSS nfet_06v0 L=1.0u W=10u
Mx2_x4_x2_XM25_f4 x2_x4_x2_net4 x2_x4_x2_net10 VSS VSS nfet_06v0 L=1.0u W=10u
Mx2_x4_x2_XM26_f1 x2_x4_x2_net5 x2_x4_x2_net10 VSS VSS nfet_06v0 L=1.0u W=10u
Mx2_x4_x2_XM26_f2 x2_x4_x2_net5 x2_x4_x2_net10 VSS VSS nfet_06v0 L=1.0u W=10u
Mx2_x4_x2_XM26_f3 x2_x4_x2_net5 x2_x4_x2_net10 VSS VSS nfet_06v0 L=1.0u W=10u
Mx2_x4_x2_XM26_f4 x2_x4_x2_net5 x2_x4_x2_net10 VSS VSS nfet_06v0 L=1.0u W=10u
Mx2_x4_x2_XM27 x2_x4_x2_net9 x2_x4_x2_net11 x2_x4_x2_net10 VSS nfet_06v0 L=1.0u W=2.5u
Mx2_x4_x2_XM28 x2_x4_x2_net12 x2_x4_x2_net11 x2_x4_x2_net22 VSS nfet_06v0 L=1.0u W=2.5u
Mx2_x4_x2_XM34 x2_x4_x2_net13 x2_x4_x2_net14 VDD VDD pfet_06v0 L=1.0u W=10.0u
Mx2_x4_x2_XM36 x2_x4_x2_net14 x2_x4_net3 x2_x4_x2_net13 VDD pfet_06v0 L=1.0u W=10.0u
Mx2_x4_x2_XM37 x2_x4_x2_net21 x2_x4_x2_net21 x2_x4_x2_net14 VDD pfet_06v0 L=1.0u W=10.0u
Mx2_x4_x2_XM38 x2_x4_x2_net21 x2_x4_net2 x2_x4_x2_net15 VSS nfet_06v0 L=1.0u W=5.0u
Mx2_x4_x2_XM39 x2_x4_x2_net15 x2_x4_net1 VSS VSS nfet_06v0 L=1.0u W=5.0u
Mx2_x4_x2_XM45 x2_x4_x2_net16 x2_x4_net4 VDD VDD pfet_06v0 L=1.0u W=10.0u
Mx2_x4_x2_XM46 x2_x4_x2_net11 x2_x4_net3 x2_x4_x2_net16 VDD pfet_06v0 L=1.0u W=10.0u
Mx2_x4_x2_XM40 x2_x4_x2_net11 x2_x4_x2_net11 x2_x4_x2_net18 VSS nfet_06v0 L=1.0u W=5.0u
Mx2_x4_x2_XM41 x2_x4_x2_net18 x2_x4_net2 x2_x4_x2_net17 VSS nfet_06v0 L=1.0u W=5.0u
Mx2_x4_x2_XM42 x2_x4_x2_net17 x2_x4_x2_net18 VSS VSS nfet_06v0 L=1.0u W=5.0u
Mx2_x4_x2_XM43_f1 x2_net1 x2_x4_x2_net12 VDD VDD pfet_06v0 L=1.0u W=30u
Mx2_x4_x2_XM43_f2 x2_net1 x2_x4_x2_net12 VDD VDD pfet_06v0 L=1.0u W=30u
Mx2_x4_x2_XM43_f3 x2_net1 x2_x4_x2_net12 VDD VDD pfet_06v0 L=1.0u W=30u
Mx2_x4_x2_XM44_f1 x2_net1 x2_x4_x2_net22 VSS VSS nfet_06v0 L=1.0u W=15u
Mx2_x4_x2_XM44_f2 x2_net1 x2_x4_x2_net22 VSS VSS nfet_06v0 L=1.0u W=15u
Mx2_x4_x2_XM44_f3 x2_net1 x2_x4_x2_net22 VSS VSS nfet_06v0 L=1.0u W=15u
Mx2_x5_x1_XM4 x2_x5_x1_net3 x2_x5_net4 VDD VDD pfet_06v0 L=1.0u W=10.0u
Mx2_x5_x1_XM5 x2_x5_net2 x2_x5_net3 x2_x5_x1_net3 VDD pfet_06v0 L=1.0u W=10.0u
Mx2_x5_x1_XM6 x2_x5_net2 x2_x5_net2 VSS VSS nfet_06v0 L=1.0u W=1.0u
Mx2_x5_x1_XM7 x2_x5_x1_net2 x2_x5_net4 VDD VDD pfet_06v0 L=1.0u W=10.0u
Mx2_x5_x1_XM8 x2_x5_net1 x2_x5_net3 x2_x5_x1_net2 VDD pfet_06v0 L=1.0u W=10.0u
Mx2_x5_x1_XM9 x2_x5_net1 x2_x5_net2 x2_x5_x1_net1 VSS nfet_06v0 L=1.0u W=5.0u
Mx2_x5_x1_XM10 x2_x5_x1_net1 x2_x5_net1 VSS VSS nfet_06v0 L=1.0u W=5.0u
Mx2_x5_x1_XM1 x2_x5_net3 x2_x5_net3 VDD VDD pfet_06v0 L=1.0u W=2u
Mx2_x5_x1_XM2 x2_x5_x1_net4 x2_x5_net4 VDD VDD pfet_06v0 L=1.0u W=10.0u
Mx2_x5_x1_XM3 x2_x5_net4 x2_x5_net3 x2_x5_x1_net4 VDD pfet_06v0 L=1.0u W=10.0u
Mx2_x5_x1_XM47 x2_x5_x1_net5 x2_x5_net3 VSS VSS nfet_06v0 L=1.0u W=1.0u
Mx2_x5_x1_XM48 x2_x5_x1_net6 x2_x5_net3 VSS VSS nfet_06v0 L=1.0u W=1.0u
Mx2_x5_x1_XM49 x2_x5_net3 x2_x5_net3 x2_x5_x1_net6 VSS nfet_06v0 L=1.0u W=1.0u
Mx2_x5_x1_XM50 x2_x5_net4 x2_x5_net3 x2_x5_x1_net5 VSS nfet_06v0 L=1.0u W=1.0u
Mx2_x5_x2_XM11 x2_x5_x2_net2 x2_x5_net4 VDD VDD pfet_06v0 L=1.0u W=10.0u
Mx2_x5_x2_XM12 x2_x5_x2_net7 x2_x5_net3 x2_x5_x2_net2 VDD pfet_06v0 L=1.0u W=10.0u
Mx2_x5_x2_XM13 x2_x5_x2_net19 x2_x5_net4 VDD VDD pfet_06v0 L=1.0u W=10.0u
Mx2_x5_x2_XM14 x2_x5_x2_net7 x2_x5_net3 x2_x5_x2_net19 VDD pfet_06v0 L=1.0u W=10.0u
Mx2_x5_x2_XM15_f1 x2_x5_x2_net5 x2_SZ x2_x5_x2_net7 VDD pfet_06v0 L=1.0u W=20.0u
Mx2_x5_x2_XM15_f2 x2_x5_x2_net5 x2_SZ x2_x5_x2_net7 VDD pfet_06v0 L=1.0u W=20.0u
Mx2_x5_x2_XM16_f1 x2_x5_x2_net4 x2_SX x2_x5_x2_net7 VDD pfet_06v0 L=1.0u W=20.0u
Mx2_x5_x2_XM16_f2 x2_x5_x2_net4 x2_SX x2_x5_x2_net7 VDD pfet_06v0 L=1.0u W=20.0u
Mx2_x5_x2_XM17 x2_x5_x2_net8 x2_x5_net2 x2_x5_x2_net1 VSS nfet_06v0 L=1.0u W=5.0u
Mx2_x5_x2_XM18 x2_x5_x2_net1 x2_x5_net1 VSS VSS nfet_06v0 L=1.0u W=5.0u
Mx2_x5_x2_XM19 x2_x5_x2_net8 x2_x5_net2 x2_x5_x2_net20 VSS nfet_06v0 L=1.0u W=5.0u
Mx2_x5_x2_XM20 x2_x5_x2_net20 x2_x5_net1 VSS VSS nfet_06v0 L=1.0u W=5.0u
Mx2_x5_x2_XM21_f1 x2_x5_x2_net6 x2_SZ x2_x5_x2_net8 VSS nfet_06v0 L=1.0u W=10u
Mx2_x5_x2_XM21_f2 x2_x5_x2_net6 x2_SZ x2_x5_x2_net8 VSS nfet_06v0 L=1.0u W=10u
Mx2_x5_x2_XM22_f1 x2_x5_x2_net3 x2_SX x2_x5_x2_net8 VSS nfet_06v0 L=1.0u W=10u
Mx2_x5_x2_XM22_f2 x2_x5_x2_net3 x2_SX x2_x5_x2_net8 VSS nfet_06v0 L=1.0u W=10u
Mx2_x5_x2_XM29_f1 x2_x5_x2_net9 x2_x5_net3 x2_x5_x2_net3 VDD pfet_06v0 L=1.0u W=10u
Mx2_x5_x2_XM29_f2 x2_x5_x2_net9 x2_x5_net3 x2_x5_x2_net3 VDD pfet_06v0 L=1.0u W=10u
Mx2_x5_x2_XM30_f1 x2_x5_x2_net12 x2_x5_net3 x2_x5_x2_net6 VDD pfet_06v0 L=1.0u W=10.0u
Mx2_x5_x2_XM30_f2 x2_x5_x2_net12 x2_x5_net3 x2_x5_x2_net6 VDD pfet_06v0 L=1.0u W=10.0u
Mx2_x5_x2_XM31_f1 x2_x5_x2_net3 x2_x5_x2_net9 VDD VDD pfet_06v0 L=1.0u W=20u
Mx2_x5_x2_XM31_f2 x2_x5_x2_net3 x2_x5_x2_net9 VDD VDD pfet_06v0 L=1.0u W=20u
Mx2_x5_x2_XM31_f3 x2_x5_x2_net3 x2_x5_x2_net9 VDD VDD pfet_06v0 L=1.0u W=20u
Mx2_x5_x2_XM31_f4 x2_x5_x2_net3 x2_x5_x2_net9 VDD VDD pfet_06v0 L=1.0u W=20u
Mx2_x5_x2_XM35_f1 x2_x5_x2_net6 x2_x5_x2_net9 VDD VDD pfet_06v0 L=1.0u W=20.0u
Mx2_x5_x2_XM35_f2 x2_x5_x2_net6 x2_x5_x2_net9 VDD VDD pfet_06v0 L=1.0u W=20.0u
Mx2_x5_x2_XM35_f3 x2_x5_x2_net6 x2_x5_x2_net9 VDD VDD pfet_06v0 L=1.0u W=20.0u
Mx2_x5_x2_XM35_f4 x2_x5_x2_net6 x2_x5_x2_net9 VDD VDD pfet_06v0 L=1.0u W=20.0u
Mx2_x5_x2_XM32 x2_x5_x2_net10 x2_x5_x2_net21 x2_x5_x2_net9 VDD pfet_06v0 L=1.0u W=5u
Mx2_x5_x2_XM33 x2_x5_x2_net22 x2_x5_x2_net21 x2_x5_x2_net12 VDD pfet_06v0 L=1.0u W=5.0u
Mx2_x5_x2_XM23_f1 x2_x5_x2_net10 x2_x5_net2 x2_x5_x2_net4 VSS nfet_06v0 L=1.0u W=5u
Mx2_x5_x2_XM23_f2 x2_x5_x2_net10 x2_x5_net2 x2_x5_x2_net4 VSS nfet_06v0 L=1.0u W=5u
Mx2_x5_x2_XM24_f1 x2_x5_x2_net22 x2_x5_net2 x2_x5_x2_net5 VSS nfet_06v0 L=1.0u W=5u
Mx2_x5_x2_XM24_f2 x2_x5_x2_net22 x2_x5_net2 x2_x5_x2_net5 VSS nfet_06v0 L=1.0u W=5u
Mx2_x5_x2_XM25_f1 x2_x5_x2_net4 x2_x5_x2_net10 VSS VSS nfet_06v0 L=1.0u W=10u
Mx2_x5_x2_XM25_f2 x2_x5_x2_net4 x2_x5_x2_net10 VSS VSS nfet_06v0 L=1.0u W=10u
Mx2_x5_x2_XM25_f3 x2_x5_x2_net4 x2_x5_x2_net10 VSS VSS nfet_06v0 L=1.0u W=10u
Mx2_x5_x2_XM25_f4 x2_x5_x2_net4 x2_x5_x2_net10 VSS VSS nfet_06v0 L=1.0u W=10u
Mx2_x5_x2_XM26_f1 x2_x5_x2_net5 x2_x5_x2_net10 VSS VSS nfet_06v0 L=1.0u W=10u
Mx2_x5_x2_XM26_f2 x2_x5_x2_net5 x2_x5_x2_net10 VSS VSS nfet_06v0 L=1.0u W=10u
Mx2_x5_x2_XM26_f3 x2_x5_x2_net5 x2_x5_x2_net10 VSS VSS nfet_06v0 L=1.0u W=10u
Mx2_x5_x2_XM26_f4 x2_x5_x2_net5 x2_x5_x2_net10 VSS VSS nfet_06v0 L=1.0u W=10u
Mx2_x5_x2_XM27 x2_x5_x2_net9 x2_x5_x2_net11 x2_x5_x2_net10 VSS nfet_06v0 L=1.0u W=2.5u
Mx2_x5_x2_XM28 x2_x5_x2_net12 x2_x5_x2_net11 x2_x5_x2_net22 VSS nfet_06v0 L=1.0u W=2.5u
Mx2_x5_x2_XM34 x2_x5_x2_net13 x2_x5_x2_net14 VDD VDD pfet_06v0 L=1.0u W=10.0u
Mx2_x5_x2_XM36 x2_x5_x2_net14 x2_x5_net3 x2_x5_x2_net13 VDD pfet_06v0 L=1.0u W=10.0u
Mx2_x5_x2_XM37 x2_x5_x2_net21 x2_x5_x2_net21 x2_x5_x2_net14 VDD pfet_06v0 L=1.0u W=10.0u
Mx2_x5_x2_XM38 x2_x5_x2_net21 x2_x5_net2 x2_x5_x2_net15 VSS nfet_06v0 L=1.0u W=5.0u
Mx2_x5_x2_XM39 x2_x5_x2_net15 x2_x5_net1 VSS VSS nfet_06v0 L=1.0u W=5.0u
Mx2_x5_x2_XM45 x2_x5_x2_net16 x2_x5_net4 VDD VDD pfet_06v0 L=1.0u W=10.0u
Mx2_x5_x2_XM46 x2_x5_x2_net11 x2_x5_net3 x2_x5_x2_net16 VDD pfet_06v0 L=1.0u W=10.0u
Mx2_x5_x2_XM40 x2_x5_x2_net11 x2_x5_x2_net11 x2_x5_x2_net18 VSS nfet_06v0 L=1.0u W=5.0u
Mx2_x5_x2_XM41 x2_x5_x2_net18 x2_x5_net2 x2_x5_x2_net17 VSS nfet_06v0 L=1.0u W=5.0u
Mx2_x5_x2_XM42 x2_x5_x2_net17 x2_x5_x2_net18 VSS VSS nfet_06v0 L=1.0u W=5.0u
Mx2_x5_x2_XM43_f1 x2_net2 x2_x5_x2_net12 VDD VDD pfet_06v0 L=1.0u W=30u
Mx2_x5_x2_XM43_f2 x2_net2 x2_x5_x2_net12 VDD VDD pfet_06v0 L=1.0u W=30u
Mx2_x5_x2_XM43_f3 x2_net2 x2_x5_x2_net12 VDD VDD pfet_06v0 L=1.0u W=30u
Mx2_x5_x2_XM44_f1 x2_net2 x2_x5_x2_net22 VSS VSS nfet_06v0 L=1.0u W=15u
Mx2_x5_x2_XM44_f2 x2_net2 x2_x5_x2_net22 VSS VSS nfet_06v0 L=1.0u W=15u
Mx2_x5_x2_XM44_f3 x2_net2 x2_x5_x2_net22 VSS VSS nfet_06v0 L=1.0u W=15u
Mx2_x6_x1_XM4 x2_x6_x1_net3 x2_x6_net4 VDD VDD pfet_06v0 L=1.0u W=10.0u
Mx2_x6_x1_XM5 x2_x6_net2 x2_x6_net3 x2_x6_x1_net3 VDD pfet_06v0 L=1.0u W=10.0u
Mx2_x6_x1_XM6 x2_x6_net2 x2_x6_net2 VSS VSS nfet_06v0 L=1.0u W=1.0u
Mx2_x6_x1_XM7 x2_x6_x1_net2 x2_x6_net4 VDD VDD pfet_06v0 L=1.0u W=10.0u
Mx2_x6_x1_XM8 x2_x6_net1 x2_x6_net3 x2_x6_x1_net2 VDD pfet_06v0 L=1.0u W=10.0u
Mx2_x6_x1_XM9 x2_x6_net1 x2_x6_net2 x2_x6_x1_net1 VSS nfet_06v0 L=1.0u W=5.0u
Mx2_x6_x1_XM10 x2_x6_x1_net1 x2_x6_net1 VSS VSS nfet_06v0 L=1.0u W=5.0u
Mx2_x6_x1_XM1 x2_x6_net3 x2_x6_net3 VDD VDD pfet_06v0 L=1.0u W=2u
Mx2_x6_x1_XM2 x2_x6_x1_net4 x2_x6_net4 VDD VDD pfet_06v0 L=1.0u W=10.0u
Mx2_x6_x1_XM3 x2_x6_net4 x2_x6_net3 x2_x6_x1_net4 VDD pfet_06v0 L=1.0u W=10.0u
Mx2_x6_x1_XM47 x2_x6_x1_net5 x2_x6_net3 VSS VSS nfet_06v0 L=1.0u W=1.0u
Mx2_x6_x1_XM48 x2_x6_x1_net6 x2_x6_net3 VSS VSS nfet_06v0 L=1.0u W=1.0u
Mx2_x6_x1_XM49 x2_x6_net3 x2_x6_net3 x2_x6_x1_net6 VSS nfet_06v0 L=1.0u W=1.0u
Mx2_x6_x1_XM50 x2_x6_net4 x2_x6_net3 x2_x6_x1_net5 VSS nfet_06v0 L=1.0u W=1.0u
Mx2_x6_x2_XM11 x2_x6_x2_net2 x2_x6_net4 VDD VDD pfet_06v0 L=1.0u W=10.0u
Mx2_x6_x2_XM12 x2_x6_x2_net7 x2_x6_net3 x2_x6_x2_net2 VDD pfet_06v0 L=1.0u W=10.0u
Mx2_x6_x2_XM13 x2_x6_x2_net19 x2_x6_net4 VDD VDD pfet_06v0 L=1.0u W=10.0u
Mx2_x6_x2_XM14 x2_x6_x2_net7 x2_x6_net3 x2_x6_x2_net19 VDD pfet_06v0 L=1.0u W=10.0u
Mx2_x6_x2_XM15_f1 x2_x6_x2_net5 x2_SZ x2_x6_x2_net7 VDD pfet_06v0 L=1.0u W=20.0u
Mx2_x6_x2_XM15_f2 x2_x6_x2_net5 x2_SZ x2_x6_x2_net7 VDD pfet_06v0 L=1.0u W=20.0u
Mx2_x6_x2_XM16_f1 x2_x6_x2_net4 x2_SY x2_x6_x2_net7 VDD pfet_06v0 L=1.0u W=20.0u
Mx2_x6_x2_XM16_f2 x2_x6_x2_net4 x2_SY x2_x6_x2_net7 VDD pfet_06v0 L=1.0u W=20.0u
Mx2_x6_x2_XM17 x2_x6_x2_net8 x2_x6_net2 x2_x6_x2_net1 VSS nfet_06v0 L=1.0u W=5.0u
Mx2_x6_x2_XM18 x2_x6_x2_net1 x2_x6_net1 VSS VSS nfet_06v0 L=1.0u W=5.0u
Mx2_x6_x2_XM19 x2_x6_x2_net8 x2_x6_net2 x2_x6_x2_net20 VSS nfet_06v0 L=1.0u W=5.0u
Mx2_x6_x2_XM20 x2_x6_x2_net20 x2_x6_net1 VSS VSS nfet_06v0 L=1.0u W=5.0u
Mx2_x6_x2_XM21_f1 x2_x6_x2_net6 x2_SZ x2_x6_x2_net8 VSS nfet_06v0 L=1.0u W=10u
Mx2_x6_x2_XM21_f2 x2_x6_x2_net6 x2_SZ x2_x6_x2_net8 VSS nfet_06v0 L=1.0u W=10u
Mx2_x6_x2_XM22_f1 x2_x6_x2_net3 x2_SY x2_x6_x2_net8 VSS nfet_06v0 L=1.0u W=10u
Mx2_x6_x2_XM22_f2 x2_x6_x2_net3 x2_SY x2_x6_x2_net8 VSS nfet_06v0 L=1.0u W=10u
Mx2_x6_x2_XM29_f1 x2_x6_x2_net9 x2_x6_net3 x2_x6_x2_net3 VDD pfet_06v0 L=1.0u W=10u
Mx2_x6_x2_XM29_f2 x2_x6_x2_net9 x2_x6_net3 x2_x6_x2_net3 VDD pfet_06v0 L=1.0u W=10u
Mx2_x6_x2_XM30_f1 x2_x6_x2_net12 x2_x6_net3 x2_x6_x2_net6 VDD pfet_06v0 L=1.0u W=10.0u
Mx2_x6_x2_XM30_f2 x2_x6_x2_net12 x2_x6_net3 x2_x6_x2_net6 VDD pfet_06v0 L=1.0u W=10.0u
Mx2_x6_x2_XM31_f1 x2_x6_x2_net3 x2_x6_x2_net9 VDD VDD pfet_06v0 L=1.0u W=20u
Mx2_x6_x2_XM31_f2 x2_x6_x2_net3 x2_x6_x2_net9 VDD VDD pfet_06v0 L=1.0u W=20u
Mx2_x6_x2_XM31_f3 x2_x6_x2_net3 x2_x6_x2_net9 VDD VDD pfet_06v0 L=1.0u W=20u
Mx2_x6_x2_XM31_f4 x2_x6_x2_net3 x2_x6_x2_net9 VDD VDD pfet_06v0 L=1.0u W=20u
Mx2_x6_x2_XM35_f1 x2_x6_x2_net6 x2_x6_x2_net9 VDD VDD pfet_06v0 L=1.0u W=20.0u
Mx2_x6_x2_XM35_f2 x2_x6_x2_net6 x2_x6_x2_net9 VDD VDD pfet_06v0 L=1.0u W=20.0u
Mx2_x6_x2_XM35_f3 x2_x6_x2_net6 x2_x6_x2_net9 VDD VDD pfet_06v0 L=1.0u W=20.0u
Mx2_x6_x2_XM35_f4 x2_x6_x2_net6 x2_x6_x2_net9 VDD VDD pfet_06v0 L=1.0u W=20.0u
Mx2_x6_x2_XM32 x2_x6_x2_net10 x2_x6_x2_net21 x2_x6_x2_net9 VDD pfet_06v0 L=1.0u W=5u
Mx2_x6_x2_XM33 x2_x6_x2_net22 x2_x6_x2_net21 x2_x6_x2_net12 VDD pfet_06v0 L=1.0u W=5.0u
Mx2_x6_x2_XM23_f1 x2_x6_x2_net10 x2_x6_net2 x2_x6_x2_net4 VSS nfet_06v0 L=1.0u W=5u
Mx2_x6_x2_XM23_f2 x2_x6_x2_net10 x2_x6_net2 x2_x6_x2_net4 VSS nfet_06v0 L=1.0u W=5u
Mx2_x6_x2_XM24_f1 x2_x6_x2_net22 x2_x6_net2 x2_x6_x2_net5 VSS nfet_06v0 L=1.0u W=5u
Mx2_x6_x2_XM24_f2 x2_x6_x2_net22 x2_x6_net2 x2_x6_x2_net5 VSS nfet_06v0 L=1.0u W=5u
Mx2_x6_x2_XM25_f1 x2_x6_x2_net4 x2_x6_x2_net10 VSS VSS nfet_06v0 L=1.0u W=10u
Mx2_x6_x2_XM25_f2 x2_x6_x2_net4 x2_x6_x2_net10 VSS VSS nfet_06v0 L=1.0u W=10u
Mx2_x6_x2_XM25_f3 x2_x6_x2_net4 x2_x6_x2_net10 VSS VSS nfet_06v0 L=1.0u W=10u
Mx2_x6_x2_XM25_f4 x2_x6_x2_net4 x2_x6_x2_net10 VSS VSS nfet_06v0 L=1.0u W=10u
Mx2_x6_x2_XM26_f1 x2_x6_x2_net5 x2_x6_x2_net10 VSS VSS nfet_06v0 L=1.0u W=10u
Mx2_x6_x2_XM26_f2 x2_x6_x2_net5 x2_x6_x2_net10 VSS VSS nfet_06v0 L=1.0u W=10u
Mx2_x6_x2_XM26_f3 x2_x6_x2_net5 x2_x6_x2_net10 VSS VSS nfet_06v0 L=1.0u W=10u
Mx2_x6_x2_XM26_f4 x2_x6_x2_net5 x2_x6_x2_net10 VSS VSS nfet_06v0 L=1.0u W=10u
Mx2_x6_x2_XM27 x2_x6_x2_net9 x2_x6_x2_net11 x2_x6_x2_net10 VSS nfet_06v0 L=1.0u W=2.5u
Mx2_x6_x2_XM28 x2_x6_x2_net12 x2_x6_x2_net11 x2_x6_x2_net22 VSS nfet_06v0 L=1.0u W=2.5u
Mx2_x6_x2_XM34 x2_x6_x2_net13 x2_x6_x2_net14 VDD VDD pfet_06v0 L=1.0u W=10.0u
Mx2_x6_x2_XM36 x2_x6_x2_net14 x2_x6_net3 x2_x6_x2_net13 VDD pfet_06v0 L=1.0u W=10.0u
Mx2_x6_x2_XM37 x2_x6_x2_net21 x2_x6_x2_net21 x2_x6_x2_net14 VDD pfet_06v0 L=1.0u W=10.0u
Mx2_x6_x2_XM38 x2_x6_x2_net21 x2_x6_net2 x2_x6_x2_net15 VSS nfet_06v0 L=1.0u W=5.0u
Mx2_x6_x2_XM39 x2_x6_x2_net15 x2_x6_net1 VSS VSS nfet_06v0 L=1.0u W=5.0u
Mx2_x6_x2_XM45 x2_x6_x2_net16 x2_x6_net4 VDD VDD pfet_06v0 L=1.0u W=10.0u
Mx2_x6_x2_XM46 x2_x6_x2_net11 x2_x6_net3 x2_x6_x2_net16 VDD pfet_06v0 L=1.0u W=10.0u
Mx2_x6_x2_XM40 x2_x6_x2_net11 x2_x6_x2_net11 x2_x6_x2_net18 VSS nfet_06v0 L=1.0u W=5.0u
Mx2_x6_x2_XM41 x2_x6_x2_net18 x2_x6_net2 x2_x6_x2_net17 VSS nfet_06v0 L=1.0u W=5.0u
Mx2_x6_x2_XM42 x2_x6_x2_net17 x2_x6_x2_net18 VSS VSS nfet_06v0 L=1.0u W=5.0u
Mx2_x6_x2_XM43_f1 x2_net3 x2_x6_x2_net12 VDD VDD pfet_06v0 L=1.0u W=30u
Mx2_x6_x2_XM43_f2 x2_net3 x2_x6_x2_net12 VDD VDD pfet_06v0 L=1.0u W=30u
Mx2_x6_x2_XM43_f3 x2_net3 x2_x6_x2_net12 VDD VDD pfet_06v0 L=1.0u W=30u
Mx2_x6_x2_XM44_f1 x2_net3 x2_x6_x2_net22 VSS VSS nfet_06v0 L=1.0u W=15u
Mx2_x6_x2_XM44_f2 x2_net3 x2_x6_x2_net22 VSS VSS nfet_06v0 L=1.0u W=15u
Mx2_x6_x2_XM44_f3 x2_net3 x2_x6_x2_net22 VSS VSS nfet_06v0 L=1.0u W=15u
Mx2_x7_x1_XM4 x2_x7_x1_net1 x2_net3 Z2 VDD pfet_06v0 L=1.0u W=3.0u
Mx2_x7_x1_XM5 VDD x2_net2 x2_x7_x1_net1 VDD pfet_06v0 L=1.0u W=3.0u
Mx2_x7_x1_XM7 VSS x2_net3 Z2 VSS nfet_06v0 L=1u W=1u
Mx2_x7_x1_XM1 VSS x2_net2 Z2 VSS nfet_06v0 L=1u W=1u
Mx2_x7_x2_x2_XM4 x2_x7_x2_net1 x2_net1 VDD VDD pfet_06v0 L=1.0u W=3.0u
Mx2_x7_x2_x2_XM5 VSS x2_net1 x2_x7_x2_net1 VSS nfet_06v0 L=1u W=1u
Mx2_x7_x2_x3_XM4 Y2 x2_x7_x2_x3_net1 VDD VDD pfet_06v0 L=1.0u W=3.0u
Mx2_x7_x2_x3_XM5 VSS x2_x7_x2_x3_net1 Y2 VSS nfet_06v0 L=1u W=1u
Mx2_x7_x2_x3_XM2 VDD x2_net3 x2_x7_x2_x3_net1 VDD pfet_06v0 L=1.0u W=3.0u
Mx2_x7_x2_x3_XM1 VDD x2_x7_x2_net1 x2_x7_x2_x3_net1 VDD pfet_06v0 L=1.0u W=3.0u
Mx2_x7_x2_x3_XM3 VSS x2_net3 x2_x7_x2_x3_net2 VSS nfet_06v0 L=1u W=1u
Mx2_x7_x2_x3_XM6 x2_x7_x2_x3_net2 x2_x7_x2_net1 x2_x7_x2_x3_net1 VSS nfet_06v0 L=1u W=1u
Mx2_x7_x3_x2_XM4 X2 x2_x7_x3_x2_net1 VDD VDD pfet_06v0 L=1.0u W=3.0u
Mx2_x7_x3_x2_XM5 VSS x2_x7_x3_x2_net1 X2 VSS nfet_06v0 L=1u W=1u
Mx2_x7_x3_x2_XM2 VDD x2_net1 x2_x7_x3_x2_net1 VDD pfet_06v0 L=1.0u W=3.0u
Mx2_x7_x3_x2_XM1 VDD x2_net2 x2_x7_x3_x2_net1 VDD pfet_06v0 L=1.0u W=3.0u
Mx2_x7_x3_x2_XM3 VSS x2_net1 x2_x7_x3_x2_net2 VSS nfet_06v0 L=1u W=1u
Mx2_x7_x3_x2_XM6 x2_x7_x3_x2_net2 x2_net2 x2_x7_x3_x2_net1 VSS nfet_06v0 L=1u W=1u
Mx3_x1_XM11 x3_x1_net5 x3_x1_net1 VDD VDD pfet_06v0 L=1.0u W=10.0u
Mx3_x1_XM12 x3_x1_net11 x3_x1_net6 x3_x1_net5 VDD pfet_06v0 L=1.0u W=10.0u
Mx3_x1_XM13 x3_x1_net23 x3_x1_net1 VDD VDD pfet_06v0 L=1.0u W=10.0u
Mx3_x1_XM14 x3_x1_net11 x3_x1_net6 x3_x1_net23 VDD pfet_06v0 L=1.0u W=10.0u
Mx3_x1_XM15 x3_x1_net9 S3P x3_x1_net11 VDD pfet_06v0 L=1.0u W=10.0u
Mx3_x1_XM16 x3_x1_net8 S3N x3_x1_net11 VDD pfet_06v0 L=1.0u W=10.0u
Mx3_x1_XM17 x3_x1_net12 x3_x1_net4 x3_x1_net2 VSS nfet_06v0 L=1.0u W=5.0u
Mx3_x1_XM18 x3_x1_net2 x3_x1_net3 VSS VSS nfet_06v0 L=1.0u W=5.0u
Mx3_x1_XM19 x3_x1_net12 x3_x1_net4 x3_x1_net24 VSS nfet_06v0 L=1.0u W=5.0u
Mx3_x1_XM20 x3_x1_net24 x3_x1_net3 VSS VSS nfet_06v0 L=1.0u W=5.0u
Mx3_x1_XM21 x3_x1_net10 S3P x3_x1_net12 VSS nfet_06v0 L=1.0u W=5u
Mx3_x1_XM22 x3_x1_net7 S3N x3_x1_net12 VSS nfet_06v0 L=1.0u W=5u
Mx3_x1_XM29 x3_x1_net13 x3_x1_net6 x3_x1_net7 VDD pfet_06v0 L=1.0u W=5u
Mx3_x1_XM30 x3_x1_net16 x3_x1_net6 x3_x1_net10 VDD pfet_06v0 L=1.0u W=5u
Mx3_x1_XM31 x3_x1_net7 x3_x1_net13 VDD VDD pfet_06v0 L=1.0u W=5u
Mx3_x1_XM35 x3_x1_net10 x3_x1_net13 VDD VDD pfet_06v0 L=1.0u W=5u
Mx3_x1_XM32 x3_x1_net14 x3_x1_net25 x3_x1_net13 VDD pfet_06v0 L=1.0u W=5.0u
Mx3_x1_XM33 x3_x1_net26 x3_x1_net25 x3_x1_net16 VDD pfet_06v0 L=1.0u W=5.0u
Mx3_x1_XM23 x3_x1_net14 x3_x1_net4 x3_x1_net8 VSS nfet_06v0 L=1.0u W=2.5u
Mx3_x1_XM24 x3_x1_net26 x3_x1_net4 x3_x1_net9 VSS nfet_06v0 L=1.0u W=2.5u
Mx3_x1_XM25 x3_x1_net8 x3_x1_net14 VSS VSS nfet_06v0 L=1.0u W=2.5u
Mx3_x1_XM26 x3_x1_net9 x3_x1_net14 VSS VSS nfet_06v0 L=1.0u W=2.5u
Mx3_x1_XM27 x3_x1_net13 x3_x1_net15 x3_x1_net14 VSS nfet_06v0 L=1.0u W=2.5u
Mx3_x1_XM28 x3_x1_net16 x3_x1_net15 x3_x1_net26 VSS nfet_06v0 L=1.0u W=2.5u
Mx3_x1_XM34 x3_x1_net17 x3_x1_net18 VDD VDD pfet_06v0 L=1.0u W=10.0u
Mx3_x1_XM36 x3_x1_net18 x3_x1_net6 x3_x1_net17 VDD pfet_06v0 L=1.0u W=10.0u
Mx3_x1_XM37 x3_x1_net25 x3_x1_net25 x3_x1_net18 VDD pfet_06v0 L=1.0u W=10.0u
Mx3_x1_XM38 x3_x1_net25 x3_x1_net4 x3_x1_net19 VSS nfet_06v0 L=1.0u W=5.0u
Mx3_x1_XM39 x3_x1_net19 x3_x1_net3 VSS VSS nfet_06v0 L=1.0u W=5.0u
Mx3_x1_XM45 x3_x1_net20 x3_x1_net1 VDD VDD pfet_06v0 L=1.0u W=10.0u
Mx3_x1_XM46 x3_x1_net15 x3_x1_net6 x3_x1_net20 VDD pfet_06v0 L=1.0u W=10.0u
Mx3_x1_XM40 x3_x1_net15 x3_x1_net15 x3_x1_net22 VSS nfet_06v0 L=1.0u W=5.0u
Mx3_x1_XM41 x3_x1_net22 x3_x1_net4 x3_x1_net21 VSS nfet_06v0 L=1.0u W=5.0u
Mx3_x1_XM42 x3_x1_net21 x3_x1_net22 VSS VSS nfet_06v0 L=1.0u W=5.0u
Mx3_x1_XM43 x3_SX x3_x1_net16 VDD VDD pfet_06v0 L=20.0u W=0.7u
Mx3_x1_XM44 x3_SX x3_x1_net26 VSS VSS nfet_06v0 L=1.0u W=1.0u
Mx3_x1_XM4 x3_x1_net29 x3_x1_net1 VDD VDD pfet_06v0 L=1.0u W=10.0u
Mx3_x1_XM5 x3_x1_net4 x3_x1_net6 x3_x1_net29 VDD pfet_06v0 L=1.0u W=10.0u
Mx3_x1_XM6 x3_x1_net4 x3_x1_net4 VSS VSS nfet_06v0 L=1.0u W=1.0u
Mx3_x1_XM7 x3_x1_net28 x3_x1_net1 VDD VDD pfet_06v0 L=1.0u W=10.0u
Mx3_x1_XM8 x3_x1_net3 x3_x1_net6 x3_x1_net28 VDD pfet_06v0 L=1.0u W=10.0u
Mx3_x1_XM9 x3_x1_net3 x3_x1_net4 x3_x1_net27 VSS nfet_06v0 L=1.0u W=5.0u
Mx3_x1_XM10 x3_x1_net27 x3_x1_net3 VSS VSS nfet_06v0 L=1.0u W=5.0u
Mx3_x1_XM1 x3_x1_net6 x3_x1_net6 VDD VDD pfet_06v0 L=1.0u W=2u
Mx3_x1_XM2 x3_x1_net30 x3_x1_net1 VDD VDD pfet_06v0 L=1.0u W=10.0u
Mx3_x1_XM3 x3_x1_net1 x3_x1_net6 x3_x1_net30 VDD pfet_06v0 L=1.0u W=10.0u
Mx3_x1_XM47 x3_x1_net31 x3_x1_net6 VSS VSS nfet_06v0 L=1.0u W=1.0u
Mx3_x1_XM48 x3_x1_net32 x3_x1_net6 VSS VSS nfet_06v0 L=1.0u W=1.0u
Mx3_x1_XM49 x3_x1_net6 x3_x1_net6 x3_x1_net32 VSS nfet_06v0 L=1.0u W=1.0u
Mx3_x1_XM50 x3_x1_net1 x3_x1_net6 x3_x1_net31 VSS nfet_06v0 L=1.0u W=1.0u
Mx3_x2_XM11 x3_x2_net5 x3_x2_net1 VDD VDD pfet_06v0 L=1.0u W=10.0u
Mx3_x2_XM12 x3_x2_net11 x3_x2_net6 x3_x2_net5 VDD pfet_06v0 L=1.0u W=10.0u
Mx3_x2_XM13 x3_x2_net23 x3_x2_net1 VDD VDD pfet_06v0 L=1.0u W=10.0u
Mx3_x2_XM14 x3_x2_net11 x3_x2_net6 x3_x2_net23 VDD pfet_06v0 L=1.0u W=10.0u
Mx3_x2_XM15 x3_x2_net9 S4P x3_x2_net11 VDD pfet_06v0 L=1.0u W=10.0u
Mx3_x2_XM16 x3_x2_net8 S4N x3_x2_net11 VDD pfet_06v0 L=1.0u W=10.0u
Mx3_x2_XM17 x3_x2_net12 x3_x2_net4 x3_x2_net2 VSS nfet_06v0 L=1.0u W=5.0u
Mx3_x2_XM18 x3_x2_net2 x3_x2_net3 VSS VSS nfet_06v0 L=1.0u W=5.0u
Mx3_x2_XM19 x3_x2_net12 x3_x2_net4 x3_x2_net24 VSS nfet_06v0 L=1.0u W=5.0u
Mx3_x2_XM20 x3_x2_net24 x3_x2_net3 VSS VSS nfet_06v0 L=1.0u W=5.0u
Mx3_x2_XM21 x3_x2_net10 S4P x3_x2_net12 VSS nfet_06v0 L=1.0u W=5u
Mx3_x2_XM22 x3_x2_net7 S4N x3_x2_net12 VSS nfet_06v0 L=1.0u W=5u
Mx3_x2_XM29 x3_x2_net13 x3_x2_net6 x3_x2_net7 VDD pfet_06v0 L=1.0u W=5u
Mx3_x2_XM30 x3_x2_net16 x3_x2_net6 x3_x2_net10 VDD pfet_06v0 L=1.0u W=5u
Mx3_x2_XM31 x3_x2_net7 x3_x2_net13 VDD VDD pfet_06v0 L=1.0u W=5u
Mx3_x2_XM35 x3_x2_net10 x3_x2_net13 VDD VDD pfet_06v0 L=1.0u W=5u
Mx3_x2_XM32 x3_x2_net14 x3_x2_net25 x3_x2_net13 VDD pfet_06v0 L=1.0u W=5.0u
Mx3_x2_XM33 x3_x2_net26 x3_x2_net25 x3_x2_net16 VDD pfet_06v0 L=1.0u W=5.0u
Mx3_x2_XM23 x3_x2_net14 x3_x2_net4 x3_x2_net8 VSS nfet_06v0 L=1.0u W=2.5u
Mx3_x2_XM24 x3_x2_net26 x3_x2_net4 x3_x2_net9 VSS nfet_06v0 L=1.0u W=2.5u
Mx3_x2_XM25 x3_x2_net8 x3_x2_net14 VSS VSS nfet_06v0 L=1.0u W=2.5u
Mx3_x2_XM26 x3_x2_net9 x3_x2_net14 VSS VSS nfet_06v0 L=1.0u W=2.5u
Mx3_x2_XM27 x3_x2_net13 x3_x2_net15 x3_x2_net14 VSS nfet_06v0 L=1.0u W=2.5u
Mx3_x2_XM28 x3_x2_net16 x3_x2_net15 x3_x2_net26 VSS nfet_06v0 L=1.0u W=2.5u
Mx3_x2_XM34 x3_x2_net17 x3_x2_net18 VDD VDD pfet_06v0 L=1.0u W=10.0u
Mx3_x2_XM36 x3_x2_net18 x3_x2_net6 x3_x2_net17 VDD pfet_06v0 L=1.0u W=10.0u
Mx3_x2_XM37 x3_x2_net25 x3_x2_net25 x3_x2_net18 VDD pfet_06v0 L=1.0u W=10.0u
Mx3_x2_XM38 x3_x2_net25 x3_x2_net4 x3_x2_net19 VSS nfet_06v0 L=1.0u W=5.0u
Mx3_x2_XM39 x3_x2_net19 x3_x2_net3 VSS VSS nfet_06v0 L=1.0u W=5.0u
Mx3_x2_XM45 x3_x2_net20 x3_x2_net1 VDD VDD pfet_06v0 L=1.0u W=10.0u
Mx3_x2_XM46 x3_x2_net15 x3_x2_net6 x3_x2_net20 VDD pfet_06v0 L=1.0u W=10.0u
Mx3_x2_XM40 x3_x2_net15 x3_x2_net15 x3_x2_net22 VSS nfet_06v0 L=1.0u W=5.0u
Mx3_x2_XM41 x3_x2_net22 x3_x2_net4 x3_x2_net21 VSS nfet_06v0 L=1.0u W=5.0u
Mx3_x2_XM42 x3_x2_net21 x3_x2_net22 VSS VSS nfet_06v0 L=1.0u W=5.0u
Mx3_x2_XM43 x3_SY x3_x2_net16 VDD VDD pfet_06v0 L=20.0u W=0.7u
Mx3_x2_XM44 x3_SY x3_x2_net26 VSS VSS nfet_06v0 L=1.0u W=1.0u
Mx3_x2_XM4 x3_x2_net29 x3_x2_net1 VDD VDD pfet_06v0 L=1.0u W=10.0u
Mx3_x2_XM5 x3_x2_net4 x3_x2_net6 x3_x2_net29 VDD pfet_06v0 L=1.0u W=10.0u
Mx3_x2_XM6 x3_x2_net4 x3_x2_net4 VSS VSS nfet_06v0 L=1.0u W=1.0u
Mx3_x2_XM7 x3_x2_net28 x3_x2_net1 VDD VDD pfet_06v0 L=1.0u W=10.0u
Mx3_x2_XM8 x3_x2_net3 x3_x2_net6 x3_x2_net28 VDD pfet_06v0 L=1.0u W=10.0u
Mx3_x2_XM9 x3_x2_net3 x3_x2_net4 x3_x2_net27 VSS nfet_06v0 L=1.0u W=5.0u
Mx3_x2_XM10 x3_x2_net27 x3_x2_net3 VSS VSS nfet_06v0 L=1.0u W=5.0u
Mx3_x2_XM1 x3_x2_net6 x3_x2_net6 VDD VDD pfet_06v0 L=1.0u W=2u
Mx3_x2_XM2 x3_x2_net30 x3_x2_net1 VDD VDD pfet_06v0 L=1.0u W=10.0u
Mx3_x2_XM3 x3_x2_net1 x3_x2_net6 x3_x2_net30 VDD pfet_06v0 L=1.0u W=10.0u
Mx3_x2_XM47 x3_x2_net31 x3_x2_net6 VSS VSS nfet_06v0 L=1.0u W=1.0u
Mx3_x2_XM48 x3_x2_net32 x3_x2_net6 VSS VSS nfet_06v0 L=1.0u W=1.0u
Mx3_x2_XM49 x3_x2_net6 x3_x2_net6 x3_x2_net32 VSS nfet_06v0 L=1.0u W=1.0u
Mx3_x2_XM50 x3_x2_net1 x3_x2_net6 x3_x2_net31 VSS nfet_06v0 L=1.0u W=1.0u
Mx3_x3_XM11 x3_x3_net5 x3_x3_net1 VDD VDD pfet_06v0 L=1.0u W=10.0u
Mx3_x3_XM12 x3_x3_net11 x3_x3_net6 x3_x3_net5 VDD pfet_06v0 L=1.0u W=10.0u
Mx3_x3_XM13 x3_x3_net23 x3_x3_net1 VDD VDD pfet_06v0 L=1.0u W=10.0u
Mx3_x3_XM14 x3_x3_net11 x3_x3_net6 x3_x3_net23 VDD pfet_06v0 L=1.0u W=10.0u
Mx3_x3_XM15 x3_x3_net9 S1P x3_x3_net11 VDD pfet_06v0 L=1.0u W=10.0u
Mx3_x3_XM16 x3_x3_net8 S1N x3_x3_net11 VDD pfet_06v0 L=1.0u W=10.0u
Mx3_x3_XM17 x3_x3_net12 x3_x3_net4 x3_x3_net2 VSS nfet_06v0 L=1.0u W=5.0u
Mx3_x3_XM18 x3_x3_net2 x3_x3_net3 VSS VSS nfet_06v0 L=1.0u W=5.0u
Mx3_x3_XM19 x3_x3_net12 x3_x3_net4 x3_x3_net24 VSS nfet_06v0 L=1.0u W=5.0u
Mx3_x3_XM20 x3_x3_net24 x3_x3_net3 VSS VSS nfet_06v0 L=1.0u W=5.0u
Mx3_x3_XM21 x3_x3_net10 S1P x3_x3_net12 VSS nfet_06v0 L=1.0u W=5u
Mx3_x3_XM22 x3_x3_net7 S1N x3_x3_net12 VSS nfet_06v0 L=1.0u W=5u
Mx3_x3_XM29 x3_x3_net13 x3_x3_net6 x3_x3_net7 VDD pfet_06v0 L=1.0u W=5u
Mx3_x3_XM30 x3_x3_net16 x3_x3_net6 x3_x3_net10 VDD pfet_06v0 L=1.0u W=5u
Mx3_x3_XM31 x3_x3_net7 x3_x3_net13 VDD VDD pfet_06v0 L=1.0u W=5u
Mx3_x3_XM35 x3_x3_net10 x3_x3_net13 VDD VDD pfet_06v0 L=1.0u W=5u
Mx3_x3_XM32 x3_x3_net14 x3_x3_net25 x3_x3_net13 VDD pfet_06v0 L=1.0u W=5.0u
Mx3_x3_XM33 x3_x3_net26 x3_x3_net25 x3_x3_net16 VDD pfet_06v0 L=1.0u W=5.0u
Mx3_x3_XM23 x3_x3_net14 x3_x3_net4 x3_x3_net8 VSS nfet_06v0 L=1.0u W=2.5u
Mx3_x3_XM24 x3_x3_net26 x3_x3_net4 x3_x3_net9 VSS nfet_06v0 L=1.0u W=2.5u
Mx3_x3_XM25 x3_x3_net8 x3_x3_net14 VSS VSS nfet_06v0 L=1.0u W=2.5u
Mx3_x3_XM26 x3_x3_net9 x3_x3_net14 VSS VSS nfet_06v0 L=1.0u W=2.5u
Mx3_x3_XM27 x3_x3_net13 x3_x3_net15 x3_x3_net14 VSS nfet_06v0 L=1.0u W=2.5u
Mx3_x3_XM28 x3_x3_net16 x3_x3_net15 x3_x3_net26 VSS nfet_06v0 L=1.0u W=2.5u
Mx3_x3_XM34 x3_x3_net17 x3_x3_net18 VDD VDD pfet_06v0 L=1.0u W=10.0u
Mx3_x3_XM36 x3_x3_net18 x3_x3_net6 x3_x3_net17 VDD pfet_06v0 L=1.0u W=10.0u
Mx3_x3_XM37 x3_x3_net25 x3_x3_net25 x3_x3_net18 VDD pfet_06v0 L=1.0u W=10.0u
Mx3_x3_XM38 x3_x3_net25 x3_x3_net4 x3_x3_net19 VSS nfet_06v0 L=1.0u W=5.0u
Mx3_x3_XM39 x3_x3_net19 x3_x3_net3 VSS VSS nfet_06v0 L=1.0u W=5.0u
Mx3_x3_XM45 x3_x3_net20 x3_x3_net1 VDD VDD pfet_06v0 L=1.0u W=10.0u
Mx3_x3_XM46 x3_x3_net15 x3_x3_net6 x3_x3_net20 VDD pfet_06v0 L=1.0u W=10.0u
Mx3_x3_XM40 x3_x3_net15 x3_x3_net15 x3_x3_net22 VSS nfet_06v0 L=1.0u W=5.0u
Mx3_x3_XM41 x3_x3_net22 x3_x3_net4 x3_x3_net21 VSS nfet_06v0 L=1.0u W=5.0u
Mx3_x3_XM42 x3_x3_net21 x3_x3_net22 VSS VSS nfet_06v0 L=1.0u W=5.0u
Mx3_x3_XM43 x3_SZ x3_x3_net16 VDD VDD pfet_06v0 L=20.0u W=0.7u
Mx3_x3_XM44 x3_SZ x3_x3_net26 VSS VSS nfet_06v0 L=1.0u W=1.0u
Mx3_x3_XM4 x3_x3_net29 x3_x3_net1 VDD VDD pfet_06v0 L=1.0u W=10.0u
Mx3_x3_XM5 x3_x3_net4 x3_x3_net6 x3_x3_net29 VDD pfet_06v0 L=1.0u W=10.0u
Mx3_x3_XM6 x3_x3_net4 x3_x3_net4 VSS VSS nfet_06v0 L=1.0u W=1.0u
Mx3_x3_XM7 x3_x3_net28 x3_x3_net1 VDD VDD pfet_06v0 L=1.0u W=10.0u
Mx3_x3_XM8 x3_x3_net3 x3_x3_net6 x3_x3_net28 VDD pfet_06v0 L=1.0u W=10.0u
Mx3_x3_XM9 x3_x3_net3 x3_x3_net4 x3_x3_net27 VSS nfet_06v0 L=1.0u W=5.0u
Mx3_x3_XM10 x3_x3_net27 x3_x3_net3 VSS VSS nfet_06v0 L=1.0u W=5.0u
Mx3_x3_XM1 x3_x3_net6 x3_x3_net6 VDD VDD pfet_06v0 L=1.0u W=2u
Mx3_x3_XM2 x3_x3_net30 x3_x3_net1 VDD VDD pfet_06v0 L=1.0u W=10.0u
Mx3_x3_XM3 x3_x3_net1 x3_x3_net6 x3_x3_net30 VDD pfet_06v0 L=1.0u W=10.0u
Mx3_x3_XM47 x3_x3_net31 x3_x3_net6 VSS VSS nfet_06v0 L=1.0u W=1.0u
Mx3_x3_XM48 x3_x3_net32 x3_x3_net6 VSS VSS nfet_06v0 L=1.0u W=1.0u
Mx3_x3_XM49 x3_x3_net6 x3_x3_net6 x3_x3_net32 VSS nfet_06v0 L=1.0u W=1.0u
Mx3_x3_XM50 x3_x3_net1 x3_x3_net6 x3_x3_net31 VSS nfet_06v0 L=1.0u W=1.0u
Mx3_x4_x1_XM4 x3_x4_x1_net3 x3_x4_net4 VDD VDD pfet_06v0 L=1.0u W=10.0u
Mx3_x4_x1_XM5 x3_x4_net2 x3_x4_net3 x3_x4_x1_net3 VDD pfet_06v0 L=1.0u W=10.0u
Mx3_x4_x1_XM6 x3_x4_net2 x3_x4_net2 VSS VSS nfet_06v0 L=1.0u W=1.0u
Mx3_x4_x1_XM7 x3_x4_x1_net2 x3_x4_net4 VDD VDD pfet_06v0 L=1.0u W=10.0u
Mx3_x4_x1_XM8 x3_x4_net1 x3_x4_net3 x3_x4_x1_net2 VDD pfet_06v0 L=1.0u W=10.0u
Mx3_x4_x1_XM9 x3_x4_net1 x3_x4_net2 x3_x4_x1_net1 VSS nfet_06v0 L=1.0u W=5.0u
Mx3_x4_x1_XM10 x3_x4_x1_net1 x3_x4_net1 VSS VSS nfet_06v0 L=1.0u W=5.0u
Mx3_x4_x1_XM1 x3_x4_net3 x3_x4_net3 VDD VDD pfet_06v0 L=1.0u W=2u
Mx3_x4_x1_XM2 x3_x4_x1_net4 x3_x4_net4 VDD VDD pfet_06v0 L=1.0u W=10.0u
Mx3_x4_x1_XM3 x3_x4_net4 x3_x4_net3 x3_x4_x1_net4 VDD pfet_06v0 L=1.0u W=10.0u
Mx3_x4_x1_XM47 x3_x4_x1_net5 x3_x4_net3 VSS VSS nfet_06v0 L=1.0u W=1.0u
Mx3_x4_x1_XM48 x3_x4_x1_net6 x3_x4_net3 VSS VSS nfet_06v0 L=1.0u W=1.0u
Mx3_x4_x1_XM49 x3_x4_net3 x3_x4_net3 x3_x4_x1_net6 VSS nfet_06v0 L=1.0u W=1.0u
Mx3_x4_x1_XM50 x3_x4_net4 x3_x4_net3 x3_x4_x1_net5 VSS nfet_06v0 L=1.0u W=1.0u
Mx3_x4_x2_XM11 x3_x4_x2_net2 x3_x4_net4 VDD VDD pfet_06v0 L=1.0u W=10.0u
Mx3_x4_x2_XM12 x3_x4_x2_net7 x3_x4_net3 x3_x4_x2_net2 VDD pfet_06v0 L=1.0u W=10.0u
Mx3_x4_x2_XM13 x3_x4_x2_net19 x3_x4_net4 VDD VDD pfet_06v0 L=1.0u W=10.0u
Mx3_x4_x2_XM14 x3_x4_x2_net7 x3_x4_net3 x3_x4_x2_net19 VDD pfet_06v0 L=1.0u W=10.0u
Mx3_x4_x2_XM15_f1 x3_x4_x2_net5 x3_SY x3_x4_x2_net7 VDD pfet_06v0 L=1.0u W=20.0u
Mx3_x4_x2_XM15_f2 x3_x4_x2_net5 x3_SY x3_x4_x2_net7 VDD pfet_06v0 L=1.0u W=20.0u
Mx3_x4_x2_XM16_f1 x3_x4_x2_net4 x3_SX x3_x4_x2_net7 VDD pfet_06v0 L=1.0u W=20.0u
Mx3_x4_x2_XM16_f2 x3_x4_x2_net4 x3_SX x3_x4_x2_net7 VDD pfet_06v0 L=1.0u W=20.0u
Mx3_x4_x2_XM17 x3_x4_x2_net8 x3_x4_net2 x3_x4_x2_net1 VSS nfet_06v0 L=1.0u W=5.0u
Mx3_x4_x2_XM18 x3_x4_x2_net1 x3_x4_net1 VSS VSS nfet_06v0 L=1.0u W=5.0u
Mx3_x4_x2_XM19 x3_x4_x2_net8 x3_x4_net2 x3_x4_x2_net20 VSS nfet_06v0 L=1.0u W=5.0u
Mx3_x4_x2_XM20 x3_x4_x2_net20 x3_x4_net1 VSS VSS nfet_06v0 L=1.0u W=5.0u
Mx3_x4_x2_XM21_f1 x3_x4_x2_net6 x3_SY x3_x4_x2_net8 VSS nfet_06v0 L=1.0u W=10u
Mx3_x4_x2_XM21_f2 x3_x4_x2_net6 x3_SY x3_x4_x2_net8 VSS nfet_06v0 L=1.0u W=10u
Mx3_x4_x2_XM22_f1 x3_x4_x2_net3 x3_SX x3_x4_x2_net8 VSS nfet_06v0 L=1.0u W=10u
Mx3_x4_x2_XM22_f2 x3_x4_x2_net3 x3_SX x3_x4_x2_net8 VSS nfet_06v0 L=1.0u W=10u
Mx3_x4_x2_XM29_f1 x3_x4_x2_net9 x3_x4_net3 x3_x4_x2_net3 VDD pfet_06v0 L=1.0u W=10u
Mx3_x4_x2_XM29_f2 x3_x4_x2_net9 x3_x4_net3 x3_x4_x2_net3 VDD pfet_06v0 L=1.0u W=10u
Mx3_x4_x2_XM30_f1 x3_x4_x2_net12 x3_x4_net3 x3_x4_x2_net6 VDD pfet_06v0 L=1.0u W=10.0u
Mx3_x4_x2_XM30_f2 x3_x4_x2_net12 x3_x4_net3 x3_x4_x2_net6 VDD pfet_06v0 L=1.0u W=10.0u
Mx3_x4_x2_XM31_f1 x3_x4_x2_net3 x3_x4_x2_net9 VDD VDD pfet_06v0 L=1.0u W=20u
Mx3_x4_x2_XM31_f2 x3_x4_x2_net3 x3_x4_x2_net9 VDD VDD pfet_06v0 L=1.0u W=20u
Mx3_x4_x2_XM31_f3 x3_x4_x2_net3 x3_x4_x2_net9 VDD VDD pfet_06v0 L=1.0u W=20u
Mx3_x4_x2_XM31_f4 x3_x4_x2_net3 x3_x4_x2_net9 VDD VDD pfet_06v0 L=1.0u W=20u
Mx3_x4_x2_XM35_f1 x3_x4_x2_net6 x3_x4_x2_net9 VDD VDD pfet_06v0 L=1.0u W=20.0u
Mx3_x4_x2_XM35_f2 x3_x4_x2_net6 x3_x4_x2_net9 VDD VDD pfet_06v0 L=1.0u W=20.0u
Mx3_x4_x2_XM35_f3 x3_x4_x2_net6 x3_x4_x2_net9 VDD VDD pfet_06v0 L=1.0u W=20.0u
Mx3_x4_x2_XM35_f4 x3_x4_x2_net6 x3_x4_x2_net9 VDD VDD pfet_06v0 L=1.0u W=20.0u
Mx3_x4_x2_XM32 x3_x4_x2_net10 x3_x4_x2_net21 x3_x4_x2_net9 VDD pfet_06v0 L=1.0u W=5u
Mx3_x4_x2_XM33 x3_x4_x2_net22 x3_x4_x2_net21 x3_x4_x2_net12 VDD pfet_06v0 L=1.0u W=5.0u
Mx3_x4_x2_XM23_f1 x3_x4_x2_net10 x3_x4_net2 x3_x4_x2_net4 VSS nfet_06v0 L=1.0u W=5u
Mx3_x4_x2_XM23_f2 x3_x4_x2_net10 x3_x4_net2 x3_x4_x2_net4 VSS nfet_06v0 L=1.0u W=5u
Mx3_x4_x2_XM24_f1 x3_x4_x2_net22 x3_x4_net2 x3_x4_x2_net5 VSS nfet_06v0 L=1.0u W=5u
Mx3_x4_x2_XM24_f2 x3_x4_x2_net22 x3_x4_net2 x3_x4_x2_net5 VSS nfet_06v0 L=1.0u W=5u
Mx3_x4_x2_XM25_f1 x3_x4_x2_net4 x3_x4_x2_net10 VSS VSS nfet_06v0 L=1.0u W=10u
Mx3_x4_x2_XM25_f2 x3_x4_x2_net4 x3_x4_x2_net10 VSS VSS nfet_06v0 L=1.0u W=10u
Mx3_x4_x2_XM25_f3 x3_x4_x2_net4 x3_x4_x2_net10 VSS VSS nfet_06v0 L=1.0u W=10u
Mx3_x4_x2_XM25_f4 x3_x4_x2_net4 x3_x4_x2_net10 VSS VSS nfet_06v0 L=1.0u W=10u
Mx3_x4_x2_XM26_f1 x3_x4_x2_net5 x3_x4_x2_net10 VSS VSS nfet_06v0 L=1.0u W=10u
Mx3_x4_x2_XM26_f2 x3_x4_x2_net5 x3_x4_x2_net10 VSS VSS nfet_06v0 L=1.0u W=10u
Mx3_x4_x2_XM26_f3 x3_x4_x2_net5 x3_x4_x2_net10 VSS VSS nfet_06v0 L=1.0u W=10u
Mx3_x4_x2_XM26_f4 x3_x4_x2_net5 x3_x4_x2_net10 VSS VSS nfet_06v0 L=1.0u W=10u
Mx3_x4_x2_XM27 x3_x4_x2_net9 x3_x4_x2_net11 x3_x4_x2_net10 VSS nfet_06v0 L=1.0u W=2.5u
Mx3_x4_x2_XM28 x3_x4_x2_net12 x3_x4_x2_net11 x3_x4_x2_net22 VSS nfet_06v0 L=1.0u W=2.5u
Mx3_x4_x2_XM34 x3_x4_x2_net13 x3_x4_x2_net14 VDD VDD pfet_06v0 L=1.0u W=10.0u
Mx3_x4_x2_XM36 x3_x4_x2_net14 x3_x4_net3 x3_x4_x2_net13 VDD pfet_06v0 L=1.0u W=10.0u
Mx3_x4_x2_XM37 x3_x4_x2_net21 x3_x4_x2_net21 x3_x4_x2_net14 VDD pfet_06v0 L=1.0u W=10.0u
Mx3_x4_x2_XM38 x3_x4_x2_net21 x3_x4_net2 x3_x4_x2_net15 VSS nfet_06v0 L=1.0u W=5.0u
Mx3_x4_x2_XM39 x3_x4_x2_net15 x3_x4_net1 VSS VSS nfet_06v0 L=1.0u W=5.0u
Mx3_x4_x2_XM45 x3_x4_x2_net16 x3_x4_net4 VDD VDD pfet_06v0 L=1.0u W=10.0u
Mx3_x4_x2_XM46 x3_x4_x2_net11 x3_x4_net3 x3_x4_x2_net16 VDD pfet_06v0 L=1.0u W=10.0u
Mx3_x4_x2_XM40 x3_x4_x2_net11 x3_x4_x2_net11 x3_x4_x2_net18 VSS nfet_06v0 L=1.0u W=5.0u
Mx3_x4_x2_XM41 x3_x4_x2_net18 x3_x4_net2 x3_x4_x2_net17 VSS nfet_06v0 L=1.0u W=5.0u
Mx3_x4_x2_XM42 x3_x4_x2_net17 x3_x4_x2_net18 VSS VSS nfet_06v0 L=1.0u W=5.0u
Mx3_x4_x2_XM43_f1 x3_net1 x3_x4_x2_net12 VDD VDD pfet_06v0 L=1.0u W=30u
Mx3_x4_x2_XM43_f2 x3_net1 x3_x4_x2_net12 VDD VDD pfet_06v0 L=1.0u W=30u
Mx3_x4_x2_XM43_f3 x3_net1 x3_x4_x2_net12 VDD VDD pfet_06v0 L=1.0u W=30u
Mx3_x4_x2_XM44_f1 x3_net1 x3_x4_x2_net22 VSS VSS nfet_06v0 L=1.0u W=15u
Mx3_x4_x2_XM44_f2 x3_net1 x3_x4_x2_net22 VSS VSS nfet_06v0 L=1.0u W=15u
Mx3_x4_x2_XM44_f3 x3_net1 x3_x4_x2_net22 VSS VSS nfet_06v0 L=1.0u W=15u
Mx3_x5_x1_XM4 x3_x5_x1_net3 x3_x5_net4 VDD VDD pfet_06v0 L=1.0u W=10.0u
Mx3_x5_x1_XM5 x3_x5_net2 x3_x5_net3 x3_x5_x1_net3 VDD pfet_06v0 L=1.0u W=10.0u
Mx3_x5_x1_XM6 x3_x5_net2 x3_x5_net2 VSS VSS nfet_06v0 L=1.0u W=1.0u
Mx3_x5_x1_XM7 x3_x5_x1_net2 x3_x5_net4 VDD VDD pfet_06v0 L=1.0u W=10.0u
Mx3_x5_x1_XM8 x3_x5_net1 x3_x5_net3 x3_x5_x1_net2 VDD pfet_06v0 L=1.0u W=10.0u
Mx3_x5_x1_XM9 x3_x5_net1 x3_x5_net2 x3_x5_x1_net1 VSS nfet_06v0 L=1.0u W=5.0u
Mx3_x5_x1_XM10 x3_x5_x1_net1 x3_x5_net1 VSS VSS nfet_06v0 L=1.0u W=5.0u
Mx3_x5_x1_XM1 x3_x5_net3 x3_x5_net3 VDD VDD pfet_06v0 L=1.0u W=2u
Mx3_x5_x1_XM2 x3_x5_x1_net4 x3_x5_net4 VDD VDD pfet_06v0 L=1.0u W=10.0u
Mx3_x5_x1_XM3 x3_x5_net4 x3_x5_net3 x3_x5_x1_net4 VDD pfet_06v0 L=1.0u W=10.0u
Mx3_x5_x1_XM47 x3_x5_x1_net5 x3_x5_net3 VSS VSS nfet_06v0 L=1.0u W=1.0u
Mx3_x5_x1_XM48 x3_x5_x1_net6 x3_x5_net3 VSS VSS nfet_06v0 L=1.0u W=1.0u
Mx3_x5_x1_XM49 x3_x5_net3 x3_x5_net3 x3_x5_x1_net6 VSS nfet_06v0 L=1.0u W=1.0u
Mx3_x5_x1_XM50 x3_x5_net4 x3_x5_net3 x3_x5_x1_net5 VSS nfet_06v0 L=1.0u W=1.0u
Mx3_x5_x2_XM11 x3_x5_x2_net2 x3_x5_net4 VDD VDD pfet_06v0 L=1.0u W=10.0u
Mx3_x5_x2_XM12 x3_x5_x2_net7 x3_x5_net3 x3_x5_x2_net2 VDD pfet_06v0 L=1.0u W=10.0u
Mx3_x5_x2_XM13 x3_x5_x2_net19 x3_x5_net4 VDD VDD pfet_06v0 L=1.0u W=10.0u
Mx3_x5_x2_XM14 x3_x5_x2_net7 x3_x5_net3 x3_x5_x2_net19 VDD pfet_06v0 L=1.0u W=10.0u
Mx3_x5_x2_XM15_f1 x3_x5_x2_net5 x3_SZ x3_x5_x2_net7 VDD pfet_06v0 L=1.0u W=20.0u
Mx3_x5_x2_XM15_f2 x3_x5_x2_net5 x3_SZ x3_x5_x2_net7 VDD pfet_06v0 L=1.0u W=20.0u
Mx3_x5_x2_XM16_f1 x3_x5_x2_net4 x3_SX x3_x5_x2_net7 VDD pfet_06v0 L=1.0u W=20.0u
Mx3_x5_x2_XM16_f2 x3_x5_x2_net4 x3_SX x3_x5_x2_net7 VDD pfet_06v0 L=1.0u W=20.0u
Mx3_x5_x2_XM17 x3_x5_x2_net8 x3_x5_net2 x3_x5_x2_net1 VSS nfet_06v0 L=1.0u W=5.0u
Mx3_x5_x2_XM18 x3_x5_x2_net1 x3_x5_net1 VSS VSS nfet_06v0 L=1.0u W=5.0u
Mx3_x5_x2_XM19 x3_x5_x2_net8 x3_x5_net2 x3_x5_x2_net20 VSS nfet_06v0 L=1.0u W=5.0u
Mx3_x5_x2_XM20 x3_x5_x2_net20 x3_x5_net1 VSS VSS nfet_06v0 L=1.0u W=5.0u
Mx3_x5_x2_XM21_f1 x3_x5_x2_net6 x3_SZ x3_x5_x2_net8 VSS nfet_06v0 L=1.0u W=10u
Mx3_x5_x2_XM21_f2 x3_x5_x2_net6 x3_SZ x3_x5_x2_net8 VSS nfet_06v0 L=1.0u W=10u
Mx3_x5_x2_XM22_f1 x3_x5_x2_net3 x3_SX x3_x5_x2_net8 VSS nfet_06v0 L=1.0u W=10u
Mx3_x5_x2_XM22_f2 x3_x5_x2_net3 x3_SX x3_x5_x2_net8 VSS nfet_06v0 L=1.0u W=10u
Mx3_x5_x2_XM29_f1 x3_x5_x2_net9 x3_x5_net3 x3_x5_x2_net3 VDD pfet_06v0 L=1.0u W=10u
Mx3_x5_x2_XM29_f2 x3_x5_x2_net9 x3_x5_net3 x3_x5_x2_net3 VDD pfet_06v0 L=1.0u W=10u
Mx3_x5_x2_XM30_f1 x3_x5_x2_net12 x3_x5_net3 x3_x5_x2_net6 VDD pfet_06v0 L=1.0u W=10.0u
Mx3_x5_x2_XM30_f2 x3_x5_x2_net12 x3_x5_net3 x3_x5_x2_net6 VDD pfet_06v0 L=1.0u W=10.0u
Mx3_x5_x2_XM31_f1 x3_x5_x2_net3 x3_x5_x2_net9 VDD VDD pfet_06v0 L=1.0u W=20u
Mx3_x5_x2_XM31_f2 x3_x5_x2_net3 x3_x5_x2_net9 VDD VDD pfet_06v0 L=1.0u W=20u
Mx3_x5_x2_XM31_f3 x3_x5_x2_net3 x3_x5_x2_net9 VDD VDD pfet_06v0 L=1.0u W=20u
Mx3_x5_x2_XM31_f4 x3_x5_x2_net3 x3_x5_x2_net9 VDD VDD pfet_06v0 L=1.0u W=20u
Mx3_x5_x2_XM35_f1 x3_x5_x2_net6 x3_x5_x2_net9 VDD VDD pfet_06v0 L=1.0u W=20.0u
Mx3_x5_x2_XM35_f2 x3_x5_x2_net6 x3_x5_x2_net9 VDD VDD pfet_06v0 L=1.0u W=20.0u
Mx3_x5_x2_XM35_f3 x3_x5_x2_net6 x3_x5_x2_net9 VDD VDD pfet_06v0 L=1.0u W=20.0u
Mx3_x5_x2_XM35_f4 x3_x5_x2_net6 x3_x5_x2_net9 VDD VDD pfet_06v0 L=1.0u W=20.0u
Mx3_x5_x2_XM32 x3_x5_x2_net10 x3_x5_x2_net21 x3_x5_x2_net9 VDD pfet_06v0 L=1.0u W=5u
Mx3_x5_x2_XM33 x3_x5_x2_net22 x3_x5_x2_net21 x3_x5_x2_net12 VDD pfet_06v0 L=1.0u W=5.0u
Mx3_x5_x2_XM23_f1 x3_x5_x2_net10 x3_x5_net2 x3_x5_x2_net4 VSS nfet_06v0 L=1.0u W=5u
Mx3_x5_x2_XM23_f2 x3_x5_x2_net10 x3_x5_net2 x3_x5_x2_net4 VSS nfet_06v0 L=1.0u W=5u
Mx3_x5_x2_XM24_f1 x3_x5_x2_net22 x3_x5_net2 x3_x5_x2_net5 VSS nfet_06v0 L=1.0u W=5u
Mx3_x5_x2_XM24_f2 x3_x5_x2_net22 x3_x5_net2 x3_x5_x2_net5 VSS nfet_06v0 L=1.0u W=5u
Mx3_x5_x2_XM25_f1 x3_x5_x2_net4 x3_x5_x2_net10 VSS VSS nfet_06v0 L=1.0u W=10u
Mx3_x5_x2_XM25_f2 x3_x5_x2_net4 x3_x5_x2_net10 VSS VSS nfet_06v0 L=1.0u W=10u
Mx3_x5_x2_XM25_f3 x3_x5_x2_net4 x3_x5_x2_net10 VSS VSS nfet_06v0 L=1.0u W=10u
Mx3_x5_x2_XM25_f4 x3_x5_x2_net4 x3_x5_x2_net10 VSS VSS nfet_06v0 L=1.0u W=10u
Mx3_x5_x2_XM26_f1 x3_x5_x2_net5 x3_x5_x2_net10 VSS VSS nfet_06v0 L=1.0u W=10u
Mx3_x5_x2_XM26_f2 x3_x5_x2_net5 x3_x5_x2_net10 VSS VSS nfet_06v0 L=1.0u W=10u
Mx3_x5_x2_XM26_f3 x3_x5_x2_net5 x3_x5_x2_net10 VSS VSS nfet_06v0 L=1.0u W=10u
Mx3_x5_x2_XM26_f4 x3_x5_x2_net5 x3_x5_x2_net10 VSS VSS nfet_06v0 L=1.0u W=10u
Mx3_x5_x2_XM27 x3_x5_x2_net9 x3_x5_x2_net11 x3_x5_x2_net10 VSS nfet_06v0 L=1.0u W=2.5u
Mx3_x5_x2_XM28 x3_x5_x2_net12 x3_x5_x2_net11 x3_x5_x2_net22 VSS nfet_06v0 L=1.0u W=2.5u
Mx3_x5_x2_XM34 x3_x5_x2_net13 x3_x5_x2_net14 VDD VDD pfet_06v0 L=1.0u W=10.0u
Mx3_x5_x2_XM36 x3_x5_x2_net14 x3_x5_net3 x3_x5_x2_net13 VDD pfet_06v0 L=1.0u W=10.0u
Mx3_x5_x2_XM37 x3_x5_x2_net21 x3_x5_x2_net21 x3_x5_x2_net14 VDD pfet_06v0 L=1.0u W=10.0u
Mx3_x5_x2_XM38 x3_x5_x2_net21 x3_x5_net2 x3_x5_x2_net15 VSS nfet_06v0 L=1.0u W=5.0u
Mx3_x5_x2_XM39 x3_x5_x2_net15 x3_x5_net1 VSS VSS nfet_06v0 L=1.0u W=5.0u
Mx3_x5_x2_XM45 x3_x5_x2_net16 x3_x5_net4 VDD VDD pfet_06v0 L=1.0u W=10.0u
Mx3_x5_x2_XM46 x3_x5_x2_net11 x3_x5_net3 x3_x5_x2_net16 VDD pfet_06v0 L=1.0u W=10.0u
Mx3_x5_x2_XM40 x3_x5_x2_net11 x3_x5_x2_net11 x3_x5_x2_net18 VSS nfet_06v0 L=1.0u W=5.0u
Mx3_x5_x2_XM41 x3_x5_x2_net18 x3_x5_net2 x3_x5_x2_net17 VSS nfet_06v0 L=1.0u W=5.0u
Mx3_x5_x2_XM42 x3_x5_x2_net17 x3_x5_x2_net18 VSS VSS nfet_06v0 L=1.0u W=5.0u
Mx3_x5_x2_XM43_f1 x3_net2 x3_x5_x2_net12 VDD VDD pfet_06v0 L=1.0u W=30u
Mx3_x5_x2_XM43_f2 x3_net2 x3_x5_x2_net12 VDD VDD pfet_06v0 L=1.0u W=30u
Mx3_x5_x2_XM43_f3 x3_net2 x3_x5_x2_net12 VDD VDD pfet_06v0 L=1.0u W=30u
Mx3_x5_x2_XM44_f1 x3_net2 x3_x5_x2_net22 VSS VSS nfet_06v0 L=1.0u W=15u
Mx3_x5_x2_XM44_f2 x3_net2 x3_x5_x2_net22 VSS VSS nfet_06v0 L=1.0u W=15u
Mx3_x5_x2_XM44_f3 x3_net2 x3_x5_x2_net22 VSS VSS nfet_06v0 L=1.0u W=15u
Mx3_x6_x1_XM4 x3_x6_x1_net3 x3_x6_net4 VDD VDD pfet_06v0 L=1.0u W=10.0u
Mx3_x6_x1_XM5 x3_x6_net2 x3_x6_net3 x3_x6_x1_net3 VDD pfet_06v0 L=1.0u W=10.0u
Mx3_x6_x1_XM6 x3_x6_net2 x3_x6_net2 VSS VSS nfet_06v0 L=1.0u W=1.0u
Mx3_x6_x1_XM7 x3_x6_x1_net2 x3_x6_net4 VDD VDD pfet_06v0 L=1.0u W=10.0u
Mx3_x6_x1_XM8 x3_x6_net1 x3_x6_net3 x3_x6_x1_net2 VDD pfet_06v0 L=1.0u W=10.0u
Mx3_x6_x1_XM9 x3_x6_net1 x3_x6_net2 x3_x6_x1_net1 VSS nfet_06v0 L=1.0u W=5.0u
Mx3_x6_x1_XM10 x3_x6_x1_net1 x3_x6_net1 VSS VSS nfet_06v0 L=1.0u W=5.0u
Mx3_x6_x1_XM1 x3_x6_net3 x3_x6_net3 VDD VDD pfet_06v0 L=1.0u W=2u
Mx3_x6_x1_XM2 x3_x6_x1_net4 x3_x6_net4 VDD VDD pfet_06v0 L=1.0u W=10.0u
Mx3_x6_x1_XM3 x3_x6_net4 x3_x6_net3 x3_x6_x1_net4 VDD pfet_06v0 L=1.0u W=10.0u
Mx3_x6_x1_XM47 x3_x6_x1_net5 x3_x6_net3 VSS VSS nfet_06v0 L=1.0u W=1.0u
Mx3_x6_x1_XM48 x3_x6_x1_net6 x3_x6_net3 VSS VSS nfet_06v0 L=1.0u W=1.0u
Mx3_x6_x1_XM49 x3_x6_net3 x3_x6_net3 x3_x6_x1_net6 VSS nfet_06v0 L=1.0u W=1.0u
Mx3_x6_x1_XM50 x3_x6_net4 x3_x6_net3 x3_x6_x1_net5 VSS nfet_06v0 L=1.0u W=1.0u
Mx3_x6_x2_XM11 x3_x6_x2_net2 x3_x6_net4 VDD VDD pfet_06v0 L=1.0u W=10.0u
Mx3_x6_x2_XM12 x3_x6_x2_net7 x3_x6_net3 x3_x6_x2_net2 VDD pfet_06v0 L=1.0u W=10.0u
Mx3_x6_x2_XM13 x3_x6_x2_net19 x3_x6_net4 VDD VDD pfet_06v0 L=1.0u W=10.0u
Mx3_x6_x2_XM14 x3_x6_x2_net7 x3_x6_net3 x3_x6_x2_net19 VDD pfet_06v0 L=1.0u W=10.0u
Mx3_x6_x2_XM15_f1 x3_x6_x2_net5 x3_SZ x3_x6_x2_net7 VDD pfet_06v0 L=1.0u W=20.0u
Mx3_x6_x2_XM15_f2 x3_x6_x2_net5 x3_SZ x3_x6_x2_net7 VDD pfet_06v0 L=1.0u W=20.0u
Mx3_x6_x2_XM16_f1 x3_x6_x2_net4 x3_SY x3_x6_x2_net7 VDD pfet_06v0 L=1.0u W=20.0u
Mx3_x6_x2_XM16_f2 x3_x6_x2_net4 x3_SY x3_x6_x2_net7 VDD pfet_06v0 L=1.0u W=20.0u
Mx3_x6_x2_XM17 x3_x6_x2_net8 x3_x6_net2 x3_x6_x2_net1 VSS nfet_06v0 L=1.0u W=5.0u
Mx3_x6_x2_XM18 x3_x6_x2_net1 x3_x6_net1 VSS VSS nfet_06v0 L=1.0u W=5.0u
Mx3_x6_x2_XM19 x3_x6_x2_net8 x3_x6_net2 x3_x6_x2_net20 VSS nfet_06v0 L=1.0u W=5.0u
Mx3_x6_x2_XM20 x3_x6_x2_net20 x3_x6_net1 VSS VSS nfet_06v0 L=1.0u W=5.0u
Mx3_x6_x2_XM21_f1 x3_x6_x2_net6 x3_SZ x3_x6_x2_net8 VSS nfet_06v0 L=1.0u W=10u
Mx3_x6_x2_XM21_f2 x3_x6_x2_net6 x3_SZ x3_x6_x2_net8 VSS nfet_06v0 L=1.0u W=10u
Mx3_x6_x2_XM22_f1 x3_x6_x2_net3 x3_SY x3_x6_x2_net8 VSS nfet_06v0 L=1.0u W=10u
Mx3_x6_x2_XM22_f2 x3_x6_x2_net3 x3_SY x3_x6_x2_net8 VSS nfet_06v0 L=1.0u W=10u
Mx3_x6_x2_XM29_f1 x3_x6_x2_net9 x3_x6_net3 x3_x6_x2_net3 VDD pfet_06v0 L=1.0u W=10u
Mx3_x6_x2_XM29_f2 x3_x6_x2_net9 x3_x6_net3 x3_x6_x2_net3 VDD pfet_06v0 L=1.0u W=10u
Mx3_x6_x2_XM30_f1 x3_x6_x2_net12 x3_x6_net3 x3_x6_x2_net6 VDD pfet_06v0 L=1.0u W=10.0u
Mx3_x6_x2_XM30_f2 x3_x6_x2_net12 x3_x6_net3 x3_x6_x2_net6 VDD pfet_06v0 L=1.0u W=10.0u
Mx3_x6_x2_XM31_f1 x3_x6_x2_net3 x3_x6_x2_net9 VDD VDD pfet_06v0 L=1.0u W=20u
Mx3_x6_x2_XM31_f2 x3_x6_x2_net3 x3_x6_x2_net9 VDD VDD pfet_06v0 L=1.0u W=20u
Mx3_x6_x2_XM31_f3 x3_x6_x2_net3 x3_x6_x2_net9 VDD VDD pfet_06v0 L=1.0u W=20u
Mx3_x6_x2_XM31_f4 x3_x6_x2_net3 x3_x6_x2_net9 VDD VDD pfet_06v0 L=1.0u W=20u
Mx3_x6_x2_XM35_f1 x3_x6_x2_net6 x3_x6_x2_net9 VDD VDD pfet_06v0 L=1.0u W=20.0u
Mx3_x6_x2_XM35_f2 x3_x6_x2_net6 x3_x6_x2_net9 VDD VDD pfet_06v0 L=1.0u W=20.0u
Mx3_x6_x2_XM35_f3 x3_x6_x2_net6 x3_x6_x2_net9 VDD VDD pfet_06v0 L=1.0u W=20.0u
Mx3_x6_x2_XM35_f4 x3_x6_x2_net6 x3_x6_x2_net9 VDD VDD pfet_06v0 L=1.0u W=20.0u
Mx3_x6_x2_XM32 x3_x6_x2_net10 x3_x6_x2_net21 x3_x6_x2_net9 VDD pfet_06v0 L=1.0u W=5u
Mx3_x6_x2_XM33 x3_x6_x2_net22 x3_x6_x2_net21 x3_x6_x2_net12 VDD pfet_06v0 L=1.0u W=5.0u
Mx3_x6_x2_XM23_f1 x3_x6_x2_net10 x3_x6_net2 x3_x6_x2_net4 VSS nfet_06v0 L=1.0u W=5u
Mx3_x6_x2_XM23_f2 x3_x6_x2_net10 x3_x6_net2 x3_x6_x2_net4 VSS nfet_06v0 L=1.0u W=5u
Mx3_x6_x2_XM24_f1 x3_x6_x2_net22 x3_x6_net2 x3_x6_x2_net5 VSS nfet_06v0 L=1.0u W=5u
Mx3_x6_x2_XM24_f2 x3_x6_x2_net22 x3_x6_net2 x3_x6_x2_net5 VSS nfet_06v0 L=1.0u W=5u
Mx3_x6_x2_XM25_f1 x3_x6_x2_net4 x3_x6_x2_net10 VSS VSS nfet_06v0 L=1.0u W=10u
Mx3_x6_x2_XM25_f2 x3_x6_x2_net4 x3_x6_x2_net10 VSS VSS nfet_06v0 L=1.0u W=10u
Mx3_x6_x2_XM25_f3 x3_x6_x2_net4 x3_x6_x2_net10 VSS VSS nfet_06v0 L=1.0u W=10u
Mx3_x6_x2_XM25_f4 x3_x6_x2_net4 x3_x6_x2_net10 VSS VSS nfet_06v0 L=1.0u W=10u
Mx3_x6_x2_XM26_f1 x3_x6_x2_net5 x3_x6_x2_net10 VSS VSS nfet_06v0 L=1.0u W=10u
Mx3_x6_x2_XM26_f2 x3_x6_x2_net5 x3_x6_x2_net10 VSS VSS nfet_06v0 L=1.0u W=10u
Mx3_x6_x2_XM26_f3 x3_x6_x2_net5 x3_x6_x2_net10 VSS VSS nfet_06v0 L=1.0u W=10u
Mx3_x6_x2_XM26_f4 x3_x6_x2_net5 x3_x6_x2_net10 VSS VSS nfet_06v0 L=1.0u W=10u
Mx3_x6_x2_XM27 x3_x6_x2_net9 x3_x6_x2_net11 x3_x6_x2_net10 VSS nfet_06v0 L=1.0u W=2.5u
Mx3_x6_x2_XM28 x3_x6_x2_net12 x3_x6_x2_net11 x3_x6_x2_net22 VSS nfet_06v0 L=1.0u W=2.5u
Mx3_x6_x2_XM34 x3_x6_x2_net13 x3_x6_x2_net14 VDD VDD pfet_06v0 L=1.0u W=10.0u
Mx3_x6_x2_XM36 x3_x6_x2_net14 x3_x6_net3 x3_x6_x2_net13 VDD pfet_06v0 L=1.0u W=10.0u
Mx3_x6_x2_XM37 x3_x6_x2_net21 x3_x6_x2_net21 x3_x6_x2_net14 VDD pfet_06v0 L=1.0u W=10.0u
Mx3_x6_x2_XM38 x3_x6_x2_net21 x3_x6_net2 x3_x6_x2_net15 VSS nfet_06v0 L=1.0u W=5.0u
Mx3_x6_x2_XM39 x3_x6_x2_net15 x3_x6_net1 VSS VSS nfet_06v0 L=1.0u W=5.0u
Mx3_x6_x2_XM45 x3_x6_x2_net16 x3_x6_net4 VDD VDD pfet_06v0 L=1.0u W=10.0u
Mx3_x6_x2_XM46 x3_x6_x2_net11 x3_x6_net3 x3_x6_x2_net16 VDD pfet_06v0 L=1.0u W=10.0u
Mx3_x6_x2_XM40 x3_x6_x2_net11 x3_x6_x2_net11 x3_x6_x2_net18 VSS nfet_06v0 L=1.0u W=5.0u
Mx3_x6_x2_XM41 x3_x6_x2_net18 x3_x6_net2 x3_x6_x2_net17 VSS nfet_06v0 L=1.0u W=5.0u
Mx3_x6_x2_XM42 x3_x6_x2_net17 x3_x6_x2_net18 VSS VSS nfet_06v0 L=1.0u W=5.0u
Mx3_x6_x2_XM43_f1 x3_net3 x3_x6_x2_net12 VDD VDD pfet_06v0 L=1.0u W=30u
Mx3_x6_x2_XM43_f2 x3_net3 x3_x6_x2_net12 VDD VDD pfet_06v0 L=1.0u W=30u
Mx3_x6_x2_XM43_f3 x3_net3 x3_x6_x2_net12 VDD VDD pfet_06v0 L=1.0u W=30u
Mx3_x6_x2_XM44_f1 x3_net3 x3_x6_x2_net22 VSS VSS nfet_06v0 L=1.0u W=15u
Mx3_x6_x2_XM44_f2 x3_net3 x3_x6_x2_net22 VSS VSS nfet_06v0 L=1.0u W=15u
Mx3_x6_x2_XM44_f3 x3_net3 x3_x6_x2_net22 VSS VSS nfet_06v0 L=1.0u W=15u
Mx3_x7_x1_XM4 x3_x7_x1_net1 x3_net3 Z3 VDD pfet_06v0 L=1.0u W=3.0u
Mx3_x7_x1_XM5 VDD x3_net2 x3_x7_x1_net1 VDD pfet_06v0 L=1.0u W=3.0u
Mx3_x7_x1_XM7 VSS x3_net3 Z3 VSS nfet_06v0 L=1u W=1u
Mx3_x7_x1_XM1 VSS x3_net2 Z3 VSS nfet_06v0 L=1u W=1u
Mx3_x7_x2_x2_XM4 x3_x7_x2_net1 x3_net1 VDD VDD pfet_06v0 L=1.0u W=3.0u
Mx3_x7_x2_x2_XM5 VSS x3_net1 x3_x7_x2_net1 VSS nfet_06v0 L=1u W=1u
Mx3_x7_x2_x3_XM4 Y3 x3_x7_x2_x3_net1 VDD VDD pfet_06v0 L=1.0u W=3.0u
Mx3_x7_x2_x3_XM5 VSS x3_x7_x2_x3_net1 Y3 VSS nfet_06v0 L=1u W=1u
Mx3_x7_x2_x3_XM2 VDD x3_net3 x3_x7_x2_x3_net1 VDD pfet_06v0 L=1.0u W=3.0u
Mx3_x7_x2_x3_XM1 VDD x3_x7_x2_net1 x3_x7_x2_x3_net1 VDD pfet_06v0 L=1.0u W=3.0u
Mx3_x7_x2_x3_XM3 VSS x3_net3 x3_x7_x2_x3_net2 VSS nfet_06v0 L=1u W=1u
Mx3_x7_x2_x3_XM6 x3_x7_x2_x3_net2 x3_x7_x2_net1 x3_x7_x2_x3_net1 VSS nfet_06v0 L=1u W=1u
Mx3_x7_x3_x2_XM4 X3 x3_x7_x3_x2_net1 VDD VDD pfet_06v0 L=1.0u W=3.0u
Mx3_x7_x3_x2_XM5 VSS x3_x7_x3_x2_net1 X3 VSS nfet_06v0 L=1u W=1u
Mx3_x7_x3_x2_XM2 VDD x3_net1 x3_x7_x3_x2_net1 VDD pfet_06v0 L=1.0u W=3.0u
Mx3_x7_x3_x2_XM1 VDD x3_net2 x3_x7_x3_x2_net1 VDD pfet_06v0 L=1.0u W=3.0u
Mx3_x7_x3_x2_XM3 VSS x3_net1 x3_x7_x3_x2_net2 VSS nfet_06v0 L=1u W=1u
Mx3_x7_x3_x2_XM6 x3_x7_x3_x2_net2 x3_net2 x3_x7_x3_x2_net1 VSS nfet_06v0 L=1u W=1u
Mx4_x1_XM11 x4_x1_net5 x4_x1_net1 VDD VDD pfet_06v0 L=1.0u W=10.0u
Mx4_x1_XM12 x4_x1_net11 x4_x1_net6 x4_x1_net5 VDD pfet_06v0 L=1.0u W=10.0u
Mx4_x1_XM13 x4_x1_net23 x4_x1_net1 VDD VDD pfet_06v0 L=1.0u W=10.0u
Mx4_x1_XM14 x4_x1_net11 x4_x1_net6 x4_x1_net23 VDD pfet_06v0 L=1.0u W=10.0u
Mx4_x1_XM15 x4_x1_net9 S3P x4_x1_net11 VDD pfet_06v0 L=1.0u W=10.0u
Mx4_x1_XM16 x4_x1_net8 S3N x4_x1_net11 VDD pfet_06v0 L=1.0u W=10.0u
Mx4_x1_XM17 x4_x1_net12 x4_x1_net4 x4_x1_net2 VSS nfet_06v0 L=1.0u W=5.0u
Mx4_x1_XM18 x4_x1_net2 x4_x1_net3 VSS VSS nfet_06v0 L=1.0u W=5.0u
Mx4_x1_XM19 x4_x1_net12 x4_x1_net4 x4_x1_net24 VSS nfet_06v0 L=1.0u W=5.0u
Mx4_x1_XM20 x4_x1_net24 x4_x1_net3 VSS VSS nfet_06v0 L=1.0u W=5.0u
Mx4_x1_XM21 x4_x1_net10 S3P x4_x1_net12 VSS nfet_06v0 L=1.0u W=5u
Mx4_x1_XM22 x4_x1_net7 S3N x4_x1_net12 VSS nfet_06v0 L=1.0u W=5u
Mx4_x1_XM29 x4_x1_net13 x4_x1_net6 x4_x1_net7 VDD pfet_06v0 L=1.0u W=5u
Mx4_x1_XM30 x4_x1_net16 x4_x1_net6 x4_x1_net10 VDD pfet_06v0 L=1.0u W=5u
Mx4_x1_XM31 x4_x1_net7 x4_x1_net13 VDD VDD pfet_06v0 L=1.0u W=5u
Mx4_x1_XM35 x4_x1_net10 x4_x1_net13 VDD VDD pfet_06v0 L=1.0u W=5u
Mx4_x1_XM32 x4_x1_net14 x4_x1_net25 x4_x1_net13 VDD pfet_06v0 L=1.0u W=5.0u
Mx4_x1_XM33 x4_x1_net26 x4_x1_net25 x4_x1_net16 VDD pfet_06v0 L=1.0u W=5.0u
Mx4_x1_XM23 x4_x1_net14 x4_x1_net4 x4_x1_net8 VSS nfet_06v0 L=1.0u W=2.5u
Mx4_x1_XM24 x4_x1_net26 x4_x1_net4 x4_x1_net9 VSS nfet_06v0 L=1.0u W=2.5u
Mx4_x1_XM25 x4_x1_net8 x4_x1_net14 VSS VSS nfet_06v0 L=1.0u W=2.5u
Mx4_x1_XM26 x4_x1_net9 x4_x1_net14 VSS VSS nfet_06v0 L=1.0u W=2.5u
Mx4_x1_XM27 x4_x1_net13 x4_x1_net15 x4_x1_net14 VSS nfet_06v0 L=1.0u W=2.5u
Mx4_x1_XM28 x4_x1_net16 x4_x1_net15 x4_x1_net26 VSS nfet_06v0 L=1.0u W=2.5u
Mx4_x1_XM34 x4_x1_net17 x4_x1_net18 VDD VDD pfet_06v0 L=1.0u W=10.0u
Mx4_x1_XM36 x4_x1_net18 x4_x1_net6 x4_x1_net17 VDD pfet_06v0 L=1.0u W=10.0u
Mx4_x1_XM37 x4_x1_net25 x4_x1_net25 x4_x1_net18 VDD pfet_06v0 L=1.0u W=10.0u
Mx4_x1_XM38 x4_x1_net25 x4_x1_net4 x4_x1_net19 VSS nfet_06v0 L=1.0u W=5.0u
Mx4_x1_XM39 x4_x1_net19 x4_x1_net3 VSS VSS nfet_06v0 L=1.0u W=5.0u
Mx4_x1_XM45 x4_x1_net20 x4_x1_net1 VDD VDD pfet_06v0 L=1.0u W=10.0u
Mx4_x1_XM46 x4_x1_net15 x4_x1_net6 x4_x1_net20 VDD pfet_06v0 L=1.0u W=10.0u
Mx4_x1_XM40 x4_x1_net15 x4_x1_net15 x4_x1_net22 VSS nfet_06v0 L=1.0u W=5.0u
Mx4_x1_XM41 x4_x1_net22 x4_x1_net4 x4_x1_net21 VSS nfet_06v0 L=1.0u W=5.0u
Mx4_x1_XM42 x4_x1_net21 x4_x1_net22 VSS VSS nfet_06v0 L=1.0u W=5.0u
Mx4_x1_XM43 x4_SX x4_x1_net16 VDD VDD pfet_06v0 L=20.0u W=0.7u
Mx4_x1_XM44 x4_SX x4_x1_net26 VSS VSS nfet_06v0 L=1.0u W=1.0u
Mx4_x1_XM4 x4_x1_net29 x4_x1_net1 VDD VDD pfet_06v0 L=1.0u W=10.0u
Mx4_x1_XM5 x4_x1_net4 x4_x1_net6 x4_x1_net29 VDD pfet_06v0 L=1.0u W=10.0u
Mx4_x1_XM6 x4_x1_net4 x4_x1_net4 VSS VSS nfet_06v0 L=1.0u W=1.0u
Mx4_x1_XM7 x4_x1_net28 x4_x1_net1 VDD VDD pfet_06v0 L=1.0u W=10.0u
Mx4_x1_XM8 x4_x1_net3 x4_x1_net6 x4_x1_net28 VDD pfet_06v0 L=1.0u W=10.0u
Mx4_x1_XM9 x4_x1_net3 x4_x1_net4 x4_x1_net27 VSS nfet_06v0 L=1.0u W=5.0u
Mx4_x1_XM10 x4_x1_net27 x4_x1_net3 VSS VSS nfet_06v0 L=1.0u W=5.0u
Mx4_x1_XM1 x4_x1_net6 x4_x1_net6 VDD VDD pfet_06v0 L=1.0u W=2u
Mx4_x1_XM2 x4_x1_net30 x4_x1_net1 VDD VDD pfet_06v0 L=1.0u W=10.0u
Mx4_x1_XM3 x4_x1_net1 x4_x1_net6 x4_x1_net30 VDD pfet_06v0 L=1.0u W=10.0u
Mx4_x1_XM47 x4_x1_net31 x4_x1_net6 VSS VSS nfet_06v0 L=1.0u W=1.0u
Mx4_x1_XM48 x4_x1_net32 x4_x1_net6 VSS VSS nfet_06v0 L=1.0u W=1.0u
Mx4_x1_XM49 x4_x1_net6 x4_x1_net6 x4_x1_net32 VSS nfet_06v0 L=1.0u W=1.0u
Mx4_x1_XM50 x4_x1_net1 x4_x1_net6 x4_x1_net31 VSS nfet_06v0 L=1.0u W=1.0u
Mx4_x2_XM11 x4_x2_net5 x4_x2_net1 VDD VDD pfet_06v0 L=1.0u W=10.0u
Mx4_x2_XM12 x4_x2_net11 x4_x2_net6 x4_x2_net5 VDD pfet_06v0 L=1.0u W=10.0u
Mx4_x2_XM13 x4_x2_net23 x4_x2_net1 VDD VDD pfet_06v0 L=1.0u W=10.0u
Mx4_x2_XM14 x4_x2_net11 x4_x2_net6 x4_x2_net23 VDD pfet_06v0 L=1.0u W=10.0u
Mx4_x2_XM15 x4_x2_net9 S4P x4_x2_net11 VDD pfet_06v0 L=1.0u W=10.0u
Mx4_x2_XM16 x4_x2_net8 S4N x4_x2_net11 VDD pfet_06v0 L=1.0u W=10.0u
Mx4_x2_XM17 x4_x2_net12 x4_x2_net4 x4_x2_net2 VSS nfet_06v0 L=1.0u W=5.0u
Mx4_x2_XM18 x4_x2_net2 x4_x2_net3 VSS VSS nfet_06v0 L=1.0u W=5.0u
Mx4_x2_XM19 x4_x2_net12 x4_x2_net4 x4_x2_net24 VSS nfet_06v0 L=1.0u W=5.0u
Mx4_x2_XM20 x4_x2_net24 x4_x2_net3 VSS VSS nfet_06v0 L=1.0u W=5.0u
Mx4_x2_XM21 x4_x2_net10 S4P x4_x2_net12 VSS nfet_06v0 L=1.0u W=5u
Mx4_x2_XM22 x4_x2_net7 S4N x4_x2_net12 VSS nfet_06v0 L=1.0u W=5u
Mx4_x2_XM29 x4_x2_net13 x4_x2_net6 x4_x2_net7 VDD pfet_06v0 L=1.0u W=5u
Mx4_x2_XM30 x4_x2_net16 x4_x2_net6 x4_x2_net10 VDD pfet_06v0 L=1.0u W=5u
Mx4_x2_XM31 x4_x2_net7 x4_x2_net13 VDD VDD pfet_06v0 L=1.0u W=5u
Mx4_x2_XM35 x4_x2_net10 x4_x2_net13 VDD VDD pfet_06v0 L=1.0u W=5u
Mx4_x2_XM32 x4_x2_net14 x4_x2_net25 x4_x2_net13 VDD pfet_06v0 L=1.0u W=5.0u
Mx4_x2_XM33 x4_x2_net26 x4_x2_net25 x4_x2_net16 VDD pfet_06v0 L=1.0u W=5.0u
Mx4_x2_XM23 x4_x2_net14 x4_x2_net4 x4_x2_net8 VSS nfet_06v0 L=1.0u W=2.5u
Mx4_x2_XM24 x4_x2_net26 x4_x2_net4 x4_x2_net9 VSS nfet_06v0 L=1.0u W=2.5u
Mx4_x2_XM25 x4_x2_net8 x4_x2_net14 VSS VSS nfet_06v0 L=1.0u W=2.5u
Mx4_x2_XM26 x4_x2_net9 x4_x2_net14 VSS VSS nfet_06v0 L=1.0u W=2.5u
Mx4_x2_XM27 x4_x2_net13 x4_x2_net15 x4_x2_net14 VSS nfet_06v0 L=1.0u W=2.5u
Mx4_x2_XM28 x4_x2_net16 x4_x2_net15 x4_x2_net26 VSS nfet_06v0 L=1.0u W=2.5u
Mx4_x2_XM34 x4_x2_net17 x4_x2_net18 VDD VDD pfet_06v0 L=1.0u W=10.0u
Mx4_x2_XM36 x4_x2_net18 x4_x2_net6 x4_x2_net17 VDD pfet_06v0 L=1.0u W=10.0u
Mx4_x2_XM37 x4_x2_net25 x4_x2_net25 x4_x2_net18 VDD pfet_06v0 L=1.0u W=10.0u
Mx4_x2_XM38 x4_x2_net25 x4_x2_net4 x4_x2_net19 VSS nfet_06v0 L=1.0u W=5.0u
Mx4_x2_XM39 x4_x2_net19 x4_x2_net3 VSS VSS nfet_06v0 L=1.0u W=5.0u
Mx4_x2_XM45 x4_x2_net20 x4_x2_net1 VDD VDD pfet_06v0 L=1.0u W=10.0u
Mx4_x2_XM46 x4_x2_net15 x4_x2_net6 x4_x2_net20 VDD pfet_06v0 L=1.0u W=10.0u
Mx4_x2_XM40 x4_x2_net15 x4_x2_net15 x4_x2_net22 VSS nfet_06v0 L=1.0u W=5.0u
Mx4_x2_XM41 x4_x2_net22 x4_x2_net4 x4_x2_net21 VSS nfet_06v0 L=1.0u W=5.0u
Mx4_x2_XM42 x4_x2_net21 x4_x2_net22 VSS VSS nfet_06v0 L=1.0u W=5.0u
Mx4_x2_XM43 x4_SY x4_x2_net16 VDD VDD pfet_06v0 L=20.0u W=0.7u
Mx4_x2_XM44 x4_SY x4_x2_net26 VSS VSS nfet_06v0 L=1.0u W=1.0u
Mx4_x2_XM4 x4_x2_net29 x4_x2_net1 VDD VDD pfet_06v0 L=1.0u W=10.0u
Mx4_x2_XM5 x4_x2_net4 x4_x2_net6 x4_x2_net29 VDD pfet_06v0 L=1.0u W=10.0u
Mx4_x2_XM6 x4_x2_net4 x4_x2_net4 VSS VSS nfet_06v0 L=1.0u W=1.0u
Mx4_x2_XM7 x4_x2_net28 x4_x2_net1 VDD VDD pfet_06v0 L=1.0u W=10.0u
Mx4_x2_XM8 x4_x2_net3 x4_x2_net6 x4_x2_net28 VDD pfet_06v0 L=1.0u W=10.0u
Mx4_x2_XM9 x4_x2_net3 x4_x2_net4 x4_x2_net27 VSS nfet_06v0 L=1.0u W=5.0u
Mx4_x2_XM10 x4_x2_net27 x4_x2_net3 VSS VSS nfet_06v0 L=1.0u W=5.0u
Mx4_x2_XM1 x4_x2_net6 x4_x2_net6 VDD VDD pfet_06v0 L=1.0u W=2u
Mx4_x2_XM2 x4_x2_net30 x4_x2_net1 VDD VDD pfet_06v0 L=1.0u W=10.0u
Mx4_x2_XM3 x4_x2_net1 x4_x2_net6 x4_x2_net30 VDD pfet_06v0 L=1.0u W=10.0u
Mx4_x2_XM47 x4_x2_net31 x4_x2_net6 VSS VSS nfet_06v0 L=1.0u W=1.0u
Mx4_x2_XM48 x4_x2_net32 x4_x2_net6 VSS VSS nfet_06v0 L=1.0u W=1.0u
Mx4_x2_XM49 x4_x2_net6 x4_x2_net6 x4_x2_net32 VSS nfet_06v0 L=1.0u W=1.0u
Mx4_x2_XM50 x4_x2_net1 x4_x2_net6 x4_x2_net31 VSS nfet_06v0 L=1.0u W=1.0u
Mx4_x3_XM11 x4_x3_net5 x4_x3_net1 VDD VDD pfet_06v0 L=1.0u W=10.0u
Mx4_x3_XM12 x4_x3_net11 x4_x3_net6 x4_x3_net5 VDD pfet_06v0 L=1.0u W=10.0u
Mx4_x3_XM13 x4_x3_net23 x4_x3_net1 VDD VDD pfet_06v0 L=1.0u W=10.0u
Mx4_x3_XM14 x4_x3_net11 x4_x3_net6 x4_x3_net23 VDD pfet_06v0 L=1.0u W=10.0u
Mx4_x3_XM15 x4_x3_net9 S2P x4_x3_net11 VDD pfet_06v0 L=1.0u W=10.0u
Mx4_x3_XM16 x4_x3_net8 S2N x4_x3_net11 VDD pfet_06v0 L=1.0u W=10.0u
Mx4_x3_XM17 x4_x3_net12 x4_x3_net4 x4_x3_net2 VSS nfet_06v0 L=1.0u W=5.0u
Mx4_x3_XM18 x4_x3_net2 x4_x3_net3 VSS VSS nfet_06v0 L=1.0u W=5.0u
Mx4_x3_XM19 x4_x3_net12 x4_x3_net4 x4_x3_net24 VSS nfet_06v0 L=1.0u W=5.0u
Mx4_x3_XM20 x4_x3_net24 x4_x3_net3 VSS VSS nfet_06v0 L=1.0u W=5.0u
Mx4_x3_XM21 x4_x3_net10 S2P x4_x3_net12 VSS nfet_06v0 L=1.0u W=5u
Mx4_x3_XM22 x4_x3_net7 S2N x4_x3_net12 VSS nfet_06v0 L=1.0u W=5u
Mx4_x3_XM29 x4_x3_net13 x4_x3_net6 x4_x3_net7 VDD pfet_06v0 L=1.0u W=5u
Mx4_x3_XM30 x4_x3_net16 x4_x3_net6 x4_x3_net10 VDD pfet_06v0 L=1.0u W=5u
Mx4_x3_XM31 x4_x3_net7 x4_x3_net13 VDD VDD pfet_06v0 L=1.0u W=5u
Mx4_x3_XM35 x4_x3_net10 x4_x3_net13 VDD VDD pfet_06v0 L=1.0u W=5u
Mx4_x3_XM32 x4_x3_net14 x4_x3_net25 x4_x3_net13 VDD pfet_06v0 L=1.0u W=5.0u
Mx4_x3_XM33 x4_x3_net26 x4_x3_net25 x4_x3_net16 VDD pfet_06v0 L=1.0u W=5.0u
Mx4_x3_XM23 x4_x3_net14 x4_x3_net4 x4_x3_net8 VSS nfet_06v0 L=1.0u W=2.5u
Mx4_x3_XM24 x4_x3_net26 x4_x3_net4 x4_x3_net9 VSS nfet_06v0 L=1.0u W=2.5u
Mx4_x3_XM25 x4_x3_net8 x4_x3_net14 VSS VSS nfet_06v0 L=1.0u W=2.5u
Mx4_x3_XM26 x4_x3_net9 x4_x3_net14 VSS VSS nfet_06v0 L=1.0u W=2.5u
Mx4_x3_XM27 x4_x3_net13 x4_x3_net15 x4_x3_net14 VSS nfet_06v0 L=1.0u W=2.5u
Mx4_x3_XM28 x4_x3_net16 x4_x3_net15 x4_x3_net26 VSS nfet_06v0 L=1.0u W=2.5u
Mx4_x3_XM34 x4_x3_net17 x4_x3_net18 VDD VDD pfet_06v0 L=1.0u W=10.0u
Mx4_x3_XM36 x4_x3_net18 x4_x3_net6 x4_x3_net17 VDD pfet_06v0 L=1.0u W=10.0u
Mx4_x3_XM37 x4_x3_net25 x4_x3_net25 x4_x3_net18 VDD pfet_06v0 L=1.0u W=10.0u
Mx4_x3_XM38 x4_x3_net25 x4_x3_net4 x4_x3_net19 VSS nfet_06v0 L=1.0u W=5.0u
Mx4_x3_XM39 x4_x3_net19 x4_x3_net3 VSS VSS nfet_06v0 L=1.0u W=5.0u
Mx4_x3_XM45 x4_x3_net20 x4_x3_net1 VDD VDD pfet_06v0 L=1.0u W=10.0u
Mx4_x3_XM46 x4_x3_net15 x4_x3_net6 x4_x3_net20 VDD pfet_06v0 L=1.0u W=10.0u
Mx4_x3_XM40 x4_x3_net15 x4_x3_net15 x4_x3_net22 VSS nfet_06v0 L=1.0u W=5.0u
Mx4_x3_XM41 x4_x3_net22 x4_x3_net4 x4_x3_net21 VSS nfet_06v0 L=1.0u W=5.0u
Mx4_x3_XM42 x4_x3_net21 x4_x3_net22 VSS VSS nfet_06v0 L=1.0u W=5.0u
Mx4_x3_XM43 x4_SZ x4_x3_net16 VDD VDD pfet_06v0 L=20.0u W=0.7u
Mx4_x3_XM44 x4_SZ x4_x3_net26 VSS VSS nfet_06v0 L=1.0u W=1.0u
Mx4_x3_XM4 x4_x3_net29 x4_x3_net1 VDD VDD pfet_06v0 L=1.0u W=10.0u
Mx4_x3_XM5 x4_x3_net4 x4_x3_net6 x4_x3_net29 VDD pfet_06v0 L=1.0u W=10.0u
Mx4_x3_XM6 x4_x3_net4 x4_x3_net4 VSS VSS nfet_06v0 L=1.0u W=1.0u
Mx4_x3_XM7 x4_x3_net28 x4_x3_net1 VDD VDD pfet_06v0 L=1.0u W=10.0u
Mx4_x3_XM8 x4_x3_net3 x4_x3_net6 x4_x3_net28 VDD pfet_06v0 L=1.0u W=10.0u
Mx4_x3_XM9 x4_x3_net3 x4_x3_net4 x4_x3_net27 VSS nfet_06v0 L=1.0u W=5.0u
Mx4_x3_XM10 x4_x3_net27 x4_x3_net3 VSS VSS nfet_06v0 L=1.0u W=5.0u
Mx4_x3_XM1 x4_x3_net6 x4_x3_net6 VDD VDD pfet_06v0 L=1.0u W=2u
Mx4_x3_XM2 x4_x3_net30 x4_x3_net1 VDD VDD pfet_06v0 L=1.0u W=10.0u
Mx4_x3_XM3 x4_x3_net1 x4_x3_net6 x4_x3_net30 VDD pfet_06v0 L=1.0u W=10.0u
Mx4_x3_XM47 x4_x3_net31 x4_x3_net6 VSS VSS nfet_06v0 L=1.0u W=1.0u
Mx4_x3_XM48 x4_x3_net32 x4_x3_net6 VSS VSS nfet_06v0 L=1.0u W=1.0u
Mx4_x3_XM49 x4_x3_net6 x4_x3_net6 x4_x3_net32 VSS nfet_06v0 L=1.0u W=1.0u
Mx4_x3_XM50 x4_x3_net1 x4_x3_net6 x4_x3_net31 VSS nfet_06v0 L=1.0u W=1.0u
Mx4_x4_x1_XM4 x4_x4_x1_net3 x4_x4_net4 VDD VDD pfet_06v0 L=1.0u W=10.0u
Mx4_x4_x1_XM5 x4_x4_net2 x4_x4_net3 x4_x4_x1_net3 VDD pfet_06v0 L=1.0u W=10.0u
Mx4_x4_x1_XM6 x4_x4_net2 x4_x4_net2 VSS VSS nfet_06v0 L=1.0u W=1.0u
Mx4_x4_x1_XM7 x4_x4_x1_net2 x4_x4_net4 VDD VDD pfet_06v0 L=1.0u W=10.0u
Mx4_x4_x1_XM8 x4_x4_net1 x4_x4_net3 x4_x4_x1_net2 VDD pfet_06v0 L=1.0u W=10.0u
Mx4_x4_x1_XM9 x4_x4_net1 x4_x4_net2 x4_x4_x1_net1 VSS nfet_06v0 L=1.0u W=5.0u
Mx4_x4_x1_XM10 x4_x4_x1_net1 x4_x4_net1 VSS VSS nfet_06v0 L=1.0u W=5.0u
Mx4_x4_x1_XM1 x4_x4_net3 x4_x4_net3 VDD VDD pfet_06v0 L=1.0u W=2u
Mx4_x4_x1_XM2 x4_x4_x1_net4 x4_x4_net4 VDD VDD pfet_06v0 L=1.0u W=10.0u
Mx4_x4_x1_XM3 x4_x4_net4 x4_x4_net3 x4_x4_x1_net4 VDD pfet_06v0 L=1.0u W=10.0u
Mx4_x4_x1_XM47 x4_x4_x1_net5 x4_x4_net3 VSS VSS nfet_06v0 L=1.0u W=1.0u
Mx4_x4_x1_XM48 x4_x4_x1_net6 x4_x4_net3 VSS VSS nfet_06v0 L=1.0u W=1.0u
Mx4_x4_x1_XM49 x4_x4_net3 x4_x4_net3 x4_x4_x1_net6 VSS nfet_06v0 L=1.0u W=1.0u
Mx4_x4_x1_XM50 x4_x4_net4 x4_x4_net3 x4_x4_x1_net5 VSS nfet_06v0 L=1.0u W=1.0u
Mx4_x4_x2_XM11 x4_x4_x2_net2 x4_x4_net4 VDD VDD pfet_06v0 L=1.0u W=10.0u
Mx4_x4_x2_XM12 x4_x4_x2_net7 x4_x4_net3 x4_x4_x2_net2 VDD pfet_06v0 L=1.0u W=10.0u
Mx4_x4_x2_XM13 x4_x4_x2_net19 x4_x4_net4 VDD VDD pfet_06v0 L=1.0u W=10.0u
Mx4_x4_x2_XM14 x4_x4_x2_net7 x4_x4_net3 x4_x4_x2_net19 VDD pfet_06v0 L=1.0u W=10.0u
Mx4_x4_x2_XM15_f1 x4_x4_x2_net5 x4_SY x4_x4_x2_net7 VDD pfet_06v0 L=1.0u W=20.0u
Mx4_x4_x2_XM15_f2 x4_x4_x2_net5 x4_SY x4_x4_x2_net7 VDD pfet_06v0 L=1.0u W=20.0u
Mx4_x4_x2_XM16_f1 x4_x4_x2_net4 x4_SX x4_x4_x2_net7 VDD pfet_06v0 L=1.0u W=20.0u
Mx4_x4_x2_XM16_f2 x4_x4_x2_net4 x4_SX x4_x4_x2_net7 VDD pfet_06v0 L=1.0u W=20.0u
Mx4_x4_x2_XM17 x4_x4_x2_net8 x4_x4_net2 x4_x4_x2_net1 VSS nfet_06v0 L=1.0u W=5.0u
Mx4_x4_x2_XM18 x4_x4_x2_net1 x4_x4_net1 VSS VSS nfet_06v0 L=1.0u W=5.0u
Mx4_x4_x2_XM19 x4_x4_x2_net8 x4_x4_net2 x4_x4_x2_net20 VSS nfet_06v0 L=1.0u W=5.0u
Mx4_x4_x2_XM20 x4_x4_x2_net20 x4_x4_net1 VSS VSS nfet_06v0 L=1.0u W=5.0u
Mx4_x4_x2_XM21_f1 x4_x4_x2_net6 x4_SY x4_x4_x2_net8 VSS nfet_06v0 L=1.0u W=10u
Mx4_x4_x2_XM21_f2 x4_x4_x2_net6 x4_SY x4_x4_x2_net8 VSS nfet_06v0 L=1.0u W=10u
Mx4_x4_x2_XM22_f1 x4_x4_x2_net3 x4_SX x4_x4_x2_net8 VSS nfet_06v0 L=1.0u W=10u
Mx4_x4_x2_XM22_f2 x4_x4_x2_net3 x4_SX x4_x4_x2_net8 VSS nfet_06v0 L=1.0u W=10u
Mx4_x4_x2_XM29_f1 x4_x4_x2_net9 x4_x4_net3 x4_x4_x2_net3 VDD pfet_06v0 L=1.0u W=10u
Mx4_x4_x2_XM29_f2 x4_x4_x2_net9 x4_x4_net3 x4_x4_x2_net3 VDD pfet_06v0 L=1.0u W=10u
Mx4_x4_x2_XM30_f1 x4_x4_x2_net12 x4_x4_net3 x4_x4_x2_net6 VDD pfet_06v0 L=1.0u W=10.0u
Mx4_x4_x2_XM30_f2 x4_x4_x2_net12 x4_x4_net3 x4_x4_x2_net6 VDD pfet_06v0 L=1.0u W=10.0u
Mx4_x4_x2_XM31_f1 x4_x4_x2_net3 x4_x4_x2_net9 VDD VDD pfet_06v0 L=1.0u W=20u
Mx4_x4_x2_XM31_f2 x4_x4_x2_net3 x4_x4_x2_net9 VDD VDD pfet_06v0 L=1.0u W=20u
Mx4_x4_x2_XM31_f3 x4_x4_x2_net3 x4_x4_x2_net9 VDD VDD pfet_06v0 L=1.0u W=20u
Mx4_x4_x2_XM31_f4 x4_x4_x2_net3 x4_x4_x2_net9 VDD VDD pfet_06v0 L=1.0u W=20u
Mx4_x4_x2_XM35_f1 x4_x4_x2_net6 x4_x4_x2_net9 VDD VDD pfet_06v0 L=1.0u W=20.0u
Mx4_x4_x2_XM35_f2 x4_x4_x2_net6 x4_x4_x2_net9 VDD VDD pfet_06v0 L=1.0u W=20.0u
Mx4_x4_x2_XM35_f3 x4_x4_x2_net6 x4_x4_x2_net9 VDD VDD pfet_06v0 L=1.0u W=20.0u
Mx4_x4_x2_XM35_f4 x4_x4_x2_net6 x4_x4_x2_net9 VDD VDD pfet_06v0 L=1.0u W=20.0u
Mx4_x4_x2_XM32 x4_x4_x2_net10 x4_x4_x2_net21 x4_x4_x2_net9 VDD pfet_06v0 L=1.0u W=5u
Mx4_x4_x2_XM33 x4_x4_x2_net22 x4_x4_x2_net21 x4_x4_x2_net12 VDD pfet_06v0 L=1.0u W=5.0u
Mx4_x4_x2_XM23_f1 x4_x4_x2_net10 x4_x4_net2 x4_x4_x2_net4 VSS nfet_06v0 L=1.0u W=5u
Mx4_x4_x2_XM23_f2 x4_x4_x2_net10 x4_x4_net2 x4_x4_x2_net4 VSS nfet_06v0 L=1.0u W=5u
Mx4_x4_x2_XM24_f1 x4_x4_x2_net22 x4_x4_net2 x4_x4_x2_net5 VSS nfet_06v0 L=1.0u W=5u
Mx4_x4_x2_XM24_f2 x4_x4_x2_net22 x4_x4_net2 x4_x4_x2_net5 VSS nfet_06v0 L=1.0u W=5u
Mx4_x4_x2_XM25_f1 x4_x4_x2_net4 x4_x4_x2_net10 VSS VSS nfet_06v0 L=1.0u W=10u
Mx4_x4_x2_XM25_f2 x4_x4_x2_net4 x4_x4_x2_net10 VSS VSS nfet_06v0 L=1.0u W=10u
Mx4_x4_x2_XM25_f3 x4_x4_x2_net4 x4_x4_x2_net10 VSS VSS nfet_06v0 L=1.0u W=10u
Mx4_x4_x2_XM25_f4 x4_x4_x2_net4 x4_x4_x2_net10 VSS VSS nfet_06v0 L=1.0u W=10u
Mx4_x4_x2_XM26_f1 x4_x4_x2_net5 x4_x4_x2_net10 VSS VSS nfet_06v0 L=1.0u W=10u
Mx4_x4_x2_XM26_f2 x4_x4_x2_net5 x4_x4_x2_net10 VSS VSS nfet_06v0 L=1.0u W=10u
Mx4_x4_x2_XM26_f3 x4_x4_x2_net5 x4_x4_x2_net10 VSS VSS nfet_06v0 L=1.0u W=10u
Mx4_x4_x2_XM26_f4 x4_x4_x2_net5 x4_x4_x2_net10 VSS VSS nfet_06v0 L=1.0u W=10u
Mx4_x4_x2_XM27 x4_x4_x2_net9 x4_x4_x2_net11 x4_x4_x2_net10 VSS nfet_06v0 L=1.0u W=2.5u
Mx4_x4_x2_XM28 x4_x4_x2_net12 x4_x4_x2_net11 x4_x4_x2_net22 VSS nfet_06v0 L=1.0u W=2.5u
Mx4_x4_x2_XM34 x4_x4_x2_net13 x4_x4_x2_net14 VDD VDD pfet_06v0 L=1.0u W=10.0u
Mx4_x4_x2_XM36 x4_x4_x2_net14 x4_x4_net3 x4_x4_x2_net13 VDD pfet_06v0 L=1.0u W=10.0u
Mx4_x4_x2_XM37 x4_x4_x2_net21 x4_x4_x2_net21 x4_x4_x2_net14 VDD pfet_06v0 L=1.0u W=10.0u
Mx4_x4_x2_XM38 x4_x4_x2_net21 x4_x4_net2 x4_x4_x2_net15 VSS nfet_06v0 L=1.0u W=5.0u
Mx4_x4_x2_XM39 x4_x4_x2_net15 x4_x4_net1 VSS VSS nfet_06v0 L=1.0u W=5.0u
Mx4_x4_x2_XM45 x4_x4_x2_net16 x4_x4_net4 VDD VDD pfet_06v0 L=1.0u W=10.0u
Mx4_x4_x2_XM46 x4_x4_x2_net11 x4_x4_net3 x4_x4_x2_net16 VDD pfet_06v0 L=1.0u W=10.0u
Mx4_x4_x2_XM40 x4_x4_x2_net11 x4_x4_x2_net11 x4_x4_x2_net18 VSS nfet_06v0 L=1.0u W=5.0u
Mx4_x4_x2_XM41 x4_x4_x2_net18 x4_x4_net2 x4_x4_x2_net17 VSS nfet_06v0 L=1.0u W=5.0u
Mx4_x4_x2_XM42 x4_x4_x2_net17 x4_x4_x2_net18 VSS VSS nfet_06v0 L=1.0u W=5.0u
Mx4_x4_x2_XM43_f1 x4_net1 x4_x4_x2_net12 VDD VDD pfet_06v0 L=1.0u W=30u
Mx4_x4_x2_XM43_f2 x4_net1 x4_x4_x2_net12 VDD VDD pfet_06v0 L=1.0u W=30u
Mx4_x4_x2_XM43_f3 x4_net1 x4_x4_x2_net12 VDD VDD pfet_06v0 L=1.0u W=30u
Mx4_x4_x2_XM44_f1 x4_net1 x4_x4_x2_net22 VSS VSS nfet_06v0 L=1.0u W=15u
Mx4_x4_x2_XM44_f2 x4_net1 x4_x4_x2_net22 VSS VSS nfet_06v0 L=1.0u W=15u
Mx4_x4_x2_XM44_f3 x4_net1 x4_x4_x2_net22 VSS VSS nfet_06v0 L=1.0u W=15u
Mx4_x5_x1_XM4 x4_x5_x1_net3 x4_x5_net4 VDD VDD pfet_06v0 L=1.0u W=10.0u
Mx4_x5_x1_XM5 x4_x5_net2 x4_x5_net3 x4_x5_x1_net3 VDD pfet_06v0 L=1.0u W=10.0u
Mx4_x5_x1_XM6 x4_x5_net2 x4_x5_net2 VSS VSS nfet_06v0 L=1.0u W=1.0u
Mx4_x5_x1_XM7 x4_x5_x1_net2 x4_x5_net4 VDD VDD pfet_06v0 L=1.0u W=10.0u
Mx4_x5_x1_XM8 x4_x5_net1 x4_x5_net3 x4_x5_x1_net2 VDD pfet_06v0 L=1.0u W=10.0u
Mx4_x5_x1_XM9 x4_x5_net1 x4_x5_net2 x4_x5_x1_net1 VSS nfet_06v0 L=1.0u W=5.0u
Mx4_x5_x1_XM10 x4_x5_x1_net1 x4_x5_net1 VSS VSS nfet_06v0 L=1.0u W=5.0u
Mx4_x5_x1_XM1 x4_x5_net3 x4_x5_net3 VDD VDD pfet_06v0 L=1.0u W=2u
Mx4_x5_x1_XM2 x4_x5_x1_net4 x4_x5_net4 VDD VDD pfet_06v0 L=1.0u W=10.0u
Mx4_x5_x1_XM3 x4_x5_net4 x4_x5_net3 x4_x5_x1_net4 VDD pfet_06v0 L=1.0u W=10.0u
Mx4_x5_x1_XM47 x4_x5_x1_net5 x4_x5_net3 VSS VSS nfet_06v0 L=1.0u W=1.0u
Mx4_x5_x1_XM48 x4_x5_x1_net6 x4_x5_net3 VSS VSS nfet_06v0 L=1.0u W=1.0u
Mx4_x5_x1_XM49 x4_x5_net3 x4_x5_net3 x4_x5_x1_net6 VSS nfet_06v0 L=1.0u W=1.0u
Mx4_x5_x1_XM50 x4_x5_net4 x4_x5_net3 x4_x5_x1_net5 VSS nfet_06v0 L=1.0u W=1.0u
Mx4_x5_x2_XM11 x4_x5_x2_net2 x4_x5_net4 VDD VDD pfet_06v0 L=1.0u W=10.0u
Mx4_x5_x2_XM12 x4_x5_x2_net7 x4_x5_net3 x4_x5_x2_net2 VDD pfet_06v0 L=1.0u W=10.0u
Mx4_x5_x2_XM13 x4_x5_x2_net19 x4_x5_net4 VDD VDD pfet_06v0 L=1.0u W=10.0u
Mx4_x5_x2_XM14 x4_x5_x2_net7 x4_x5_net3 x4_x5_x2_net19 VDD pfet_06v0 L=1.0u W=10.0u
Mx4_x5_x2_XM15_f1 x4_x5_x2_net5 x4_SZ x4_x5_x2_net7 VDD pfet_06v0 L=1.0u W=20.0u
Mx4_x5_x2_XM15_f2 x4_x5_x2_net5 x4_SZ x4_x5_x2_net7 VDD pfet_06v0 L=1.0u W=20.0u
Mx4_x5_x2_XM16_f1 x4_x5_x2_net4 x4_SX x4_x5_x2_net7 VDD pfet_06v0 L=1.0u W=20.0u
Mx4_x5_x2_XM16_f2 x4_x5_x2_net4 x4_SX x4_x5_x2_net7 VDD pfet_06v0 L=1.0u W=20.0u
Mx4_x5_x2_XM17 x4_x5_x2_net8 x4_x5_net2 x4_x5_x2_net1 VSS nfet_06v0 L=1.0u W=5.0u
Mx4_x5_x2_XM18 x4_x5_x2_net1 x4_x5_net1 VSS VSS nfet_06v0 L=1.0u W=5.0u
Mx4_x5_x2_XM19 x4_x5_x2_net8 x4_x5_net2 x4_x5_x2_net20 VSS nfet_06v0 L=1.0u W=5.0u
Mx4_x5_x2_XM20 x4_x5_x2_net20 x4_x5_net1 VSS VSS nfet_06v0 L=1.0u W=5.0u
Mx4_x5_x2_XM21_f1 x4_x5_x2_net6 x4_SZ x4_x5_x2_net8 VSS nfet_06v0 L=1.0u W=10u
Mx4_x5_x2_XM21_f2 x4_x5_x2_net6 x4_SZ x4_x5_x2_net8 VSS nfet_06v0 L=1.0u W=10u
Mx4_x5_x2_XM22_f1 x4_x5_x2_net3 x4_SX x4_x5_x2_net8 VSS nfet_06v0 L=1.0u W=10u
Mx4_x5_x2_XM22_f2 x4_x5_x2_net3 x4_SX x4_x5_x2_net8 VSS nfet_06v0 L=1.0u W=10u
Mx4_x5_x2_XM29_f1 x4_x5_x2_net9 x4_x5_net3 x4_x5_x2_net3 VDD pfet_06v0 L=1.0u W=10u
Mx4_x5_x2_XM29_f2 x4_x5_x2_net9 x4_x5_net3 x4_x5_x2_net3 VDD pfet_06v0 L=1.0u W=10u
Mx4_x5_x2_XM30_f1 x4_x5_x2_net12 x4_x5_net3 x4_x5_x2_net6 VDD pfet_06v0 L=1.0u W=10.0u
Mx4_x5_x2_XM30_f2 x4_x5_x2_net12 x4_x5_net3 x4_x5_x2_net6 VDD pfet_06v0 L=1.0u W=10.0u
Mx4_x5_x2_XM31_f1 x4_x5_x2_net3 x4_x5_x2_net9 VDD VDD pfet_06v0 L=1.0u W=20u
Mx4_x5_x2_XM31_f2 x4_x5_x2_net3 x4_x5_x2_net9 VDD VDD pfet_06v0 L=1.0u W=20u
Mx4_x5_x2_XM31_f3 x4_x5_x2_net3 x4_x5_x2_net9 VDD VDD pfet_06v0 L=1.0u W=20u
Mx4_x5_x2_XM31_f4 x4_x5_x2_net3 x4_x5_x2_net9 VDD VDD pfet_06v0 L=1.0u W=20u
Mx4_x5_x2_XM35_f1 x4_x5_x2_net6 x4_x5_x2_net9 VDD VDD pfet_06v0 L=1.0u W=20.0u
Mx4_x5_x2_XM35_f2 x4_x5_x2_net6 x4_x5_x2_net9 VDD VDD pfet_06v0 L=1.0u W=20.0u
Mx4_x5_x2_XM35_f3 x4_x5_x2_net6 x4_x5_x2_net9 VDD VDD pfet_06v0 L=1.0u W=20.0u
Mx4_x5_x2_XM35_f4 x4_x5_x2_net6 x4_x5_x2_net9 VDD VDD pfet_06v0 L=1.0u W=20.0u
Mx4_x5_x2_XM32 x4_x5_x2_net10 x4_x5_x2_net21 x4_x5_x2_net9 VDD pfet_06v0 L=1.0u W=5u
Mx4_x5_x2_XM33 x4_x5_x2_net22 x4_x5_x2_net21 x4_x5_x2_net12 VDD pfet_06v0 L=1.0u W=5.0u
Mx4_x5_x2_XM23_f1 x4_x5_x2_net10 x4_x5_net2 x4_x5_x2_net4 VSS nfet_06v0 L=1.0u W=5u
Mx4_x5_x2_XM23_f2 x4_x5_x2_net10 x4_x5_net2 x4_x5_x2_net4 VSS nfet_06v0 L=1.0u W=5u
Mx4_x5_x2_XM24_f1 x4_x5_x2_net22 x4_x5_net2 x4_x5_x2_net5 VSS nfet_06v0 L=1.0u W=5u
Mx4_x5_x2_XM24_f2 x4_x5_x2_net22 x4_x5_net2 x4_x5_x2_net5 VSS nfet_06v0 L=1.0u W=5u
Mx4_x5_x2_XM25_f1 x4_x5_x2_net4 x4_x5_x2_net10 VSS VSS nfet_06v0 L=1.0u W=10u
Mx4_x5_x2_XM25_f2 x4_x5_x2_net4 x4_x5_x2_net10 VSS VSS nfet_06v0 L=1.0u W=10u
Mx4_x5_x2_XM25_f3 x4_x5_x2_net4 x4_x5_x2_net10 VSS VSS nfet_06v0 L=1.0u W=10u
Mx4_x5_x2_XM25_f4 x4_x5_x2_net4 x4_x5_x2_net10 VSS VSS nfet_06v0 L=1.0u W=10u
Mx4_x5_x2_XM26_f1 x4_x5_x2_net5 x4_x5_x2_net10 VSS VSS nfet_06v0 L=1.0u W=10u
Mx4_x5_x2_XM26_f2 x4_x5_x2_net5 x4_x5_x2_net10 VSS VSS nfet_06v0 L=1.0u W=10u
Mx4_x5_x2_XM26_f3 x4_x5_x2_net5 x4_x5_x2_net10 VSS VSS nfet_06v0 L=1.0u W=10u
Mx4_x5_x2_XM26_f4 x4_x5_x2_net5 x4_x5_x2_net10 VSS VSS nfet_06v0 L=1.0u W=10u
Mx4_x5_x2_XM27 x4_x5_x2_net9 x4_x5_x2_net11 x4_x5_x2_net10 VSS nfet_06v0 L=1.0u W=2.5u
Mx4_x5_x2_XM28 x4_x5_x2_net12 x4_x5_x2_net11 x4_x5_x2_net22 VSS nfet_06v0 L=1.0u W=2.5u
Mx4_x5_x2_XM34 x4_x5_x2_net13 x4_x5_x2_net14 VDD VDD pfet_06v0 L=1.0u W=10.0u
Mx4_x5_x2_XM36 x4_x5_x2_net14 x4_x5_net3 x4_x5_x2_net13 VDD pfet_06v0 L=1.0u W=10.0u
Mx4_x5_x2_XM37 x4_x5_x2_net21 x4_x5_x2_net21 x4_x5_x2_net14 VDD pfet_06v0 L=1.0u W=10.0u
Mx4_x5_x2_XM38 x4_x5_x2_net21 x4_x5_net2 x4_x5_x2_net15 VSS nfet_06v0 L=1.0u W=5.0u
Mx4_x5_x2_XM39 x4_x5_x2_net15 x4_x5_net1 VSS VSS nfet_06v0 L=1.0u W=5.0u
Mx4_x5_x2_XM45 x4_x5_x2_net16 x4_x5_net4 VDD VDD pfet_06v0 L=1.0u W=10.0u
Mx4_x5_x2_XM46 x4_x5_x2_net11 x4_x5_net3 x4_x5_x2_net16 VDD pfet_06v0 L=1.0u W=10.0u
Mx4_x5_x2_XM40 x4_x5_x2_net11 x4_x5_x2_net11 x4_x5_x2_net18 VSS nfet_06v0 L=1.0u W=5.0u
Mx4_x5_x2_XM41 x4_x5_x2_net18 x4_x5_net2 x4_x5_x2_net17 VSS nfet_06v0 L=1.0u W=5.0u
Mx4_x5_x2_XM42 x4_x5_x2_net17 x4_x5_x2_net18 VSS VSS nfet_06v0 L=1.0u W=5.0u
Mx4_x5_x2_XM43_f1 x4_net2 x4_x5_x2_net12 VDD VDD pfet_06v0 L=1.0u W=30u
Mx4_x5_x2_XM43_f2 x4_net2 x4_x5_x2_net12 VDD VDD pfet_06v0 L=1.0u W=30u
Mx4_x5_x2_XM43_f3 x4_net2 x4_x5_x2_net12 VDD VDD pfet_06v0 L=1.0u W=30u
Mx4_x5_x2_XM44_f1 x4_net2 x4_x5_x2_net22 VSS VSS nfet_06v0 L=1.0u W=15u
Mx4_x5_x2_XM44_f2 x4_net2 x4_x5_x2_net22 VSS VSS nfet_06v0 L=1.0u W=15u
Mx4_x5_x2_XM44_f3 x4_net2 x4_x5_x2_net22 VSS VSS nfet_06v0 L=1.0u W=15u
Mx4_x6_x1_XM4 x4_x6_x1_net3 x4_x6_net4 VDD VDD pfet_06v0 L=1.0u W=10.0u
Mx4_x6_x1_XM5 x4_x6_net2 x4_x6_net3 x4_x6_x1_net3 VDD pfet_06v0 L=1.0u W=10.0u
Mx4_x6_x1_XM6 x4_x6_net2 x4_x6_net2 VSS VSS nfet_06v0 L=1.0u W=1.0u
Mx4_x6_x1_XM7 x4_x6_x1_net2 x4_x6_net4 VDD VDD pfet_06v0 L=1.0u W=10.0u
Mx4_x6_x1_XM8 x4_x6_net1 x4_x6_net3 x4_x6_x1_net2 VDD pfet_06v0 L=1.0u W=10.0u
Mx4_x6_x1_XM9 x4_x6_net1 x4_x6_net2 x4_x6_x1_net1 VSS nfet_06v0 L=1.0u W=5.0u
Mx4_x6_x1_XM10 x4_x6_x1_net1 x4_x6_net1 VSS VSS nfet_06v0 L=1.0u W=5.0u
Mx4_x6_x1_XM1 x4_x6_net3 x4_x6_net3 VDD VDD pfet_06v0 L=1.0u W=2u
Mx4_x6_x1_XM2 x4_x6_x1_net4 x4_x6_net4 VDD VDD pfet_06v0 L=1.0u W=10.0u
Mx4_x6_x1_XM3 x4_x6_net4 x4_x6_net3 x4_x6_x1_net4 VDD pfet_06v0 L=1.0u W=10.0u
Mx4_x6_x1_XM47 x4_x6_x1_net5 x4_x6_net3 VSS VSS nfet_06v0 L=1.0u W=1.0u
Mx4_x6_x1_XM48 x4_x6_x1_net6 x4_x6_net3 VSS VSS nfet_06v0 L=1.0u W=1.0u
Mx4_x6_x1_XM49 x4_x6_net3 x4_x6_net3 x4_x6_x1_net6 VSS nfet_06v0 L=1.0u W=1.0u
Mx4_x6_x1_XM50 x4_x6_net4 x4_x6_net3 x4_x6_x1_net5 VSS nfet_06v0 L=1.0u W=1.0u
Mx4_x6_x2_XM11 x4_x6_x2_net2 x4_x6_net4 VDD VDD pfet_06v0 L=1.0u W=10.0u
Mx4_x6_x2_XM12 x4_x6_x2_net7 x4_x6_net3 x4_x6_x2_net2 VDD pfet_06v0 L=1.0u W=10.0u
Mx4_x6_x2_XM13 x4_x6_x2_net19 x4_x6_net4 VDD VDD pfet_06v0 L=1.0u W=10.0u
Mx4_x6_x2_XM14 x4_x6_x2_net7 x4_x6_net3 x4_x6_x2_net19 VDD pfet_06v0 L=1.0u W=10.0u
Mx4_x6_x2_XM15_f1 x4_x6_x2_net5 x4_SZ x4_x6_x2_net7 VDD pfet_06v0 L=1.0u W=20.0u
Mx4_x6_x2_XM15_f2 x4_x6_x2_net5 x4_SZ x4_x6_x2_net7 VDD pfet_06v0 L=1.0u W=20.0u
Mx4_x6_x2_XM16_f1 x4_x6_x2_net4 x4_SY x4_x6_x2_net7 VDD pfet_06v0 L=1.0u W=20.0u
Mx4_x6_x2_XM16_f2 x4_x6_x2_net4 x4_SY x4_x6_x2_net7 VDD pfet_06v0 L=1.0u W=20.0u
Mx4_x6_x2_XM17 x4_x6_x2_net8 x4_x6_net2 x4_x6_x2_net1 VSS nfet_06v0 L=1.0u W=5.0u
Mx4_x6_x2_XM18 x4_x6_x2_net1 x4_x6_net1 VSS VSS nfet_06v0 L=1.0u W=5.0u
Mx4_x6_x2_XM19 x4_x6_x2_net8 x4_x6_net2 x4_x6_x2_net20 VSS nfet_06v0 L=1.0u W=5.0u
Mx4_x6_x2_XM20 x4_x6_x2_net20 x4_x6_net1 VSS VSS nfet_06v0 L=1.0u W=5.0u
Mx4_x6_x2_XM21_f1 x4_x6_x2_net6 x4_SZ x4_x6_x2_net8 VSS nfet_06v0 L=1.0u W=10u
Mx4_x6_x2_XM21_f2 x4_x6_x2_net6 x4_SZ x4_x6_x2_net8 VSS nfet_06v0 L=1.0u W=10u
Mx4_x6_x2_XM22_f1 x4_x6_x2_net3 x4_SY x4_x6_x2_net8 VSS nfet_06v0 L=1.0u W=10u
Mx4_x6_x2_XM22_f2 x4_x6_x2_net3 x4_SY x4_x6_x2_net8 VSS nfet_06v0 L=1.0u W=10u
Mx4_x6_x2_XM29_f1 x4_x6_x2_net9 x4_x6_net3 x4_x6_x2_net3 VDD pfet_06v0 L=1.0u W=10u
Mx4_x6_x2_XM29_f2 x4_x6_x2_net9 x4_x6_net3 x4_x6_x2_net3 VDD pfet_06v0 L=1.0u W=10u
Mx4_x6_x2_XM30_f1 x4_x6_x2_net12 x4_x6_net3 x4_x6_x2_net6 VDD pfet_06v0 L=1.0u W=10.0u
Mx4_x6_x2_XM30_f2 x4_x6_x2_net12 x4_x6_net3 x4_x6_x2_net6 VDD pfet_06v0 L=1.0u W=10.0u
Mx4_x6_x2_XM31_f1 x4_x6_x2_net3 x4_x6_x2_net9 VDD VDD pfet_06v0 L=1.0u W=20u
Mx4_x6_x2_XM31_f2 x4_x6_x2_net3 x4_x6_x2_net9 VDD VDD pfet_06v0 L=1.0u W=20u
Mx4_x6_x2_XM31_f3 x4_x6_x2_net3 x4_x6_x2_net9 VDD VDD pfet_06v0 L=1.0u W=20u
Mx4_x6_x2_XM31_f4 x4_x6_x2_net3 x4_x6_x2_net9 VDD VDD pfet_06v0 L=1.0u W=20u
Mx4_x6_x2_XM35_f1 x4_x6_x2_net6 x4_x6_x2_net9 VDD VDD pfet_06v0 L=1.0u W=20.0u
Mx4_x6_x2_XM35_f2 x4_x6_x2_net6 x4_x6_x2_net9 VDD VDD pfet_06v0 L=1.0u W=20.0u
Mx4_x6_x2_XM35_f3 x4_x6_x2_net6 x4_x6_x2_net9 VDD VDD pfet_06v0 L=1.0u W=20.0u
Mx4_x6_x2_XM35_f4 x4_x6_x2_net6 x4_x6_x2_net9 VDD VDD pfet_06v0 L=1.0u W=20.0u
Mx4_x6_x2_XM32 x4_x6_x2_net10 x4_x6_x2_net21 x4_x6_x2_net9 VDD pfet_06v0 L=1.0u W=5u
Mx4_x6_x2_XM33 x4_x6_x2_net22 x4_x6_x2_net21 x4_x6_x2_net12 VDD pfet_06v0 L=1.0u W=5.0u
Mx4_x6_x2_XM23_f1 x4_x6_x2_net10 x4_x6_net2 x4_x6_x2_net4 VSS nfet_06v0 L=1.0u W=5u
Mx4_x6_x2_XM23_f2 x4_x6_x2_net10 x4_x6_net2 x4_x6_x2_net4 VSS nfet_06v0 L=1.0u W=5u
Mx4_x6_x2_XM24_f1 x4_x6_x2_net22 x4_x6_net2 x4_x6_x2_net5 VSS nfet_06v0 L=1.0u W=5u
Mx4_x6_x2_XM24_f2 x4_x6_x2_net22 x4_x6_net2 x4_x6_x2_net5 VSS nfet_06v0 L=1.0u W=5u
Mx4_x6_x2_XM25_f1 x4_x6_x2_net4 x4_x6_x2_net10 VSS VSS nfet_06v0 L=1.0u W=10u
Mx4_x6_x2_XM25_f2 x4_x6_x2_net4 x4_x6_x2_net10 VSS VSS nfet_06v0 L=1.0u W=10u
Mx4_x6_x2_XM25_f3 x4_x6_x2_net4 x4_x6_x2_net10 VSS VSS nfet_06v0 L=1.0u W=10u
Mx4_x6_x2_XM25_f4 x4_x6_x2_net4 x4_x6_x2_net10 VSS VSS nfet_06v0 L=1.0u W=10u
Mx4_x6_x2_XM26_f1 x4_x6_x2_net5 x4_x6_x2_net10 VSS VSS nfet_06v0 L=1.0u W=10u
Mx4_x6_x2_XM26_f2 x4_x6_x2_net5 x4_x6_x2_net10 VSS VSS nfet_06v0 L=1.0u W=10u
Mx4_x6_x2_XM26_f3 x4_x6_x2_net5 x4_x6_x2_net10 VSS VSS nfet_06v0 L=1.0u W=10u
Mx4_x6_x2_XM26_f4 x4_x6_x2_net5 x4_x6_x2_net10 VSS VSS nfet_06v0 L=1.0u W=10u
Mx4_x6_x2_XM27 x4_x6_x2_net9 x4_x6_x2_net11 x4_x6_x2_net10 VSS nfet_06v0 L=1.0u W=2.5u
Mx4_x6_x2_XM28 x4_x6_x2_net12 x4_x6_x2_net11 x4_x6_x2_net22 VSS nfet_06v0 L=1.0u W=2.5u
Mx4_x6_x2_XM34 x4_x6_x2_net13 x4_x6_x2_net14 VDD VDD pfet_06v0 L=1.0u W=10.0u
Mx4_x6_x2_XM36 x4_x6_x2_net14 x4_x6_net3 x4_x6_x2_net13 VDD pfet_06v0 L=1.0u W=10.0u
Mx4_x6_x2_XM37 x4_x6_x2_net21 x4_x6_x2_net21 x4_x6_x2_net14 VDD pfet_06v0 L=1.0u W=10.0u
Mx4_x6_x2_XM38 x4_x6_x2_net21 x4_x6_net2 x4_x6_x2_net15 VSS nfet_06v0 L=1.0u W=5.0u
Mx4_x6_x2_XM39 x4_x6_x2_net15 x4_x6_net1 VSS VSS nfet_06v0 L=1.0u W=5.0u
Mx4_x6_x2_XM45 x4_x6_x2_net16 x4_x6_net4 VDD VDD pfet_06v0 L=1.0u W=10.0u
Mx4_x6_x2_XM46 x4_x6_x2_net11 x4_x6_net3 x4_x6_x2_net16 VDD pfet_06v0 L=1.0u W=10.0u
Mx4_x6_x2_XM40 x4_x6_x2_net11 x4_x6_x2_net11 x4_x6_x2_net18 VSS nfet_06v0 L=1.0u W=5.0u
Mx4_x6_x2_XM41 x4_x6_x2_net18 x4_x6_net2 x4_x6_x2_net17 VSS nfet_06v0 L=1.0u W=5.0u
Mx4_x6_x2_XM42 x4_x6_x2_net17 x4_x6_x2_net18 VSS VSS nfet_06v0 L=1.0u W=5.0u
Mx4_x6_x2_XM43_f1 x4_net3 x4_x6_x2_net12 VDD VDD pfet_06v0 L=1.0u W=30u
Mx4_x6_x2_XM43_f2 x4_net3 x4_x6_x2_net12 VDD VDD pfet_06v0 L=1.0u W=30u
Mx4_x6_x2_XM43_f3 x4_net3 x4_x6_x2_net12 VDD VDD pfet_06v0 L=1.0u W=30u
Mx4_x6_x2_XM44_f1 x4_net3 x4_x6_x2_net22 VSS VSS nfet_06v0 L=1.0u W=15u
Mx4_x6_x2_XM44_f2 x4_net3 x4_x6_x2_net22 VSS VSS nfet_06v0 L=1.0u W=15u
Mx4_x6_x2_XM44_f3 x4_net3 x4_x6_x2_net22 VSS VSS nfet_06v0 L=1.0u W=15u
Mx4_x7_x1_XM4 x4_x7_x1_net1 x4_net3 Z4 VDD pfet_06v0 L=1.0u W=3.0u
Mx4_x7_x1_XM5 VDD x4_net2 x4_x7_x1_net1 VDD pfet_06v0 L=1.0u W=3.0u
Mx4_x7_x1_XM7 VSS x4_net3 Z4 VSS nfet_06v0 L=1u W=1u
Mx4_x7_x1_XM1 VSS x4_net2 Z4 VSS nfet_06v0 L=1u W=1u
Mx4_x7_x2_x2_XM4 x4_x7_x2_net1 x4_net1 VDD VDD pfet_06v0 L=1.0u W=3.0u
Mx4_x7_x2_x2_XM5 VSS x4_net1 x4_x7_x2_net1 VSS nfet_06v0 L=1u W=1u
Mx4_x7_x2_x3_XM4 Y4 x4_x7_x2_x3_net1 VDD VDD pfet_06v0 L=1.0u W=3.0u
Mx4_x7_x2_x3_XM5 VSS x4_x7_x2_x3_net1 Y4 VSS nfet_06v0 L=1u W=1u
Mx4_x7_x2_x3_XM2 VDD x4_net3 x4_x7_x2_x3_net1 VDD pfet_06v0 L=1.0u W=3.0u
Mx4_x7_x2_x3_XM1 VDD x4_x7_x2_net1 x4_x7_x2_x3_net1 VDD pfet_06v0 L=1.0u W=3.0u
Mx4_x7_x2_x3_XM3 VSS x4_net3 x4_x7_x2_x3_net2 VSS nfet_06v0 L=1u W=1u
Mx4_x7_x2_x3_XM6 x4_x7_x2_x3_net2 x4_x7_x2_net1 x4_x7_x2_x3_net1 VSS nfet_06v0 L=1u W=1u
Mx4_x7_x3_x2_XM4 X4 x4_x7_x3_x2_net1 VDD VDD pfet_06v0 L=1.0u W=3.0u
Mx4_x7_x3_x2_XM5 VSS x4_x7_x3_x2_net1 X4 VSS nfet_06v0 L=1u W=1u
Mx4_x7_x3_x2_XM2 VDD x4_net1 x4_x7_x3_x2_net1 VDD pfet_06v0 L=1.0u W=3.0u
Mx4_x7_x3_x2_XM1 VDD x4_net2 x4_x7_x3_x2_net1 VDD pfet_06v0 L=1.0u W=3.0u
Mx4_x7_x3_x2_XM3 VSS x4_net1 x4_x7_x3_x2_net2 VSS nfet_06v0 L=1u W=1u
Mx4_x7_x3_x2_XM6 x4_x7_x3_x2_net2 x4_net2 x4_x7_x3_x2_net1 VSS nfet_06v0 L=1u W=1u
Mx5_XM2_f1 X X VDD VDD pfet_06v0 L=1u W=2u
Mx5_XM2_f2 X X VDD VDD pfet_06v0 L=1u W=2u
Mx5_XM2_f3 X X VDD VDD pfet_06v0 L=1u W=2u
Mx5_XM2_f4 X X VDD VDD pfet_06v0 L=1u W=2u
Mx5_XM2_f5 X X VDD VDD pfet_06v0 L=1u W=2u
Mx5_XM2_f6 X X VDD VDD pfet_06v0 L=1u W=2u
Mx5_XM3_f1 X X4 x5_net1 VSS nfet_06v0 L=1u W=2.48u
Mx5_XM3_f2 X X4 x5_net1 VSS nfet_06v0 L=1u W=2.48u
Mx5_XM5_f1 X X2 x5_net2 VSS nfet_06v0 L=1u W=2.48u
Mx5_XM5_f2 X X2 x5_net2 VSS nfet_06v0 L=1u W=2.48u
Mx5_XM6 x5_net2 x5_IN VSS VSS nfet_06v0 L=1u W=1.24u
Mx5_XM1_f1 X X x5_net3 VSS nfet_06v0 L=1u W=2u
Mx5_XM1_f2 X X x5_net3 VSS nfet_06v0 L=1u W=2u
Mx5_XM7 x5_net3 X x5_net4 VSS nfet_06v0 L=1u W=2u
Mx5_XM8 x5_net4 X VSS VSS nfet_06v0 L=1u W=2u
Mx5_XM9_f1 X X1 x5_net5 VSS nfet_06v0 L=1u W=2.48u
Mx5_XM9_f2 X X1 x5_net5 VSS nfet_06v0 L=1u W=2.48u
Mx5_XM10 x5_net5 x5_IN VSS VSS nfet_06v0 L=1u W=1.24u
Mx5_XM11_f1 X X3 x5_net6 VSS nfet_06v0 L=1u W=2.48u
Mx5_XM11_f2 X X3 x5_net6 VSS nfet_06v0 L=1u W=2.48u
Mx5_XM12 x5_net6 x5_IN VSS VSS nfet_06v0 L=1u W=1.24u
Mx5_XM4 x5_net1 x5_IN VSS VSS nfet_06v0 L=1u W=1.24u
Mx5_XM13 x5_IN x5_IN VDD VDD pfet_06v0 L=1u W=2u
Mx5_XM14 x5_net8 x5_IN x5_net9 VSS nfet_06v0 L=1u W=0.7u
Mx5_XM15 x5_net7 x5_IN x5_net8 VSS nfet_06v0 L=1u W=0.7u
Mx5_XM16 x5_IN x5_IN x5_net7 VSS nfet_06v0 L=1u W=0.7u
Mx5_XM17 x5_net9 x5_IN VSS VSS nfet_06v0 L=1u W=0.7u
Mx6_XM2_f1 Y Y VDD VDD pfet_06v0 L=1u W=2u
Mx6_XM2_f2 Y Y VDD VDD pfet_06v0 L=1u W=2u
Mx6_XM2_f3 Y Y VDD VDD pfet_06v0 L=1u W=2u
Mx6_XM2_f4 Y Y VDD VDD pfet_06v0 L=1u W=2u
Mx6_XM2_f5 Y Y VDD VDD pfet_06v0 L=1u W=2u
Mx6_XM2_f6 Y Y VDD VDD pfet_06v0 L=1u W=2u
Mx6_XM3_f1 Y Y4 x6_net1 VSS nfet_06v0 L=1u W=2.48u
Mx6_XM3_f2 Y Y4 x6_net1 VSS nfet_06v0 L=1u W=2.48u
Mx6_XM5_f1 Y Y2 x6_net2 VSS nfet_06v0 L=1u W=2.48u
Mx6_XM5_f2 Y Y2 x6_net2 VSS nfet_06v0 L=1u W=2.48u
Mx6_XM6 x6_net2 x6_IN VSS VSS nfet_06v0 L=1u W=1.24u
Mx6_XM1_f1 Y Y x6_net3 VSS nfet_06v0 L=1u W=2u
Mx6_XM1_f2 Y Y x6_net3 VSS nfet_06v0 L=1u W=2u
Mx6_XM7 x6_net3 Y x6_net4 VSS nfet_06v0 L=1u W=2u
Mx6_XM8 x6_net4 Y VSS VSS nfet_06v0 L=1u W=2u
Mx6_XM9_f1 Y Y1 x6_net5 VSS nfet_06v0 L=1u W=2.48u
Mx6_XM9_f2 Y Y1 x6_net5 VSS nfet_06v0 L=1u W=2.48u
Mx6_XM10 x6_net5 x6_IN VSS VSS nfet_06v0 L=1u W=1.24u
Mx6_XM11_f1 Y Y3 x6_net6 VSS nfet_06v0 L=1u W=2.48u
Mx6_XM11_f2 Y Y3 x6_net6 VSS nfet_06v0 L=1u W=2.48u
Mx6_XM12 x6_net6 x6_IN VSS VSS nfet_06v0 L=1u W=1.24u
Mx6_XM4 x6_net1 x6_IN VSS VSS nfet_06v0 L=1u W=1.24u
Mx6_XM13 x6_IN x6_IN VDD VDD pfet_06v0 L=1u W=2u
Mx6_XM14 x6_net8 x6_IN x6_net9 VSS nfet_06v0 L=1u W=0.7u
Mx6_XM15 x6_net7 x6_IN x6_net8 VSS nfet_06v0 L=1u W=0.7u
Mx6_XM16 x6_IN x6_IN x6_net7 VSS nfet_06v0 L=1u W=0.7u
Mx6_XM17 x6_net9 x6_IN VSS VSS nfet_06v0 L=1u W=0.7u
Mx7_XM2_f1 Z Z VDD VDD pfet_06v0 L=1u W=2u
Mx7_XM2_f2 Z Z VDD VDD pfet_06v0 L=1u W=2u
Mx7_XM2_f3 Z Z VDD VDD pfet_06v0 L=1u W=2u
Mx7_XM2_f4 Z Z VDD VDD pfet_06v0 L=1u W=2u
Mx7_XM2_f5 Z Z VDD VDD pfet_06v0 L=1u W=2u
Mx7_XM2_f6 Z Z VDD VDD pfet_06v0 L=1u W=2u
Mx7_XM3_f1 Z Z4 x7_net1 VSS nfet_06v0 L=1u W=2.48u
Mx7_XM3_f2 Z Z4 x7_net1 VSS nfet_06v0 L=1u W=2.48u
Mx7_XM5_f1 Z Z2 x7_net2 VSS nfet_06v0 L=1u W=2.48u
Mx7_XM5_f2 Z Z2 x7_net2 VSS nfet_06v0 L=1u W=2.48u
Mx7_XM6 x7_net2 x7_IN VSS VSS nfet_06v0 L=1u W=1.24u
Mx7_XM1_f1 Z Z x7_net3 VSS nfet_06v0 L=1u W=2u
Mx7_XM1_f2 Z Z x7_net3 VSS nfet_06v0 L=1u W=2u
Mx7_XM7 x7_net3 Z x7_net4 VSS nfet_06v0 L=1u W=2u
Mx7_XM8 x7_net4 Z VSS VSS nfet_06v0 L=1u W=2u
Mx7_XM9_f1 Z Z1 x7_net5 VSS nfet_06v0 L=1u W=2.48u
Mx7_XM9_f2 Z Z1 x7_net5 VSS nfet_06v0 L=1u W=2.48u
Mx7_XM10 x7_net5 x7_IN VSS VSS nfet_06v0 L=1u W=1.24u
Mx7_XM11_f1 Z Z3 x7_net6 VSS nfet_06v0 L=1u W=2.48u
Mx7_XM11_f2 Z Z3 x7_net6 VSS nfet_06v0 L=1u W=2.48u
Mx7_XM12 x7_net6 x7_IN VSS VSS nfet_06v0 L=1u W=1.24u
Mx7_XM4 x7_net1 x7_IN VSS VSS nfet_06v0 L=1u W=1.24u
Mx7_XM13 x7_IN x7_IN VDD VDD pfet_06v0 L=1u W=2u
Mx7_XM14 x7_net8 x7_IN x7_net9 VSS nfet_06v0 L=1u W=0.7u
Mx7_XM15 x7_net7 x7_IN x7_net8 VSS nfet_06v0 L=1u W=0.7u
Mx7_XM16 x7_IN x7_IN x7_net7 VSS nfet_06v0 L=1u W=0.7u
Mx7_XM17 x7_net9 x7_IN VSS VSS nfet_06v0 L=1u W=0.7u
Mx8_x1_XM3 x8_net1 X VDD VDD pfet_05v0 L=0.5u W=1.83u
Mx8_x1_XM4 x8_net1 X VSS VSS nfet_05v0 L=0.6u W=1.32u
Mx8_x2_XM3 XP x8_net1 VDD VDD pfet_05v0 L=0.5u W=1.83u
Mx8_x2_XM4 XP x8_net1 VSS VSS nfet_05v0 L=0.6u W=1.32u
Mx8_x3_XM3 XN XP VDD VDD pfet_05v0 L=0.5u W=1.83u
Mx8_x3_XM4 XN XP VSS VSS nfet_05v0 L=0.6u W=1.32u
Mx9_x1_XM3 x9_net1 Y VDD VDD pfet_05v0 L=0.5u W=1.83u
Mx9_x1_XM4 x9_net1 Y VSS VSS nfet_05v0 L=0.6u W=1.32u
Mx9_x2_XM3 YP x9_net1 VDD VDD pfet_05v0 L=0.5u W=1.83u
Mx9_x2_XM4 YP x9_net1 VSS VSS nfet_05v0 L=0.6u W=1.32u
Mx9_x3_XM3 YN YP VDD VDD pfet_05v0 L=0.5u W=1.83u
Mx9_x3_XM4 YN YP VSS VSS nfet_05v0 L=0.6u W=1.32u
Mx10_x1_XM3 x10_net1 Z VDD VDD pfet_05v0 L=0.5u W=1.83u
Mx10_x1_XM4 x10_net1 Z VSS VSS nfet_05v0 L=0.6u W=1.32u
Mx10_x2_XM3 ZP x10_net1 VDD VDD pfet_05v0 L=0.5u W=1.83u
Mx10_x2_XM4 ZP x10_net1 VSS VSS nfet_05v0 L=0.6u W=1.32u
Mx10_x3_XM3 ZN ZP VDD VDD pfet_05v0 L=0.5u W=1.83u
Mx10_x3_XM4 ZN ZP VSS VSS nfet_05v0 L=0.6u W=1.32u
* condensadores: elemento 'C' con W/L en METROS, no 'X' con c_width/c_length.
*   El deck de KLayout los lee con un delegate (custom_classes.lvs, SubcircuitModelsReader#element)
*   que SOLO actua si el elemento empieza por 'C', y de ahi saca A=W*L*1e12 y P=2*(W+L)*1e6.
*   Escrito como 'X...' se leeria como llamada a subcircuito y no emparejaria con nada.
Cx1_x1_XC3 x1_x1_net10 x1_SX cap_mim_2f0fF W=2e-05 L=1e-05
Cx1_x1_XC1 x1_SX x1_x1_net9 cap_mim_2f0fF W=2e-05 L=1e-05
Cx1_x2_XC3 x1_x2_net10 x1_SY cap_mim_2f0fF W=2e-05 L=1e-05
Cx1_x2_XC1 x1_SY x1_x2_net9 cap_mim_2f0fF W=2e-05 L=1e-05
Cx1_x3_XC3 x1_x3_net10 x1_SZ cap_mim_2f0fF W=2e-05 L=1e-05
Cx1_x3_XC1 x1_SZ x1_x3_net9 cap_mim_2f0fF W=2e-05 L=1e-05
Cx1_x4_x2_XC2 x1_net1 x1_x4_x2_net5 cap_mim_2f0fF W=2e-05 L=1e-05
Cx1_x4_x2_XC3 x1_x4_x2_net6 x1_net1 cap_mim_2f0fF W=2e-05 L=1e-05
Cx1_x5_x2_XC2 x1_net2 x1_x5_x2_net5 cap_mim_2f0fF W=2e-05 L=1e-05
Cx1_x5_x2_XC3 x1_x5_x2_net6 x1_net2 cap_mim_2f0fF W=2e-05 L=1e-05
Cx1_x6_x2_XC2 x1_net3 x1_x6_x2_net5 cap_mim_2f0fF W=2e-05 L=1e-05
Cx1_x6_x2_XC3 x1_x6_x2_net6 x1_net3 cap_mim_2f0fF W=2e-05 L=1e-05
Cx2_x1_XC3 x2_x1_net10 x2_SX cap_mim_2f0fF W=2e-05 L=1e-05
Cx2_x1_XC1 x2_SX x2_x1_net9 cap_mim_2f0fF W=2e-05 L=1e-05
Cx2_x2_XC3 x2_x2_net10 x2_SY cap_mim_2f0fF W=2e-05 L=1e-05
Cx2_x2_XC1 x2_SY x2_x2_net9 cap_mim_2f0fF W=2e-05 L=1e-05
Cx2_x3_XC3 x2_x3_net10 x2_SZ cap_mim_2f0fF W=2e-05 L=1e-05
Cx2_x3_XC1 x2_SZ x2_x3_net9 cap_mim_2f0fF W=2e-05 L=1e-05
Cx2_x4_x2_XC2 x2_net1 x2_x4_x2_net5 cap_mim_2f0fF W=2e-05 L=1e-05
Cx2_x4_x2_XC3 x2_x4_x2_net6 x2_net1 cap_mim_2f0fF W=2e-05 L=1e-05
Cx2_x5_x2_XC2 x2_net2 x2_x5_x2_net5 cap_mim_2f0fF W=2e-05 L=1e-05
Cx2_x5_x2_XC3 x2_x5_x2_net6 x2_net2 cap_mim_2f0fF W=2e-05 L=1e-05
Cx2_x6_x2_XC2 x2_net3 x2_x6_x2_net5 cap_mim_2f0fF W=2e-05 L=1e-05
Cx2_x6_x2_XC3 x2_x6_x2_net6 x2_net3 cap_mim_2f0fF W=2e-05 L=1e-05
Cx3_x1_XC3 x3_x1_net10 x3_SX cap_mim_2f0fF W=2e-05 L=1e-05
Cx3_x1_XC1 x3_SX x3_x1_net9 cap_mim_2f0fF W=2e-05 L=1e-05
Cx3_x2_XC3 x3_x2_net10 x3_SY cap_mim_2f0fF W=2e-05 L=1e-05
Cx3_x2_XC1 x3_SY x3_x2_net9 cap_mim_2f0fF W=2e-05 L=1e-05
Cx3_x3_XC3 x3_x3_net10 x3_SZ cap_mim_2f0fF W=2e-05 L=1e-05
Cx3_x3_XC1 x3_SZ x3_x3_net9 cap_mim_2f0fF W=2e-05 L=1e-05
Cx3_x4_x2_XC2 x3_net1 x3_x4_x2_net5 cap_mim_2f0fF W=2e-05 L=1e-05
Cx3_x4_x2_XC3 x3_x4_x2_net6 x3_net1 cap_mim_2f0fF W=2e-05 L=1e-05
Cx3_x5_x2_XC2 x3_net2 x3_x5_x2_net5 cap_mim_2f0fF W=2e-05 L=1e-05
Cx3_x5_x2_XC3 x3_x5_x2_net6 x3_net2 cap_mim_2f0fF W=2e-05 L=1e-05
Cx3_x6_x2_XC2 x3_net3 x3_x6_x2_net5 cap_mim_2f0fF W=2e-05 L=1e-05
Cx3_x6_x2_XC3 x3_x6_x2_net6 x3_net3 cap_mim_2f0fF W=2e-05 L=1e-05
Cx4_x1_XC3 x4_x1_net10 x4_SX cap_mim_2f0fF W=2e-05 L=1e-05
Cx4_x1_XC1 x4_SX x4_x1_net9 cap_mim_2f0fF W=2e-05 L=1e-05
Cx4_x2_XC3 x4_x2_net10 x4_SY cap_mim_2f0fF W=2e-05 L=1e-05
Cx4_x2_XC1 x4_SY x4_x2_net9 cap_mim_2f0fF W=2e-05 L=1e-05
Cx4_x3_XC3 x4_x3_net10 x4_SZ cap_mim_2f0fF W=2e-05 L=1e-05
Cx4_x3_XC1 x4_SZ x4_x3_net9 cap_mim_2f0fF W=2e-05 L=1e-05
Cx4_x4_x2_XC2 x4_net1 x4_x4_x2_net5 cap_mim_2f0fF W=2e-05 L=1e-05
Cx4_x4_x2_XC3 x4_x4_x2_net6 x4_net1 cap_mim_2f0fF W=2e-05 L=1e-05
Cx4_x5_x2_XC2 x4_net2 x4_x5_x2_net5 cap_mim_2f0fF W=2e-05 L=1e-05
Cx4_x5_x2_XC3 x4_x5_x2_net6 x4_net2 cap_mim_2f0fF W=2e-05 L=1e-05
Cx4_x6_x2_XC2 x4_net3 x4_x6_x2_net5 cap_mim_2f0fF W=2e-05 L=1e-05
Cx4_x6_x2_XC3 x4_x6_x2_net6 x4_net3 cap_mim_2f0fF W=2e-05 L=1e-05
.ends
