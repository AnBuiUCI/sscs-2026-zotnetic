* NGSPICE file created from GRADIENT_NAV2.ext - technology: gf180mcuD

.subckt GRADIENT_NAV2 VDD VSS XP X XN YP Y YN ZP Z ZN S2P S2N S4P S4N S3P S3N S1P S1N
X0 a_55330_28838# a_55130_28794# VSS VSS nfet_06v0 ad=1.25p pd=5.5u as=2.2p ps=10.88u w=5u l=1u
X1 a_2594_44453# a_2594_44453# VDD VDD pfet_06v0 ad=0.88p pd=4.88u as=0.88p ps=4.88u w=2u l=1u
X2 a_69682_23596# a_69682_23596# VDD VDD pfet_06v0 ad=0.88p pd=4.88u as=0.88p ps=4.88u w=2u l=1u
X3 a_42790_49723# a_34818_54123# VDD VDD pfet_06v0 ad=2.6p pd=10.52u as=4.4p ps=20.88u w=10u l=1u
X4 a_19390_53193# a_2294_53077# VDD VDD pfet_06v0 ad=2.5p pd=10.5u as=4.4p ps=20.88u w=10u l=1u
X5 VDD VSS VDD VDD pfet_06v0 ad=0.44p pd=2.88u as=1.86749n ps=8.9035m w=1u l=2u
X6 a_25154_28838# a_24954_28794# a_24854_28838# VSS nfet_06v0 ad=2.2p pd=10.88u as=1.25p ps=5.5u w=5u l=1u
X7 a_70694_35696# a_69382_35580# VDD VDD pfet_06v0 ad=2.5p pd=10.5u as=4.4p ps=20.88u w=10u l=1u
X8 a_72338_16854# S1N a_69842_16854# VSS nfet_06v0 ad=3.74p pd=17.88u as=3.74p ps=17.88u w=8.5u l=1u
X9 a_72054_51200# a_72142_51084# Y VSS nfet_06v0 ad=1.0912p pd=5.84u as=0.6448p ps=3u w=2.48u l=1u
X10 VSS a_72314_66956# a_72142_51084# VSS nfet_06v0 ad=0.44p pd=2.88u as=0.44p ps=2.88u w=1u l=1u
X11 VSS VDD VSS VSS nfet_06v0 ad=7.92p pd=36.88u as=1.23306n ps=6.04388m w=18u l=2u
X12 VSS VDD VSS VSS nfet_06v0 ad=7.92p pd=36.88u as=0 ps=0 w=18u l=2u
X13 a_8870_49607# a_25568_21316# VDD VDD pfet_06v0 ad=0.44p pd=2.88u as=0.44p ps=2.88u w=1u l=1u
X14 a_31030_49723# a_25666_53077# a_34818_54123# VDD pfet_06v0 ad=2.2p pd=10.88u as=1.3p ps=5.52u w=5u l=1u
X15 a_30026_44569# a_8870_40983# a_32586_44499# VDD pfet_06v0 ad=4.4p pd=20.88u as=2.6p ps=10.52u w=10u l=1u
X16 a_7758_66967# a_25568_33300# VDD VDD pfet_06v0 ad=0.44p pd=2.88u as=0.44p ps=2.88u w=1u l=1u
X17 a_76410_51130# Y VSS VSS nfet_06v0 ad=0.5p pd=2.5u as=0.88p ps=4.88u w=2u l=1u
X18 a_12006_16854# a_3168_21316# VDD VDD pfet_06v0 ad=0.44p pd=2.88u as=0.44p ps=2.88u w=1u l=1u
X19 a_60222_4870# a_47282_11612# VSS VSS nfet_06v0 ad=0.25p pd=1.5u as=0.44p ps=2.88u w=1u l=1u
X20 a_2986_49609# a_2594_53077# a_3606_53193# VDD pfet_06v0 ad=4.4p pd=20.88u as=2.5p ps=10.5u w=10u l=1u
X21 a_8870_58343# a_3168_33300# VDD VDD pfet_06v0 ad=0.44p pd=2.88u as=0.44p ps=2.88u w=1u l=1u
X22 a_52850_58389# a_48510_58345# a_52550_58389# VSS nfet_06v0 ad=1.65p pd=5.66u as=1.25p ps=5.5u w=5u l=1u
X23 a_3606_23712# a_2294_23596# VDD VDD pfet_06v0 ad=2.5p pd=10.5u as=4.4p ps=20.88u w=10u l=1u
X24 a_55770_53123# a_48510_49609# a_56438_49723# VSS nfet_06v0 ad=1.1p pd=5.88u as=0.65p ps=3.02u w=2.5u l=1u
X25 a_8398_61859# a_7758_58343# a_6954_61929# VDD pfet_06v0 ad=2.6p pd=10.52u as=4.4p ps=20.88u w=10u l=1u
X26 a_25566_61929# a_25366_61813# VDD VDD pfet_06v0 ad=2.5p pd=10.5u as=4.4p ps=20.88u w=10u l=1u
X27 a_69542_16854# a_69342_16810# VSS VSS nfet_06v0 ad=1.25p pd=5.5u as=2.2p ps=10.88u w=5u l=1u
X28 a_9598_16854# a_2254_16810# VSS VSS nfet_06v0 ad=1.25p pd=5.5u as=2.2p ps=10.88u w=5u l=1u
X29 a_75022_28794# a_75022_28794# a_77530_28794# VSS nfet_06v0 ad=2.2p pd=10.88u as=1.65p ps=5.66u w=5u l=1u
X30 a_31470_70483# a_33254_67083# VSS VSS nfet_06v0 ad=0.65p pd=3.02u as=0.65p ps=3.02u w=2.5u l=1u
X31 a_5530_37596# a_5794_28794# VSS VSS nfet_06v0 ad=0.825p pd=3.16u as=1.1p ps=5.88u w=2.5u l=1u
X32 a_49242_49609# a_48850_53077# a_49862_53193# VDD pfet_06v0 ad=4.4p pd=20.88u as=2.5p ps=10.5u w=10u l=1u
X33 a_25666_61813# a_25666_61813# VDD VDD pfet_06v0 ad=0.88p pd=4.88u as=0.88p ps=4.88u w=2u l=1u
X34 a_25194_11728# a_24994_11612# a_26006_11728# VDD pfet_06v0 ad=4.4p pd=20.88u as=2.5p ps=10.5u w=10u l=1u
X35 a_55770_70483# a_56438_67083# VSS VSS nfet_06v0 ad=0.65p pd=3.02u as=0.65p ps=3.02u w=2.5u l=1u
X36 a_72882_4826# a_69642_4826# a_72618_13628# VSS nfet_06v0 ad=1.1p pd=5.88u as=0.825p ps=3.16u w=2.5u l=1u
X37 a_24894_11728# a_24694_11612# VDD VDD pfet_06v0 ad=2.5p pd=10.5u as=4.4p ps=20.88u w=10u l=1u
X38 a_55326_41099# a_48850_44453# a_56886_45499# VDD pfet_06v0 ad=2.2p pd=10.88u as=1.3p ps=5.52u w=5u l=1u
X39 a_42790_58459# a_34818_62859# VDD VDD pfet_06v0 ad=4.4p pd=20.88u as=2.6p ps=10.52u w=10u l=1u
X40 a_33254_49723# a_39182_54077# a_33702_54123# VDD pfet_06v0 ad=2.2p pd=10.88u as=2.2p ps=10.88u w=5u l=1u
X41 VSS a_56438_67083# a_54654_70483# VSS nfet_06v0 ad=0.65p pd=3.02u as=0.65p ps=3.02u w=2.5u l=1u
X42 a_84634_40972# a_65974_41099# VDD VDD pfet_06v0 ad=0.99p pd=3.66u as=1.32p ps=6.88u w=3u l=1u
X43 a_55326_41099# a_7758_40983# a_52850_41029# VSS nfet_06v0 ad=1.3p pd=5.52u as=2.2p ps=10.88u w=5u l=1u
X44 a_32142_49723# a_33702_54123# VDD VDD pfet_06v0 ad=1.3p pd=5.52u as=1.3p ps=5.52u w=5u l=1u
X45 a_32142_67083# a_33702_71483# VDD VDD pfet_06v0 ad=1.3p pd=5.52u as=2.2p ps=10.88u w=5u l=1u
X46 a_6954_44569# a_8870_40983# a_9514_44499# VDD pfet_06v0 ad=4.4p pd=20.88u as=2.6p ps=10.52u w=10u l=1u
X47 a_76686_16854# a_69342_16810# VSS VSS nfet_06v0 ad=1.25p pd=5.5u as=2.2p ps=10.88u w=5u l=1u
X48 a_24654_28794# a_24994_35580# a_40542_35696# VDD pfet_06v0 ad=4.4p pd=20.88u as=2.5p ps=10.5u w=10u l=1u
X49 a_7934_4826# a_7934_4826# a_10442_4826# VSS nfet_06v0 ad=2.2p pd=10.88u as=1.65p ps=5.66u w=5u l=1u
X50 VDD a_56886_54123# a_54214_49723# VDD pfet_06v0 ad=1.3p pd=5.52u as=1.3p ps=5.52u w=5u l=1u
X51 VSS a_49242_58345# a_53182_58389# VSS nfet_06v0 ad=2.2p pd=10.88u as=1.25p ps=5.5u w=5u l=1u
X52 a_54286_16854# a_46942_16810# VSS VSS nfet_06v0 ad=1.25p pd=5.5u as=2.2p ps=10.88u w=5u l=1u
X53 a_72618_37596# a_72882_28794# VSS VSS nfet_06v0 ad=0.825p pd=3.16u as=1.1p ps=5.88u w=2.5u l=1u
X54 a_3168_10682# a_7758_40983# VSS ppolyf_u_1k r_width=1u r_length=76.45u
X55 a_50218_37596# a_50482_28794# VSS VSS nfet_06v0 ad=0.825p pd=3.16u as=1.1p ps=5.88u w=2.5u l=1u
X56 a_20066_23712# a_2294_23596# VDD VDD pfet_06v0 ad=2.5p pd=10.5u as=4.4p ps=20.88u w=10u l=1u
X57 a_26058_40985# a_25326_40985# a_26258_41029# VSS nfet_06v0 ad=2.2p pd=10.88u as=1.25p ps=5.5u w=5u l=1u
X58 a_52550_49653# a_49242_49609# VSS VSS nfet_06v0 ad=1.25p pd=5.5u as=2.2p ps=10.88u w=5u l=1u
X59 a_29666_58389# a_8870_58343# a_32142_58459# VSS nfet_06v0 ad=2.2p pd=10.88u as=1.3p ps=5.52u w=5u l=1u
X60 VDD VSS VDD VDD pfet_06v0 ad=0.44p pd=2.88u as=0 ps=0 w=1u l=2u
X61 a_42790_67083# a_34366_67083# VSS VSS nfet_06v0 ad=1.3p pd=5.52u as=2.2p ps=10.88u w=5u l=1u
X62 VSS a_19718_49723# a_88406_49640# VSS nfet_06v0 ad=0.44p pd=2.88u as=0.25p ps=1.5u w=1u l=1u
X63 a_9070_49723# a_2594_53077# a_10630_54123# VDD pfet_06v0 ad=2.2p pd=10.88u as=1.3p ps=5.52u w=5u l=1u
X64 a_2294_61813# a_2594_61813# a_4218_58389# VSS nfet_06v0 ad=0.44p pd=2.88u as=0.25p ps=1.5u w=1u l=1u
X65 VSS VDD VSS VSS nfet_06v0 ad=4.29p pd=20.38u as=0 ps=0 w=9.75u l=2u
X66 a_30334_28794# a_24994_35580# a_35070_35696# VDD pfet_06v0 ad=4.4p pd=20.88u as=2.5p ps=10.5u w=10u l=1u
X67 a_33254_67083# a_25326_66969# a_32586_70483# VSS nfet_06v0 ad=0.65p pd=3.02u as=1.1p ps=5.88u w=2.5u l=1u
X68 VDD VSS VDD VDD pfet_06v0 ad=7.92p pd=36.88u as=0 ps=0 w=18u l=2u
X69 a_9390_24796# a_9390_24796# a_11026_23596# VDD pfet_06v0 ad=4.4p pd=20.88u as=3.3p ps=10.66u w=10u l=1u
X70 a_69882_11728# a_69682_11612# a_70694_11728# VDD pfet_06v0 ad=4.4p pd=20.88u as=2.5p ps=10.5u w=10u l=1u
X71 a_72314_66956# a_65974_67083# VDD VDD pfet_06v0 ad=0.99p pd=3.66u as=1.32p ps=6.88u w=3u l=1u
X72 a_9070_58459# a_8870_58343# a_6594_58389# VSS nfet_06v0 ad=1.3p pd=5.52u as=2.2p ps=10.88u w=5u l=1u
X73 a_73254_51084# a_84634_49596# VDD VDD pfet_06v0 ad=1.32p pd=6.88u as=1.32p ps=6.88u w=3u l=1u
X74 a_79086_42348# a_87474_58332# VDD VDD pfet_06v0 ad=1.32p pd=6.88u as=1.32p ps=6.88u w=3u l=1u
X75 a_29998_67013# a_25326_66969# a_29666_67013# VSS nfet_06v0 ad=1.25p pd=5.5u as=1.65p ps=5.66u w=5u l=1u
X76 a_70256_10682# a_7758_49607# VSS ppolyf_u_1k r_width=1u r_length=76.45u
X77 a_54214_67083# a_48850_70437# a_58002_71483# VDD pfet_06v0 ad=2.2p pd=10.88u as=1.3p ps=5.52u w=5u l=1u
X78 a_24694_11612# a_24994_11612# a_36902_4870# VSS nfet_06v0 ad=0.44p pd=2.88u as=0.25p ps=1.5u w=1u l=1u
X79 a_78314_35696# a_78114_35580# VDD VDD pfet_06v0 ad=2.5p pd=10.5u as=4.4p ps=20.88u w=10u l=1u
X80 VSS a_87474_49596# a_73254_42348# VSS nfet_06v0 ad=0.44p pd=2.88u as=0.44p ps=2.88u w=1u l=1u
X81 VSS VDD VSS VSS nfet_06v0 ad=0.44p pd=2.88u as=0 ps=0 w=1u l=2u
X82 a_2986_58345# a_2254_58345# a_3186_58389# VSS nfet_06v0 ad=2.2p pd=10.88u as=1.25p ps=5.5u w=5u l=1u
X83 a_9598_4870# a_2254_4826# VSS VSS nfet_06v0 ad=1.25p pd=5.5u as=2.2p ps=10.88u w=5u l=1u
X84 a_17746_44453# a_2594_44453# a_17946_44569# VDD pfet_06v0 ad=3.3p pd=10.66u as=2.5p ps=10.5u w=10u l=1u
X85 a_51786_61929# a_48550_61813# VDD VDD pfet_06v0 ad=2.5p pd=10.5u as=4.4p ps=20.88u w=10u l=1u
X86 a_69642_28794# a_69682_35580# a_84118_35696# VDD pfet_06v0 ad=4.4p pd=20.88u as=2.5p ps=10.5u w=10u l=1u
X87 a_38718_40985# a_25666_44453# a_42462_44569# VDD pfet_06v0 ad=4.4p pd=20.88u as=2.5p ps=10.5u w=10u l=1u
X88 a_11746_71483# a_2594_70437# a_7958_67083# VDD pfet_06v0 ad=1.3p pd=5.52u as=2.2p ps=10.88u w=5u l=1u
X89 a_75388_62164# Z VSS VSS nfet_05v0 ad=0.5808p pd=3.52u as=0.5808p ps=3.52u w=1.32u l=0.6u
X90 a_25566_53193# a_25366_53077# VDD VDD pfet_06v0 ad=2.5p pd=10.5u as=4.4p ps=20.88u w=10u l=1u
X91 VDD VSS VDD VDD pfet_06v0 ad=0.44p pd=2.88u as=0 ps=0 w=1u l=2u
X92 a_64002_44453# a_48850_44453# a_64202_44569# VDD pfet_06v0 ad=3.3p pd=10.66u as=2.5p ps=10.5u w=10u l=1u
X93 a_18154_58345# a_2254_58345# a_18354_58389# VSS nfet_06v0 ad=1.65p pd=5.66u as=1.25p ps=5.5u w=5u l=1u
X94 a_4218_49653# a_2594_53077# VSS VSS nfet_06v0 ad=0.25p pd=1.5u as=0.44p ps=2.88u w=1u l=1u
X95 a_52622_16810# a_52622_16810# a_55130_16810# VSS nfet_06v0 ad=2.2p pd=10.88u as=1.65p ps=5.66u w=5u l=1u
X96 VDD Z Z VDD pfet_06v0 ad=0.52p pd=2.52u as=0.52p ps=2.52u w=2u l=1u
X97 a_8870_66967# a_74490_28838# VSS VSS nfet_06v0 ad=0.44p pd=2.88u as=0.44p ps=2.88u w=1u l=1u
X98 a_73166_51200# a_73254_51084# Y VSS nfet_06v0 ad=1.0912p pd=5.84u as=0.6448p ps=3u w=2.48u l=1u
X99 VSS VDD VSS VSS nfet_06v0 ad=7.92p pd=36.88u as=0 ps=0 w=18u l=2u
X100 VDD VSS VDD VDD pfet_06v0 ad=4.29p pd=20.38u as=0 ps=0 w=9.75u l=2u
X101 a_82622_28838# a_69682_35580# VSS VSS nfet_06v0 ad=0.25p pd=1.5u as=0.44p ps=2.88u w=1u l=1u
X102 a_64410_58345# a_48510_58345# a_64610_58389# VSS nfet_06v0 ad=1.65p pd=5.66u as=1.25p ps=5.5u w=5u l=1u
X103 a_30830_66967# a_52090_28838# VSS VSS nfet_06v0 ad=0.44p pd=2.88u as=0.44p ps=2.88u w=1u l=1u
X104 a_7958_41099# a_10630_45499# VDD VDD pfet_06v0 ad=1.3p pd=5.52u as=1.3p ps=5.52u w=5u l=1u
X105 a_60222_28838# a_47282_35580# VSS VSS nfet_06v0 ad=0.25p pd=1.5u as=0.44p ps=2.88u w=1u l=1u
X106 a_28602_44569# a_25366_44453# VDD VDD pfet_06v0 ad=2.5p pd=10.5u as=4.4p ps=20.88u w=10u l=1u
X107 a_73768_58616# a_72104_58500# VSS VSS nfet_06v0 ad=0.175p pd=1.2u as=0.308p ps=2.28u w=0.7u l=1u
X108 VDD a_33702_62859# a_31030_58459# VDD pfet_06v0 ad=2.2p pd=10.88u as=1.3p ps=5.52u w=5u l=1u
X109 a_31030_67083# a_30830_66967# a_29666_67013# VSS nfet_06v0 ad=1.3p pd=5.52u as=2.2p ps=10.88u w=5u l=1u
X110 a_6654_70553# a_2294_70437# VDD VDD pfet_06v0 ad=2.5p pd=10.5u as=4.4p ps=20.88u w=10u l=1u
X111 VSS a_56438_58459# a_55770_61859# VSS nfet_06v0 ad=1.1p pd=5.88u as=0.65p ps=3.02u w=2.5u l=1u
X112 a_54654_53123# a_48510_49609# a_57550_49723# VSS nfet_06v0 ad=1.1p pd=5.88u as=0.65p ps=3.02u w=2.5u l=1u
X113 a_26678_61929# a_25366_61813# VDD VDD pfet_06v0 ad=2.5p pd=10.5u as=4.4p ps=20.88u w=10u l=1u
X114 a_2794_35696# a_2594_35580# a_3606_35696# VDD pfet_06v0 ad=4.4p pd=20.88u as=2.5p ps=10.5u w=10u l=1u
X115 a_29666_41029# a_30830_40983# a_31030_41099# VSS nfet_06v0 ad=2.2p pd=10.88u as=1.3p ps=5.52u w=5u l=1u
X116 a_81590_28838# a_69682_35580# VSS VSS nfet_06v0 ad=0.25p pd=1.5u as=0.44p ps=2.88u w=1u l=1u
X117 VSS VDD VSS VSS nfet_06v0 ad=0.44p pd=2.88u as=0 ps=0 w=1u l=2u
X118 a_65974_41099# a_57550_41099# VSS VSS nfet_06v0 ad=1.3p pd=5.52u as=2.2p ps=10.88u w=5u l=1u
X119 a_3168_22666# a_18586_22216# VSS ppolyf_u_1k r_width=1u r_length=76.45u
X120 a_18354_49653# a_18154_49609# VSS VSS nfet_06v0 ad=1.25p pd=5.5u as=2.2p ps=10.88u w=5u l=1u
X121 a_73430_23712# a_75022_16810# a_72882_16810# VSS nfet_06v0 ad=0.88p pd=4.88u as=0.88p ps=4.88u w=2u l=1u
X122 a_19718_49723# a_11294_49723# VSS VSS nfet_06v0 ad=1.3p pd=5.52u as=2.2p ps=10.88u w=5u l=1u
X123 a_6342_11728# a_2594_11612# a_5250_4870# VDD pfet_06v0 ad=4.4p pd=20.88u as=4.4p ps=20.88u w=10u l=1u
X124 VDD VSS VDD VDD pfet_06v0 ad=0.44p pd=2.88u as=0 ps=0 w=1u l=2u
X125 a_72618_13628# a_72882_4826# VSS VSS nfet_06v0 ad=0.825p pd=3.16u as=1.1p ps=5.88u w=2.5u l=1u
X126 a_56438_41099# a_48510_40985# a_55770_44499# VSS nfet_06v0 ad=0.65p pd=3.02u as=1.1p ps=5.88u w=2.5u l=1u
X127 a_64610_49653# a_64410_49609# VSS VSS nfet_06v0 ad=1.25p pd=5.5u as=2.2p ps=10.88u w=5u l=1u
X128 VDD VSS VDD VDD pfet_06v0 ad=4.29p pd=20.38u as=0 ps=0 w=9.75u l=2u
X129 a_24694_23596# a_24994_23596# a_42466_23712# VDD pfet_06v0 ad=4.4p pd=20.88u as=2.5p ps=10.5u w=10u l=1u
X130 VSS a_19718_41099# a_83814_41016# VSS nfet_06v0 ad=0.44p pd=2.88u as=0.44p ps=2.88u w=1u l=1u
X131 VSS a_34366_58459# a_42790_58459# VSS nfet_06v0 ad=1.3p pd=5.52u as=1.3p ps=5.52u w=5u l=1u
X132 a_4518_16854# S2P a_2754_16854# VSS nfet_06v0 ad=3.3p pd=15.88u as=3.3p ps=15.88u w=7.5u l=1u
X133 a_2294_23596# a_2594_23596# a_20066_23712# VDD pfet_06v0 ad=4.4p pd=20.88u as=2.5p ps=10.5u w=10u l=1u
X134 a_7286_70553# a_2594_70437# a_6954_70553# VDD pfet_06v0 ad=2.5p pd=10.5u as=3.3p ps=10.66u w=10u l=1u
X135 a_78114_11612# a_69682_11612# a_78314_11728# VDD pfet_06v0 ad=3.3p pd=10.66u as=2.5p ps=10.5u w=10u l=1u
X136 VSS a_33254_41099# a_31470_44499# VSS nfet_06v0 ad=0.65p pd=3.02u as=0.65p ps=3.02u w=2.5u l=1u
X137 a_55714_11612# a_47282_11612# a_55914_11728# VDD pfet_06v0 ad=3.3p pd=10.66u as=2.5p ps=10.5u w=10u l=1u
X138 a_32586_61859# a_25326_58345# a_33254_58459# VSS nfet_06v0 ad=1.1p pd=5.88u as=0.65p ps=3.02u w=2.5u l=1u
X139 a_69342_4826# a_69642_4826# a_80558_4870# VSS nfet_06v0 ad=2.2p pd=10.88u as=1.25p ps=5.5u w=5u l=1u
X140 a_70256_22666# a_85674_22216# VSS ppolyf_u_1k r_width=1u r_length=76.45u
X141 X X VDD VDD pfet_06v0 ad=0.52p pd=2.52u as=0.88p ps=4.88u w=2u l=1u
X142 VDD VSS VDD VDD pfet_06v0 ad=4.29p pd=20.38u as=0 ps=0 w=9.75u l=2u
X143 a_73430_11728# a_69682_11612# a_72338_4870# VDD pfet_06v0 ad=4.4p pd=20.88u as=4.4p ps=20.88u w=10u l=1u
X144 a_32142_41099# a_33702_45499# VDD VDD pfet_06v0 ad=1.3p pd=5.52u as=2.2p ps=10.88u w=5u l=1u
X145 a_54654_44499# a_56438_41099# VSS VSS nfet_06v0 ad=0.65p pd=3.02u as=1.1p ps=5.88u w=2.5u l=1u
X146 a_16110_45453# a_2254_40985# a_17310_41029# VSS nfet_06v0 ad=2.2p pd=10.88u as=1.25p ps=5.5u w=5u l=1u
X147 a_6594_41029# a_2254_40985# a_6294_41029# VSS nfet_06v0 ad=1.65p pd=5.66u as=1.25p ps=5.5u w=5u l=1u
X148 a_85566_58376# a_83814_58376# a_84634_58332# VSS nfet_06v0 ad=0.25p pd=1.5u as=0.44p ps=2.88u w=1u l=1u
X149 a_31030_58459# a_33702_62859# VDD VDD pfet_06v0 ad=1.3p pd=5.52u as=2.2p ps=10.88u w=5u l=1u
X150 a_36902_16854# a_24994_23596# VSS VSS nfet_06v0 ad=0.25p pd=1.5u as=0.44p ps=2.88u w=1u l=1u
X151 a_34366_67083# a_25326_66969# a_31470_70483# VSS nfet_06v0 ad=0.65p pd=3.02u as=1.1p ps=5.88u w=2.5u l=1u
X152 VDD a_48550_61813# a_53542_61929# VDD pfet_06v0 ad=4.4p pd=20.88u as=2.5p ps=10.5u w=10u l=1u
X153 a_2594_35580# a_2594_35580# VDD VDD pfet_06v0 ad=0.88p pd=4.88u as=0.88p ps=4.88u w=2u l=1u
X154 a_51786_53193# a_48550_53077# VDD VDD pfet_06v0 ad=2.5p pd=10.5u as=4.4p ps=20.88u w=10u l=1u
X155 VSS a_26058_66969# a_29998_67013# VSS nfet_06v0 ad=2.2p pd=10.88u as=1.25p ps=5.5u w=5u l=1u
X156 a_14502_16854# a_2594_23596# VSS VSS nfet_06v0 ad=0.25p pd=1.5u as=0.44p ps=2.88u w=1u l=1u
X157 a_71606_16854# S1P a_69842_16854# VSS nfet_06v0 ad=3.3p pd=15.88u as=3.3p ps=15.88u w=7.5u l=1u
X158 a_10182_58459# a_2254_58345# a_9514_61859# VSS nfet_06v0 ad=0.65p pd=3.02u as=1.1p ps=5.88u w=2.5u l=1u
X159 a_3486_16854# a_2254_16810# VSS VSS nfet_06v0 ad=1.25p pd=5.5u as=2.2p ps=10.88u w=5u l=1u
X160 a_61902_49609# a_61902_49609# a_64410_49609# VSS nfet_06v0 ad=2.2p pd=10.88u as=1.65p ps=5.66u w=5u l=1u
X161 a_72338_28838# S2N a_69842_28838# VSS nfet_06v0 ad=3.74p pd=17.88u as=3.74p ps=17.88u w=8.5u l=1u
X162 Z a_72142_59708# a_72054_59824# VSS nfet_06v0 ad=0.6448p pd=3u as=1.0912p ps=5.84u w=2.48u l=1u
X163 a_69682_11612# a_69682_11612# a_82622_4870# VSS nfet_06v0 ad=0.44p pd=2.88u as=0.25p ps=1.5u w=1u l=1u
X164 a_2254_66969# a_2594_70437# a_2494_70553# VDD pfet_06v0 ad=4.4p pd=20.88u as=2.5p ps=10.5u w=10u l=1u
X165 a_9514_70483# a_10182_67083# VSS VSS nfet_06v0 ad=0.65p pd=3.02u as=1.1p ps=5.88u w=2.5u l=1u
X166 VSS VDD VSS VSS nfet_06v0 ad=7.92p pd=36.88u as=0 ps=0 w=18u l=2u
X167 VSS VDD VSS VSS nfet_06v0 ad=7.92p pd=36.88u as=0 ps=0 w=18u l=2u
X168 a_33702_62859# a_25666_61813# a_32142_58459# VDD pfet_06v0 ad=1.3p pd=5.52u as=2.2p ps=10.88u w=5u l=1u
X169 a_35870_16854# a_24654_16810# VSS VSS nfet_06v0 ad=1.25p pd=5.5u as=2.2p ps=10.88u w=5u l=1u
X170 a_2294_61813# a_2594_61813# a_5530_61929# VDD pfet_06v0 ad=4.4p pd=20.88u as=2.5p ps=10.5u w=10u l=1u
X171 a_13470_16854# a_2254_16810# VSS VSS nfet_06v0 ad=1.25p pd=5.5u as=2.2p ps=10.88u w=5u l=1u
X172 a_70256_33300# a_69682_35580# a_71606_28838# VDD pfet_06v0 ad=4.4p pd=20.88u as=4.4p ps=20.88u w=10u l=1u
X173 a_70574_16854# a_69342_16810# VSS VSS nfet_06v0 ad=1.25p pd=5.5u as=2.2p ps=10.88u w=5u l=1u
X174 a_3168_21316# a_7934_16810# a_7402_16854# VSS nfet_06v0 ad=0.88p pd=4.88u as=0.88p ps=4.88u w=2u l=1u
X175 VSS a_11294_67083# a_19718_67083# VSS nfet_06v0 ad=1.3p pd=5.52u as=1.3p ps=5.52u w=5u l=1u
X176 a_69542_28838# a_69342_28794# VSS VSS nfet_06v0 ad=1.25p pd=5.5u as=2.2p ps=10.88u w=5u l=1u
X177 a_38718_40985# a_38718_40985# a_41226_40985# VSS nfet_06v0 ad=2.2p pd=10.88u as=1.65p ps=5.66u w=5u l=1u
X178 a_54214_41099# a_48850_44453# a_58002_45499# VDD pfet_06v0 ad=2.2p pd=10.88u as=1.3p ps=5.52u w=5u l=1u
X179 a_26678_53193# a_25366_53077# VDD VDD pfet_06v0 ad=2.5p pd=10.5u as=4.4p ps=20.88u w=10u l=1u
X180 a_9598_28838# a_2254_28794# VSS VSS nfet_06v0 ad=1.25p pd=5.5u as=2.2p ps=10.88u w=5u l=1u
X181 a_75388_53540# Y VSS VSS nfet_05v0 ad=0.5808p pd=3.52u as=0.5808p ps=3.52u w=1.32u l=0.6u
X182 a_29802_28838# a_31790_36780# a_25568_33300# VDD pfet_06v0 ad=1.76p pd=8.88u as=1.76p ps=8.88u w=4u l=1u
X183 a_72304_58616# a_72104_58500# VSS VSS nfet_06v0 ad=0.5456p pd=3.36u as=0.5456p ps=3.36u w=1.24u l=1u
X184 a_71806_13618# a_72882_4826# VSS VSS nfet_06v0 ad=0.825p pd=3.16u as=1.1p ps=5.88u w=2.5u l=1u
X185 VSS VDD VSS VSS nfet_06v0 ad=4.29p pd=20.38u as=0 ps=0 w=9.75u l=2u
X186 Z Z a_75010_59824# VSS nfet_06v0 ad=0.52p pd=2.52u as=0.88p ps=4.88u w=2u l=1u
X187 a_7402_28838# a_9390_36780# a_3168_33300# VDD pfet_06v0 ad=1.76p pd=8.88u as=1.76p ps=8.88u w=4u l=1u
X188 a_4518_4870# a_6342_11728# VDD VDD pfet_06v0 ad=2.2p pd=10.88u as=2.2p ps=10.88u w=5u l=1u
X189 VSS VDD VSS VSS nfet_06v0 ad=4.29p pd=20.38u as=0 ps=0 w=9.75u l=2u
X190 a_26006_35696# a_24694_35580# VDD VDD pfet_06v0 ad=2.5p pd=10.5u as=4.4p ps=20.88u w=10u l=1u
X191 a_35070_23712# a_24694_23596# VDD VDD pfet_06v0 ad=2.5p pd=10.5u as=4.4p ps=20.88u w=10u l=1u
X192 a_11746_45499# a_2594_44453# a_7958_41099# VDD pfet_06v0 ad=1.3p pd=5.52u as=2.2p ps=10.88u w=5u l=1u
X193 VSS VDD VSS VSS nfet_06v0 ad=4.29p pd=20.38u as=0 ps=0 w=9.75u l=2u
X194 VSS a_33254_67083# a_32586_70483# VSS nfet_06v0 ad=1.1p pd=5.88u as=0.65p ps=3.02u w=2.5u l=1u
X195 a_12670_23712# a_2294_23596# VDD VDD pfet_06v0 ad=2.5p pd=10.5u as=4.4p ps=20.88u w=10u l=1u
X196 a_32142_67083# a_8870_66967# a_29666_67013# VSS nfet_06v0 ad=1.3p pd=5.52u as=2.2p ps=10.88u w=5u l=1u
X197 a_70256_21316# a_75022_16810# a_74490_16854# VSS nfet_06v0 ad=0.88p pd=4.88u as=0.88p ps=4.88u w=2u l=1u
X198 a_73768_49992# a_72104_49876# VSS VSS nfet_06v0 ad=0.175p pd=1.2u as=0.308p ps=2.28u w=0.7u l=1u
X199 a_28322_67013# a_25666_70437# VSS VSS nfet_06v0 ad=0.25p pd=1.5u as=0.44p ps=2.88u w=1u l=1u
X200 a_47856_21316# a_52622_16810# a_52090_16854# VSS nfet_06v0 ad=0.88p pd=4.88u as=0.88p ps=4.88u w=2u l=1u
X201 a_76686_28838# a_69342_28794# VSS VSS nfet_06v0 ad=1.25p pd=5.5u as=2.2p ps=10.88u w=5u l=1u
X202 VSS a_56438_49723# a_55770_53123# VSS nfet_06v0 ad=0.65p pd=3.02u as=0.65p ps=3.02u w=2.5u l=1u
X203 VDD VSS VDD VDD pfet_06v0 ad=4.29p pd=20.38u as=0 ps=0 w=9.75u l=2u
X204 a_33042_16854# a_32842_16810# VSS VSS nfet_06v0 ad=1.25p pd=5.5u as=2.2p ps=10.88u w=5u l=1u
X205 VSS a_10182_67083# a_8398_70483# VSS nfet_06v0 ad=0.65p pd=3.02u as=0.65p ps=3.02u w=2.5u l=1u
X206 a_54286_28838# a_46942_28794# VSS VSS nfet_06v0 ad=1.25p pd=5.5u as=2.2p ps=10.88u w=5u l=1u
X207 a_41226_66969# a_25326_66969# a_41426_67013# VSS nfet_06v0 ad=1.65p pd=5.66u as=1.25p ps=5.5u w=5u l=1u
X208 a_29666_41029# a_8870_40983# a_32142_41099# VSS nfet_06v0 ad=2.2p pd=10.88u as=1.3p ps=5.52u w=5u l=1u
X209 a_27650_4870# S3N a_25154_4870# VSS nfet_06v0 ad=3.74p pd=17.88u as=3.74p ps=17.88u w=8.5u l=1u
X210 a_3168_22666# a_12006_16854# VSS ppolyf_u_1k r_width=1u r_length=76.45u
X211 a_75010_51200# Y Y VSS nfet_06v0 ad=0.88p pd=4.88u as=0.52p ps=2.52u w=2u l=1u
X212 a_10642_16854# a_10442_16810# VSS VSS nfet_06v0 ad=1.25p pd=5.5u as=2.2p ps=10.88u w=5u l=1u
X213 a_32142_67083# a_25666_70437# a_33702_71483# VDD pfet_06v0 ad=2.2p pd=10.88u as=1.3p ps=5.52u w=5u l=1u
X214 a_71606_4870# a_73430_11728# VDD VDD pfet_06v0 ad=2.2p pd=10.88u as=2.2p ps=10.88u w=5u l=1u
X215 a_53210_53193# a_12006_16854# a_54654_53123# VDD pfet_06v0 ad=4.4p pd=20.88u as=2.6p ps=10.52u w=10u l=1u
X216 a_49206_4870# a_51030_11728# VDD VDD pfet_06v0 ad=2.2p pd=10.88u as=2.2p ps=10.88u w=5u l=1u
X217 a_6654_44569# a_2294_44453# VDD VDD pfet_06v0 ad=2.5p pd=10.5u as=4.4p ps=20.88u w=10u l=1u
X218 VSS VDD VSS VSS nfet_06v0 ad=4.29p pd=20.38u as=0 ps=0 w=9.75u l=2u
X219 a_84118_23712# a_69382_23596# VDD VDD pfet_06v0 ad=2.5p pd=10.5u as=4.4p ps=20.88u w=10u l=1u
X220 VDD VSS VDD VDD pfet_06v0 ad=7.92p pd=36.88u as=0 ps=0 w=18u l=2u
X221 VDD X X VDD pfet_06v0 ad=0.88p pd=4.88u as=0.52p ps=2.52u w=2u l=1u
X222 VDD a_48550_53077# a_53542_53193# VDD pfet_06v0 ad=4.4p pd=20.88u as=2.5p ps=10.5u w=10u l=1u
X223 a_27290_67013# a_25666_70437# VSS VSS nfet_06v0 ad=0.25p pd=1.5u as=0.44p ps=2.88u w=1u l=1u
X224 a_85230_35696# a_69382_35580# VDD VDD pfet_06v0 ad=2.5p pd=10.5u as=4.4p ps=20.88u w=10u l=1u
X225 a_9070_41099# a_8870_40983# a_6594_41029# VSS nfet_06v0 ad=1.3p pd=5.52u as=2.2p ps=10.88u w=5u l=1u
X226 a_47856_9332# a_63274_9332# VSS ppolyf_u_1k r_width=1u r_length=76.45u
X227 a_49406_25602# a_7758_58343# cap_mim_2f0_m4m5_noshield c_width=25u c_length=8u
X228 a_61718_23712# a_46982_23596# VDD VDD pfet_06v0 ad=2.5p pd=10.5u as=4.4p ps=20.88u w=10u l=1u
X229 VDD VSS VDD VDD pfet_06v0 ad=0.44p pd=2.88u as=0 ps=0 w=1u l=2u
X230 a_70256_22666# a_30830_58343# VSS ppolyf_u_1k r_width=1u r_length=76.45u
X231 a_47282_23596# a_47282_23596# VDD VDD pfet_06v0 ad=0.88p pd=4.88u as=0.88p ps=4.88u w=2u l=1u
X232 VSS VDD VSS VSS nfet_06v0 ad=0.44p pd=2.88u as=0 ps=0 w=1u l=2u
X233 a_65974_58459# a_54214_58459# cap_mim_2f0_m4m5_noshield c_width=20u c_length=10u
X234 VSS a_42790_49723# a_73254_59708# VSS nfet_06v0 ad=0.44p pd=2.88u as=0.33p ps=1.66u w=1u l=1u
X235 a_30334_16810# a_30334_16810# a_32842_16810# VSS nfet_06v0 ad=2.2p pd=10.88u as=1.65p ps=5.66u w=5u l=1u
X236 a_28194_16810# a_31790_24796# a_28742_23712# VDD pfet_06v0 ad=1.76p pd=8.88u as=1.76p ps=8.88u w=4u l=1u
X237 a_71806_25602# a_30830_58343# cap_mim_2f0_m4m5_noshield c_width=25u c_length=8u
X238 a_7934_16810# a_7934_16810# a_10442_16810# VSS nfet_06v0 ad=2.2p pd=10.88u as=1.65p ps=5.66u w=5u l=1u
X239 a_25194_23712# a_24994_23596# a_24894_23712# VDD pfet_06v0 ad=4.4p pd=20.88u as=2.5p ps=10.5u w=10u l=1u
X240 a_52550_41029# a_49242_40985# VSS VSS nfet_06v0 ad=1.25p pd=5.5u as=2.2p ps=10.88u w=5u l=1u
X241 a_6954_70553# a_7758_66967# a_8398_70483# VDD pfet_06v0 ad=4.4p pd=20.88u as=2.6p ps=10.52u w=10u l=1u
X242 a_65974_41099# a_54214_41099# cap_mim_2f0_m4m5_noshield c_width=20u c_length=10u
X243 a_54078_12812# a_47242_4826# a_54286_4870# VSS nfet_06v0 ad=2.2p pd=10.88u as=1.25p ps=5.5u w=5u l=1u
X244 a_72104_58500# a_72104_58500# a_74368_58616# VSS nfet_06v0 ad=0.308p pd=2.28u as=0.175p ps=1.2u w=0.7u l=1u
X245 a_2294_53077# a_2594_53077# a_5530_53193# VDD pfet_06v0 ad=4.4p pd=20.88u as=2.5p ps=10.5u w=10u l=1u
X246 VSS a_19718_41099# a_88406_41016# VSS nfet_06v0 ad=0.44p pd=2.88u as=0.25p ps=1.5u w=1u l=1u
X247 a_7286_44569# a_2594_44453# a_6954_44569# VDD pfet_06v0 ad=2.5p pd=10.5u as=3.3p ps=10.66u w=10u l=1u
X248 a_32586_70483# a_33254_67083# VSS VSS nfet_06v0 ad=0.65p pd=3.02u as=1.1p ps=5.88u w=2.5u l=1u
X249 a_75388_44804# X VSS VSS nfet_05v0 ad=0.5808p pd=3.52u as=0.5808p ps=3.52u w=1.32u l=0.6u
X250 a_47142_16854# a_46942_16810# VSS VSS nfet_06v0 ad=1.25p pd=5.5u as=2.2p ps=10.88u w=5u l=1u
X251 a_72304_58616# a_79086_59708# Z VSS nfet_06v0 ad=1.0912p pd=5.84u as=0.6448p ps=3u w=2.48u l=1u
X252 a_39430_11728# a_24694_11612# VDD VDD pfet_06v0 ad=2.5p pd=10.5u as=4.4p ps=20.88u w=10u l=1u
X253 Z a_73254_59708# a_73166_59824# VSS nfet_06v0 ad=0.6448p pd=3u as=1.0912p ps=5.84u w=2.48u l=1u
X254 a_41426_58389# a_41226_58345# VSS VSS nfet_06v0 ad=1.25p pd=5.5u as=2.2p ps=10.88u w=5u l=1u
X255 a_15534_4870# a_2594_11612# VSS VSS nfet_06v0 ad=0.25p pd=1.5u as=0.44p ps=2.88u w=1u l=1u
X256 a_27930_25612# S4N a_25194_23712# VDD pfet_06v0 ad=0.22p pd=1.88u as=0.22p ps=1.88u w=0.5u l=1u
X257 a_52622_28794# a_52622_28794# a_55130_28794# VSS nfet_06v0 ad=2.2p pd=10.88u as=1.65p ps=5.66u w=5u l=1u
X258 a_49242_49609# a_48510_49609# a_49442_49653# VSS nfet_06v0 ad=2.2p pd=10.88u as=1.25p ps=5.5u w=5u l=1u
X259 a_72054_59824# a_72104_58500# VSS VSS nfet_06v0 ad=0.5456p pd=3.36u as=0.5456p ps=3.36u w=1.24u l=1u
X260 a_58002_62859# a_48850_61813# a_54214_58459# VDD pfet_06v0 ad=1.3p pd=5.52u as=2.2p ps=10.88u w=5u l=1u
X261 a_8870_40983# a_47856_9332# VDD VDD pfet_06v0 ad=0.44p pd=2.88u as=0.44p ps=2.88u w=1u l=1u
X262 a_73768_41256# a_72104_41140# VSS VSS nfet_06v0 ad=0.175p pd=1.2u as=0.308p ps=2.28u w=0.7u l=1u
X263 a_29666_49653# a_25326_49609# a_29366_49653# VSS nfet_06v0 ad=1.65p pd=5.66u as=1.25p ps=5.5u w=5u l=1u
X264 a_31470_53123# a_12006_16854# a_30026_53193# VDD pfet_06v0 ad=2.6p pd=10.52u as=4.4p ps=20.88u w=10u l=1u
X265 a_7402_16854# a_2554_16810# a_4718_25602# VSS nfet_06v0 ad=1.1p pd=5.88u as=0.825p ps=3.16u w=2.5u l=1u
X266 Z VDD a_75112_58616# VSS nfet_06v0 ad=0.6448p pd=3u as=1.0912p ps=5.84u w=2.48u l=1u
X267 VDD VSS VDD VDD pfet_06v0 ad=4.29p pd=20.38u as=0 ps=0 w=9.75u l=2u
X268 a_28194_4826# a_24954_4826# a_27930_13628# VSS nfet_06v0 ad=1.1p pd=5.88u as=0.825p ps=3.16u w=2.5u l=1u
X269 VSS a_56438_41099# a_55770_44499# VSS nfet_06v0 ad=1.1p pd=5.88u as=0.65p ps=3.02u w=2.5u l=1u
X270 VSS a_87474_40972# a_77242_42348# VSS nfet_06v0 ad=0.44p pd=2.88u as=0.44p ps=2.88u w=1u l=1u
X271 a_69842_4870# a_69642_4826# a_69542_4870# VSS nfet_06v0 ad=2.2p pd=10.88u as=1.25p ps=5.5u w=5u l=1u
X272 a_2254_40985# a_2594_44453# a_2494_44569# VDD pfet_06v0 ad=4.4p pd=20.88u as=2.5p ps=10.5u w=10u l=1u
X273 a_2254_49609# a_2254_49609# VSS VSS nfet_06v0 ad=0.44p pd=2.88u as=0.44p ps=2.88u w=1u l=1u
X274 a_47856_34650# a_63274_34200# VSS ppolyf_u_1k r_width=1u r_length=76.45u
X275 a_70256_9332# a_85674_9332# VSS ppolyf_u_1k r_width=1u r_length=76.45u
X276 a_25154_4870# a_24954_4826# a_24854_4870# VSS nfet_06v0 ad=2.2p pd=10.88u as=1.25p ps=5.5u w=5u l=1u
X277 Y Y VDD VDD pfet_06v0 ad=0.52p pd=2.52u as=0.52p ps=2.52u w=2u l=1u
X278 VDD VSS VDD VDD pfet_06v0 ad=0.44p pd=2.88u as=0 ps=0 w=1u l=2u
X279 a_4218_41029# a_2594_44453# VSS VSS nfet_06v0 ad=0.25p pd=1.5u as=0.44p ps=2.88u w=1u l=1u
X280 a_72304_49992# a_72104_49876# VSS VSS nfet_06v0 ad=0.5456p pd=3.36u as=0.5456p ps=3.36u w=1.24u l=1u
X281 a_69342_4826# a_69682_11612# a_85230_11728# VDD pfet_06v0 ad=4.4p pd=20.88u as=2.5p ps=10.5u w=10u l=1u
X282 a_73430_35696# a_75022_28794# a_72882_28794# VSS nfet_06v0 ad=0.88p pd=4.88u as=0.88p ps=4.88u w=2u l=1u
X283 a_2454_4870# a_2254_4826# VSS VSS nfet_06v0 ad=1.25p pd=5.5u as=2.2p ps=10.88u w=5u l=1u
X284 a_8398_61859# a_10182_58459# VSS VSS nfet_06v0 ad=0.65p pd=3.02u as=0.65p ps=3.02u w=2.5u l=1u
X285 a_30830_66967# a_47856_33300# VDD VDD pfet_06v0 ad=0.44p pd=2.88u as=0.44p ps=2.88u w=1u l=1u
X286 a_65974_67083# a_58002_71483# VDD VDD pfet_06v0 ad=2.6p pd=10.52u as=4.4p ps=20.88u w=10u l=1u
X287 a_46982_11612# a_47282_11612# a_59190_4870# VSS nfet_06v0 ad=0.44p pd=2.88u as=0.25p ps=1.5u w=1u l=1u
X288 a_9514_53123# a_10182_49723# VSS VSS nfet_06v0 ad=0.65p pd=3.02u as=0.65p ps=3.02u w=2.5u l=1u
X289 a_65974_49723# a_58002_54123# VDD VDD pfet_06v0 ad=4.4p pd=20.88u as=2.6p ps=10.52u w=10u l=1u
X290 VDD a_56886_62859# a_55326_58459# VDD pfet_06v0 ad=1.3p pd=5.52u as=1.3p ps=5.52u w=5u l=1u
X291 VDD VSS VDD VDD pfet_06v0 ad=7.92p pd=36.88u as=0 ps=0 w=18u l=2u
X292 a_7934_28794# a_2594_35580# a_12670_35696# VDD pfet_06v0 ad=4.4p pd=20.88u as=2.5p ps=10.5u w=10u l=1u
X293 VSS a_34366_41099# a_42790_41099# VSS nfet_06v0 ad=1.3p pd=5.52u as=1.3p ps=5.52u w=5u l=1u
X294 VSS a_57550_49723# a_65974_49723# VSS nfet_06v0 ad=1.3p pd=5.52u as=1.3p ps=5.52u w=5u l=1u
X295 VSS a_75154_66956# a_72142_42348# VSS nfet_06v0 ad=0.44p pd=2.88u as=0.44p ps=2.88u w=1u l=1u
X296 a_4518_28838# S3P a_2754_28838# VSS nfet_06v0 ad=3.3p pd=15.88u as=3.3p ps=15.88u w=7.5u l=1u
X297 a_25568_9332# a_24994_11612# a_26918_4870# VDD pfet_06v0 ad=4.4p pd=20.88u as=4.4p ps=20.88u w=10u l=1u
X298 a_32586_44499# a_25326_40985# a_33254_41099# VSS nfet_06v0 ad=1.1p pd=5.88u as=0.65p ps=3.02u w=2.5u l=1u
X299 a_6594_49653# a_7758_49607# a_7958_49723# VSS nfet_06v0 ad=2.2p pd=10.88u as=1.3p ps=5.52u w=5u l=1u
X300 VDD a_33702_54123# a_31030_49723# VDD pfet_06v0 ad=1.3p pd=5.52u as=1.3p ps=5.52u w=5u l=1u
X301 a_9070_58459# a_10630_62859# VDD VDD pfet_06v0 ad=1.3p pd=5.52u as=2.2p ps=10.88u w=5u l=1u
X302 VSS a_84634_58332# a_79086_51084# VSS nfet_06v0 ad=0.44p pd=2.88u as=0.44p ps=2.88u w=1u l=1u
X303 a_62366_62813# a_48510_58345# a_63566_58389# VSS nfet_06v0 ad=2.2p pd=10.88u as=1.25p ps=5.5u w=5u l=1u
X304 a_55914_35696# a_55714_35580# VDD VDD pfet_06v0 ad=2.5p pd=10.5u as=4.4p ps=20.88u w=10u l=1u
X305 a_53182_49653# a_48510_49609# a_52850_49653# VSS nfet_06v0 ad=1.25p pd=5.5u as=1.65p ps=5.66u w=5u l=1u
X306 a_30358_61929# a_25666_61813# a_30026_61929# VDD pfet_06v0 ad=2.5p pd=10.5u as=3.3p ps=10.66u w=10u l=1u
X307 a_5250_16854# a_6342_23712# VDD VDD pfet_06v0 ad=2.2p pd=10.88u as=2.2p ps=10.88u w=5u l=1u
X308 a_36902_28838# a_24994_35580# VSS VSS nfet_06v0 ad=0.25p pd=1.5u as=0.44p ps=2.88u w=1u l=1u
X309 a_2754_16854# a_2554_16810# a_2454_16854# VSS nfet_06v0 ad=2.2p pd=10.88u as=1.25p ps=5.5u w=5u l=1u
X310 a_18354_41029# a_18154_40985# VSS VSS nfet_06v0 ad=1.25p pd=5.5u as=2.2p ps=10.88u w=5u l=1u
X311 a_10182_41099# a_2254_40985# a_9514_44499# VSS nfet_06v0 ad=0.65p pd=3.02u as=1.1p ps=5.88u w=2.5u l=1u
X312 a_14502_28838# a_2594_35580# VSS VSS nfet_06v0 ad=0.25p pd=1.5u as=0.44p ps=2.88u w=1u l=1u
X313 a_27118_25602# a_28194_16810# VSS VSS nfet_06v0 ad=0.825p pd=3.16u as=1.1p ps=5.88u w=2.5u l=1u
X314 a_71606_28838# S2P a_69842_28838# VSS nfet_06v0 ad=3.3p pd=15.88u as=3.3p ps=15.88u w=7.5u l=1u
X315 a_3486_28838# a_2254_28794# VSS VSS nfet_06v0 ad=1.25p pd=5.5u as=2.2p ps=10.88u w=5u l=1u
X316 a_47242_28794# a_47282_35580# a_61718_35696# VDD pfet_06v0 ad=4.4p pd=20.88u as=2.5p ps=10.5u w=10u l=1u
X317 X a_72142_42348# a_72054_42464# VSS nfet_06v0 ad=0.6448p pd=3u as=1.0912p ps=5.84u w=2.48u l=1u
X318 a_32142_41099# a_25666_44453# a_33702_45499# VDD pfet_06v0 ad=2.2p pd=10.88u as=1.3p ps=5.52u w=5u l=1u
X319 a_64610_41029# a_64410_40985# VSS VSS nfet_06v0 ad=1.25p pd=5.5u as=2.2p ps=10.88u w=5u l=1u
X320 VSS VDD VSS VSS nfet_06v0 ad=7.92p pd=36.88u as=0 ps=0 w=18u l=2u
X321 VSS a_10182_67083# a_8398_70483# VSS nfet_06v0 ad=1.1p pd=5.88u as=0.65p ps=3.02u w=2.5u l=1u
X322 a_79758_23712# a_69382_23596# VDD VDD pfet_06v0 ad=2.5p pd=10.5u as=4.4p ps=20.88u w=10u l=1u
X323 a_72338_16854# a_73430_23712# VDD VDD pfet_06v0 ad=2.2p pd=10.88u as=2.2p ps=10.88u w=5u l=1u
X324 a_55326_67083# a_56886_71483# VDD VDD pfet_06v0 ad=1.3p pd=5.52u as=1.3p ps=5.52u w=5u l=1u
X325 a_6342_23712# a_7934_16810# a_5794_16810# VSS nfet_06v0 ad=0.88p pd=4.88u as=0.88p ps=4.88u w=2u l=1u
X326 a_76478_36780# a_76478_36780# a_78114_35580# VDD pfet_06v0 ad=4.4p pd=20.88u as=3.3p ps=10.66u w=10u l=1u
X327 a_19718_58459# a_11746_62859# VDD VDD pfet_06v0 ad=2.6p pd=10.52u as=4.4p ps=20.88u w=10u l=1u
X328 VSS VDD VSS VSS nfet_06v0 ad=4.29p pd=20.38u as=0 ps=0 w=9.75u l=2u
X329 a_57358_23712# a_46982_23596# VDD VDD pfet_06v0 ad=2.5p pd=10.5u as=4.4p ps=20.88u w=10u l=1u
X330 a_35870_28838# a_24654_28794# VSS VSS nfet_06v0 ad=1.25p pd=5.5u as=2.2p ps=10.88u w=5u l=1u
X331 a_49938_16854# a_51030_23712# VDD VDD pfet_06v0 ad=2.2p pd=10.88u as=2.2p ps=10.88u w=5u l=1u
X332 a_3168_33750# a_18586_33300# VSS ppolyf_u_1k r_width=1u r_length=76.45u
X333 a_54078_36780# a_54078_36780# a_55714_35580# VDD pfet_06v0 ad=4.4p pd=20.88u as=3.3p ps=10.66u w=10u l=1u
X334 a_13470_28838# a_2254_28794# VSS VSS nfet_06v0 ad=1.25p pd=5.5u as=2.2p ps=10.88u w=5u l=1u
X335 a_3168_33300# a_7934_28794# a_7402_28838# VSS nfet_06v0 ad=0.88p pd=4.88u as=0.88p ps=4.88u w=2u l=1u
X336 a_70574_28838# a_69342_28794# VSS VSS nfet_06v0 ad=1.25p pd=5.5u as=2.2p ps=10.88u w=5u l=1u
X337 a_72104_49876# a_72104_49876# a_74368_49992# VSS nfet_06v0 ad=0.308p pd=2.28u as=0.175p ps=1.2u w=0.7u l=1u
X338 a_54654_61859# a_65974_58459# cap_mim_2f0_m4m5_noshield c_width=20u c_length=10u
X339 a_63566_49653# a_49242_49609# VSS VSS nfet_06v0 ad=1.25p pd=5.5u as=2.2p ps=10.88u w=5u l=1u
X340 a_25568_21316# a_30334_16810# a_29802_16854# VSS nfet_06v0 ad=0.88p pd=4.88u as=0.88p ps=4.88u w=2u l=1u
X341 a_72304_41256# a_72104_41140# VSS VSS nfet_06v0 ad=0.5456p pd=3.36u as=0.5456p ps=3.36u w=1.24u l=1u
X342 a_3186_49653# a_2986_49609# VSS VSS nfet_06v0 ad=1.25p pd=5.5u as=2.2p ps=10.88u w=5u l=1u
X343 a_65974_67083# a_57550_67083# VSS VSS nfet_06v0 ad=2.2p pd=10.88u as=1.3p ps=5.52u w=5u l=1u
X344 a_52850_49653# a_12006_16854# a_54214_49723# VSS nfet_06v0 ad=2.2p pd=10.88u as=1.3p ps=5.52u w=5u l=1u
X345 X X a_75010_42464# VSS nfet_06v0 ad=0.52p pd=2.52u as=0.88p ps=4.88u w=2u l=1u
X346 VDD a_10630_71483# a_9070_67083# VDD pfet_06v0 ad=1.3p pd=5.52u as=1.3p ps=5.52u w=5u l=1u
X347 a_7758_58343# a_49206_16854# cap_mim_2f0_m4m5_noshield c_width=25u c_length=8u
X348 VDD a_10630_54123# a_9070_49723# VDD pfet_06v0 ad=2.2p pd=10.88u as=1.3p ps=5.52u w=5u l=1u
X349 VDD VSS VDD VDD pfet_06v0 ad=7.92p pd=36.88u as=0 ps=0 w=18u l=2u
X350 a_6954_44569# a_7758_40983# a_8398_44499# VDD pfet_06v0 ad=4.4p pd=20.88u as=2.6p ps=10.52u w=10u l=1u
X351 a_2594_53077# a_2594_53077# a_5250_49653# VSS nfet_06v0 ad=0.44p pd=2.88u as=0.25p ps=1.5u w=1u l=1u
X352 a_61902_40985# a_61902_40985# a_64410_40985# VSS nfet_06v0 ad=2.2p pd=10.88u as=1.65p ps=5.66u w=5u l=1u
X353 a_55770_53123# a_7758_49607# a_53210_53193# VDD pfet_06v0 ad=2.6p pd=10.52u as=4.4p ps=20.88u w=10u l=1u
X354 a_57550_58459# a_62366_62813# a_58002_62859# VDD pfet_06v0 ad=2.2p pd=10.88u as=2.2p ps=10.88u w=5u l=1u
X355 VSS VDD VSS VSS nfet_06v0 ad=4.29p pd=20.38u as=0 ps=0 w=9.75u l=2u
X356 a_72054_51200# a_72104_49876# VSS VSS nfet_06v0 ad=0.5456p pd=3.36u as=0.5456p ps=3.36u w=1.24u l=1u
X357 a_70256_33750# a_85674_33300# VSS ppolyf_u_1k r_width=1u r_length=76.45u
X358 a_75112_58616# a_72104_58500# VSS VSS nfet_06v0 ad=0.5456p pd=3.36u as=0.5456p ps=3.36u w=1.24u l=1u
X359 a_51030_23712# a_52622_16810# a_50482_16810# VSS nfet_06v0 ad=0.88p pd=4.88u as=0.88p ps=4.88u w=2u l=1u
X360 a_70256_33300# a_75022_28794# a_74490_28838# VSS nfet_06v0 ad=0.88p pd=4.88u as=0.88p ps=4.88u w=2u l=1u
X361 a_47856_34650# a_30830_66967# VSS ppolyf_u_1k r_width=1u r_length=76.45u
X362 VDD VSS VDD VDD pfet_06v0 ad=0.44p pd=2.88u as=0 ps=0 w=1u l=2u
X363 a_35870_4870# a_24654_4826# VSS VSS nfet_06v0 ad=1.25p pd=5.5u as=2.2p ps=10.88u w=5u l=1u
X364 Y VDD a_75112_49992# VSS nfet_06v0 ad=0.6448p pd=3u as=1.0912p ps=5.84u w=2.48u l=1u
X365 VDD VSS VDD VDD pfet_06v0 ad=4.29p pd=20.38u as=0 ps=0 w=9.75u l=2u
X366 a_47856_33300# a_52622_28794# a_52090_28838# VSS nfet_06v0 ad=0.88p pd=4.88u as=0.88p ps=4.88u w=2u l=1u
X367 VDD a_71494_67000# a_72314_66956# VDD pfet_06v0 ad=1.32p pd=6.88u as=0.99p ps=3.66u w=3u l=1u
X368 a_76086_67000# a_42790_67083# a_75154_66956# VSS nfet_06v0 ad=0.25p pd=1.5u as=0.44p ps=2.88u w=1u l=1u
X369 a_33042_28838# a_32842_28794# VSS VSS nfet_06v0 ad=1.25p pd=5.5u as=2.2p ps=10.88u w=5u l=1u
X370 a_9514_70483# a_2254_66969# a_10182_67083# VSS nfet_06v0 ad=1.1p pd=5.88u as=0.65p ps=3.02u w=2.5u l=1u
X371 a_41018_70553# a_40818_70437# VDD VDD pfet_06v0 ad=2.5p pd=10.5u as=4.4p ps=20.88u w=10u l=1u
X372 a_84634_58332# a_65974_58459# VDD VDD pfet_06v0 ad=0.99p pd=3.66u as=1.32p ps=6.88u w=3u l=1u
X373 VSS VDD VSS VSS nfet_06v0 ad=0.44p pd=2.88u as=0 ps=0 w=1u l=2u
X374 a_15646_66969# a_2594_70437# a_19390_70553# VDD pfet_06v0 ad=4.4p pd=20.88u as=2.5p ps=10.5u w=10u l=1u
X375 a_72882_16810# a_76478_24796# a_73430_23712# VDD pfet_06v0 ad=1.76p pd=8.88u as=1.76p ps=8.88u w=4u l=1u
X376 a_10642_28838# a_10442_28794# VSS VSS nfet_06v0 ad=1.25p pd=5.5u as=2.2p ps=10.88u w=5u l=1u
X377 a_32586_61859# a_8870_58343# a_30026_61929# VDD pfet_06v0 ad=2.6p pd=10.52u as=4.4p ps=20.88u w=10u l=1u
X378 a_49406_25602# S4P a_47482_23712# VDD pfet_06v0 ad=0.242p pd=1.98u as=0.242p ps=1.98u w=0.55u l=1u
X379 a_24994_23596# a_24994_23596# VDD VDD pfet_06v0 ad=0.88p pd=4.88u as=0.88p ps=4.88u w=2u l=1u
X380 VDD VSS VDD VDD pfet_06v0 ad=4.29p pd=20.38u as=0 ps=0 w=9.75u l=2u
X381 a_32586_53123# a_33254_49723# VSS VSS nfet_06v0 ad=0.65p pd=3.02u as=0.65p ps=3.02u w=2.5u l=1u
X382 a_50482_16810# a_54078_24796# a_51030_23712# VDD pfet_06v0 ad=1.76p pd=8.88u as=1.76p ps=8.88u w=4u l=1u
X383 a_7958_67083# a_10630_71483# VDD VDD pfet_06v0 ad=1.3p pd=5.52u as=2.2p ps=10.88u w=5u l=1u
X384 VDD a_11746_71483# a_19718_67083# VDD pfet_06v0 ad=2.6p pd=10.52u as=2.6p ps=10.52u w=10u l=1u
X385 a_30358_53193# a_25666_53077# a_30026_53193# VDD pfet_06v0 ad=2.5p pd=10.5u as=3.3p ps=10.66u w=10u l=1u
X386 a_19718_49723# a_11294_49723# VSS VSS nfet_06v0 ad=2.2p pd=10.88u as=1.3p ps=5.52u w=5u l=1u
X387 a_26058_58345# a_25326_58345# a_26258_58389# VSS nfet_06v0 ad=2.2p pd=10.88u as=1.25p ps=5.5u w=5u l=1u
X388 a_51030_11728# a_47282_11612# a_49938_4870# VDD pfet_06v0 ad=4.4p pd=20.88u as=4.4p ps=20.88u w=10u l=1u
X389 VDD VSS VDD VDD pfet_06v0 ad=4.29p pd=20.38u as=0 ps=0 w=9.75u l=2u
X390 a_15646_49609# a_15646_49609# a_18154_49609# VSS nfet_06v0 ad=2.2p pd=10.88u as=1.65p ps=5.66u w=5u l=1u
X391 a_8398_53123# a_10182_49723# VSS VSS nfet_06v0 ad=0.65p pd=3.02u as=1.1p ps=5.88u w=2.5u l=1u
X392 a_54214_67083# a_56886_71483# VDD VDD pfet_06v0 ad=1.3p pd=5.52u as=2.2p ps=10.88u w=5u l=1u
X393 a_27118_13618# a_30830_40983# cap_mim_2f0_m4m5_noshield c_width=25u c_length=8u
X394 a_54214_49723# a_56886_54123# VDD VDD pfet_06v0 ad=1.3p pd=5.52u as=1.3p ps=5.52u w=5u l=1u
X395 a_3168_33300# a_2594_35580# a_4518_28838# VDD pfet_06v0 ad=4.4p pd=20.88u as=4.4p ps=20.88u w=10u l=1u
X396 a_7758_49607# a_70256_9332# VDD VDD pfet_06v0 ad=0.44p pd=2.88u as=0.44p ps=2.88u w=1u l=1u
X397 a_4718_13618# a_7758_40983# cap_mim_2f0_m4m5_noshield c_width=25u c_length=8u
X398 a_56886_62859# a_48850_61813# a_55326_58459# VDD pfet_06v0 ad=1.3p pd=5.52u as=2.2p ps=10.88u w=5u l=1u
X399 a_6594_49653# a_8870_49607# a_9070_49723# VSS nfet_06v0 ad=2.2p pd=10.88u as=1.3p ps=5.52u w=5u l=1u
X400 a_24854_16854# a_24654_16810# VSS VSS nfet_06v0 ad=1.25p pd=5.5u as=2.2p ps=10.88u w=5u l=1u
X401 a_48850_53077# a_48850_53077# a_51506_49653# VSS nfet_06v0 ad=0.44p pd=2.88u as=0.25p ps=1.5u w=1u l=1u
X402 a_10630_71483# a_2594_70437# a_9070_67083# VDD pfet_06v0 ad=1.3p pd=5.52u as=2.2p ps=10.88u w=5u l=1u
X403 a_30334_28794# a_30334_28794# a_32842_28794# VSS nfet_06v0 ad=2.2p pd=10.88u as=1.65p ps=5.66u w=5u l=1u
X404 a_65974_41099# a_58002_45499# VDD VDD pfet_06v0 ad=2.6p pd=10.52u as=4.4p ps=20.88u w=10u l=1u
X405 a_7934_28794# a_7934_28794# a_10442_28794# VSS nfet_06v0 ad=2.2p pd=10.88u as=1.65p ps=5.66u w=5u l=1u
X406 a_31470_61859# a_42790_58459# cap_mim_2f0_m4m5_noshield c_width=20u c_length=10u
X407 a_72104_41140# a_72104_41140# a_74368_41256# VSS nfet_06v0 ad=0.308p pd=2.28u as=0.175p ps=1.2u w=0.7u l=1u
X408 a_69382_35580# a_69682_35580# a_87154_35696# VDD pfet_06v0 ad=4.4p pd=20.88u as=2.5p ps=10.5u w=10u l=1u
X409 a_29726_70553# a_25366_70437# VDD VDD pfet_06v0 ad=2.5p pd=10.5u as=4.4p ps=20.88u w=10u l=1u
X410 a_47856_33300# a_47282_35580# a_49206_28838# VDD pfet_06v0 ad=4.4p pd=20.88u as=4.4p ps=20.88u w=10u l=1u
X411 a_72304_41256# a_79086_42348# X VSS nfet_06v0 ad=1.0912p pd=5.84u as=0.6448p ps=3u w=2.48u l=1u
X412 X a_73254_42348# a_73166_42464# VSS nfet_06v0 ad=0.6448p pd=3u as=1.0912p ps=5.84u w=2.48u l=1u
X413 a_47142_28838# a_46942_28794# VSS VSS nfet_06v0 ad=1.25p pd=5.5u as=2.2p ps=10.88u w=5u l=1u
X414 a_26258_49653# a_26058_49609# VSS VSS nfet_06v0 ad=1.25p pd=5.5u as=2.2p ps=10.88u w=5u l=1u
X415 a_33702_71483# a_38718_66969# a_33254_67083# VSS nfet_06v0 ad=1.1p pd=5.88u as=1.1p ps=5.88u w=2.5u l=1u
X416 a_31998_16854# a_24654_16810# VSS VSS nfet_06v0 ad=1.25p pd=5.5u as=2.2p ps=10.88u w=5u l=1u
X417 a_25568_34650# a_40986_34200# VSS ppolyf_u_1k r_width=1u r_length=76.45u
X418 a_48550_53077# a_48850_53077# a_50474_49653# VSS nfet_06v0 ad=0.44p pd=2.88u as=0.25p ps=1.5u w=1u l=1u
X419 a_42790_58459# a_34818_62859# VDD VDD pfet_06v0 ad=2.6p pd=10.52u as=4.4p ps=20.88u w=10u l=1u
X420 a_72054_42464# a_72104_41140# VSS VSS nfet_06v0 ad=0.5456p pd=3.36u as=0.5456p ps=3.36u w=1.24u l=1u
X421 a_11294_58459# a_2254_58345# a_8398_61859# VSS nfet_06v0 ad=0.65p pd=3.02u as=1.1p ps=5.88u w=2.5u l=1u
X422 a_48750_61929# a_48550_61813# VDD VDD pfet_06v0 ad=2.5p pd=10.5u as=4.4p ps=20.88u w=10u l=1u
X423 a_28742_23712# a_24994_23596# a_27650_16854# VDD pfet_06v0 ad=4.4p pd=20.88u as=4.4p ps=20.88u w=10u l=1u
X424 a_3168_33750# a_18586_34200# VSS ppolyf_u_1k r_width=1u r_length=76.45u
X425 VSS VDD VSS VSS nfet_06v0 ad=4.29p pd=20.38u as=0 ps=0 w=9.75u l=2u
X426 a_7402_28838# a_2554_28794# a_4718_37586# VSS nfet_06v0 ad=1.1p pd=5.88u as=0.825p ps=3.16u w=2.5u l=1u
X427 a_69582_23712# a_69382_23596# VDD VDD pfet_06v0 ad=2.5p pd=10.5u as=4.4p ps=20.88u w=10u l=1u
X428 X VDD a_75112_41256# VSS nfet_06v0 ad=0.6448p pd=3u as=1.0912p ps=5.84u w=2.48u l=1u
X429 a_57550_49723# a_62366_54077# a_58002_54123# VDD pfet_06v0 ad=2.2p pd=10.88u as=2.2p ps=10.88u w=5u l=1u
X430 a_65974_49723# a_54214_49723# cap_mim_2f0_m4m5_noshield c_width=20u c_length=10u
X431 VSS a_42790_41099# a_77242_59708# VSS nfet_06v0 ad=0.44p pd=2.88u as=0.33p ps=1.66u w=1u l=1u
X432 a_75022_28794# a_69682_35580# a_79758_35696# VDD pfet_06v0 ad=4.4p pd=20.88u as=2.5p ps=10.5u w=10u l=1u
X433 a_52622_28794# a_47282_35580# a_57358_35696# VDD pfet_06v0 ad=4.4p pd=20.88u as=2.5p ps=10.5u w=10u l=1u
X434 a_31030_58459# a_25666_61813# a_34818_62859# VDD pfet_06v0 ad=2.2p pd=10.88u as=1.3p ps=5.52u w=5u l=1u
X435 a_8870_58343# a_4518_28838# cap_mim_2f0_m4m5_noshield c_width=25u c_length=8u
X436 a_55326_41099# a_56886_45499# VDD VDD pfet_06v0 ad=1.3p pd=5.52u as=1.3p ps=5.52u w=5u l=1u
X437 a_70256_33750# a_85674_34200# VSS ppolyf_u_1k r_width=1u r_length=76.45u
X438 VSS VDD VSS VSS nfet_06v0 ad=7.92p pd=36.88u as=0 ps=0 w=18u l=2u
X439 a_65646_61929# a_48550_61813# VDD VDD pfet_06v0 ad=2.5p pd=10.5u as=4.4p ps=20.88u w=10u l=1u
X440 a_8398_44499# a_10182_41099# VSS VSS nfet_06v0 ad=0.65p pd=3.02u as=0.65p ps=3.02u w=2.5u l=1u
X441 a_48174_4870# a_46942_4826# VSS VSS nfet_06v0 ad=1.25p pd=5.5u as=2.2p ps=10.88u w=5u l=1u
X442 a_33626_35696# a_33426_35580# VDD VDD pfet_06v0 ad=2.5p pd=10.5u as=4.4p ps=20.88u w=10u l=1u
X443 a_49242_40985# a_48510_40985# a_49442_41029# VSS nfet_06v0 ad=2.2p pd=10.88u as=1.25p ps=5.5u w=5u l=1u
X444 a_52850_58389# a_7758_58343# a_55326_58459# VSS nfet_06v0 ad=2.2p pd=10.88u as=1.3p ps=5.52u w=5u l=1u
X445 VSS a_42790_67083# a_72142_59708# VSS nfet_06v0 ad=0.44p pd=2.88u as=0.33p ps=1.66u w=1u l=1u
X446 VSS VDD VSS VSS nfet_06v0 ad=4.29p pd=20.38u as=0 ps=0 w=9.75u l=2u
X447 a_4718_13618# S2P a_2794_11728# VDD pfet_06v0 ad=0.242p pd=1.98u as=0.242p ps=1.98u w=0.55u l=1u
X448 a_29666_41029# a_25326_40985# a_29366_41029# VSS nfet_06v0 ad=1.65p pd=5.66u as=1.25p ps=5.5u w=5u l=1u
X449 a_11226_35696# a_11026_35580# VDD VDD pfet_06v0 ad=2.5p pd=10.5u as=4.4p ps=20.88u w=10u l=1u
X450 a_75112_49992# a_72104_49876# VSS VSS nfet_06v0 ad=0.5456p pd=3.36u as=0.5456p ps=3.36u w=1.24u l=1u
X451 VSS a_56438_58459# a_54654_61859# VSS nfet_06v0 ad=1.1p pd=5.88u as=0.65p ps=3.02u w=2.5u l=1u
X452 a_83814_41016# a_19718_41099# VDD VDD pfet_06v0 ad=1.32p pd=6.88u as=1.32p ps=6.88u w=3u l=1u
X453 VDD a_10630_45499# a_9070_41099# VDD pfet_06v0 ad=1.3p pd=5.52u as=1.3p ps=5.52u w=5u l=1u
X454 a_30830_58343# a_70256_21316# VDD VDD pfet_06v0 ad=0.44p pd=2.88u as=0.44p ps=2.88u w=1u l=1u
X455 a_62830_35696# a_46982_35580# VDD VDD pfet_06v0 ad=2.5p pd=10.5u as=4.4p ps=20.88u w=10u l=1u
X456 a_6926_67013# a_2254_66969# a_6594_67013# VSS nfet_06v0 ad=1.25p pd=5.5u as=1.65p ps=5.66u w=5u l=1u
X457 VDD a_34818_71483# a_42790_67083# VDD pfet_06v0 ad=2.6p pd=10.52u as=2.6p ps=10.52u w=10u l=1u
X458 a_8398_70483# a_2254_66969# a_11294_67083# VSS nfet_06v0 ad=1.1p pd=5.88u as=0.65p ps=3.02u w=2.5u l=1u
X459 a_32142_58459# a_33702_62859# VDD VDD pfet_06v0 ad=1.3p pd=5.52u as=1.3p ps=5.52u w=5u l=1u
X460 VDD VSS VDD VDD pfet_06v0 ad=0.44p pd=2.88u as=0 ps=0 w=1u l=2u
X461 a_2254_40985# a_2254_40985# VSS VSS nfet_06v0 ad=0.44p pd=2.88u as=0.44p ps=2.88u w=1u l=1u
X462 a_40382_67013# a_26058_66969# VSS VSS nfet_06v0 ad=1.25p pd=5.5u as=2.2p ps=10.88u w=5u l=1u
X463 a_42790_49723# a_34366_49723# VSS VSS nfet_06v0 ad=2.2p pd=10.88u as=1.3p ps=5.52u w=5u l=1u
X464 a_25326_66969# a_25666_70437# a_25566_70553# VDD pfet_06v0 ad=4.4p pd=20.88u as=2.5p ps=10.5u w=10u l=1u
X465 VSS a_19718_58459# a_83814_58376# VSS nfet_06v0 ad=0.44p pd=2.88u as=0.44p ps=2.88u w=1u l=1u
X466 VDD a_56886_62859# a_54214_58459# VDD pfet_06v0 ad=1.3p pd=5.52u as=1.3p ps=5.52u w=5u l=1u
X467 a_24954_16810# a_24994_23596# a_39430_23712# VDD pfet_06v0 ad=4.4p pd=20.88u as=2.5p ps=10.5u w=10u l=1u
X468 a_31470_53123# a_33254_49723# VSS VSS nfet_06v0 ad=0.65p pd=3.02u as=1.1p ps=5.88u w=2.5u l=1u
X469 a_69642_16810# a_69642_16810# VSS VSS nfet_06v0 ad=0.44p pd=2.88u as=0.44p ps=2.88u w=1u l=1u
X470 a_2554_16810# a_2594_23596# a_17030_23712# VDD pfet_06v0 ad=4.4p pd=20.88u as=2.5p ps=10.5u w=10u l=1u
X471 a_47242_16810# a_47242_16810# VSS VSS nfet_06v0 ad=0.44p pd=2.88u as=0.44p ps=2.88u w=1u l=1u
X472 a_71806_13618# S1P a_69882_11728# VDD pfet_06v0 ad=0.242p pd=1.98u as=0.242p ps=1.98u w=0.55u l=1u
X473 a_2754_28838# a_2554_28794# a_2454_28838# VSS nfet_06v0 ad=2.2p pd=10.88u as=1.25p ps=5.5u w=5u l=1u
X474 a_25366_61813# a_25666_61813# a_28602_61929# VDD pfet_06v0 ad=4.4p pd=20.88u as=2.5p ps=10.5u w=10u l=1u
X475 a_41018_44569# a_40818_44453# VDD VDD pfet_06v0 ad=2.5p pd=10.5u as=4.4p ps=20.88u w=10u l=1u
X476 a_9070_58459# a_2594_61813# a_10630_62859# VDD pfet_06v0 ad=2.2p pd=10.88u as=1.3p ps=5.52u w=5u l=1u
X477 a_27650_16854# a_28742_23712# VDD VDD pfet_06v0 ad=2.2p pd=10.88u as=2.2p ps=10.88u w=5u l=1u
X478 a_27118_37586# a_28194_28794# VSS VSS nfet_06v0 ad=0.825p pd=3.16u as=1.1p ps=5.88u w=2.5u l=1u
X479 a_31790_36780# a_31790_36780# a_33426_35580# VDD pfet_06v0 ad=4.4p pd=20.88u as=3.3p ps=10.66u w=10u l=1u
X480 a_15646_40985# a_2594_44453# a_19390_44569# VDD pfet_06v0 ad=4.4p pd=20.88u as=2.5p ps=10.5u w=10u l=1u
X481 a_16110_62813# a_2254_58345# a_17310_58389# VSS nfet_06v0 ad=2.2p pd=10.88u as=1.25p ps=5.5u w=5u l=1u
X482 XN a_75388_44804# VDD VDD pfet_05v0 ad=0.8052p pd=4.54u as=0.8052p ps=4.54u w=1.83u l=0.5u
X483 Y a_79086_51084# a_72304_49992# VSS nfet_06v0 ad=0.6448p pd=3u as=1.0912p ps=5.84u w=2.48u l=1u
X484 a_71494_67000# a_19718_67083# VDD VDD pfet_06v0 ad=1.32p pd=6.88u as=1.32p ps=6.88u w=3u l=1u
X485 a_6594_58389# a_2254_58345# a_6294_58389# VSS nfet_06v0 ad=1.65p pd=5.66u as=1.25p ps=5.5u w=5u l=1u
X486 a_7958_58459# a_7758_58343# a_6594_58389# VSS nfet_06v0 ad=1.3p pd=5.52u as=2.2p ps=10.88u w=5u l=1u
X487 VDD a_11746_45499# a_19718_41099# VDD pfet_06v0 ad=2.6p pd=10.52u as=2.6p ps=10.52u w=10u l=1u
X488 a_17030_11728# a_2294_11612# VDD VDD pfet_06v0 ad=2.5p pd=10.5u as=4.4p ps=20.88u w=10u l=1u
X489 a_7958_41099# a_10630_45499# VDD VDD pfet_06v0 ad=1.3p pd=5.52u as=2.2p ps=10.88u w=5u l=1u
X490 VSS VDD VSS VSS nfet_06v0 ad=7.92p pd=36.88u as=0 ps=0 w=18u l=2u
X491 a_48750_53193# a_48550_53077# VDD VDD pfet_06v0 ad=2.5p pd=10.5u as=4.4p ps=20.88u w=10u l=1u
X492 a_5794_28794# a_9390_36780# a_6342_35696# VDD pfet_06v0 ad=1.76p pd=8.88u as=1.76p ps=8.88u w=4u l=1u
X493 a_11746_54123# a_15646_49609# a_11294_49723# VSS nfet_06v0 ad=1.1p pd=5.88u as=1.1p ps=5.88u w=2.5u l=1u
X494 a_54214_41099# a_56886_45499# VDD VDD pfet_06v0 ad=1.3p pd=5.52u as=2.2p ps=10.88u w=5u l=1u
X495 VSS VDD VSS VSS nfet_06v0 ad=4.29p pd=20.38u as=0 ps=0 w=9.75u l=2u
X496 a_65974_67083# a_54214_67083# cap_mim_2f0_m4m5_noshield c_width=20u c_length=10u
X497 a_72618_13628# S1N a_69882_11728# VDD pfet_06v0 ad=0.22p pd=1.88u as=0.22p ps=1.88u w=0.5u l=1u
X498 a_6342_35696# a_7934_28794# a_5794_28794# VSS nfet_06v0 ad=0.88p pd=4.88u as=0.88p ps=4.88u w=2u l=1u
X499 VDD VSS VDD VDD pfet_06v0 ad=4.29p pd=20.38u as=0 ps=0 w=9.75u l=2u
X500 a_19718_58459# a_7958_58459# cap_mim_2f0_m4m5_noshield c_width=20u c_length=10u
X501 a_58002_54123# a_61902_49609# a_57550_49723# VSS nfet_06v0 ad=1.1p pd=5.88u as=1.1p ps=5.88u w=2.5u l=1u
X502 a_50218_13628# S1N a_47482_11728# VDD pfet_06v0 ad=0.22p pd=1.88u as=0.22p ps=1.88u w=0.5u l=1u
X503 a_53182_41029# a_48510_40985# a_52850_41029# VSS nfet_06v0 ad=1.25p pd=5.5u as=1.65p ps=5.66u w=5u l=1u
X504 a_28742_23712# a_30334_16810# a_28194_16810# VSS nfet_06v0 ad=0.88p pd=4.88u as=0.88p ps=4.88u w=2u l=1u
X505 VSS VDD VSS VSS nfet_06v0 ad=0.44p pd=2.88u as=0 ps=0 w=1u l=2u
X506 a_25568_34650# a_7758_66967# VSS ppolyf_u_1k r_width=1u r_length=76.45u
X507 a_3606_61929# a_2294_61813# VDD VDD pfet_06v0 ad=2.5p pd=10.5u as=4.4p ps=20.88u w=10u l=1u
X508 VDD a_33702_71483# a_32142_67083# VDD pfet_06v0 ad=2.2p pd=10.88u as=1.3p ps=5.52u w=5u l=1u
X509 a_25568_33300# a_30334_28794# a_29802_28838# VSS nfet_06v0 ad=0.88p pd=4.88u as=0.88p ps=4.88u w=2u l=1u
X510 a_10630_45499# a_2594_44453# a_9070_41099# VDD pfet_06v0 ad=1.3p pd=5.52u as=2.2p ps=10.88u w=5u l=1u
X511 a_2494_11728# a_2294_11612# VDD VDD pfet_06v0 ad=2.5p pd=10.5u as=4.4p ps=20.88u w=10u l=1u
X512 a_19718_41099# a_7958_41099# cap_mim_2f0_m4m5_noshield c_width=20u c_length=10u
X513 a_70574_4870# a_69342_4826# VSS VSS nfet_06v0 ad=1.25p pd=5.5u as=2.2p ps=10.88u w=5u l=1u
X514 a_30830_58343# a_70256_21316# VDD VDD pfet_06v0 ad=0.44p pd=2.88u as=0.44p ps=2.88u w=1u l=1u
X515 a_4718_37586# a_8870_58343# cap_mim_2f0_m4m5_noshield c_width=25u c_length=8u
X516 a_74490_16854# a_76478_24796# a_70256_21316# VDD pfet_06v0 ad=1.76p pd=8.88u as=1.76p ps=8.88u w=4u l=1u
X517 a_8870_66967# a_70256_33300# VDD VDD pfet_06v0 ad=0.44p pd=2.88u as=0.44p ps=2.88u w=1u l=1u
X518 a_49862_61929# a_48550_61813# VDD VDD pfet_06v0 ad=2.5p pd=10.5u as=4.4p ps=20.88u w=10u l=1u
X519 a_38718_58345# a_38718_58345# a_41226_58345# VSS nfet_06v0 ad=2.2p pd=10.88u as=1.65p ps=5.66u w=5u l=1u
X520 a_33426_11612# a_24994_11612# a_33626_11728# VDD pfet_06v0 ad=3.3p pd=10.66u as=2.5p ps=10.5u w=10u l=1u
X521 a_17310_49653# a_2986_49609# VSS VSS nfet_06v0 ad=1.25p pd=5.5u as=2.2p ps=10.88u w=5u l=1u
X522 a_65646_53193# a_48550_53077# VDD VDD pfet_06v0 ad=2.5p pd=10.5u as=4.4p ps=20.88u w=10u l=1u
X523 a_75112_41256# a_72104_41140# VSS VSS nfet_06v0 ad=0.5456p pd=3.36u as=0.5456p ps=3.36u w=1.24u l=1u
X524 a_11026_11612# a_2594_11612# a_11226_11728# VDD pfet_06v0 ad=3.3p pd=10.66u as=2.5p ps=10.5u w=10u l=1u
X525 a_7758_58343# a_47856_21316# VDD VDD pfet_06v0 ad=0.44p pd=2.88u as=0.44p ps=2.88u w=1u l=1u
X526 a_29726_44569# a_25366_44453# VDD VDD pfet_06v0 ad=2.5p pd=10.5u as=4.4p ps=20.88u w=10u l=1u
X527 a_6294_49653# a_2986_49609# VSS VSS nfet_06v0 ad=1.25p pd=5.5u as=2.2p ps=10.88u w=5u l=1u
X528 a_47856_21316# a_63274_21316# VSS ppolyf_u_1k r_width=1u r_length=76.45u
X529 a_69882_35696# a_69682_35580# a_69582_35696# VDD pfet_06v0 ad=4.4p pd=20.88u as=2.5p ps=10.5u w=10u l=1u
X530 a_48294_23712# a_46982_23596# VDD VDD pfet_06v0 ad=2.5p pd=10.5u as=4.4p ps=20.88u w=10u l=1u
X531 a_46942_4826# a_47282_11612# a_62830_11728# VDD pfet_06v0 ad=4.4p pd=20.88u as=2.5p ps=10.5u w=10u l=1u
X532 a_25568_9332# a_40986_9332# VSS ppolyf_u_1k r_width=1u r_length=76.45u
X533 a_51030_35696# a_52622_28794# a_50482_28794# VSS nfet_06v0 ad=0.88p pd=4.88u as=0.88p ps=4.88u w=2u l=1u
X534 a_47482_35696# a_47282_35580# a_47182_35696# VDD pfet_06v0 ad=4.4p pd=20.88u as=2.5p ps=10.5u w=10u l=1u
X535 a_30026_53193# a_8870_49607# a_32586_53123# VDD pfet_06v0 ad=4.4p pd=20.88u as=2.6p ps=10.52u w=10u l=1u
X536 a_52850_67013# a_48510_66969# a_52550_67013# VSS nfet_06v0 ad=1.65p pd=5.66u as=1.25p ps=5.5u w=5u l=1u
X537 VSS VDD VSS VSS nfet_06v0 ad=0.44p pd=2.88u as=0 ps=0 w=1u l=2u
X538 a_48550_70437# a_48850_70437# a_51786_70553# VDD pfet_06v0 ad=4.4p pd=20.88u as=2.5p ps=10.5u w=10u l=1u
X539 a_63566_41029# a_49242_40985# VSS VSS nfet_06v0 ad=1.25p pd=5.5u as=2.2p ps=10.88u w=5u l=1u
X540 a_31030_67083# a_33702_71483# VDD VDD pfet_06v0 ad=1.3p pd=5.52u as=1.3p ps=5.52u w=5u l=1u
X541 a_54654_53123# a_65974_49723# cap_mim_2f0_m4m5_noshield c_width=20u c_length=10u
X542 a_42462_70553# a_25366_70437# VDD VDD pfet_06v0 ad=2.5p pd=10.5u as=4.4p ps=20.88u w=10u l=1u
X543 a_50218_13628# a_50482_4826# VSS VSS nfet_06v0 ad=0.825p pd=3.16u as=1.1p ps=5.88u w=2.5u l=1u
X544 a_3186_41029# a_2986_40985# VSS VSS nfet_06v0 ad=1.25p pd=5.5u as=2.2p ps=10.88u w=5u l=1u
X545 VSS VDD VSS VSS nfet_06v0 ad=0.44p pd=2.88u as=0 ps=0 w=1u l=2u
X546 a_31790_12812# a_24954_4826# a_31998_4870# VSS nfet_06v0 ad=2.2p pd=10.88u as=1.25p ps=5.5u w=5u l=1u
X547 a_64202_70553# a_64002_70437# VDD VDD pfet_06v0 ad=2.5p pd=10.5u as=4.4p ps=20.88u w=10u l=1u
X548 a_31470_53123# a_33254_49723# VSS VSS nfet_06v0 ad=0.65p pd=3.02u as=0.65p ps=3.02u w=2.5u l=1u
X549 a_55326_49723# a_48850_53077# a_56886_54123# VDD pfet_06v0 ad=2.2p pd=10.88u as=1.3p ps=5.52u w=5u l=1u
X550 a_2594_44453# a_2594_44453# a_5250_41029# VSS nfet_06v0 ad=0.44p pd=2.88u as=0.25p ps=1.5u w=1u l=1u
X551 a_55770_61859# a_48510_58345# a_56438_58459# VSS nfet_06v0 ad=1.1p pd=5.88u as=0.65p ps=3.02u w=2.5u l=1u
X552 a_87154_23712# a_69382_23596# VDD VDD pfet_06v0 ad=2.5p pd=10.5u as=4.4p ps=20.88u w=10u l=1u
X553 a_55770_53123# a_56438_49723# VSS VSS nfet_06v0 ad=0.65p pd=3.02u as=0.65p ps=3.02u w=2.5u l=1u
X554 a_58158_16854# a_46942_16810# VSS VSS nfet_06v0 ad=1.25p pd=5.5u as=2.2p ps=10.88u w=5u l=1u
X555 a_25366_53077# a_25666_53077# a_28602_53193# VDD pfet_06v0 ad=4.4p pd=20.88u as=2.5p ps=10.5u w=10u l=1u
X556 a_64754_23712# a_46982_23596# VDD VDD pfet_06v0 ad=2.5p pd=10.5u as=4.4p ps=20.88u w=10u l=1u
X557 Y a_77242_51084# a_77154_51200# VSS nfet_06v0 ad=0.6448p pd=3u as=1.0912p ps=5.84u w=2.48u l=1u
X558 VSS a_56438_49723# a_54654_53123# VSS nfet_06v0 ad=0.65p pd=3.02u as=0.65p ps=3.02u w=2.5u l=1u
X559 a_6954_53193# a_8870_49607# a_9514_53123# VDD pfet_06v0 ad=4.4p pd=20.88u as=2.6p ps=10.52u w=10u l=1u
X560 a_57550_67083# a_48510_66969# a_54654_70483# VSS nfet_06v0 ad=0.65p pd=3.02u as=1.1p ps=5.88u w=2.5u l=1u
X561 a_54654_70483# a_30830_66967# a_53210_70553# VDD pfet_06v0 ad=2.6p pd=10.52u as=4.4p ps=20.88u w=10u l=1u
X562 a_26058_66969# a_25666_70437# a_26678_70553# VDD pfet_06v0 ad=4.4p pd=20.88u as=2.5p ps=10.5u w=10u l=1u
X563 VSS a_49242_66969# a_53182_67013# VSS nfet_06v0 ad=2.2p pd=10.88u as=1.25p ps=5.5u w=5u l=1u
X564 a_24854_28838# a_24654_28794# VSS VSS nfet_06v0 ad=1.25p pd=5.5u as=2.2p ps=10.88u w=5u l=1u
X565 VSS VDD VSS VSS nfet_06v0 ad=7.92p pd=36.88u as=0 ps=0 w=18u l=2u
X566 a_2254_16810# a_2594_23596# a_18142_23712# VDD pfet_06v0 ad=4.4p pd=20.88u as=2.5p ps=10.5u w=10u l=1u
X567 a_47282_11612# a_47282_11612# a_60222_4870# VSS nfet_06v0 ad=0.44p pd=2.88u as=0.25p ps=1.5u w=1u l=1u
X568 a_2294_70437# a_2594_70437# a_4218_67013# VSS nfet_06v0 ad=0.44p pd=2.88u as=0.25p ps=1.5u w=1u l=1u
X569 VDD VSS VDD VDD pfet_06v0 ad=7.92p pd=36.88u as=0 ps=0 w=18u l=2u
X570 VDD a_34818_45499# a_42790_41099# VDD pfet_06v0 ad=2.6p pd=10.52u as=2.6p ps=10.52u w=10u l=1u
X571 a_42790_49723# a_34366_49723# VSS VSS nfet_06v0 ad=1.3p pd=5.52u as=2.2p ps=10.88u w=5u l=1u
X572 a_72104_41140# a_72104_41140# VDD VDD pfet_06v0 ad=0.88p pd=4.88u as=0.88p ps=4.88u w=2u l=1u
X573 a_46982_23596# a_47282_23596# a_59190_16854# VSS nfet_06v0 ad=0.44p pd=2.88u as=0.25p ps=1.5u w=1u l=1u
X574 a_25326_40985# a_25666_44453# a_25566_44569# VDD pfet_06v0 ad=4.4p pd=20.88u as=2.5p ps=10.5u w=10u l=1u
X575 a_25326_49609# a_25326_49609# VSS VSS nfet_06v0 ad=0.44p pd=2.88u as=0.44p ps=2.88u w=1u l=1u
X576 a_3606_53193# a_2294_53077# VDD VDD pfet_06v0 ad=2.5p pd=10.5u as=4.4p ps=20.88u w=10u l=1u
X577 a_52550_58389# a_49242_58345# VSS VSS nfet_06v0 ad=1.25p pd=5.5u as=2.2p ps=10.88u w=5u l=1u
X578 a_15646_40985# a_15646_40985# a_18154_40985# VSS nfet_06v0 ad=2.2p pd=10.88u as=1.65p ps=5.66u w=5u l=1u
X579 VSS a_19718_58459# a_88406_58376# VSS nfet_06v0 ad=0.44p pd=2.88u as=0.25p ps=1.5u w=1u l=1u
X580 a_11294_41099# a_2254_40985# a_8398_44499# VSS nfet_06v0 ad=0.65p pd=3.02u as=1.1p ps=5.88u w=2.5u l=1u
X581 a_33254_49723# a_25326_49609# a_32586_53123# VSS nfet_06v0 ad=0.65p pd=3.02u as=1.1p ps=5.88u w=2.5u l=1u
X582 a_31998_28838# a_24654_28794# VSS VSS nfet_06v0 ad=1.25p pd=5.5u as=2.2p ps=10.88u w=5u l=1u
X583 a_18142_11728# a_2294_11612# VDD VDD pfet_06v0 ad=2.5p pd=10.5u as=4.4p ps=20.88u w=10u l=1u
X584 a_49862_53193# a_48550_53077# VDD VDD pfet_06v0 ad=2.5p pd=10.5u as=4.4p ps=20.88u w=10u l=1u
X585 a_30830_40983# a_25568_9332# VDD VDD pfet_06v0 ad=0.44p pd=2.88u as=0.44p ps=2.88u w=1u l=1u
X586 a_7758_40983# a_3168_9332# VDD VDD pfet_06v0 ad=0.44p pd=2.88u as=0.44p ps=2.88u w=1u l=1u
X587 a_48850_44453# a_48850_44453# a_51506_41029# VSS nfet_06v0 ad=0.44p pd=2.88u as=0.25p ps=1.5u w=1u l=1u
X588 a_26918_4870# a_28742_11728# VDD VDD pfet_06v0 ad=2.2p pd=10.88u as=2.2p ps=10.88u w=5u l=1u
X589 VSS VDD VSS VSS nfet_06v0 ad=4.29p pd=20.38u as=0 ps=0 w=9.75u l=2u
X590 a_2986_66969# a_2254_66969# a_3186_67013# VSS nfet_06v0 ad=2.2p pd=10.88u as=1.25p ps=5.5u w=5u l=1u
X591 a_6954_61929# a_2594_61813# a_6654_61929# VDD pfet_06v0 ad=3.3p pd=10.66u as=2.5p ps=10.5u w=10u l=1u
X592 VSS a_33254_67083# a_31470_70483# VSS nfet_06v0 ad=1.1p pd=5.88u as=0.65p ps=3.02u w=2.5u l=1u
X593 VSS VDD VSS VSS nfet_06v0 ad=4.29p pd=20.38u as=0 ps=0 w=9.75u l=2u
X594 a_31470_53123# a_42790_49723# cap_mim_2f0_m4m5_noshield c_width=20u c_length=10u
X595 a_49406_13618# a_50482_4826# VSS VSS nfet_06v0 ad=0.825p pd=3.16u as=1.1p ps=5.88u w=2.5u l=1u
X596 a_40542_35696# a_24694_35580# VDD VDD pfet_06v0 ad=2.5p pd=10.5u as=4.4p ps=20.88u w=10u l=1u
X597 a_75388_53540# Y VDD VDD pfet_05v0 ad=0.8052p pd=4.54u as=0.8052p ps=4.54u w=1.83u l=0.5u
X598 VSS a_87474_58332# a_79086_42348# VSS nfet_06v0 ad=0.44p pd=2.88u as=0.44p ps=2.88u w=1u l=1u
X599 a_18154_66969# a_2254_66969# a_18354_67013# VSS nfet_06v0 ad=1.65p pd=5.66u as=1.25p ps=5.5u w=5u l=1u
X600 a_72104_49876# a_72104_49876# VDD VDD pfet_06v0 ad=0.88p pd=4.88u as=0.88p ps=4.88u w=2u l=1u
X601 a_54654_70483# a_56438_67083# VSS VSS nfet_06v0 ad=0.65p pd=3.02u as=0.65p ps=3.02u w=2.5u l=1u
X602 a_54654_70483# a_65974_67083# cap_mim_2f0_m4m5_noshield c_width=20u c_length=10u
X603 VDD VSS VDD VDD pfet_06v0 ad=4.29p pd=20.38u as=0 ps=0 w=9.75u l=2u
X604 a_26258_41029# a_26058_40985# VSS VSS nfet_06v0 ad=1.25p pd=5.5u as=2.2p ps=10.88u w=5u l=1u
X605 a_64410_66969# a_48510_66969# a_64610_67013# VSS nfet_06v0 ad=1.65p pd=5.66u as=1.25p ps=5.5u w=5u l=1u
X606 a_52850_41029# a_7758_40983# a_55326_41099# VSS nfet_06v0 ad=2.2p pd=10.88u as=1.3p ps=5.52u w=5u l=1u
X607 a_48550_44453# a_48850_44453# a_50474_41029# VSS nfet_06v0 ad=0.44p pd=2.88u as=0.25p ps=1.5u w=1u l=1u
X608 a_7958_49723# a_10630_54123# VDD VDD pfet_06v0 ad=1.3p pd=5.52u as=1.3p ps=5.52u w=5u l=1u
X609 a_7758_66967# a_25568_33300# VDD VDD pfet_06v0 ad=0.44p pd=2.88u as=0.44p ps=2.88u w=1u l=1u
X610 VDD X X VDD pfet_06v0 ad=0.52p pd=2.52u as=0.52p ps=2.52u w=2u l=1u
X611 a_88406_49640# a_42790_49723# a_87474_49596# VSS nfet_06v0 ad=0.25p pd=1.5u as=0.44p ps=2.88u w=1u l=1u
X612 VDD a_33702_45499# a_32142_41099# VDD pfet_06v0 ad=2.2p pd=10.88u as=1.3p ps=5.52u w=5u l=1u
X613 VSS a_56438_41099# a_54654_44499# VSS nfet_06v0 ad=1.1p pd=5.88u as=0.65p ps=3.02u w=2.5u l=1u
X614 a_47482_35696# a_47282_35580# a_48294_35696# VDD pfet_06v0 ad=4.4p pd=20.88u as=2.5p ps=10.5u w=10u l=1u
X615 a_8870_58343# a_3168_33300# VDD VDD pfet_06v0 ad=0.44p pd=2.88u as=0.44p ps=2.88u w=1u l=1u
X616 VDD VSS VDD VDD pfet_06v0 ad=4.29p pd=20.38u as=0 ps=0 w=9.75u l=2u
X617 a_4218_58389# a_2594_61813# VSS VSS nfet_06v0 ad=0.25p pd=1.5u as=0.44p ps=2.88u w=1u l=1u
X618 VDD a_2294_61813# a_7286_61929# VDD pfet_06v0 ad=4.4p pd=20.88u as=2.5p ps=10.5u w=10u l=1u
X619 a_70694_11728# a_69382_11612# VDD VDD pfet_06v0 ad=2.5p pd=10.5u as=4.4p ps=20.88u w=10u l=1u
X620 a_40818_61813# a_25666_61813# a_41018_61929# VDD pfet_06v0 ad=3.3p pd=10.66u as=2.5p ps=10.5u w=10u l=1u
X621 a_31030_49723# a_12006_16854# a_29666_49653# VSS nfet_06v0 ad=1.3p pd=5.52u as=2.2p ps=10.88u w=5u l=1u
X622 VSS a_10182_67083# a_9514_70483# VSS nfet_06v0 ad=1.1p pd=5.88u as=0.65p ps=3.02u w=2.5u l=1u
X623 a_69342_16810# a_69642_16810# a_80558_16854# VSS nfet_06v0 ad=2.2p pd=10.88u as=1.25p ps=5.5u w=5u l=1u
X624 a_69642_28794# a_69642_28794# VSS VSS nfet_06v0 ad=0.44p pd=2.88u as=0.44p ps=2.88u w=1u l=1u
X625 a_77154_59824# a_72104_58500# VSS VSS nfet_06v0 ad=0.5456p pd=3.36u as=0.5456p ps=3.36u w=1.24u l=1u
X626 a_30830_40983# a_25568_9332# VDD VDD pfet_06v0 ad=0.44p pd=2.88u as=0.44p ps=2.88u w=1u l=1u
X627 a_47242_28794# a_47242_28794# VSS VSS nfet_06v0 ad=0.44p pd=2.88u as=0.44p ps=2.88u w=1u l=1u
X628 a_54654_61859# a_48510_58345# a_57550_58459# VSS nfet_06v0 ad=1.1p pd=5.88u as=0.65p ps=3.02u w=2.5u l=1u
X629 a_53210_61929# a_30830_58343# a_54654_61859# VDD pfet_06v0 ad=4.4p pd=20.88u as=2.6p ps=10.52u w=10u l=1u
X630 a_7758_40983# a_3168_9332# VDD VDD pfet_06v0 ad=0.44p pd=2.88u as=0.44p ps=2.88u w=1u l=1u
X631 a_9390_12812# a_2554_4826# a_9598_4870# VSS nfet_06v0 ad=2.2p pd=10.88u as=1.25p ps=5.5u w=5u l=1u
X632 a_48550_44453# a_48850_44453# a_51786_44569# VDD pfet_06v0 ad=4.4p pd=20.88u as=2.5p ps=10.5u w=10u l=1u
X633 YP YN VDD VDD pfet_05v0 ad=0.8052p pd=4.54u as=0.8052p ps=4.54u w=1.83u l=0.5u
X634 a_46982_35580# a_47282_35580# a_64754_35696# VDD pfet_06v0 ad=4.4p pd=20.88u as=2.5p ps=10.5u w=10u l=1u
X635 a_86922_51052# a_65974_49723# a_73254_59708# VDD pfet_06v0 ad=0.75p pd=3.5u as=1.32p ps=6.88u w=3u l=1u
X636 a_31030_41099# a_33702_45499# VDD VDD pfet_06v0 ad=1.3p pd=5.52u as=1.3p ps=5.52u w=5u l=1u
X637 a_7958_41099# a_7758_40983# a_6594_41029# VSS nfet_06v0 ad=1.3p pd=5.52u as=2.2p ps=10.88u w=5u l=1u
X638 a_42462_44569# a_25366_44453# VDD VDD pfet_06v0 ad=2.5p pd=10.5u as=4.4p ps=20.88u w=10u l=1u
X639 a_55770_70483# a_56438_67083# VSS VSS nfet_06v0 ad=0.65p pd=3.02u as=1.1p ps=5.88u w=2.5u l=1u
X640 a_64202_44569# a_64002_44453# VDD VDD pfet_06v0 ad=2.5p pd=10.5u as=4.4p ps=20.88u w=10u l=1u
X641 a_18354_58389# a_18154_58345# VSS VSS nfet_06v0 ad=1.25p pd=5.5u as=2.2p ps=10.88u w=5u l=1u
X642 a_69682_35580# a_69682_35580# VDD VDD pfet_06v0 ad=0.88p pd=4.88u as=0.88p ps=4.88u w=2u l=1u
X643 a_10630_54123# a_15646_49609# a_10182_49723# VSS nfet_06v0 ad=1.1p pd=5.88u as=1.1p ps=5.88u w=2.5u l=1u
X644 a_19718_58459# a_11294_58459# VSS VSS nfet_06v0 ad=1.3p pd=5.52u as=2.2p ps=10.88u w=5u l=1u
X645 a_25666_53077# a_25666_53077# a_28322_49653# VSS nfet_06v0 ad=0.44p pd=2.88u as=0.25p ps=1.5u w=1u l=1u
X646 VDD VSS VDD VDD pfet_06v0 ad=0.44p pd=2.88u as=0 ps=0 w=1u l=2u
X647 a_64610_58389# a_64410_58345# VSS VSS nfet_06v0 ad=1.25p pd=5.5u as=2.2p ps=10.88u w=5u l=1u
X648 a_56886_54123# a_61902_49609# a_56438_49723# VSS nfet_06v0 ad=1.1p pd=5.88u as=1.1p ps=5.88u w=2.5u l=1u
X649 a_47182_23712# a_46982_23596# VDD VDD pfet_06v0 ad=2.5p pd=10.5u as=4.4p ps=20.88u w=10u l=1u
X650 a_7958_67083# a_2594_70437# a_11746_71483# VDD pfet_06v0 ad=2.2p pd=10.88u as=1.3p ps=5.52u w=5u l=1u
X651 a_32142_49723# a_33702_54123# VDD VDD pfet_06v0 ad=1.3p pd=5.52u as=2.2p ps=10.88u w=5u l=1u
X652 a_25568_21316# a_40986_21316# VSS ppolyf_u_1k r_width=1u r_length=76.45u
X653 a_6954_53193# a_2594_53077# a_6654_53193# VDD pfet_06v0 ad=3.3p pd=10.66u as=2.5p ps=10.5u w=10u l=1u
X654 a_24654_4826# a_24994_11612# a_40542_11728# VDD pfet_06v0 ad=4.4p pd=20.88u as=2.5p ps=10.5u w=10u l=1u
X655 a_7758_66967# a_25568_33300# VDD VDD pfet_06v0 ad=0.44p pd=2.88u as=0.44p ps=2.88u w=1u l=1u
X656 a_28742_35696# a_30334_28794# a_28194_28794# VSS nfet_06v0 ad=0.88p pd=4.88u as=0.88p ps=4.88u w=2u l=1u
X657 a_54654_44499# a_30830_40983# a_53210_44569# VDD pfet_06v0 ad=2.6p pd=10.52u as=4.4p ps=20.88u w=10u l=1u
X658 a_28194_16810# a_24954_16810# a_27930_25612# VSS nfet_06v0 ad=1.1p pd=5.88u as=0.825p ps=3.16u w=2.5u l=1u
X659 Z Z VDD VDD pfet_06v0 ad=0.52p pd=2.52u as=0.52p ps=2.52u w=2u l=1u
X660 a_31470_70483# a_42790_67083# cap_mim_2f0_m4m5_noshield c_width=20u c_length=10u
X661 a_8870_58343# a_3168_33300# VDD VDD pfet_06v0 ad=0.44p pd=2.88u as=0.44p ps=2.88u w=1u l=1u
X662 a_26058_40985# a_25666_44453# a_26678_44569# VDD pfet_06v0 ad=4.4p pd=20.88u as=2.5p ps=10.5u w=10u l=1u
X663 a_3606_35696# a_2294_35580# VDD VDD pfet_06v0 ad=2.5p pd=10.5u as=4.4p ps=20.88u w=10u l=1u
X664 a_34366_49723# a_25326_49609# a_31470_53123# VSS nfet_06v0 ad=0.65p pd=3.02u as=1.1p ps=5.88u w=2.5u l=1u
X665 Y Y VDD VDD pfet_06v0 ad=0.52p pd=2.52u as=0.88p ps=4.88u w=2u l=1u
X666 a_25366_53077# a_25666_53077# a_27290_49653# VSS nfet_06v0 ad=0.44p pd=2.88u as=0.25p ps=1.5u w=1u l=1u
X667 a_47442_4870# a_47242_4826# a_47142_4870# VSS nfet_06v0 ad=2.2p pd=10.88u as=1.25p ps=5.5u w=5u l=1u
X668 a_30334_4826# a_24994_11612# a_35070_11728# VDD pfet_06v0 ad=4.4p pd=20.88u as=2.5p ps=10.5u w=10u l=1u
X669 a_9514_53123# a_10182_49723# VSS VSS nfet_06v0 ad=0.65p pd=3.02u as=1.1p ps=5.88u w=2.5u l=1u
X670 VSS a_2986_49609# a_6926_49653# VSS nfet_06v0 ad=2.2p pd=10.88u as=1.25p ps=5.5u w=5u l=1u
X671 a_52910_61929# a_48550_61813# VDD VDD pfet_06v0 ad=2.5p pd=10.5u as=4.4p ps=20.88u w=10u l=1u
X672 a_31470_61859# a_30830_58343# a_30026_61929# VDD pfet_06v0 ad=2.6p pd=10.52u as=4.4p ps=20.88u w=10u l=1u
X673 a_61902_58345# a_61902_58345# a_64410_58345# VSS nfet_06v0 ad=2.2p pd=10.88u as=1.65p ps=5.66u w=5u l=1u
X674 a_11746_45499# a_15646_40985# a_11294_41099# VSS nfet_06v0 ad=1.1p pd=5.88u as=1.1p ps=5.88u w=2.5u l=1u
X675 a_27118_25602# a_8870_49607# cap_mim_2f0_m4m5_noshield c_width=25u c_length=8u
X676 a_9070_67083# a_10630_71483# VDD VDD pfet_06v0 ad=1.3p pd=5.52u as=1.3p ps=5.52u w=5u l=1u
X677 a_42466_23712# a_24694_23596# VDD VDD pfet_06v0 ad=2.5p pd=10.5u as=4.4p ps=20.88u w=10u l=1u
X678 VDD a_2294_53077# a_7286_53193# VDD pfet_06v0 ad=4.4p pd=20.88u as=2.5p ps=10.5u w=10u l=1u
X679 a_19718_49723# a_7958_49723# cap_mim_2f0_m4m5_noshield c_width=20u c_length=10u
X680 a_58002_45499# a_61902_40985# a_57550_41099# VSS nfet_06v0 ad=1.1p pd=5.88u as=1.1p ps=5.88u w=2.5u l=1u
X681 a_7758_58343# a_47856_21316# VDD VDD pfet_06v0 ad=0.44p pd=2.88u as=0.44p ps=2.88u w=1u l=1u
X682 a_24994_23596# a_24994_23596# a_37934_16854# VSS nfet_06v0 ad=0.44p pd=2.88u as=0.25p ps=1.5u w=1u l=1u
X683 a_54214_49723# a_48850_53077# a_58002_54123# VDD pfet_06v0 ad=2.2p pd=10.88u as=1.3p ps=5.52u w=5u l=1u
X684 a_40818_53077# a_25666_53077# a_41018_53193# VDD pfet_06v0 ad=3.3p pd=10.66u as=2.5p ps=10.5u w=10u l=1u
X685 VDD VSS VDD VDD pfet_06v0 ad=0.44p pd=2.88u as=0 ps=0 w=1u l=2u
X686 a_78314_11728# a_78114_11612# VDD VDD pfet_06v0 ad=2.5p pd=10.5u as=4.4p ps=20.88u w=10u l=1u
X687 a_47856_9782# a_63274_9332# VSS ppolyf_u_1k r_width=1u r_length=76.45u
X688 VSS a_11294_49723# a_19718_49723# VSS nfet_06v0 ad=1.3p pd=5.52u as=1.3p ps=5.52u w=5u l=1u
X689 a_75010_59824# Z a_76410_59754# VSS nfet_06v0 ad=0.88p pd=4.88u as=0.5p ps=2.5u w=2u l=1u
X690 a_20066_35696# a_2294_35580# VDD VDD pfet_06v0 ad=2.5p pd=10.5u as=4.4p ps=20.88u w=10u l=1u
X691 a_55770_44499# a_48510_40985# a_56438_41099# VSS nfet_06v0 ad=1.1p pd=5.88u as=0.65p ps=3.02u w=2.5u l=1u
X692 a_30830_58343# a_71606_16854# cap_mim_2f0_m4m5_noshield c_width=25u c_length=8u
X693 a_77730_4870# a_77530_4826# VSS VSS nfet_06v0 ad=1.25p pd=5.5u as=2.2p ps=10.88u w=5u l=1u
X694 a_56438_67083# a_62366_71437# a_56886_71483# VDD pfet_06v0 ad=2.2p pd=10.88u as=2.2p ps=10.88u w=5u l=1u
X695 a_69642_4826# a_69682_11612# a_84118_11728# VDD pfet_06v0 ad=4.4p pd=20.88u as=2.5p ps=10.5u w=10u l=1u
X696 a_58158_28838# a_46942_28794# VSS VSS nfet_06v0 ad=1.25p pd=5.5u as=2.2p ps=10.88u w=5u l=1u
X697 a_87474_40972# a_19718_41099# VDD VDD pfet_06v0 ad=0.99p pd=3.66u as=1.32p ps=6.88u w=3u l=1u
X698 a_17310_41029# a_2986_40985# VSS VSS nfet_06v0 ad=1.25p pd=5.5u as=2.2p ps=10.88u w=5u l=1u
X699 a_11746_54123# a_2594_53077# a_7958_49723# VDD pfet_06v0 ad=1.3p pd=5.52u as=2.2p ps=10.88u w=5u l=1u
X700 a_6294_41029# a_2986_40985# VSS VSS nfet_06v0 ad=1.25p pd=5.5u as=2.2p ps=10.88u w=5u l=1u
X701 a_53542_61929# a_48850_61813# a_53210_61929# VDD pfet_06v0 ad=2.5p pd=10.5u as=3.3p ps=10.66u w=10u l=1u
X702 a_65974_58459# a_58002_62859# VDD VDD pfet_06v0 ad=4.4p pd=20.88u as=2.6p ps=10.52u w=10u l=1u
X703 a_9390_36780# a_9390_36780# a_11026_35580# VDD pfet_06v0 ad=4.4p pd=20.88u as=3.3p ps=10.66u w=10u l=1u
X704 VDD Z Z VDD pfet_06v0 ad=0.52p pd=2.52u as=0.52p ps=2.52u w=2u l=1u
X705 VSS a_33254_49723# a_32586_53123# VSS nfet_06v0 ad=1.1p pd=5.88u as=0.65p ps=3.02u w=2.5u l=1u
X706 a_33042_4870# a_32842_4826# VSS VSS nfet_06v0 ad=1.25p pd=5.5u as=2.2p ps=10.88u w=5u l=1u
X707 a_32142_49723# a_8870_49607# a_29666_49653# VSS nfet_06v0 ad=1.3p pd=5.52u as=2.2p ps=10.88u w=5u l=1u
X708 a_2794_23712# a_2594_23596# a_2494_23712# VDD pfet_06v0 ad=4.4p pd=20.88u as=2.5p ps=10.5u w=10u l=1u
X709 a_2494_70553# a_2294_70437# VDD VDD pfet_06v0 ad=2.5p pd=10.5u as=4.4p ps=20.88u w=10u l=1u
X710 VDD a_33702_62859# a_31030_58459# VDD pfet_06v0 ad=1.3p pd=5.52u as=1.3p ps=5.52u w=5u l=1u
X711 VSS VDD VSS VSS nfet_06v0 ad=7.92p pd=36.88u as=0 ps=0 w=18u l=2u
X712 a_31470_70483# a_25326_66969# a_34366_67083# VSS nfet_06v0 ad=1.1p pd=5.88u as=0.65p ps=3.02u w=2.5u l=1u
X713 VSS a_10182_49723# a_8398_53123# VSS nfet_06v0 ad=0.65p pd=3.02u as=0.65p ps=3.02u w=2.5u l=1u
X714 a_30026_70553# a_30830_66967# a_31470_70483# VDD pfet_06v0 ad=4.4p pd=20.88u as=2.6p ps=10.52u w=10u l=1u
X715 VSS a_56438_58459# a_55770_61859# VSS nfet_06v0 ad=0.65p pd=3.02u as=0.65p ps=3.02u w=2.5u l=1u
X716 VSS VDD VSS VSS nfet_06v0 ad=4.29p pd=20.38u as=0 ps=0 w=9.75u l=2u
X717 VSS VDD VSS VSS nfet_06v0 ad=7.92p pd=36.88u as=0 ps=0 w=18u l=2u
X718 a_5530_25612# S2N a_2794_23712# VDD pfet_06v0 ad=0.22p pd=1.88u as=0.22p ps=1.88u w=0.5u l=1u
X719 a_5530_61929# a_2294_61813# VDD VDD pfet_06v0 ad=2.5p pd=10.5u as=4.4p ps=20.88u w=10u l=1u
X720 VSS a_10182_67083# a_9514_70483# VSS nfet_06v0 ad=0.65p pd=3.02u as=0.65p ps=3.02u w=2.5u l=1u
X721 a_75154_66956# a_19718_67083# VDD VDD pfet_06v0 ad=0.99p pd=3.66u as=1.32p ps=6.88u w=3u l=1u
X722 a_2794_11728# a_2594_11612# a_3606_11728# VDD pfet_06v0 ad=4.4p pd=20.88u as=2.5p ps=10.5u w=10u l=1u
X723 a_46982_35580# a_47282_35580# a_59190_28838# VSS nfet_06v0 ad=0.44p pd=2.88u as=0.25p ps=1.5u w=1u l=1u
X724 a_73254_42348# a_87474_49596# VDD VDD pfet_06v0 ad=1.32p pd=6.88u as=1.32p ps=6.88u w=3u l=1u
X725 a_52090_16854# a_54078_24796# a_47856_21316# VDD pfet_06v0 ad=1.76p pd=8.88u as=1.76p ps=8.88u w=4u l=1u
X726 a_27118_25602# S4P a_25194_23712# VDD pfet_06v0 ad=0.242p pd=1.98u as=0.242p ps=1.98u w=0.55u l=1u
X727 VDD Y Y VDD pfet_06v0 ad=0.88p pd=4.88u as=0.52p ps=2.52u w=2u l=1u
X728 a_25886_4870# a_24654_4826# VSS VSS nfet_06v0 ad=1.25p pd=5.5u as=2.2p ps=10.88u w=5u l=1u
X729 a_52910_53193# a_48550_53077# VDD VDD pfet_06v0 ad=2.5p pd=10.5u as=4.4p ps=20.88u w=10u l=1u
X730 a_70256_9782# a_85674_9332# VSS ppolyf_u_1k r_width=1u r_length=76.45u
X731 VDD a_25366_70437# a_30358_70553# VDD pfet_06v0 ad=4.4p pd=20.88u as=2.5p ps=10.5u w=10u l=1u
X732 a_34818_54123# a_38718_49609# a_34366_49723# VSS nfet_06v0 ad=1.1p pd=5.88u as=1.1p ps=5.88u w=2.5u l=1u
X733 a_8870_40983# a_49206_4870# cap_mim_2f0_m4m5_noshield c_width=25u c_length=8u
X734 VSS a_42790_58459# a_79086_59708# VSS nfet_06v0 ad=0.44p pd=2.88u as=0.33p ps=1.66u w=1u l=1u
X735 a_11294_58459# a_16110_62813# a_11746_62859# VDD pfet_06v0 ad=2.2p pd=10.88u as=2.2p ps=10.88u w=5u l=1u
X736 a_19718_67083# a_7958_67083# cap_mim_2f0_m4m5_noshield c_width=20u c_length=10u
X737 a_32586_53123# a_33254_49723# VSS VSS nfet_06v0 ad=0.65p pd=3.02u as=1.1p ps=5.88u w=2.5u l=1u
X738 a_17946_70553# a_17746_70437# VDD VDD pfet_06v0 ad=2.5p pd=10.5u as=4.4p ps=20.88u w=10u l=1u
X739 a_25326_40985# a_25326_40985# VSS VSS nfet_06v0 ad=0.44p pd=2.88u as=0.44p ps=2.88u w=1u l=1u
X740 a_41426_67013# a_41226_66969# VSS VSS nfet_06v0 ad=1.25p pd=5.5u as=2.2p ps=10.88u w=5u l=1u
X741 a_7958_41099# a_2594_44453# a_11746_45499# VDD pfet_06v0 ad=2.2p pd=10.88u as=1.3p ps=5.52u w=5u l=1u
X742 a_13470_4870# a_2254_4826# VSS VSS nfet_06v0 ad=1.25p pd=5.5u as=2.2p ps=10.88u w=5u l=1u
X743 VDD a_10630_62859# a_9070_58459# VDD pfet_06v0 ad=2.2p pd=10.88u as=1.3p ps=5.52u w=5u l=1u
X744 a_48850_70437# a_48850_70437# VDD VDD pfet_06v0 ad=0.88p pd=4.88u as=0.88p ps=4.88u w=2u l=1u
X745 a_8870_49607# a_29802_16854# VSS VSS nfet_06v0 ad=0.44p pd=2.88u as=0.44p ps=2.88u w=1u l=1u
X746 a_5250_4870# S2N a_2754_4870# VSS nfet_06v0 ad=3.74p pd=17.88u as=3.74p ps=17.88u w=8.5u l=1u
X747 a_55770_61859# a_7758_58343# a_53210_61929# VDD pfet_06v0 ad=2.6p pd=10.52u as=4.4p ps=20.88u w=10u l=1u
X748 a_2594_11612# a_2594_11612# VDD VDD pfet_06v0 ad=0.88p pd=4.88u as=0.88p ps=4.88u w=2u l=1u
X749 a_53542_53193# a_48850_53077# a_53210_53193# VDD pfet_06v0 ad=2.5p pd=10.5u as=3.3p ps=10.66u w=10u l=1u
X750 a_46942_4826# a_47242_4826# a_58158_4870# VSS nfet_06v0 ad=2.2p pd=10.88u as=1.25p ps=5.5u w=5u l=1u
X751 a_49242_58345# a_48510_58345# a_49442_58389# VSS nfet_06v0 ad=2.2p pd=10.88u as=1.25p ps=5.5u w=5u l=1u
X752 a_24694_35580# a_24994_35580# a_42466_35696# VDD pfet_06v0 ad=4.4p pd=20.88u as=2.5p ps=10.5u w=10u l=1u
X753 VDD VSS VDD VDD pfet_06v0 ad=4.29p pd=20.38u as=0 ps=0 w=9.75u l=2u
X754 a_29666_58389# a_25326_58345# a_29366_58389# VSS nfet_06v0 ad=1.65p pd=5.66u as=1.25p ps=5.5u w=5u l=1u
X755 a_2294_35580# a_2594_35580# a_20066_35696# VDD pfet_06v0 ad=4.4p pd=20.88u as=2.5p ps=10.5u w=10u l=1u
X756 a_69342_28794# a_69642_28794# a_80558_28838# VSS nfet_06v0 ad=2.2p pd=10.88u as=1.25p ps=5.5u w=5u l=1u
X757 a_83814_58376# a_19718_58459# VDD VDD pfet_06v0 ad=1.32p pd=6.88u as=1.32p ps=6.88u w=3u l=1u
X758 a_54214_67083# a_30830_66967# a_52850_67013# VSS nfet_06v0 ad=1.3p pd=5.52u as=2.2p ps=10.88u w=5u l=1u
X759 a_77154_42464# a_72104_41140# VSS VSS nfet_06v0 ad=0.5456p pd=3.36u as=0.5456p ps=3.36u w=1.24u l=1u
X760 a_16110_71437# a_16110_71437# a_17746_70437# VDD pfet_06v0 ad=4.4p pd=20.88u as=3.3p ps=10.66u w=10u l=1u
X761 a_47442_16854# a_47242_16810# a_48174_16854# VSS nfet_06v0 ad=2.2p pd=10.88u as=1.25p ps=5.5u w=5u l=1u
X762 a_54654_44499# a_48510_40985# a_57550_41099# VSS nfet_06v0 ad=1.1p pd=5.88u as=0.65p ps=3.02u w=2.5u l=1u
X763 a_2254_58345# a_2254_58345# VSS VSS nfet_06v0 ad=0.44p pd=2.88u as=0.44p ps=2.88u w=1u l=1u
X764 a_25194_23712# a_24994_23596# a_26006_23712# VDD pfet_06v0 ad=4.4p pd=20.88u as=2.5p ps=10.5u w=10u l=1u
X765 a_51030_11728# a_52622_4826# a_50482_4826# VSS nfet_06v0 ad=0.88p pd=4.88u as=0.88p ps=4.88u w=2u l=1u
X766 a_9070_41099# a_10630_45499# VDD VDD pfet_06v0 ad=1.3p pd=5.52u as=1.3p ps=5.52u w=5u l=1u
X767 a_62366_71437# a_62366_71437# a_64002_70437# VDD pfet_06v0 ad=4.4p pd=20.88u as=3.3p ps=10.66u w=10u l=1u
X768 a_70256_9332# a_69682_11612# a_71606_4870# VDD pfet_06v0 ad=4.4p pd=20.88u as=4.4p ps=20.88u w=10u l=1u
X769 a_24894_23712# a_24694_23596# VDD VDD pfet_06v0 ad=2.5p pd=10.5u as=4.4p ps=20.88u w=10u l=1u
X770 a_74368_58616# a_72104_58500# a_74068_58616# VSS nfet_06v0 ad=0.175p pd=1.2u as=0.175p ps=1.2u w=0.7u l=1u
X771 a_5530_53193# a_2294_53077# VDD VDD pfet_06v0 ad=2.5p pd=10.5u as=4.4p ps=20.88u w=10u l=1u
X772 a_88406_41016# a_42790_41099# a_87474_40972# VSS nfet_06v0 ad=0.25p pd=1.5u as=0.44p ps=2.88u w=1u l=1u
X773 a_54214_58459# a_56886_62859# VDD VDD pfet_06v0 ad=1.3p pd=5.52u as=1.3p ps=5.52u w=5u l=1u
X774 a_29802_4870# a_31790_12812# a_25568_9332# VDD pfet_06v0 ad=1.76p pd=8.88u as=1.76p ps=8.88u w=4u l=1u
X775 a_2594_11612# a_2594_11612# a_15534_4870# VSS nfet_06v0 ad=0.44p pd=2.88u as=0.25p ps=1.5u w=1u l=1u
X776 a_19718_41099# a_11294_41099# VSS VSS nfet_06v0 ad=1.3p pd=5.52u as=2.2p ps=10.88u w=5u l=1u
X777 a_7402_4870# a_9390_12812# a_3168_9332# VDD pfet_06v0 ad=1.76p pd=8.88u as=1.76p ps=8.88u w=4u l=1u
X778 a_26006_11728# a_24694_11612# VDD VDD pfet_06v0 ad=2.5p pd=10.5u as=4.4p ps=20.88u w=10u l=1u
X779 a_9514_61859# a_10182_58459# VSS VSS nfet_06v0 ad=0.65p pd=3.02u as=0.65p ps=3.02u w=2.5u l=1u
X780 a_56438_41099# a_62366_45453# a_56886_45499# VDD pfet_06v0 ad=2.2p pd=10.88u as=2.2p ps=10.88u w=5u l=1u
X781 a_53210_70553# a_7758_66967# a_55770_70483# VDD pfet_06v0 ad=4.4p pd=20.88u as=2.6p ps=10.52u w=10u l=1u
X782 a_49442_49653# a_49242_49609# VSS VSS nfet_06v0 ad=1.25p pd=5.5u as=2.2p ps=10.88u w=5u l=1u
X783 VSS a_33254_67083# a_32586_70483# VSS nfet_06v0 ad=0.65p pd=3.02u as=0.65p ps=3.02u w=2.5u l=1u
X784 VSS a_57550_58459# a_65974_58459# VSS nfet_06v0 ad=1.3p pd=5.52u as=1.3p ps=5.52u w=5u l=1u
X785 a_29366_49653# a_26058_49609# VSS VSS nfet_06v0 ad=1.25p pd=5.5u as=2.2p ps=10.88u w=5u l=1u
X786 a_62366_71437# a_48510_66969# a_63566_67013# VSS nfet_06v0 ad=2.2p pd=10.88u as=1.25p ps=5.5u w=5u l=1u
X787 a_6594_58389# a_7758_58343# a_7958_58459# VSS nfet_06v0 ad=2.2p pd=10.88u as=1.3p ps=5.52u w=5u l=1u
X788 a_28194_28794# a_24954_28794# a_27930_37596# VSS nfet_06v0 ad=1.1p pd=5.88u as=0.825p ps=3.16u w=2.5u l=1u
X789 a_11294_49723# a_16110_54077# a_11746_54123# VDD pfet_06v0 ad=2.2p pd=10.88u as=2.2p ps=10.88u w=5u l=1u
X790 a_2494_44569# a_2294_44453# VDD VDD pfet_06v0 ad=2.5p pd=10.5u as=4.4p ps=20.88u w=10u l=1u
X791 a_5794_4826# a_2554_4826# a_5530_13628# VSS nfet_06v0 ad=1.1p pd=5.88u as=0.825p ps=3.16u w=2.5u l=1u
X792 a_77154_59824# a_77242_59708# Z VSS nfet_06v0 ad=1.0912p pd=5.84u as=0.6448p ps=3u w=2.48u l=1u
X793 a_69882_23712# a_69682_23596# a_70694_23712# VDD pfet_06v0 ad=4.4p pd=20.88u as=2.5p ps=10.5u w=10u l=1u
X794 a_32142_49723# a_25666_53077# a_33702_54123# VDD pfet_06v0 ad=2.2p pd=10.88u as=1.3p ps=5.52u w=5u l=1u
X795 VDD VSS VDD VDD pfet_06v0 ad=7.92p pd=36.88u as=0 ps=0 w=18u l=2u
X796 a_30026_44569# a_30830_40983# a_31470_44499# VDD pfet_06v0 ad=4.4p pd=20.88u as=2.6p ps=10.52u w=10u l=1u
X797 a_53182_58389# a_48510_58345# a_52850_58389# VSS nfet_06v0 ad=1.25p pd=5.5u as=1.65p ps=5.66u w=5u l=1u
X798 VSS VDD VSS VSS nfet_06v0 ad=4.29p pd=20.38u as=0 ps=0 w=9.75u l=2u
X799 a_34366_58459# a_39182_62813# a_34818_62859# VDD pfet_06v0 ad=2.2p pd=10.88u as=2.2p ps=10.88u w=5u l=1u
X800 a_2754_4870# a_2554_4826# a_2454_4870# VSS nfet_06v0 ad=2.2p pd=10.88u as=1.25p ps=5.5u w=5u l=1u
X801 a_52090_4870# a_47242_4826# a_49406_13618# VSS nfet_06v0 ad=1.1p pd=5.88u as=0.825p ps=3.16u w=2.5u l=1u
X802 a_10630_45499# a_15646_40985# a_10182_41099# VSS nfet_06v0 ad=1.1p pd=5.88u as=1.1p ps=5.88u w=2.5u l=1u
X803 VDD a_10630_71483# a_7958_67083# VDD pfet_06v0 ad=2.2p pd=10.88u as=1.3p ps=5.52u w=5u l=1u
X804 a_24954_16810# a_24954_16810# VSS VSS nfet_06v0 ad=0.44p pd=2.88u as=0.44p ps=2.88u w=1u l=1u
X805 a_25666_44453# a_25666_44453# a_28322_41029# VSS nfet_06v0 ad=0.44p pd=2.88u as=0.25p ps=1.5u w=1u l=1u
X806 a_85230_11728# a_69382_11612# VDD VDD pfet_06v0 ad=2.5p pd=10.5u as=4.4p ps=20.88u w=10u l=1u
X807 a_35070_35696# a_24694_35580# VDD VDD pfet_06v0 ad=2.5p pd=10.5u as=4.4p ps=20.88u w=10u l=1u
X808 a_2554_16810# a_2554_16810# VSS VSS nfet_06v0 ad=0.44p pd=2.88u as=0.44p ps=2.88u w=1u l=1u
X809 a_56886_45499# a_61902_40985# a_56438_41099# VSS nfet_06v0 ad=1.1p pd=5.88u as=1.1p ps=5.88u w=2.5u l=1u
X810 VSS a_10182_49723# a_8398_53123# VSS nfet_06v0 ad=1.1p pd=5.88u as=0.65p ps=3.02u w=2.5u l=1u
X811 VDD a_56886_71483# a_54214_67083# VDD pfet_06v0 ad=2.2p pd=10.88u as=1.3p ps=5.52u w=5u l=1u
X812 a_12670_35696# a_2294_35580# VDD VDD pfet_06v0 ad=2.5p pd=10.5u as=4.4p ps=20.88u w=10u l=1u
X813 a_24994_35580# a_24994_35580# a_37934_28838# VSS nfet_06v0 ad=0.44p pd=2.88u as=0.25p ps=1.5u w=1u l=1u
X814 a_29802_4870# a_24954_4826# a_27118_13618# VSS nfet_06v0 ad=1.1p pd=5.88u as=0.825p ps=3.16u w=2.5u l=1u
X815 a_75010_42464# X a_76410_42394# VSS nfet_06v0 ad=0.88p pd=4.88u as=0.5p ps=2.5u w=2u l=1u
X816 a_70256_9332# a_75022_4826# a_74490_4870# VSS nfet_06v0 ad=0.88p pd=4.88u as=0.88p ps=4.88u w=2u l=1u
X817 VDD a_58002_71483# a_65974_67083# VDD pfet_06v0 ad=2.6p pd=10.52u as=2.6p ps=10.52u w=10u l=1u
X818 a_6954_53193# a_7758_49607# a_8398_53123# VDD pfet_06v0 ad=4.4p pd=20.88u as=2.6p ps=10.52u w=10u l=1u
X819 a_34818_71483# a_25666_70437# a_31030_67083# VDD pfet_06v0 ad=1.3p pd=5.52u as=2.2p ps=10.88u w=5u l=1u
X820 VDD a_25366_44453# a_30358_44569# VDD pfet_06v0 ad=4.4p pd=20.88u as=2.5p ps=10.5u w=10u l=1u
X821 a_65974_49723# a_57550_49723# VSS VSS nfet_06v0 ad=2.2p pd=10.88u as=1.3p ps=5.52u w=5u l=1u
X822 a_48510_66969# a_48850_70437# a_48750_70553# VDD pfet_06v0 ad=4.4p pd=20.88u as=2.5p ps=10.5u w=10u l=1u
X823 a_25366_44453# a_25666_44453# a_27290_41029# VSS nfet_06v0 ad=0.44p pd=2.88u as=0.25p ps=1.5u w=1u l=1u
X824 a_63566_58389# a_49242_58345# VSS VSS nfet_06v0 ad=1.25p pd=5.5u as=2.2p ps=10.88u w=5u l=1u
X825 a_3186_58389# a_2986_58345# VSS VSS nfet_06v0 ad=1.25p pd=5.5u as=2.2p ps=10.88u w=5u l=1u
X826 a_36902_4870# a_24994_11612# VSS VSS nfet_06v0 ad=0.25p pd=1.5u as=0.44p ps=2.88u w=1u l=1u
X827 a_52850_58389# a_30830_58343# a_54214_58459# VSS nfet_06v0 ad=2.2p pd=10.88u as=1.3p ps=5.52u w=5u l=1u
X828 a_2454_16854# a_2254_16810# VSS VSS nfet_06v0 ad=1.25p pd=5.5u as=2.2p ps=10.88u w=5u l=1u
X829 a_17946_44569# a_17746_44453# VDD VDD pfet_06v0 ad=2.5p pd=10.5u as=4.4p ps=20.88u w=10u l=1u
X830 VSS a_2986_40985# a_6926_41029# VSS nfet_06v0 ad=2.2p pd=10.88u as=1.25p ps=5.5u w=5u l=1u
X831 VSS VDD VSS VSS nfet_06v0 ad=0.44p pd=2.88u as=0 ps=0 w=1u l=2u
X832 a_2594_61813# a_2594_61813# a_5250_58389# VSS nfet_06v0 ad=0.44p pd=2.88u as=0.25p ps=1.5u w=1u l=1u
X833 a_84118_35696# a_69382_35580# VDD VDD pfet_06v0 ad=2.5p pd=10.5u as=4.4p ps=20.88u w=10u l=1u
X834 a_61718_35696# a_46982_35580# VDD VDD pfet_06v0 ad=2.5p pd=10.5u as=4.4p ps=20.88u w=10u l=1u
X835 a_48850_44453# a_48850_44453# VDD VDD pfet_06v0 ad=0.88p pd=4.88u as=0.88p ps=4.88u w=2u l=1u
X836 a_10182_67083# a_16110_71437# a_10630_71483# VDD pfet_06v0 ad=2.2p pd=10.88u as=2.2p ps=10.88u w=5u l=1u
X837 a_55326_67083# a_7758_66967# a_52850_67013# VSS nfet_06v0 ad=1.3p pd=5.52u as=2.2p ps=10.88u w=5u l=1u
X838 a_47282_35580# a_47282_35580# VDD VDD pfet_06v0 ad=0.88p pd=4.88u as=0.88p ps=4.88u w=2u l=1u
X839 a_71806_13618# a_7758_49607# cap_mim_2f0_m4m5_noshield c_width=25u c_length=8u
X840 VDD VSS VDD VDD pfet_06v0 ad=0.44p pd=2.88u as=0 ps=0 w=1u l=2u
X841 a_28194_28794# a_31790_36780# a_28742_35696# VDD pfet_06v0 ad=1.76p pd=8.88u as=1.76p ps=8.88u w=4u l=1u
X842 VSS a_56438_41099# a_55770_44499# VSS nfet_06v0 ad=0.65p pd=3.02u as=0.65p ps=3.02u w=2.5u l=1u
X843 a_9514_53123# a_2254_49609# a_10182_49723# VSS nfet_06v0 ad=1.1p pd=5.88u as=0.65p ps=3.02u w=2.5u l=1u
X844 a_61902_66969# a_48850_70437# a_65646_70553# VDD pfet_06v0 ad=4.4p pd=20.88u as=2.5p ps=10.5u w=10u l=1u
X845 a_9514_70483# a_8870_66967# a_6954_70553# VDD pfet_06v0 ad=2.6p pd=10.52u as=4.4p ps=20.88u w=10u l=1u
X846 VDD a_33702_71483# a_32142_67083# VDD pfet_06v0 ad=1.3p pd=5.52u as=1.3p ps=5.52u w=5u l=1u
X847 a_26058_66969# a_25326_66969# a_26258_67013# VSS nfet_06v0 ad=2.2p pd=10.88u as=1.25p ps=5.5u w=5u l=1u
X848 a_30026_61929# a_25666_61813# a_29726_61929# VDD pfet_06v0 ad=3.3p pd=10.66u as=2.5p ps=10.5u w=10u l=1u
X849 a_25194_35696# a_24994_35580# a_24894_35696# VDD pfet_06v0 ad=4.4p pd=20.88u as=2.5p ps=10.5u w=10u l=1u
X850 a_3168_34650# a_18586_34200# VSS ppolyf_u_1k r_width=1u r_length=76.45u
X851 a_53210_70553# a_48850_70437# a_52910_70553# VDD pfet_06v0 ad=3.3p pd=10.66u as=2.5p ps=10.5u w=10u l=1u
X852 VDD a_42790_41099# a_86922_42428# VDD pfet_06v0 ad=1.32p pd=6.88u as=0.75p ps=3.5u w=3u l=1u
X853 a_2594_53077# a_2594_53077# VDD VDD pfet_06v0 ad=0.88p pd=4.88u as=0.88p ps=4.88u w=2u l=1u
X854 a_30830_40983# a_26918_4870# cap_mim_2f0_m4m5_noshield c_width=25u c_length=8u
X855 a_6342_23712# a_2594_23596# a_5250_16854# VDD pfet_06v0 ad=4.4p pd=20.88u as=4.4p ps=20.88u w=10u l=1u
X856 a_74368_49992# a_72104_49876# a_74068_49992# VSS nfet_06v0 ad=0.175p pd=1.2u as=0.175p ps=1.2u w=0.7u l=1u
X857 a_32586_61859# a_33254_58459# VSS VSS nfet_06v0 ad=0.65p pd=3.02u as=0.65p ps=3.02u w=2.5u l=1u
X858 a_16110_45453# a_16110_45453# a_17746_44453# VDD pfet_06v0 ad=4.4p pd=20.88u as=3.3p ps=10.66u w=10u l=1u
X859 VDD a_56886_71483# a_55326_67083# VDD pfet_06v0 ad=2.2p pd=10.88u as=1.3p ps=5.52u w=5u l=1u
X860 a_19718_58459# a_11294_58459# VSS VSS nfet_06v0 ad=2.2p pd=10.88u as=1.3p ps=5.52u w=5u l=1u
X861 VDD VSS VDD VDD pfet_06v0 ad=4.29p pd=20.38u as=0 ps=0 w=9.75u l=2u
X862 a_62366_45453# a_62366_45453# a_64002_44453# VDD pfet_06v0 ad=4.4p pd=20.88u as=3.3p ps=10.66u w=10u l=1u
X863 a_8398_61859# a_10182_58459# VSS VSS nfet_06v0 ad=0.65p pd=3.02u as=1.1p ps=5.88u w=2.5u l=1u
X864 a_27930_37596# S3N a_25194_35696# VDD pfet_06v0 ad=0.22p pd=1.88u as=0.22p ps=1.88u w=0.5u l=1u
X865 a_5250_49653# a_2594_53077# VSS VSS nfet_06v0 ad=0.25p pd=1.5u as=0.44p ps=2.88u w=1u l=1u
X866 a_15646_58345# a_15646_58345# a_18154_58345# VSS nfet_06v0 ad=2.2p pd=10.88u as=1.65p ps=5.66u w=5u l=1u
X867 a_78114_23596# a_69682_23596# a_78314_23712# VDD pfet_06v0 ad=3.3p pd=10.66u as=2.5p ps=10.5u w=10u l=1u
X868 a_34366_49723# a_39182_54077# a_34818_54123# VDD pfet_06v0 ad=2.2p pd=10.88u as=2.2p ps=10.88u w=5u l=1u
X869 a_8870_40983# a_47856_9332# VDD VDD pfet_06v0 ad=0.44p pd=2.88u as=0.44p ps=2.88u w=1u l=1u
X870 a_65974_49723# a_58002_54123# VDD VDD pfet_06v0 ad=2.6p pd=10.52u as=4.4p ps=20.88u w=10u l=1u
X871 a_55714_23596# a_47282_23596# a_55914_23712# VDD pfet_06v0 ad=3.3p pd=10.66u as=2.5p ps=10.5u w=10u l=1u
X872 a_39182_54077# a_25326_49609# a_40382_49653# VSS nfet_06v0 ad=2.2p pd=10.88u as=1.25p ps=5.5u w=5u l=1u
X873 a_7934_4826# a_2594_11612# a_12670_11728# VDD pfet_06v0 ad=4.4p pd=20.88u as=2.5p ps=10.5u w=10u l=1u
X874 a_47856_9782# a_63274_10232# VSS ppolyf_u_1k r_width=1u r_length=76.45u
X875 a_8398_61859# a_19718_58459# cap_mim_2f0_m4m5_noshield c_width=20u c_length=10u
X876 a_70256_34650# a_85674_34200# VSS ppolyf_u_1k r_width=1u r_length=76.45u
X877 a_24654_4826# a_24954_4826# a_35870_4870# VSS nfet_06v0 ad=2.2p pd=10.88u as=1.25p ps=5.5u w=5u l=1u
X878 VSS VDD VSS VSS nfet_06v0 ad=0.44p pd=2.88u as=0 ps=0 w=1u l=2u
X879 a_6594_58389# a_8870_58343# a_9070_58459# VSS nfet_06v0 ad=2.2p pd=10.88u as=1.3p ps=5.52u w=5u l=1u
X880 a_73430_23712# a_69682_23596# a_72338_16854# VDD pfet_06v0 ad=4.4p pd=20.88u as=4.4p ps=20.88u w=10u l=1u
X881 a_48850_61813# a_48850_61813# a_51506_58389# VSS nfet_06v0 ad=0.44p pd=2.88u as=0.25p ps=1.5u w=1u l=1u
X882 a_53210_44569# a_7758_40983# a_55770_44499# VDD pfet_06v0 ad=4.4p pd=20.88u as=2.6p ps=10.52u w=10u l=1u
X883 a_39182_62813# a_39182_62813# a_40818_61813# VDD pfet_06v0 ad=4.4p pd=20.88u as=3.3p ps=10.66u w=10u l=1u
X884 a_2594_23596# a_2594_23596# a_15534_16854# VSS nfet_06v0 ad=0.44p pd=2.88u as=0.25p ps=1.5u w=1u l=1u
X885 a_2594_61813# a_2594_61813# VDD VDD pfet_06v0 ad=0.88p pd=4.88u as=0.88p ps=4.88u w=2u l=1u
X886 a_19390_70553# a_2294_70437# VDD VDD pfet_06v0 ad=2.5p pd=10.5u as=4.4p ps=20.88u w=10u l=1u
X887 a_55914_11728# a_55714_11612# VDD VDD pfet_06v0 ad=2.5p pd=10.5u as=4.4p ps=20.88u w=10u l=1u
X888 a_5530_13628# a_5794_4826# VSS VSS nfet_06v0 ad=0.825p pd=3.16u as=1.1p ps=5.88u w=2.5u l=1u
X889 a_7758_66967# a_29802_28838# VSS VSS nfet_06v0 ad=0.44p pd=2.88u as=0.44p ps=2.88u w=1u l=1u
X890 a_26258_58389# a_26058_58345# VSS VSS nfet_06v0 ad=1.25p pd=5.5u as=2.2p ps=10.88u w=5u l=1u
X891 a_47242_4826# a_47282_11612# a_61718_11728# VDD pfet_06v0 ad=4.4p pd=20.88u as=2.5p ps=10.5u w=10u l=1u
X892 a_48550_61813# a_48850_61813# a_50474_58389# VSS nfet_06v0 ad=0.44p pd=2.88u as=0.25p ps=1.5u w=1u l=1u
X893 a_30026_61929# a_8870_58343# a_32586_61859# VDD pfet_06v0 ad=4.4p pd=20.88u as=2.6p ps=10.52u w=10u l=1u
X894 a_34818_45499# a_38718_40985# a_34366_41099# VSS nfet_06v0 ad=1.1p pd=5.88u as=1.1p ps=5.88u w=2.5u l=1u
X895 a_2986_66969# a_2594_70437# a_3606_70553# VDD pfet_06v0 ad=4.4p pd=20.88u as=2.5p ps=10.5u w=10u l=1u
X896 VDD a_10630_71483# a_7958_67083# VDD pfet_06v0 ad=1.3p pd=5.52u as=1.3p ps=5.52u w=5u l=1u
X897 a_19718_67083# a_11746_71483# VDD VDD pfet_06v0 ad=4.4p pd=20.88u as=2.6p ps=10.52u w=10u l=1u
X898 VDD a_10630_45499# a_7958_41099# VDD pfet_06v0 ad=2.2p pd=10.88u as=1.3p ps=5.52u w=5u l=1u
X899 a_55326_67083# a_56886_71483# VDD VDD pfet_06v0 ad=1.3p pd=5.52u as=2.2p ps=10.88u w=5u l=1u
X900 a_51506_49653# a_48850_53077# VSS VSS nfet_06v0 ad=0.25p pd=1.5u as=0.44p ps=2.88u w=1u l=1u
X901 a_55326_49723# a_56886_54123# VDD VDD pfet_06v0 ad=1.3p pd=5.52u as=1.3p ps=5.52u w=5u l=1u
X902 a_76478_12812# a_76478_12812# a_78114_11612# VDD pfet_06v0 ad=4.4p pd=20.88u as=3.3p ps=10.66u w=10u l=1u
X903 a_47442_28838# a_47242_28794# a_48174_28838# VSS nfet_06v0 ad=2.2p pd=10.88u as=1.25p ps=5.5u w=5u l=1u
X904 a_49242_66969# a_48850_70437# a_49862_70553# VDD pfet_06v0 ad=4.4p pd=20.88u as=2.5p ps=10.5u w=10u l=1u
X905 VDD a_56886_45499# a_54214_41099# VDD pfet_06v0 ad=2.2p pd=10.88u as=1.3p ps=5.52u w=5u l=1u
X906 a_29666_67013# a_30830_66967# a_31030_67083# VSS nfet_06v0 ad=2.2p pd=10.88u as=1.3p ps=5.52u w=5u l=1u
X907 a_54078_12812# a_54078_12812# a_55714_11612# VDD pfet_06v0 ad=4.4p pd=20.88u as=3.3p ps=10.66u w=10u l=1u
X908 a_74368_41256# a_72104_41140# a_74068_41256# VSS nfet_06v0 ad=0.175p pd=1.2u as=0.175p ps=1.2u w=0.7u l=1u
X909 a_55326_58459# a_48850_61813# a_56886_62859# VDD pfet_06v0 ad=2.2p pd=10.88u as=1.3p ps=5.52u w=5u l=1u
X910 a_4518_16854# a_6342_23712# VDD VDD pfet_06v0 ad=2.2p pd=10.88u as=2.2p ps=10.88u w=5u l=1u
X911 Y a_72142_51084# a_72054_51200# VSS nfet_06v0 ad=0.6448p pd=3u as=1.0912p ps=5.84u w=2.48u l=1u
X912 a_33254_67083# a_39182_71437# a_33702_71483# VDD pfet_06v0 ad=2.2p pd=10.88u as=2.2p ps=10.88u w=5u l=1u
X913 a_30026_53193# a_25666_53077# a_29726_53193# VDD pfet_06v0 ad=3.3p pd=10.66u as=2.5p ps=10.5u w=10u l=1u
X914 a_5250_28838# a_6342_35696# VDD VDD pfet_06v0 ad=2.2p pd=10.88u as=2.2p ps=10.88u w=5u l=1u
X915 a_65974_67083# a_57550_67083# VSS VSS nfet_06v0 ad=1.3p pd=5.52u as=2.2p ps=10.88u w=5u l=1u
X916 VDD a_10630_54123# a_9070_49723# VDD pfet_06v0 ad=1.3p pd=5.52u as=1.3p ps=5.52u w=5u l=1u
X917 VDD a_58002_45499# a_65974_41099# VDD pfet_06v0 ad=2.6p pd=10.52u as=2.6p ps=10.52u w=10u l=1u
X918 a_34818_45499# a_25666_44453# a_31030_41099# VDD pfet_06v0 ad=1.3p pd=5.52u as=2.2p ps=10.88u w=5u l=1u
X919 a_48510_40985# a_48850_44453# a_48750_44569# VDD pfet_06v0 ad=4.4p pd=20.88u as=2.5p ps=10.5u w=10u l=1u
X920 a_6954_61929# a_8870_58343# a_9514_61859# VDD pfet_06v0 ad=4.4p pd=20.88u as=2.6p ps=10.52u w=10u l=1u
X921 a_9514_44499# a_10182_41099# VSS VSS nfet_06v0 ad=0.65p pd=3.02u as=0.65p ps=3.02u w=2.5u l=1u
X922 a_48510_49609# a_48510_49609# VSS VSS nfet_06v0 ad=0.44p pd=2.88u as=0.44p ps=2.88u w=1u l=1u
X923 a_56438_67083# a_48510_66969# a_55770_70483# VSS nfet_06v0 ad=0.65p pd=3.02u as=1.1p ps=5.88u w=2.5u l=1u
X924 VDD VSS VDD VDD pfet_06v0 ad=7.92p pd=36.88u as=0 ps=0 w=18u l=2u
X925 VSS a_57550_41099# a_65974_41099# VSS nfet_06v0 ad=1.3p pd=5.52u as=1.3p ps=5.52u w=5u l=1u
X926 a_50474_49653# a_48850_53077# VSS VSS nfet_06v0 ad=0.25p pd=1.5u as=0.44p ps=2.88u w=1u l=1u
X927 a_8398_53123# a_2254_49609# a_11294_49723# VSS nfet_06v0 ad=1.1p pd=5.88u as=0.65p ps=3.02u w=2.5u l=1u
X928 a_3168_34650# a_8870_58343# VSS ppolyf_u_1k r_width=1u r_length=76.45u
X929 VSS a_33254_67083# a_31470_70483# VSS nfet_06v0 ad=0.65p pd=3.02u as=0.65p ps=3.02u w=2.5u l=1u
X930 a_42790_58459# a_31030_58459# cap_mim_2f0_m4m5_noshield c_width=20u c_length=10u
X931 a_71606_16854# a_73430_23712# VDD VDD pfet_06v0 ad=2.2p pd=10.88u as=2.2p ps=10.88u w=5u l=1u
X932 a_79758_35696# a_69382_35580# VDD VDD pfet_06v0 ad=2.5p pd=10.5u as=4.4p ps=20.88u w=10u l=1u
X933 a_6594_41029# a_7758_40983# a_7958_41099# VSS nfet_06v0 ad=2.2p pd=10.88u as=1.3p ps=5.52u w=5u l=1u
X934 a_72142_59708# a_65974_67083# VSS VSS nfet_06v0 ad=0.33p pd=1.66u as=0.44p ps=2.88u w=1u l=1u
X935 a_72338_28838# a_73430_35696# VDD VDD pfet_06v0 ad=2.2p pd=10.88u as=2.2p ps=10.88u w=5u l=1u
X936 a_49206_16854# a_51030_23712# VDD VDD pfet_06v0 ad=2.2p pd=10.88u as=2.2p ps=10.88u w=5u l=1u
X937 a_42790_58459# a_34366_58459# VSS VSS nfet_06v0 ad=2.2p pd=10.88u as=1.3p ps=5.52u w=5u l=1u
X938 a_7758_66967# a_26918_28838# cap_mim_2f0_m4m5_noshield c_width=25u c_length=8u
X939 a_57358_35696# a_46982_35580# VDD VDD pfet_06v0 ad=2.5p pd=10.5u as=4.4p ps=20.88u w=10u l=1u
X940 a_49938_28838# a_51030_35696# VDD VDD pfet_06v0 ad=2.2p pd=10.88u as=2.2p ps=10.88u w=5u l=1u
X941 a_10182_41099# a_16110_45453# a_10630_45499# VDD pfet_06v0 ad=2.2p pd=10.88u as=2.2p ps=10.88u w=5u l=1u
X942 a_77154_42464# a_77242_42348# X VSS nfet_06v0 ad=1.0912p pd=5.84u as=0.6448p ps=3u w=2.48u l=1u
X943 Y Y a_75010_51200# VSS nfet_06v0 ad=0.52p pd=2.52u as=0.88p ps=4.88u w=2u l=1u
X944 a_31470_61859# a_33254_58459# VSS VSS nfet_06v0 ad=0.65p pd=3.02u as=1.1p ps=5.88u w=2.5u l=1u
X945 a_47856_21766# a_63274_21316# VSS ppolyf_u_1k r_width=1u r_length=76.45u
X946 a_16110_71437# a_2254_66969# a_17310_67013# VSS nfet_06v0 ad=2.2p pd=10.88u as=1.25p ps=5.5u w=5u l=1u
X947 VSS VDD VSS VSS nfet_06v0 ad=4.29p pd=20.38u as=0 ps=0 w=9.75u l=2u
X948 a_54654_70483# a_56438_67083# VSS VSS nfet_06v0 ad=0.65p pd=3.02u as=1.1p ps=5.88u w=2.5u l=1u
X949 a_75388_62164# Z VDD VDD pfet_05v0 ad=0.8052p pd=4.54u as=0.8052p ps=4.54u w=1.83u l=0.5u
X950 a_25568_9782# a_40986_9332# VSS ppolyf_u_1k r_width=1u r_length=76.45u
X951 a_6594_67013# a_2254_66969# a_6294_67013# VSS nfet_06v0 ad=1.65p pd=5.66u as=1.25p ps=5.5u w=5u l=1u
X952 a_42790_41099# a_31030_41099# cap_mim_2f0_m4m5_noshield c_width=20u c_length=10u
X953 a_39182_54077# a_39182_54077# a_40818_53077# VDD pfet_06v0 ad=4.4p pd=20.88u as=3.3p ps=10.66u w=10u l=1u
X954 VDD a_11746_54123# a_19718_49723# VDD pfet_06v0 ad=2.6p pd=10.52u as=2.6p ps=10.52u w=10u l=1u
X955 a_7958_49723# a_10630_54123# VDD VDD pfet_06v0 ad=1.3p pd=5.52u as=2.2p ps=10.88u w=5u l=1u
X956 a_61902_40985# a_48850_44453# a_65646_44569# VDD pfet_06v0 ad=4.4p pd=20.88u as=2.5p ps=10.5u w=10u l=1u
X957 a_70256_34650# a_8870_66967# VSS ppolyf_u_1k r_width=1u r_length=76.45u
X958 a_9514_44499# a_8870_40983# a_6954_44569# VDD pfet_06v0 ad=2.6p pd=10.52u as=4.4p ps=20.88u w=10u l=1u
X959 VDD a_33702_45499# a_32142_41099# VDD pfet_06v0 ad=1.3p pd=5.52u as=1.3p ps=5.52u w=5u l=1u
X960 a_12006_16854# a_7402_16854# VSS VSS nfet_06v0 ad=0.44p pd=2.88u as=0.44p ps=2.88u w=1u l=1u
X961 a_53210_44569# a_48850_44453# a_52910_44569# VDD pfet_06v0 ad=3.3p pd=10.66u as=2.5p ps=10.5u w=10u l=1u
X962 a_54214_49723# a_56886_54123# VDD VDD pfet_06v0 ad=1.3p pd=5.52u as=2.2p ps=10.88u w=5u l=1u
X963 VSS VDD VSS VSS nfet_06v0 ad=7.92p pd=36.88u as=0 ps=0 w=18u l=2u
X964 a_24954_28794# a_24954_28794# VSS VSS nfet_06v0 ad=0.44p pd=2.88u as=0.44p ps=2.88u w=1u l=1u
X965 a_3168_9332# a_2594_11612# a_4518_4870# VDD pfet_06v0 ad=4.4p pd=20.88u as=4.4p ps=20.88u w=10u l=1u
X966 a_49442_41029# a_49242_40985# VSS VSS nfet_06v0 ad=1.25p pd=5.5u as=2.2p ps=10.88u w=5u l=1u
X967 a_2554_28794# a_2554_28794# VSS VSS nfet_06v0 ad=0.44p pd=2.88u as=0.44p ps=2.88u w=1u l=1u
X968 a_29366_41029# a_26058_40985# VSS VSS nfet_06v0 ad=1.25p pd=5.5u as=2.2p ps=10.88u w=5u l=1u
X969 VDD a_42790_41099# a_87474_40972# VDD pfet_06v0 ad=1.32p pd=6.88u as=0.99p ps=3.66u w=3u l=1u
X970 VDD a_56886_45499# a_55326_41099# VDD pfet_06v0 ad=2.2p pd=10.88u as=1.3p ps=5.52u w=5u l=1u
X971 a_71606_4870# S1P a_69842_4870# VSS nfet_06v0 ad=3.3p pd=15.88u as=3.3p ps=15.88u w=7.5u l=1u
X972 VDD VSS VDD VDD pfet_06v0 ad=4.29p pd=20.38u as=0 ps=0 w=9.75u l=2u
X973 a_10630_54123# a_2594_53077# a_9070_49723# VDD pfet_06v0 ad=1.3p pd=5.52u as=2.2p ps=10.88u w=5u l=1u
X974 a_11746_62859# a_15646_58345# a_11294_58459# VSS nfet_06v0 ad=1.1p pd=5.88u as=1.1p ps=5.88u w=2.5u l=1u
X975 a_17746_61813# a_2594_61813# a_17946_61929# VDD pfet_06v0 ad=3.3p pd=10.66u as=2.5p ps=10.5u w=10u l=1u
X976 a_38718_58345# a_25666_61813# a_42462_61929# VDD pfet_06v0 ad=4.4p pd=20.88u as=2.5p ps=10.5u w=10u l=1u
X977 a_8398_70483# a_7758_66967# a_6954_70553# VDD pfet_06v0 ad=2.6p pd=10.52u as=4.4p ps=20.88u w=10u l=1u
X978 a_25566_70553# a_25366_70437# VDD VDD pfet_06v0 ad=2.5p pd=10.5u as=4.4p ps=20.88u w=10u l=1u
X979 a_58002_62859# a_61902_58345# a_57550_58459# VSS nfet_06v0 ad=1.1p pd=5.88u as=1.1p ps=5.88u w=2.5u l=1u
X980 a_64002_61813# a_48850_61813# a_64202_61929# VDD pfet_06v0 ad=3.3p pd=10.66u as=2.5p ps=10.5u w=10u l=1u
X981 a_39430_23712# a_24694_23596# VDD VDD pfet_06v0 ad=2.5p pd=10.5u as=4.4p ps=20.88u w=10u l=1u
X982 a_38718_66969# a_38718_66969# a_41226_66969# VSS nfet_06v0 ad=2.2p pd=10.88u as=1.65p ps=5.66u w=5u l=1u
X983 a_72882_28794# a_76478_36780# a_73430_35696# VDD pfet_06v0 ad=1.76p pd=8.88u as=1.76p ps=8.88u w=4u l=1u
X984 a_24994_35580# a_24994_35580# VDD VDD pfet_06v0 ad=0.88p pd=4.88u as=0.88p ps=4.88u w=2u l=1u
X985 a_49406_37586# S4P a_47482_35696# VDD pfet_06v0 ad=0.242p pd=1.98u as=0.242p ps=1.98u w=0.55u l=1u
X986 a_4718_25602# a_5794_16810# VSS VSS nfet_06v0 ad=0.825p pd=3.16u as=1.1p ps=5.88u w=2.5u l=1u
X987 a_25666_70437# a_25666_70437# VDD VDD pfet_06v0 ad=0.88p pd=4.88u as=0.88p ps=4.88u w=2u l=1u
X988 a_50482_28794# a_54078_36780# a_51030_35696# VDD pfet_06v0 ad=1.76p pd=8.88u as=1.76p ps=8.88u w=4u l=1u
X989 a_69382_11612# a_69682_11612# a_87154_11728# VDD pfet_06v0 ad=4.4p pd=20.88u as=2.5p ps=10.5u w=10u l=1u
X990 a_52850_41029# a_30830_40983# a_54214_41099# VSS nfet_06v0 ad=2.2p pd=10.88u as=1.3p ps=5.52u w=5u l=1u
X991 a_7758_58343# a_47856_21316# VDD VDD pfet_06v0 ad=0.44p pd=2.88u as=0.44p ps=2.88u w=1u l=1u
X992 a_7958_58459# a_10630_62859# VDD VDD pfet_06v0 ad=1.3p pd=5.52u as=1.3p ps=5.52u w=5u l=1u
X993 a_27650_16854# S4N a_25154_16854# VSS nfet_06v0 ad=3.74p pd=17.88u as=3.74p ps=17.88u w=8.5u l=1u
X994 VSS VDD VSS VSS nfet_06v0 ad=0.44p pd=2.88u as=0 ps=0 w=1u l=2u
X995 a_42790_67083# a_34818_71483# VDD VDD pfet_06v0 ad=4.4p pd=20.88u as=2.6p ps=10.52u w=10u l=1u
X996 ZP ZN VDD VDD pfet_05v0 ad=0.8052p pd=4.54u as=0.8052p ps=4.54u w=1.83u l=0.5u
X997 a_47856_9332# a_47282_11612# a_49206_4870# VDD pfet_06v0 ad=4.4p pd=20.88u as=4.4p ps=20.88u w=10u l=1u
X998 a_2454_28838# a_2254_28794# VSS VSS nfet_06v0 ad=1.25p pd=5.5u as=2.2p ps=10.88u w=5u l=1u
X999 a_28602_61929# a_25366_61813# VDD VDD pfet_06v0 ad=2.5p pd=10.5u as=4.4p ps=20.88u w=10u l=1u
X1000 VDD a_83814_41016# a_84634_40972# VDD pfet_06v0 ad=1.32p pd=6.88u as=0.99p ps=3.66u w=3u l=1u
X1001 VDD a_42790_67083# a_75154_66956# VDD pfet_06v0 ad=1.32p pd=6.88u as=0.99p ps=3.66u w=3u l=1u
X1002 a_19390_44569# a_2294_44453# VDD VDD pfet_06v0 ad=2.5p pd=10.5u as=4.4p ps=20.88u w=10u l=1u
X1003 a_84634_49596# a_65974_49723# VDD VDD pfet_06v0 ad=0.99p pd=3.66u as=1.32p ps=6.88u w=3u l=1u
X1004 a_87474_58332# a_19718_58459# VDD VDD pfet_06v0 ad=0.99p pd=3.66u as=1.32p ps=6.88u w=3u l=1u
X1005 a_17310_58389# a_2986_58345# VSS VSS nfet_06v0 ad=1.25p pd=5.5u as=2.2p ps=10.88u w=5u l=1u
X1006 a_6294_58389# a_2986_58345# VSS VSS nfet_06v0 ad=1.25p pd=5.5u as=2.2p ps=10.88u w=5u l=1u
X1007 a_75022_4826# a_69682_11612# a_79758_11728# VDD pfet_06v0 ad=4.4p pd=20.88u as=2.5p ps=10.5u w=10u l=1u
X1008 a_52622_4826# a_47282_11612# a_57358_11728# VDD pfet_06v0 ad=4.4p pd=20.88u as=2.5p ps=10.5u w=10u l=1u
X1009 a_29666_67013# a_8870_66967# a_32142_67083# VSS nfet_06v0 ad=2.2p pd=10.88u as=1.3p ps=5.52u w=5u l=1u
X1010 a_72304_49992# a_79086_51084# Y VSS nfet_06v0 ad=1.0912p pd=5.84u as=0.6448p ps=3u w=2.48u l=1u
X1011 Y a_73254_51084# a_73166_51200# VSS nfet_06v0 ad=0.6448p pd=3u as=1.0912p ps=5.84u w=2.48u l=1u
X1012 a_25568_9782# a_40986_10232# VSS ppolyf_u_1k r_width=1u r_length=76.45u
X1013 a_32586_44499# a_33254_41099# VSS VSS nfet_06v0 ad=0.65p pd=3.02u as=0.65p ps=3.02u w=2.5u l=1u
X1014 a_2986_40985# a_2594_44453# a_3606_44569# VDD pfet_06v0 ad=4.4p pd=20.88u as=2.5p ps=10.5u w=10u l=1u
X1015 a_69342_16810# a_69682_23596# a_85230_23712# VDD pfet_06v0 ad=4.4p pd=20.88u as=2.5p ps=10.5u w=10u l=1u
X1016 a_19718_41099# a_11746_45499# VDD VDD pfet_06v0 ad=4.4p pd=20.88u as=2.6p ps=10.52u w=10u l=1u
X1017 VDD a_10630_45499# a_7958_41099# VDD pfet_06v0 ad=1.3p pd=5.52u as=1.3p ps=5.52u w=5u l=1u
X1018 a_69842_4870# a_69642_4826# a_70574_4870# VSS nfet_06v0 ad=2.2p pd=10.88u as=1.25p ps=5.5u w=5u l=1u
X1019 a_55326_41099# a_56886_45499# VDD VDD pfet_06v0 ad=1.3p pd=5.52u as=2.2p ps=10.88u w=5u l=1u
X1020 a_27930_13628# a_28194_4826# VSS VSS nfet_06v0 ad=0.825p pd=3.16u as=1.1p ps=5.88u w=2.5u l=1u
X1021 a_19718_41099# a_11294_41099# VSS VSS nfet_06v0 ad=2.2p pd=10.88u as=1.3p ps=5.52u w=5u l=1u
X1022 a_31470_61859# a_33254_58459# VSS VSS nfet_06v0 ad=0.65p pd=3.02u as=0.65p ps=3.02u w=2.5u l=1u
X1023 VSS VDD VSS VSS nfet_06v0 ad=4.29p pd=20.38u as=0 ps=0 w=9.75u l=2u
X1024 a_49242_40985# a_48850_44453# a_49862_44569# VDD pfet_06v0 ad=4.4p pd=20.88u as=2.5p ps=10.5u w=10u l=1u
X1025 a_8398_44499# a_10182_41099# VSS VSS nfet_06v0 ad=0.65p pd=3.02u as=1.1p ps=5.88u w=2.5u l=1u
X1026 a_9070_67083# a_8870_66967# a_6594_67013# VSS nfet_06v0 ad=1.3p pd=5.52u as=2.2p ps=10.88u w=5u l=1u
X1027 a_55770_61859# a_56438_58459# VSS VSS nfet_06v0 ad=0.65p pd=3.02u as=0.65p ps=3.02u w=2.5u l=1u
X1028 a_25568_21316# a_24994_23596# a_26918_16854# VDD pfet_06v0 ad=4.4p pd=20.88u as=4.4p ps=20.88u w=10u l=1u
X1029 a_33254_41099# a_39182_45453# a_33702_45499# VDD pfet_06v0 ad=2.2p pd=10.88u as=2.2p ps=10.88u w=5u l=1u
X1030 a_57550_49723# a_48510_49609# a_54654_53123# VSS nfet_06v0 ad=0.65p pd=3.02u as=1.1p ps=5.88u w=2.5u l=1u
X1031 a_33626_11728# a_33426_11612# VDD VDD pfet_06v0 ad=2.5p pd=10.5u as=4.4p ps=20.88u w=10u l=1u
X1032 a_28742_35696# a_24994_35580# a_27650_28838# VDD pfet_06v0 ad=4.4p pd=20.88u as=4.4p ps=20.88u w=10u l=1u
X1033 VSS a_56438_58459# a_54654_61859# VSS nfet_06v0 ad=0.65p pd=3.02u as=0.65p ps=3.02u w=2.5u l=1u
X1034 a_11226_11728# a_11026_11612# VDD VDD pfet_06v0 ad=2.5p pd=10.5u as=4.4p ps=20.88u w=10u l=1u
X1035 a_69582_35696# a_69382_35580# VDD VDD pfet_06v0 ad=2.5p pd=10.5u as=4.4p ps=20.88u w=10u l=1u
X1036 a_47856_21766# a_63274_22216# VSS ppolyf_u_1k r_width=1u r_length=76.45u
X1037 a_6594_41029# a_8870_40983# a_9070_41099# VSS nfet_06v0 ad=2.2p pd=10.88u as=1.3p ps=5.52u w=5u l=1u
X1038 a_29998_49653# a_25326_49609# a_29666_49653# VSS nfet_06v0 ad=1.25p pd=5.5u as=1.65p ps=5.66u w=5u l=1u
X1039 a_62830_11728# a_46982_11612# VDD VDD pfet_06v0 ad=2.5p pd=10.5u as=4.4p ps=20.88u w=10u l=1u
X1040 VDD a_34818_54123# a_42790_49723# VDD pfet_06v0 ad=2.6p pd=10.52u as=2.6p ps=10.52u w=10u l=1u
X1041 a_32142_58459# a_33702_62859# VDD VDD pfet_06v0 ad=1.3p pd=5.52u as=2.2p ps=10.88u w=5u l=1u
X1042 a_3168_9332# a_18586_9332# VSS ppolyf_u_1k r_width=1u r_length=76.45u
X1043 a_73430_11728# a_75022_4826# a_72882_4826# VSS nfet_06v0 ad=0.88p pd=4.88u as=0.88p ps=4.88u w=2u l=1u
X1044 a_52550_67013# a_49242_66969# VSS VSS nfet_06v0 ad=1.25p pd=5.5u as=2.2p ps=10.88u w=5u l=1u
X1045 a_17746_53077# a_2594_53077# a_17946_53193# VDD pfet_06v0 ad=3.3p pd=10.66u as=2.5p ps=10.5u w=10u l=1u
X1046 a_51786_70553# a_48550_70437# VDD VDD pfet_06v0 ad=2.5p pd=10.5u as=4.4p ps=20.88u w=10u l=1u
X1047 a_59190_4870# a_47282_11612# VSS VSS nfet_06v0 ad=0.25p pd=1.5u as=0.44p ps=2.88u w=1u l=1u
X1048 a_2594_35580# a_2594_35580# a_15534_28838# VSS nfet_06v0 ad=0.44p pd=2.88u as=0.25p ps=1.5u w=1u l=1u
X1049 a_38718_49609# a_25666_53077# a_42462_53193# VDD pfet_06v0 ad=4.4p pd=20.88u as=2.5p ps=10.5u w=10u l=1u
X1050 a_28742_11728# a_30334_4826# a_28194_4826# VSS nfet_06v0 ad=0.88p pd=4.88u as=0.88p ps=4.88u w=2u l=1u
X1051 VDD VSS VDD VDD pfet_06v0 ad=7.92p pd=36.88u as=0 ps=0 w=18u l=2u
X1052 a_64002_53077# a_48850_53077# a_64202_53193# VDD pfet_06v0 ad=3.3p pd=10.66u as=2.5p ps=10.5u w=10u l=1u
X1053 a_42790_58459# a_34366_58459# VSS VSS nfet_06v0 ad=1.3p pd=5.52u as=2.2p ps=10.88u w=5u l=1u
X1054 a_24994_11612# a_24994_11612# a_37934_4870# VSS nfet_06v0 ad=0.44p pd=2.88u as=0.25p ps=1.5u w=1u l=1u
X1055 a_25326_58345# a_25326_58345# VSS VSS nfet_06v0 ad=0.44p pd=2.88u as=0.44p ps=2.88u w=1u l=1u
X1056 a_5250_41029# a_2594_44453# VSS VSS nfet_06v0 ad=0.25p pd=1.5u as=0.44p ps=2.88u w=1u l=1u
X1057 a_31790_12812# a_31790_12812# a_33426_11612# VDD pfet_06v0 ad=4.4p pd=20.88u as=3.3p ps=10.66u w=10u l=1u
X1058 a_33254_58459# a_25326_58345# a_32586_61859# VSS nfet_06v0 ad=0.65p pd=3.02u as=1.1p ps=5.88u w=2.5u l=1u
X1059 a_28602_53193# a_25366_53077# VDD VDD pfet_06v0 ad=2.5p pd=10.5u as=4.4p ps=20.88u w=10u l=1u
X1060 VDD a_33702_71483# a_31030_67083# VDD pfet_06v0 ad=2.2p pd=10.88u as=1.3p ps=5.52u w=5u l=1u
X1061 a_77242_51084# a_84634_40972# VDD VDD pfet_06v0 ad=1.32p pd=6.88u as=1.32p ps=6.88u w=3u l=1u
X1062 a_39182_45453# a_25326_40985# a_40382_41029# VSS nfet_06v0 ad=2.2p pd=10.88u as=1.25p ps=5.5u w=5u l=1u
X1063 a_8398_53123# a_19718_49723# cap_mim_2f0_m4m5_noshield c_width=20u c_length=10u
X1064 a_8870_66967# a_70256_33300# VDD VDD pfet_06v0 ad=0.44p pd=2.88u as=0.44p ps=2.88u w=1u l=1u
X1065 VSS a_56438_67083# a_55770_70483# VSS nfet_06v0 ad=1.1p pd=5.88u as=0.65p ps=3.02u w=2.5u l=1u
X1066 VSS a_33254_49723# a_31470_53123# VSS nfet_06v0 ad=1.1p pd=5.88u as=0.65p ps=3.02u w=2.5u l=1u
X1067 a_5794_4826# a_9390_12812# a_6342_11728# VDD pfet_06v0 ad=1.76p pd=8.88u as=1.76p ps=8.88u w=4u l=1u
X1068 a_55330_4870# a_55130_4826# VSS VSS nfet_06v0 ad=1.25p pd=5.5u as=2.2p ps=10.88u w=5u l=1u
X1069 VSS a_65974_49723# a_85566_49640# VSS nfet_06v0 ad=0.44p pd=2.88u as=0.25p ps=1.5u w=1u l=1u
X1070 a_26678_70553# a_25366_70437# VDD VDD pfet_06v0 ad=2.5p pd=10.5u as=4.4p ps=20.88u w=10u l=1u
X1071 a_54214_58459# a_48850_61813# a_58002_62859# VDD pfet_06v0 ad=2.2p pd=10.88u as=1.3p ps=5.52u w=5u l=1u
X1072 VDD VSS VDD VDD pfet_06v0 ad=0.44p pd=2.88u as=0 ps=0 w=1u l=2u
X1073 VSS VDD VSS VSS nfet_06v0 ad=0.44p pd=2.88u as=0 ps=0 w=1u l=2u
X1074 a_49406_13618# a_8870_40983# cap_mim_2f0_m4m5_noshield c_width=25u c_length=8u
X1075 a_24954_28794# a_24994_35580# a_39430_35696# VDD pfet_06v0 ad=4.4p pd=20.88u as=2.5p ps=10.5u w=10u l=1u
X1076 VDD VSS VDD VDD pfet_06v0 ad=7.92p pd=36.88u as=0 ps=0 w=18u l=2u
X1077 a_54654_53123# a_56438_49723# VSS VSS nfet_06v0 ad=0.65p pd=3.02u as=0.65p ps=3.02u w=2.5u l=1u
X1078 a_10642_4870# a_10442_4826# VSS VSS nfet_06v0 ad=1.25p pd=5.5u as=2.2p ps=10.88u w=5u l=1u
X1079 a_2554_28794# a_2594_35580# a_17030_35696# VDD pfet_06v0 ad=4.4p pd=20.88u as=2.5p ps=10.5u w=10u l=1u
X1080 VDD a_33702_54123# a_32142_49723# VDD pfet_06v0 ad=2.2p pd=10.88u as=1.3p ps=5.52u w=5u l=1u
X1081 ZP ZN VSS VSS nfet_05v0 ad=0.5808p pd=3.52u as=0.5808p ps=3.52u w=1.32u l=0.6u
X1082 a_4218_67013# a_2594_70437# VSS VSS nfet_06v0 ad=0.25p pd=1.5u as=0.44p ps=2.88u w=1u l=1u
X1083 a_74490_4870# a_69642_4826# a_71806_13618# VSS nfet_06v0 ad=1.1p pd=5.88u as=0.825p ps=3.16u w=2.5u l=1u
X1084 a_11746_62859# a_2594_61813# a_7958_58459# VDD pfet_06v0 ad=1.3p pd=5.52u as=2.2p ps=10.88u w=5u l=1u
X1085 a_27650_28838# a_28742_35696# VDD VDD pfet_06v0 ad=2.2p pd=10.88u as=2.2p ps=10.88u w=5u l=1u
X1086 a_25566_44569# a_25366_44453# VDD VDD pfet_06v0 ad=2.5p pd=10.5u as=4.4p ps=20.88u w=10u l=1u
X1087 a_8398_44499# a_7758_40983# a_6954_44569# VDD pfet_06v0 ad=2.6p pd=10.52u as=4.4p ps=20.88u w=10u l=1u
X1088 a_7758_49607# a_70256_9332# VDD VDD pfet_06v0 ad=0.44p pd=2.88u as=0.44p ps=2.88u w=1u l=1u
X1089 VDD VSS VDD VDD pfet_06v0 ad=0.44p pd=2.88u as=0 ps=0 w=1u l=2u
X1090 a_72142_51084# a_72314_66956# VDD VDD pfet_06v0 ad=1.32p pd=6.88u as=1.32p ps=6.88u w=3u l=1u
X1091 a_25568_21766# a_40986_21316# VSS ppolyf_u_1k r_width=1u r_length=76.45u
X1092 VDD VSS VDD VDD pfet_06v0 ad=4.29p pd=20.38u as=0 ps=0 w=9.75u l=2u
X1093 a_25666_44453# a_25666_44453# VDD VDD pfet_06v0 ad=0.88p pd=4.88u as=0.88p ps=4.88u w=2u l=1u
X1094 VDD Y Y VDD pfet_06v0 ad=0.52p pd=2.52u as=0.52p ps=2.52u w=2u l=1u
X1095 a_88406_58376# a_42790_58459# a_87474_58332# VSS nfet_06v0 ad=0.25p pd=1.5u as=0.44p ps=2.88u w=1u l=1u
X1096 VSS a_34366_67083# a_42790_67083# VSS nfet_06v0 ad=1.3p pd=5.52u as=1.3p ps=5.52u w=5u l=1u
X1097 a_3168_21316# a_18586_21316# VSS ppolyf_u_1k r_width=1u r_length=76.45u
X1098 VDD VSS VDD VDD pfet_06v0 ad=4.29p pd=20.38u as=0 ps=0 w=9.75u l=2u
X1099 a_69882_11728# a_69682_11612# a_69582_11728# VDD pfet_06v0 ad=4.4p pd=20.88u as=2.5p ps=10.5u w=10u l=1u
X1100 a_73166_59824# a_72104_58500# VSS VSS nfet_06v0 ad=0.5456p pd=3.36u as=0.5456p ps=3.36u w=1.24u l=1u
X1101 a_42790_41099# a_34818_45499# VDD VDD pfet_06v0 ad=4.4p pd=20.88u as=2.6p ps=10.52u w=10u l=1u
X1102 a_5794_16810# a_2554_16810# a_5530_25612# VSS nfet_06v0 ad=1.1p pd=5.88u as=0.825p ps=3.16u w=2.5u l=1u
X1103 a_47482_11728# a_47282_11612# a_47182_11728# VDD pfet_06v0 ad=4.4p pd=20.88u as=2.5p ps=10.5u w=10u l=1u
X1104 a_32586_70483# a_25326_66969# a_33254_67083# VSS nfet_06v0 ad=1.1p pd=5.88u as=0.65p ps=3.02u w=2.5u l=1u
X1105 a_81590_4870# a_69682_11612# VSS VSS nfet_06v0 ad=0.25p pd=1.5u as=0.44p ps=2.88u w=1u l=1u
X1106 VSS a_10182_49723# a_9514_53123# VSS nfet_06v0 ad=1.1p pd=5.88u as=0.65p ps=3.02u w=2.5u l=1u
X1107 a_51506_41029# a_48850_44453# VSS VSS nfet_06v0 ad=0.25p pd=1.5u as=0.44p ps=2.88u w=1u l=1u
X1108 a_42790_41099# a_34366_41099# VSS VSS nfet_06v0 ad=2.2p pd=10.88u as=1.3p ps=5.52u w=5u l=1u
X1109 a_31030_58459# a_30830_58343# a_29666_58389# VSS nfet_06v0 ad=1.3p pd=5.52u as=2.2p ps=10.88u w=5u l=1u
X1110 a_6654_61929# a_2294_61813# VDD VDD pfet_06v0 ad=2.5p pd=10.5u as=4.4p ps=20.88u w=10u l=1u
X1111 a_31470_44499# a_33254_41099# VSS VSS nfet_06v0 ad=0.65p pd=3.02u as=1.1p ps=5.88u w=2.5u l=1u
X1112 VDD VSS VDD VDD pfet_06v0 ad=4.29p pd=20.38u as=0 ps=0 w=9.75u l=2u
X1113 VDD a_42790_67083# a_74602_68412# VDD pfet_06v0 ad=1.32p pd=6.88u as=0.75p ps=3.5u w=3u l=1u
X1114 a_51030_23712# a_47282_23596# a_49938_16854# VDD pfet_06v0 ad=4.4p pd=20.88u as=4.4p ps=20.88u w=10u l=1u
X1115 a_31030_67083# a_33702_71483# VDD VDD pfet_06v0 ad=1.3p pd=5.52u as=2.2p ps=10.88u w=5u l=1u
X1116 a_31030_49723# a_33702_54123# VDD VDD pfet_06v0 ad=1.3p pd=5.52u as=1.3p ps=5.52u w=5u l=1u
X1117 VDD a_48550_70437# a_53542_70553# VDD pfet_06v0 ad=4.4p pd=20.88u as=2.5p ps=10.5u w=10u l=1u
X1118 VSS VDD VSS VSS nfet_06v0 ad=7.92p pd=36.88u as=0 ps=0 w=18u l=2u
X1119 a_70256_21316# a_85674_21316# VSS ppolyf_u_1k r_width=1u r_length=76.45u
X1120 a_30830_58343# a_70256_21316# VDD VDD pfet_06v0 ad=0.44p pd=2.88u as=0.44p ps=2.88u w=1u l=1u
X1121 a_10182_67083# a_2254_66969# a_9514_70483# VSS nfet_06v0 ad=0.65p pd=3.02u as=1.1p ps=5.88u w=2.5u l=1u
X1122 a_18354_67013# a_18154_66969# VSS VSS nfet_06v0 ad=1.25p pd=5.5u as=2.2p ps=10.88u w=5u l=1u
X1123 a_8870_66967# a_70256_33300# VDD VDD pfet_06v0 ad=0.44p pd=2.88u as=0.44p ps=2.88u w=1u l=1u
X1124 VSS VDD VSS VSS nfet_06v0 ad=0.44p pd=2.88u as=0 ps=0 w=1u l=2u
X1125 a_74490_28838# a_76478_36780# a_70256_33300# VDD pfet_06v0 ad=1.76p pd=8.88u as=1.76p ps=8.88u w=4u l=1u
X1126 a_72882_16810# a_69642_16810# a_72618_25612# VSS nfet_06v0 ad=1.1p pd=5.88u as=0.825p ps=3.16u w=2.5u l=1u
X1127 a_55770_53123# a_56438_49723# VSS VSS nfet_06v0 ad=0.65p pd=3.02u as=1.1p ps=5.88u w=2.5u l=1u
X1128 VSS a_26058_49609# a_29998_49653# VSS nfet_06v0 ad=2.2p pd=10.88u as=1.25p ps=5.5u w=5u l=1u
X1129 a_48510_40985# a_48510_40985# VSS VSS nfet_06v0 ad=0.44p pd=2.88u as=0.44p ps=2.88u w=1u l=1u
X1130 a_64610_67013# a_64410_66969# VSS VSS nfet_06v0 ad=1.25p pd=5.5u as=2.2p ps=10.88u w=5u l=1u
X1131 a_25154_16854# a_24954_16810# a_25886_16854# VSS nfet_06v0 ad=2.2p pd=10.88u as=1.25p ps=5.5u w=5u l=1u
X1132 a_8870_58343# a_7402_28838# VSS VSS nfet_06v0 ad=0.44p pd=2.88u as=0.44p ps=2.88u w=1u l=1u
X1133 VSS VDD VSS VSS nfet_06v0 ad=7.92p pd=36.88u as=0 ps=0 w=18u l=2u
X1134 a_50474_41029# a_48850_44453# VSS VSS nfet_06v0 ad=0.25p pd=1.5u as=0.44p ps=2.88u w=1u l=1u
X1135 a_30830_66967# a_47856_33300# VDD VDD pfet_06v0 ad=0.44p pd=2.88u as=0.44p ps=2.88u w=1u l=1u
X1136 VDD VSS VDD VDD pfet_06v0 ad=0.44p pd=2.88u as=0 ps=0 w=1u l=2u
X1137 a_33702_71483# a_25666_70437# a_32142_67083# VDD pfet_06v0 ad=1.3p pd=5.52u as=2.2p ps=10.88u w=5u l=1u
X1138 a_48294_35696# a_46982_35580# VDD VDD pfet_06v0 ad=2.5p pd=10.5u as=4.4p ps=20.88u w=10u l=1u
X1139 a_54654_53123# a_12006_16854# a_53210_53193# VDD pfet_06v0 ad=2.6p pd=10.52u as=4.4p ps=20.88u w=10u l=1u
X1140 a_10630_62859# a_15646_58345# a_10182_58459# VSS nfet_06v0 ad=1.1p pd=5.88u as=1.1p ps=5.88u w=2.5u l=1u
X1141 a_25666_61813# a_25666_61813# a_28322_58389# VSS nfet_06v0 ad=0.44p pd=2.88u as=0.25p ps=1.5u w=1u l=1u
X1142 a_42790_49723# a_31030_49723# cap_mim_2f0_m4m5_noshield c_width=20u c_length=10u
X1143 a_2294_70437# a_2594_70437# a_5530_70553# VDD pfet_06v0 ad=4.4p pd=20.88u as=2.5p ps=10.5u w=10u l=1u
X1144 a_7286_61929# a_2594_61813# a_6954_61929# VDD pfet_06v0 ad=2.5p pd=10.5u as=3.3p ps=10.66u w=10u l=1u
X1145 a_8398_70483# a_19718_67083# cap_mim_2f0_m4m5_noshield c_width=20u c_length=10u
X1146 a_56886_62859# a_61902_58345# a_56438_58459# VSS nfet_06v0 ad=1.1p pd=5.88u as=1.1p ps=5.88u w=2.5u l=1u
X1147 X X VDD VDD pfet_06v0 ad=0.52p pd=2.52u as=0.52p ps=2.52u w=2u l=1u
X1148 a_80558_16854# a_69342_16810# VSS VSS nfet_06v0 ad=1.25p pd=5.5u as=2.2p ps=10.88u w=5u l=1u
X1149 a_4718_37586# a_5794_28794# VSS VSS nfet_06v0 ad=0.825p pd=3.16u as=1.1p ps=5.88u w=2.5u l=1u
X1150 a_6342_11728# a_7934_4826# a_5794_4826# VSS nfet_06v0 ad=0.88p pd=4.88u as=0.88p ps=4.88u w=2u l=1u
X1151 a_27650_28838# S3N a_25154_28838# VSS nfet_06v0 ad=3.74p pd=17.88u as=3.74p ps=17.88u w=8.5u l=1u
X1152 a_34366_58459# a_25326_58345# a_31470_61859# VSS nfet_06v0 ad=0.65p pd=3.02u as=1.1p ps=5.88u w=2.5u l=1u
X1153 a_61902_66969# a_61902_66969# a_64410_66969# VSS nfet_06v0 ad=2.2p pd=10.88u as=1.65p ps=5.66u w=5u l=1u
X1154 a_87154_35696# a_69382_35580# VDD VDD pfet_06v0 ad=2.5p pd=10.5u as=4.4p ps=20.88u w=10u l=1u
X1155 a_51786_44569# a_48550_44453# VDD VDD pfet_06v0 ad=2.5p pd=10.5u as=4.4p ps=20.88u w=10u l=1u
X1156 VSS VDD VSS VSS nfet_06v0 ad=4.29p pd=20.38u as=0 ps=0 w=9.75u l=2u
X1157 a_27930_25612# a_28194_16810# VSS VSS nfet_06v0 ad=0.825p pd=3.16u as=1.1p ps=5.88u w=2.5u l=1u
X1158 a_25366_61813# a_25666_61813# a_27290_58389# VSS nfet_06v0 ad=0.44p pd=2.88u as=0.25p ps=1.5u w=1u l=1u
X1159 a_64754_35696# a_46982_35580# VDD VDD pfet_06v0 ad=2.5p pd=10.5u as=4.4p ps=20.88u w=10u l=1u
X1160 a_54654_44499# a_65974_41099# cap_mim_2f0_m4m5_noshield c_width=20u c_length=10u
X1161 a_2254_58345# a_2594_61813# a_2494_61929# VDD pfet_06v0 ad=4.4p pd=20.88u as=2.5p ps=10.5u w=10u l=1u
X1162 a_9514_61859# a_10182_58459# VSS VSS nfet_06v0 ad=0.65p pd=3.02u as=1.1p ps=5.88u w=2.5u l=1u
X1163 VSS a_2986_58345# a_6926_58389# VSS nfet_06v0 ad=2.2p pd=10.88u as=1.25p ps=5.5u w=5u l=1u
X1164 a_28322_49653# a_25666_53077# VSS VSS nfet_06v0 ad=0.25p pd=1.5u as=0.44p ps=2.88u w=1u l=1u
X1165 a_2254_28794# a_2594_35580# a_18142_35696# VDD pfet_06v0 ad=4.4p pd=20.88u as=2.5p ps=10.5u w=10u l=1u
X1166 VDD a_33702_45499# a_31030_41099# VDD pfet_06v0 ad=2.2p pd=10.88u as=1.3p ps=5.52u w=5u l=1u
X1167 a_41226_49609# a_25326_49609# a_41426_49653# VSS nfet_06v0 ad=1.65p pd=5.66u as=1.25p ps=5.5u w=5u l=1u
X1168 a_25568_21766# a_40986_22216# VSS ppolyf_u_1k r_width=1u r_length=76.45u
X1169 a_6654_53193# a_2294_53077# VDD VDD pfet_06v0 ad=2.5p pd=10.5u as=4.4p ps=20.88u w=10u l=1u
X1170 a_40542_11728# a_24694_11612# VDD VDD pfet_06v0 ad=2.5p pd=10.5u as=4.4p ps=20.88u w=10u l=1u
X1171 VSS a_11294_58459# a_19718_58459# VSS nfet_06v0 ad=1.3p pd=5.52u as=1.3p ps=5.52u w=5u l=1u
X1172 a_4718_25602# S2P a_2794_23712# VDD pfet_06v0 ad=0.242p pd=1.98u as=0.242p ps=1.98u w=0.55u l=1u
X1173 a_31470_44499# a_33254_41099# VSS VSS nfet_06v0 ad=0.65p pd=3.02u as=0.65p ps=3.02u w=2.5u l=1u
X1174 VSS VDD VSS VSS nfet_06v0 ad=4.29p pd=20.38u as=0 ps=0 w=9.75u l=2u
X1175 a_26678_44569# a_25366_44453# VDD VDD pfet_06v0 ad=2.5p pd=10.5u as=4.4p ps=20.88u w=10u l=1u
X1176 YP YN VSS VSS nfet_05v0 ad=0.5808p pd=3.52u as=0.5808p ps=3.52u w=1.32u l=0.6u
X1177 a_49406_37586# a_30830_66967# cap_mim_2f0_m4m5_noshield c_width=25u c_length=8u
X1178 a_55770_44499# a_56438_41099# VSS VSS nfet_06v0 ad=0.65p pd=3.02u as=0.65p ps=3.02u w=2.5u l=1u
X1179 VSS VDD VSS VSS nfet_06v0 ad=4.29p pd=20.38u as=0 ps=0 w=9.75u l=2u
X1180 VDD a_42790_58459# a_86922_59788# VDD pfet_06v0 ad=1.32p pd=6.88u as=0.75p ps=3.5u w=3u l=1u
X1181 VDD X X VDD pfet_06v0 ad=0.52p pd=2.52u as=0.52p ps=2.52u w=2u l=1u
X1182 a_27290_49653# a_25666_53077# VSS VSS nfet_06v0 ad=0.25p pd=1.5u as=0.44p ps=2.88u w=1u l=1u
X1183 a_30830_40983# a_25568_9332# VDD VDD pfet_06v0 ad=0.44p pd=2.88u as=0.44p ps=2.88u w=1u l=1u
X1184 VSS a_56438_41099# a_54654_44499# VSS nfet_06v0 ad=0.65p pd=3.02u as=0.65p ps=3.02u w=2.5u l=1u
X1185 a_47482_11728# a_47282_11612# a_48294_11728# VDD pfet_06v0 ad=4.4p pd=20.88u as=2.5p ps=10.5u w=10u l=1u
X1186 VSS VDD VSS VSS nfet_06v0 ad=4.29p pd=20.38u as=0 ps=0 w=9.75u l=2u
X1187 a_7758_40983# a_3168_9332# VDD VDD pfet_06v0 ad=0.44p pd=2.88u as=0.44p ps=2.88u w=1u l=1u
X1188 VSS VDD VSS VSS nfet_06v0 ad=0.44p pd=2.88u as=0 ps=0 w=1u l=2u
X1189 VSS a_33254_58459# a_32586_61859# VSS nfet_06v0 ad=1.1p pd=5.88u as=0.65p ps=3.02u w=2.5u l=1u
X1190 a_71806_37586# a_8870_66967# cap_mim_2f0_m4m5_noshield c_width=25u c_length=8u
X1191 a_32142_58459# a_8870_58343# a_29666_58389# VSS nfet_06v0 ad=1.3p pd=5.52u as=2.2p ps=10.88u w=5u l=1u
X1192 a_31470_53123# a_25326_49609# a_34366_49723# VSS nfet_06v0 ad=1.1p pd=5.88u as=0.65p ps=3.02u w=2.5u l=1u
X1193 VDD VSS VDD VDD pfet_06v0 ad=4.29p pd=20.38u as=0 ps=0 w=9.75u l=2u
X1194 a_71806_25602# S1P a_69882_23712# VDD pfet_06v0 ad=0.242p pd=1.98u as=0.242p ps=1.98u w=0.55u l=1u
X1195 a_72054_59824# a_72142_59708# Z VSS nfet_06v0 ad=1.0912p pd=5.84u as=0.6448p ps=3u w=2.48u l=1u
X1196 a_42790_67083# a_31030_67083# cap_mim_2f0_m4m5_noshield c_width=20u c_length=10u
X1197 a_7286_53193# a_2594_53077# a_6954_53193# VDD pfet_06v0 ad=2.5p pd=10.5u as=3.3p ps=10.66u w=10u l=1u
X1198 VSS a_10182_58459# a_8398_61859# VSS nfet_06v0 ad=0.65p pd=3.02u as=0.65p ps=3.02u w=2.5u l=1u
X1199 VSS a_10182_49723# a_9514_53123# VSS nfet_06v0 ad=0.65p pd=3.02u as=0.65p ps=3.02u w=2.5u l=1u
X1200 a_42790_41099# a_34366_41099# VSS VSS nfet_06v0 ad=1.3p pd=5.52u as=2.2p ps=10.88u w=5u l=1u
X1201 a_32142_58459# a_25666_61813# a_33702_62859# VDD pfet_06v0 ad=2.2p pd=10.88u as=1.3p ps=5.52u w=5u l=1u
X1202 VDD VSS VDD VDD pfet_06v0 ad=7.92p pd=36.88u as=0 ps=0 w=18u l=2u
X1203 a_76410_59754# Z VSS VSS nfet_06v0 ad=0.5p pd=2.5u as=0.88p ps=4.88u w=2u l=1u
X1204 a_26918_4870# S3P a_25154_4870# VSS nfet_06v0 ad=3.3p pd=15.88u as=3.3p ps=15.88u w=7.5u l=1u
X1205 a_17030_23712# a_2294_23596# VDD VDD pfet_06v0 ad=2.5p pd=10.5u as=4.4p ps=20.88u w=10u l=1u
X1206 VDD VSS VDD VDD pfet_06v0 ad=4.29p pd=20.38u as=0 ps=0 w=9.75u l=2u
X1207 a_77530_4826# a_69642_4826# a_77730_4870# VSS nfet_06v0 ad=1.65p pd=5.66u as=1.25p ps=5.5u w=5u l=1u
X1208 a_31470_44499# a_42790_41099# cap_mim_2f0_m4m5_noshield c_width=20u c_length=10u
X1209 a_33254_41099# a_25326_40985# a_32586_44499# VSS nfet_06v0 ad=0.65p pd=3.02u as=1.1p ps=5.88u w=2.5u l=1u
X1210 a_31030_41099# a_33702_45499# VDD VDD pfet_06v0 ad=1.3p pd=5.52u as=2.2p ps=10.88u w=5u l=1u
X1211 a_58002_71483# a_48850_70437# a_54214_67083# VDD pfet_06v0 ad=1.3p pd=5.52u as=2.2p ps=10.88u w=5u l=1u
X1212 VDD a_48550_44453# a_53542_44569# VDD pfet_06v0 ad=4.4p pd=20.88u as=2.5p ps=10.5u w=10u l=1u
X1213 a_46982_11612# a_47282_11612# a_64754_11728# VDD pfet_06v0 ad=4.4p pd=20.88u as=2.5p ps=10.5u w=10u l=1u
X1214 a_47856_9332# a_52622_4826# a_52090_4870# VSS nfet_06v0 ad=0.88p pd=4.88u as=0.88p ps=4.88u w=2u l=1u
X1215 a_72618_25612# S1N a_69882_23712# VDD pfet_06v0 ad=0.22p pd=1.88u as=0.22p ps=1.88u w=0.5u l=1u
X1216 a_69682_11612# a_69682_11612# VDD VDD pfet_06v0 ad=0.88p pd=4.88u as=0.88p ps=4.88u w=2u l=1u
X1217 a_50218_25612# S4N a_47482_23712# VDD pfet_06v0 ad=0.22p pd=1.88u as=0.22p ps=1.88u w=0.5u l=1u
X1218 a_29998_41029# a_25326_40985# a_29666_41029# VSS nfet_06v0 ad=1.25p pd=5.5u as=1.65p ps=5.66u w=5u l=1u
X1219 a_2254_49609# a_2594_53077# a_2494_53193# VDD pfet_06v0 ad=4.4p pd=20.88u as=2.5p ps=10.5u w=10u l=1u
X1220 a_2494_23712# a_2294_23596# VDD VDD pfet_06v0 ad=2.5p pd=10.5u as=4.4p ps=20.88u w=10u l=1u
X1221 a_14502_4870# a_2594_11612# VSS VSS nfet_06v0 ad=0.25p pd=1.5u as=0.44p ps=2.88u w=1u l=1u
X1222 a_7958_49723# a_2594_53077# a_11746_54123# VDD pfet_06v0 ad=2.2p pd=10.88u as=1.3p ps=5.52u w=5u l=1u
X1223 a_34818_62859# a_38718_58345# a_34366_58459# VSS nfet_06v0 ad=1.1p pd=5.88u as=1.1p ps=5.88u w=2.5u l=1u
X1224 a_33702_45499# a_25666_44453# a_32142_41099# VDD pfet_06v0 ad=1.3p pd=5.52u as=2.2p ps=10.88u w=5u l=1u
X1225 a_30830_40983# a_25568_9332# VDD VDD pfet_06v0 ad=0.44p pd=2.88u as=0.44p ps=2.88u w=1u l=1u
X1226 a_6954_61929# a_7758_58343# a_8398_61859# VDD pfet_06v0 ad=4.4p pd=20.88u as=2.6p ps=10.52u w=10u l=1u
X1227 XP XN VSS VSS nfet_05v0 ad=0.5808p pd=3.52u as=0.5808p ps=3.52u w=1.32u l=0.6u
X1228 Z Z VDD VDD pfet_06v0 ad=0.52p pd=2.52u as=0.52p ps=2.52u w=2u l=1u
X1229 a_33426_23596# a_24994_23596# a_33626_23712# VDD pfet_06v0 ad=3.3p pd=10.66u as=2.5p ps=10.5u w=10u l=1u
X1230 a_2294_44453# a_2594_44453# a_5530_44569# VDD pfet_06v0 ad=4.4p pd=20.88u as=2.5p ps=10.5u w=10u l=1u
X1231 a_7758_40983# a_3168_9332# VDD VDD pfet_06v0 ad=0.44p pd=2.88u as=0.44p ps=2.88u w=1u l=1u
X1232 a_32586_61859# a_33254_58459# VSS VSS nfet_06v0 ad=0.65p pd=3.02u as=1.1p ps=5.88u w=2.5u l=1u
X1233 a_11026_23596# a_2594_23596# a_11226_23712# VDD pfet_06v0 ad=3.3p pd=10.66u as=2.5p ps=10.5u w=10u l=1u
X1234 a_47856_33300# a_63274_33300# VSS ppolyf_u_1k r_width=1u r_length=76.45u
X1235 a_8398_70483# a_10182_67083# VSS VSS nfet_06v0 ad=0.65p pd=3.02u as=0.65p ps=3.02u w=2.5u l=1u
X1236 a_46942_16810# a_47282_23596# a_62830_23712# VDD pfet_06v0 ad=4.4p pd=20.88u as=2.5p ps=10.5u w=10u l=1u
X1237 a_3606_11728# a_2294_11612# VDD VDD pfet_06v0 ad=2.5p pd=10.5u as=4.4p ps=20.88u w=10u l=1u
X1238 VDD a_56886_71483# a_55326_67083# VDD pfet_06v0 ad=1.3p pd=5.52u as=1.3p ps=5.52u w=5u l=1u
X1239 a_49242_66969# a_48510_66969# a_49442_67013# VSS nfet_06v0 ad=2.2p pd=10.88u as=1.25p ps=5.5u w=5u l=1u
X1240 a_29666_67013# a_25326_66969# a_29366_67013# VSS nfet_06v0 ad=1.65p pd=5.66u as=1.25p ps=5.5u w=5u l=1u
X1241 VDD VSS VDD VDD pfet_06v0 ad=0.44p pd=2.88u as=0 ps=0 w=1u l=2u
X1242 a_73166_42464# a_72104_41140# VSS VSS nfet_06v0 ad=0.5456p pd=3.36u as=0.5456p ps=3.36u w=1.24u l=1u
X1243 a_25154_4870# a_24954_4826# a_25886_4870# VSS nfet_06v0 ad=2.2p pd=10.88u as=1.25p ps=5.5u w=5u l=1u
X1244 a_5794_28794# a_2554_28794# a_5530_37596# VSS nfet_06v0 ad=1.1p pd=5.88u as=0.825p ps=3.16u w=2.5u l=1u
X1245 VSS a_65974_41099# a_85566_41016# VSS nfet_06v0 ad=0.44p pd=2.88u as=0.25p ps=1.5u w=1u l=1u
X1246 a_2254_66969# a_2254_66969# VSS VSS nfet_06v0 ad=0.44p pd=2.88u as=0.44p ps=2.88u w=1u l=1u
X1247 a_31030_41099# a_30830_40983# a_29666_41029# VSS nfet_06v0 ad=1.3p pd=5.52u as=2.2p ps=10.88u w=5u l=1u
X1248 a_54214_49723# a_12006_16854# a_52850_49653# VSS nfet_06v0 ad=1.3p pd=5.52u as=2.2p ps=10.88u w=5u l=1u
X1249 VDD VSS VDD VDD pfet_06v0 ad=4.29p pd=20.38u as=0 ps=0 w=9.75u l=2u
X1250 a_9070_67083# a_10630_71483# VDD VDD pfet_06v0 ad=1.3p pd=5.52u as=2.2p ps=10.88u w=5u l=1u
X1251 a_3486_4870# a_2254_4826# VSS VSS nfet_06v0 ad=1.25p pd=5.5u as=2.2p ps=10.88u w=5u l=1u
X1252 a_9070_49723# a_10630_54123# VDD VDD pfet_06v0 ad=1.3p pd=5.52u as=1.3p ps=5.52u w=5u l=1u
X1253 a_47182_35696# a_46982_35580# VDD VDD pfet_06v0 ad=2.5p pd=10.5u as=4.4p ps=20.88u w=10u l=1u
X1254 a_30358_70553# a_25666_70437# a_30026_70553# VDD pfet_06v0 ad=2.5p pd=10.5u as=3.3p ps=10.66u w=10u l=1u
X1255 a_77530_16810# a_69642_16810# a_77730_16854# VSS nfet_06v0 ad=1.65p pd=5.66u as=1.25p ps=5.5u w=5u l=1u
X1256 a_55130_16810# a_47242_16810# a_55330_16854# VSS nfet_06v0 ad=1.65p pd=5.66u as=1.25p ps=5.5u w=5u l=1u
X1257 a_20066_11728# a_2294_11612# VDD VDD pfet_06v0 ad=2.5p pd=10.5u as=4.4p ps=20.88u w=10u l=1u
X1258 a_2254_4826# a_2554_4826# a_13470_4870# VSS nfet_06v0 ad=2.2p pd=10.88u as=1.25p ps=5.5u w=5u l=1u
X1259 a_76686_4870# a_69342_4826# VSS VSS nfet_06v0 ad=1.25p pd=5.5u as=2.2p ps=10.88u w=5u l=1u
X1260 VDD VSS VDD VDD pfet_06v0 ad=7.92p pd=36.88u as=0 ps=0 w=18u l=2u
X1261 a_72882_28794# a_69642_28794# a_72618_37596# VSS nfet_06v0 ad=1.1p pd=5.88u as=0.825p ps=3.16u w=2.5u l=1u
X1262 VDD VSS VDD VDD pfet_06v0 ad=7.92p pd=36.88u as=0 ps=0 w=18u l=2u
X1263 a_25154_28838# a_24954_28794# a_25886_28838# VSS nfet_06v0 ad=2.2p pd=10.88u as=1.25p ps=5.5u w=5u l=1u
X1264 a_49206_16854# S4P a_47442_16854# VSS nfet_06v0 ad=3.3p pd=15.88u as=3.3p ps=15.88u w=7.5u l=1u
X1265 VSS a_65974_67083# a_73246_67000# VSS nfet_06v0 ad=0.44p pd=2.88u as=0.25p ps=1.5u w=1u l=1u
X1266 a_65974_58459# a_58002_62859# VDD VDD pfet_06v0 ad=2.6p pd=10.52u as=4.4p ps=20.88u w=10u l=1u
X1267 VSS VDD VSS VSS nfet_06v0 ad=7.92p pd=36.88u as=0 ps=0 w=18u l=2u
X1268 VSS a_33254_49723# a_32586_53123# VSS nfet_06v0 ad=0.65p pd=3.02u as=0.65p ps=3.02u w=2.5u l=1u
X1269 a_9390_12812# a_9390_12812# a_11026_11612# VDD pfet_06v0 ad=4.4p pd=20.88u as=3.3p ps=10.66u w=10u l=1u
X1270 a_31998_4870# a_24654_4826# VSS VSS nfet_06v0 ad=1.25p pd=5.5u as=2.2p ps=10.88u w=5u l=1u
X1271 a_73166_59824# a_73254_59708# Z VSS nfet_06v0 ad=1.0912p pd=5.84u as=0.6448p ps=3u w=2.48u l=1u
X1272 a_19718_67083# a_11746_71483# VDD VDD pfet_06v0 ad=2.6p pd=10.52u as=4.4p ps=20.88u w=10u l=1u
X1273 a_49442_58389# a_49242_58345# VSS VSS nfet_06v0 ad=1.25p pd=5.5u as=2.2p ps=10.88u w=5u l=1u
X1274 a_42466_35696# a_24694_35580# VDD VDD pfet_06v0 ad=2.5p pd=10.5u as=4.4p ps=20.88u w=10u l=1u
X1275 VDD a_42790_58459# a_87474_58332# VDD pfet_06v0 ad=1.32p pd=6.88u as=0.99p ps=3.66u w=3u l=1u
X1276 a_29366_58389# a_26058_58345# VSS VSS nfet_06v0 ad=1.25p pd=5.5u as=2.2p ps=10.88u w=5u l=1u
X1277 a_30830_66967# a_47856_33300# VDD VDD pfet_06v0 ad=0.44p pd=2.88u as=0.44p ps=2.88u w=1u l=1u
X1278 a_53182_67013# a_48510_66969# a_52850_67013# VSS nfet_06v0 ad=1.25p pd=5.5u as=1.65p ps=5.66u w=5u l=1u
X1279 a_30026_53193# a_12006_16854# a_31470_53123# VDD pfet_06v0 ad=4.4p pd=20.88u as=2.6p ps=10.52u w=10u l=1u
X1280 a_80558_28838# a_69342_28794# VSS VSS nfet_06v0 ad=1.25p pd=5.5u as=2.2p ps=10.88u w=5u l=1u
X1281 a_7758_40983# a_7402_4870# VSS VSS nfet_06v0 ad=0.44p pd=2.88u as=0.44p ps=2.88u w=1u l=1u
X1282 VDD VSS VDD VDD pfet_06v0 ad=0.44p pd=2.88u as=0 ps=0 w=1u l=2u
X1283 a_75112_58616# VDD Z VSS nfet_06v0 ad=1.0912p pd=5.84u as=0.6448p ps=3u w=2.48u l=1u
X1284 a_18142_23712# a_2294_23596# VDD VDD pfet_06v0 ad=2.5p pd=10.5u as=4.4p ps=20.88u w=10u l=1u
X1285 a_30830_66967# a_49206_28838# cap_mim_2f0_m4m5_noshield c_width=25u c_length=8u
X1286 a_8870_49607# a_25568_21316# VDD VDD pfet_06v0 ad=0.44p pd=2.88u as=0.44p ps=2.88u w=1u l=1u
X1287 a_34366_41099# a_25326_40985# a_31470_44499# VSS nfet_06v0 ad=0.65p pd=3.02u as=1.1p ps=5.88u w=2.5u l=1u
X1288 a_12006_16854# a_3168_21316# VDD VDD pfet_06v0 ad=0.44p pd=2.88u as=0.44p ps=2.88u w=1u l=1u
X1289 VSS a_26058_40985# a_29998_41029# VSS nfet_06v0 ad=2.2p pd=10.88u as=1.25p ps=5.5u w=5u l=1u
X1290 a_57550_67083# a_62366_71437# a_58002_71483# VDD pfet_06v0 ad=2.2p pd=10.88u as=2.2p ps=10.88u w=5u l=1u
X1291 a_26918_16854# a_28742_23712# VDD VDD pfet_06v0 ad=2.2p pd=10.88u as=2.2p ps=10.88u w=5u l=1u
X1292 a_27930_37596# a_28194_28794# VSS VSS nfet_06v0 ad=0.825p pd=3.16u as=1.1p ps=5.88u w=2.5u l=1u
X1293 a_59190_16854# a_47282_23596# VSS VSS nfet_06v0 ad=0.25p pd=1.5u as=0.44p ps=2.88u w=1u l=1u
X1294 a_9514_44499# a_10182_41099# VSS VSS nfet_06v0 ad=0.65p pd=3.02u as=1.1p ps=5.88u w=2.5u l=1u
X1295 VDD VSS VDD VDD pfet_06v0 ad=4.29p pd=20.38u as=0 ps=0 w=9.75u l=2u
X1296 VDD a_83814_58376# a_84634_58332# VDD pfet_06v0 ad=1.32p pd=6.88u as=0.99p ps=3.66u w=3u l=1u
X1297 a_2794_35696# a_2594_35580# a_2494_35696# VDD pfet_06v0 ad=4.4p pd=20.88u as=2.5p ps=10.5u w=10u l=1u
X1298 a_58002_45499# a_48850_44453# a_54214_41099# VDD pfet_06v0 ad=1.3p pd=5.52u as=2.2p ps=10.88u w=5u l=1u
X1299 VSS a_10182_58459# a_8398_61859# VSS nfet_06v0 ad=1.1p pd=5.88u as=0.65p ps=3.02u w=2.5u l=1u
X1300 a_32586_70483# a_8870_66967# a_30026_70553# VDD pfet_06v0 ad=2.6p pd=10.52u as=4.4p ps=20.88u w=10u l=1u
X1301 a_55326_58459# a_56886_62859# VDD VDD pfet_06v0 ad=1.3p pd=5.52u as=1.3p ps=5.52u w=5u l=1u
X1302 a_63566_67013# a_49242_66969# VSS VSS nfet_06v0 ad=1.25p pd=5.5u as=2.2p ps=10.88u w=5u l=1u
X1303 a_3186_67013# a_2986_66969# VSS VSS nfet_06v0 ad=1.25p pd=5.5u as=2.2p ps=10.88u w=5u l=1u
X1304 VSS a_11294_41099# a_19718_41099# VSS nfet_06v0 ad=1.3p pd=5.52u as=1.3p ps=5.52u w=5u l=1u
X1305 a_52622_4826# a_52622_4826# a_55130_4826# VSS nfet_06v0 ad=2.2p pd=10.88u as=1.65p ps=5.66u w=5u l=1u
X1306 a_5530_37596# S3N a_2794_35696# VDD pfet_06v0 ad=0.22p pd=1.88u as=0.22p ps=1.88u w=0.5u l=1u
X1307 a_2594_70437# a_2594_70437# a_5250_67013# VSS nfet_06v0 ad=0.44p pd=2.88u as=0.25p ps=1.5u w=1u l=1u
X1308 a_47856_10682# a_63274_10232# VSS ppolyf_u_1k r_width=1u r_length=76.45u
X1309 a_65974_58459# a_57550_58459# VSS VSS nfet_06v0 ad=2.2p pd=10.88u as=1.3p ps=5.52u w=5u l=1u
X1310 VDD a_10630_62859# a_9070_58459# VDD pfet_06v0 ad=1.3p pd=5.52u as=1.3p ps=5.52u w=5u l=1u
X1311 a_70694_23712# a_69382_23596# VDD VDD pfet_06v0 ad=2.5p pd=10.5u as=4.4p ps=20.88u w=10u l=1u
X1312 a_56886_71483# a_48850_70437# a_55326_67083# VDD pfet_06v0 ad=1.3p pd=5.52u as=2.2p ps=10.88u w=5u l=1u
X1313 VSS VDD VSS VSS nfet_06v0 ad=4.29p pd=20.38u as=0 ps=0 w=9.75u l=2u
X1314 a_52090_28838# a_54078_36780# a_47856_33300# VDD pfet_06v0 ad=1.76p pd=8.88u as=1.76p ps=8.88u w=4u l=1u
X1315 a_50482_16810# a_47242_16810# a_50218_25612# VSS nfet_06v0 ad=1.1p pd=5.88u as=0.825p ps=3.16u w=2.5u l=1u
X1316 VSS a_33254_41099# a_32586_44499# VSS nfet_06v0 ad=1.1p pd=5.88u as=0.65p ps=3.02u w=2.5u l=1u
X1317 ZN a_75388_62164# VSS VSS nfet_05v0 ad=0.5808p pd=3.52u as=0.5808p ps=3.52u w=1.32u l=0.6u
X1318 a_27118_37586# S3P a_25194_35696# VDD pfet_06v0 ad=0.242p pd=1.98u as=0.242p ps=1.98u w=0.55u l=1u
X1319 a_32142_41099# a_8870_40983# a_29666_41029# VSS nfet_06v0 ad=1.3p pd=5.52u as=2.2p ps=10.88u w=5u l=1u
X1320 a_69642_4826# a_69642_4826# VSS VSS nfet_06v0 ad=0.44p pd=2.88u as=0.44p ps=2.88u w=1u l=1u
X1321 a_55326_49723# a_7758_49607# a_52850_49653# VSS nfet_06v0 ad=1.3p pd=5.52u as=2.2p ps=10.88u w=5u l=1u
X1322 a_28322_41029# a_25666_44453# VSS VSS nfet_06v0 ad=0.25p pd=1.5u as=0.44p ps=2.88u w=1u l=1u
X1323 VDD a_56886_45499# a_55326_41099# VDD pfet_06v0 ad=1.3p pd=5.52u as=1.3p ps=5.52u w=5u l=1u
X1324 a_49938_16854# S4N a_47442_16854# VSS nfet_06v0 ad=3.74p pd=17.88u as=3.74p ps=17.88u w=8.5u l=1u
X1325 a_8870_49607# a_25568_21316# VDD VDD pfet_06v0 ad=0.44p pd=2.88u as=0.44p ps=2.88u w=1u l=1u
X1326 VDD VSS VDD VDD pfet_06v0 ad=0.44p pd=2.88u as=0 ps=0 w=1u l=2u
X1327 a_72054_42464# a_72142_42348# X VSS nfet_06v0 ad=1.0912p pd=5.84u as=0.6448p ps=3u w=2.48u l=1u
X1328 a_24694_11612# a_24994_11612# a_42466_11728# VDD pfet_06v0 ad=4.4p pd=20.88u as=2.5p ps=10.5u w=10u l=1u
X1329 a_12006_16854# a_3168_21316# VDD VDD pfet_06v0 ad=0.44p pd=2.88u as=0.44p ps=2.88u w=1u l=1u
X1330 VSS a_10182_41099# a_8398_44499# VSS nfet_06v0 ad=0.65p pd=3.02u as=0.65p ps=3.02u w=2.5u l=1u
X1331 a_24694_23596# a_24994_23596# a_36902_16854# VSS nfet_06v0 ad=0.44p pd=2.88u as=0.25p ps=1.5u w=1u l=1u
X1332 a_41226_40985# a_25326_40985# a_41426_41029# VSS nfet_06v0 ad=1.65p pd=5.66u as=1.25p ps=5.5u w=5u l=1u
X1333 a_2294_11612# a_2594_11612# a_20066_11728# VDD pfet_06v0 ad=4.4p pd=20.88u as=2.5p ps=10.5u w=10u l=1u
X1334 a_24954_4826# a_24954_4826# VSS VSS nfet_06v0 ad=0.44p pd=2.88u as=0.44p ps=2.88u w=1u l=1u
X1335 a_9514_61859# a_2254_58345# a_10182_58459# VSS nfet_06v0 ad=1.1p pd=5.88u as=0.65p ps=3.02u w=2.5u l=1u
X1336 a_41018_61929# a_40818_61813# VDD VDD pfet_06v0 ad=2.5p pd=10.5u as=4.4p ps=20.88u w=10u l=1u
X1337 a_15646_58345# a_2594_61813# a_19390_61929# VDD pfet_06v0 ad=4.4p pd=20.88u as=2.5p ps=10.5u w=10u l=1u
X1338 a_76410_42394# X VSS VSS nfet_06v0 ad=0.5p pd=2.5u as=0.88p ps=4.88u w=2u l=1u
X1339 a_9070_41099# a_10630_45499# VDD VDD pfet_06v0 ad=1.3p pd=5.52u as=2.2p ps=10.88u w=5u l=1u
X1340 a_7402_4870# a_2554_4826# a_4718_13618# VSS nfet_06v0 ad=1.1p pd=5.88u as=0.825p ps=3.16u w=2.5u l=1u
X1341 a_15646_66969# a_15646_66969# a_18154_66969# VSS nfet_06v0 ad=2.2p pd=10.88u as=1.65p ps=5.66u w=5u l=1u
X1342 a_7958_58459# a_10630_62859# VDD VDD pfet_06v0 ad=1.3p pd=5.52u as=2.2p ps=10.88u w=5u l=1u
X1343 VDD a_11746_62859# a_19718_58459# VDD pfet_06v0 ad=2.6p pd=10.52u as=2.6p ps=10.52u w=10u l=1u
X1344 VSS VDD VSS VSS nfet_06v0 ad=7.92p pd=36.88u as=0 ps=0 w=18u l=2u
X1345 a_30358_44569# a_25666_44453# a_30026_44569# VDD pfet_06v0 ad=2.5p pd=10.5u as=3.3p ps=10.66u w=10u l=1u
X1346 a_42790_67083# a_34818_71483# VDD VDD pfet_06v0 ad=2.6p pd=10.52u as=4.4p ps=20.88u w=10u l=1u
X1347 a_11294_67083# a_2254_66969# a_8398_70483# VSS nfet_06v0 ad=0.65p pd=3.02u as=1.1p ps=5.88u w=2.5u l=1u
X1348 a_69682_23596# a_69682_23596# a_82622_16854# VSS nfet_06v0 ad=0.44p pd=2.88u as=0.25p ps=1.5u w=1u l=1u
X1349 a_48750_70553# a_48550_70437# VDD VDD pfet_06v0 ad=2.5p pd=10.5u as=4.4p ps=20.88u w=10u l=1u
X1350 a_27290_41029# a_25666_44453# VSS VSS nfet_06v0 ad=0.25p pd=1.5u as=0.44p ps=2.88u w=1u l=1u
X1351 a_47282_23596# a_47282_23596# a_60222_16854# VSS nfet_06v0 ad=0.44p pd=2.88u as=0.25p ps=1.5u w=1u l=1u
X1352 a_33702_54123# a_38718_49609# a_33254_49723# VSS nfet_06v0 ad=1.1p pd=5.88u as=1.1p ps=5.88u w=2.5u l=1u
X1353 a_54214_58459# a_56886_62859# VDD VDD pfet_06v0 ad=1.3p pd=5.52u as=2.2p ps=10.88u w=5u l=1u
X1354 a_49938_4870# S1N a_47442_4870# VSS nfet_06v0 ad=3.74p pd=17.88u as=3.74p ps=17.88u w=8.5u l=1u
X1355 a_48850_70437# a_48850_70437# a_51506_67013# VSS nfet_06v0 ad=0.44p pd=2.88u as=0.25p ps=1.5u w=1u l=1u
X1356 a_25568_33300# a_40986_33300# VSS ppolyf_u_1k r_width=1u r_length=76.45u
X1357 a_5250_58389# a_2594_61813# VSS VSS nfet_06v0 ad=0.25p pd=1.5u as=0.44p ps=2.88u w=1u l=1u
X1358 a_24654_16810# a_24994_23596# a_40542_23712# VDD pfet_06v0 ad=4.4p pd=20.88u as=2.5p ps=10.5u w=10u l=1u
X1359 a_77154_51200# a_72104_49876# VSS VSS nfet_06v0 ad=0.5456p pd=3.36u as=0.5456p ps=3.36u w=1.24u l=1u
X1360 a_31030_67083# a_25666_70437# a_34818_71483# VDD pfet_06v0 ad=2.2p pd=10.88u as=1.3p ps=5.52u w=5u l=1u
X1361 a_53210_53193# a_7758_49607# a_55770_53123# VDD pfet_06v0 ad=4.4p pd=20.88u as=2.6p ps=10.52u w=10u l=1u
X1362 a_39182_62813# a_25326_58345# a_40382_58389# VSS nfet_06v0 ad=2.2p pd=10.88u as=1.25p ps=5.5u w=5u l=1u
X1363 a_10630_62859# a_2594_61813# a_9070_58459# VDD pfet_06v0 ad=1.3p pd=5.52u as=2.2p ps=10.88u w=5u l=1u
X1364 a_79086_51084# a_84634_58332# VDD VDD pfet_06v0 ad=1.32p pd=6.88u as=1.32p ps=6.88u w=3u l=1u
X1365 a_69382_23596# a_69682_23596# a_81590_16854# VSS nfet_06v0 ad=0.44p pd=2.88u as=0.25p ps=1.5u w=1u l=1u
X1366 a_7758_49607# a_74490_4870# VSS VSS nfet_06v0 ad=0.44p pd=2.88u as=0.44p ps=2.88u w=1u l=1u
X1367 a_32586_44499# a_33254_41099# VSS VSS nfet_06v0 ad=0.65p pd=3.02u as=1.1p ps=5.88u w=2.5u l=1u
X1368 a_19718_41099# a_11746_45499# VDD VDD pfet_06v0 ad=2.6p pd=10.52u as=4.4p ps=20.88u w=10u l=1u
X1369 a_75112_49992# VDD Y VSS nfet_06v0 ad=1.0912p pd=5.84u as=0.6448p ps=3u w=2.48u l=1u
X1370 a_25194_35696# a_24994_35580# a_26006_35696# VDD pfet_06v0 ad=4.4p pd=20.88u as=2.5p ps=10.5u w=10u l=1u
X1371 a_65646_70553# a_48550_70437# VDD VDD pfet_06v0 ad=2.5p pd=10.5u as=4.4p ps=20.88u w=10u l=1u
X1372 a_30334_16810# a_24994_23596# a_35070_23712# VDD pfet_06v0 ad=4.4p pd=20.88u as=2.5p ps=10.5u w=10u l=1u
X1373 a_26258_67013# a_26058_66969# VSS VSS nfet_06v0 ad=1.25p pd=5.5u as=2.2p ps=10.88u w=5u l=1u
X1374 a_29726_61929# a_25366_61813# VDD VDD pfet_06v0 ad=2.5p pd=10.5u as=4.4p ps=20.88u w=10u l=1u
X1375 a_24894_35696# a_24694_35580# VDD VDD pfet_06v0 ad=2.5p pd=10.5u as=4.4p ps=20.88u w=10u l=1u
X1376 a_52850_67013# a_7758_66967# a_55326_67083# VSS nfet_06v0 ad=2.2p pd=10.88u as=1.3p ps=5.52u w=5u l=1u
X1377 a_75010_59824# Z Z VSS nfet_06v0 ad=0.88p pd=4.88u as=0.52p ps=2.52u w=2u l=1u
X1378 a_48550_70437# a_48850_70437# a_50474_67013# VSS nfet_06v0 ad=0.44p pd=2.88u as=0.25p ps=1.5u w=1u l=1u
X1379 VSS VDD VSS VSS nfet_06v0 ad=4.29p pd=20.38u as=0 ps=0 w=9.75u l=2u
X1380 VSS a_56438_67083# a_54654_70483# VSS nfet_06v0 ad=1.1p pd=5.88u as=0.65p ps=3.02u w=2.5u l=1u
X1381 a_83814_49640# a_19718_49723# VDD VDD pfet_06v0 ad=1.32p pd=6.88u as=1.32p ps=6.88u w=3u l=1u
X1382 a_73254_59708# a_65974_49723# VSS VSS nfet_06v0 ad=0.33p pd=1.66u as=0.44p ps=2.88u w=1u l=1u
X1383 VSS VDD VSS VSS nfet_06v0 ad=4.29p pd=20.38u as=0 ps=0 w=9.75u l=2u
X1384 a_32842_16810# a_24954_16810# a_33042_16854# VSS nfet_06v0 ad=1.65p pd=5.66u as=1.25p ps=5.5u w=5u l=1u
X1385 VDD a_10630_54123# a_7958_49723# VDD pfet_06v0 ad=2.2p pd=10.88u as=1.3p ps=5.52u w=5u l=1u
X1386 VDD VSS VDD VDD pfet_06v0 ad=7.92p pd=36.88u as=0 ps=0 w=18u l=2u
X1387 VDD VSS VDD VDD pfet_06v0 ad=0.44p pd=2.88u as=0 ps=0 w=1u l=2u
X1388 a_32142_67083# a_33702_71483# VDD VDD pfet_06v0 ad=1.3p pd=5.52u as=1.3p ps=5.52u w=5u l=1u
X1389 a_57550_41099# a_62366_45453# a_58002_45499# VDD pfet_06v0 ad=2.2p pd=10.88u as=2.2p ps=10.88u w=5u l=1u
X1390 a_78314_23712# a_78114_23596# VDD VDD pfet_06v0 ad=2.5p pd=10.5u as=4.4p ps=20.88u w=10u l=1u
X1391 a_35070_11728# a_24694_11612# VDD VDD pfet_06v0 ad=2.5p pd=10.5u as=4.4p ps=20.88u w=10u l=1u
X1392 VDD a_56886_71483# a_54214_67083# VDD pfet_06v0 ad=1.3p pd=5.52u as=1.3p ps=5.52u w=5u l=1u
X1393 a_6926_49653# a_2254_49609# a_6594_49653# VSS nfet_06v0 ad=1.25p pd=5.5u as=1.65p ps=5.66u w=5u l=1u
X1394 VDD a_56886_54123# a_54214_49723# VDD pfet_06v0 ad=2.2p pd=10.88u as=1.3p ps=5.52u w=5u l=1u
X1395 a_12670_11728# a_2294_11612# VDD VDD pfet_06v0 ad=2.5p pd=10.5u as=4.4p ps=20.88u w=10u l=1u
X1396 a_40382_49653# a_26058_49609# VSS VSS nfet_06v0 ad=1.25p pd=5.5u as=2.2p ps=10.88u w=5u l=1u
X1397 a_47856_10682# a_8870_40983# VSS ppolyf_u_1k r_width=1u r_length=76.45u
X1398 a_47142_4870# a_46942_4826# VSS VSS nfet_06v0 ad=1.25p pd=5.5u as=2.2p ps=10.88u w=5u l=1u
X1399 VDD VSS VDD VDD pfet_06v0 ad=4.29p pd=20.38u as=0 ps=0 w=9.75u l=2u
X1400 a_69642_16810# a_69682_23596# a_84118_23712# VDD pfet_06v0 ad=4.4p pd=20.88u as=2.5p ps=10.5u w=10u l=1u
X1401 a_29666_49653# a_12006_16854# a_31030_49723# VSS nfet_06v0 ad=2.2p pd=10.88u as=1.3p ps=5.52u w=5u l=1u
X1402 a_51506_58389# a_48850_61813# VSS VSS nfet_06v0 ad=0.25p pd=1.5u as=0.44p ps=2.88u w=1u l=1u
X1403 a_77530_28794# a_69642_28794# a_77730_28838# VSS nfet_06v0 ad=1.65p pd=5.66u as=1.25p ps=5.5u w=5u l=1u
X1404 a_25366_70437# a_25666_70437# a_28602_70553# VDD pfet_06v0 ad=4.4p pd=20.88u as=2.5p ps=10.5u w=10u l=1u
X1405 a_12006_16854# a_4518_16854# cap_mim_2f0_m4m5_noshield c_width=25u c_length=8u
X1406 a_37934_16854# a_24994_23596# VSS VSS nfet_06v0 ad=0.25p pd=1.5u as=0.44p ps=2.88u w=1u l=1u
X1407 a_41018_53193# a_40818_53077# VDD VDD pfet_06v0 ad=2.5p pd=10.5u as=4.4p ps=20.88u w=10u l=1u
X1408 a_9070_67083# a_2594_70437# a_10630_71483# VDD pfet_06v0 ad=2.2p pd=10.88u as=1.3p ps=5.52u w=5u l=1u
X1409 a_55130_28794# a_47242_28794# a_55330_28838# VSS nfet_06v0 ad=1.65p pd=5.66u as=1.25p ps=5.5u w=5u l=1u
X1410 VDD a_58002_54123# a_65974_49723# VDD pfet_06v0 ad=2.6p pd=10.52u as=2.6p ps=10.52u w=10u l=1u
X1411 a_72338_4870# S1N a_69842_4870# VSS nfet_06v0 ad=3.74p pd=17.88u as=3.74p ps=17.88u w=8.5u l=1u
X1412 a_34818_54123# a_25666_53077# a_31030_49723# VDD pfet_06v0 ad=1.3p pd=5.52u as=2.2p ps=10.88u w=5u l=1u
X1413 a_15646_49609# a_2594_53077# a_19390_53193# VDD pfet_06v0 ad=4.4p pd=20.88u as=2.5p ps=10.5u w=10u l=1u
X1414 a_32586_44499# a_8870_40983# a_30026_44569# VDD pfet_06v0 ad=2.6p pd=10.52u as=4.4p ps=20.88u w=10u l=1u
X1415 a_65974_49723# a_57550_49723# VSS VSS nfet_06v0 ad=1.3p pd=5.52u as=2.2p ps=10.88u w=5u l=1u
X1416 a_15534_16854# a_2594_23596# VSS VSS nfet_06v0 ad=0.25p pd=1.5u as=0.44p ps=2.88u w=1u l=1u
X1417 a_69882_35696# a_69682_35580# a_70694_35696# VDD pfet_06v0 ad=4.4p pd=20.88u as=2.5p ps=10.5u w=10u l=1u
X1418 VDD VSS VDD VDD pfet_06v0 ad=7.92p pd=36.88u as=0 ps=0 w=18u l=2u
X1419 a_7958_67083# a_7758_66967# a_6594_67013# VSS nfet_06v0 ad=1.3p pd=5.52u as=2.2p ps=10.88u w=5u l=1u
X1420 VDD VSS VDD VDD pfet_06v0 ad=7.92p pd=36.88u as=0 ps=0 w=18u l=2u
X1421 VDD VSS VDD VDD pfet_06v0 ad=7.92p pd=36.88u as=0 ps=0 w=18u l=2u
X1422 a_49206_28838# S4P a_47442_28838# VSS nfet_06v0 ad=3.3p pd=15.88u as=3.3p ps=15.88u w=7.5u l=1u
X1423 a_56438_49723# a_48510_49609# a_55770_53123# VSS nfet_06v0 ad=0.65p pd=3.02u as=1.1p ps=5.88u w=2.5u l=1u
X1424 VSS VDD VSS VSS nfet_06v0 ad=7.92p pd=36.88u as=0 ps=0 w=18u l=2u
X1425 YN a_75388_53540# VSS VSS nfet_05v0 ad=0.5808p pd=3.52u as=0.5808p ps=3.52u w=1.32u l=0.6u
X1426 a_84118_11728# a_69382_11612# VDD VDD pfet_06v0 ad=2.5p pd=10.5u as=4.4p ps=20.88u w=10u l=1u
X1427 a_73166_42464# a_73254_42348# X VSS nfet_06v0 ad=1.0912p pd=5.84u as=0.6448p ps=3u w=2.48u l=1u
X1428 a_75010_51200# Y a_76410_51130# VSS nfet_06v0 ad=0.88p pd=4.88u as=0.5p ps=2.5u w=2u l=1u
X1429 a_48510_58345# a_48510_58345# VSS VSS nfet_06v0 ad=0.44p pd=2.88u as=0.44p ps=2.88u w=1u l=1u
X1430 a_61718_11728# a_46982_11612# VDD VDD pfet_06v0 ad=2.5p pd=10.5u as=4.4p ps=20.88u w=10u l=1u
X1431 VSS a_33254_49723# a_31470_53123# VSS nfet_06v0 ad=0.65p pd=3.02u as=0.65p ps=3.02u w=2.5u l=1u
X1432 a_50474_58389# a_48850_61813# VSS VSS nfet_06v0 ad=0.25p pd=1.5u as=0.44p ps=2.88u w=1u l=1u
X1433 a_56886_45499# a_48850_44453# a_55326_41099# VDD pfet_06v0 ad=1.3p pd=5.52u as=2.2p ps=10.88u w=5u l=1u
X1434 VDD a_34818_62859# a_42790_58459# VDD pfet_06v0 ad=2.6p pd=10.52u as=2.6p ps=10.52u w=10u l=1u
X1435 a_8398_61859# a_2254_58345# a_11294_58459# VSS nfet_06v0 ad=1.1p pd=5.88u as=0.65p ps=3.02u w=2.5u l=1u
X1436 a_2794_23712# a_2594_23596# a_3606_23712# VDD pfet_06v0 ad=4.4p pd=20.88u as=2.5p ps=10.5u w=10u l=1u
X1437 VDD VSS VDD VDD pfet_06v0 ad=0.44p pd=2.88u as=0 ps=0 w=1u l=2u
X1438 a_47282_11612# a_47282_11612# VDD VDD pfet_06v0 ad=0.88p pd=4.88u as=0.88p ps=4.88u w=2u l=1u
X1439 a_3606_70553# a_2294_70437# VDD VDD pfet_06v0 ad=2.5p pd=10.5u as=4.4p ps=20.88u w=10u l=1u
X1440 a_25326_58345# a_25666_61813# a_25566_61929# VDD pfet_06v0 ad=4.4p pd=20.88u as=2.5p ps=10.5u w=10u l=1u
X1441 a_69842_16854# a_69642_16810# a_69542_16854# VSS nfet_06v0 ad=2.2p pd=10.88u as=1.25p ps=5.5u w=5u l=1u
X1442 a_9390_24796# a_2554_16810# a_9598_16854# VSS nfet_06v0 ad=2.2p pd=10.88u as=1.25p ps=5.5u w=5u l=1u
X1443 VSS VDD VSS VSS nfet_06v0 ad=0.44p pd=2.88u as=0 ps=0 w=1u l=2u
X1444 a_75112_41256# VDD X VSS nfet_06v0 ad=1.0912p pd=5.84u as=0.6448p ps=3u w=2.48u l=1u
X1445 a_47442_16854# a_47242_16810# a_47142_16854# VSS nfet_06v0 ad=2.2p pd=10.88u as=1.25p ps=5.5u w=5u l=1u
X1446 a_28194_4826# a_31790_12812# a_28742_11728# VDD pfet_06v0 ad=1.76p pd=8.88u as=1.76p ps=8.88u w=4u l=1u
X1447 a_5250_16854# S2N a_2754_16854# VSS nfet_06v0 ad=3.74p pd=17.88u as=3.74p ps=17.88u w=8.5u l=1u
X1448 VDD VSS VDD VDD pfet_06v0 ad=7.92p pd=36.88u as=0 ps=0 w=18u l=2u
X1449 VSS a_19718_67083# a_71494_67000# VSS nfet_06v0 ad=0.44p pd=2.88u as=0.44p ps=2.88u w=1u l=1u
X1450 a_75388_44804# X VDD VDD pfet_05v0 ad=0.8052p pd=4.54u as=0.8052p ps=4.54u w=1.83u l=0.5u
X1451 a_54654_53123# a_56438_49723# VSS VSS nfet_06v0 ad=0.65p pd=3.02u as=1.1p ps=5.88u w=2.5u l=1u
X1452 a_9514_53123# a_8870_49607# a_6954_53193# VDD pfet_06v0 ad=2.6p pd=10.52u as=4.4p ps=20.88u w=10u l=1u
X1453 VDD a_33702_54123# a_32142_49723# VDD pfet_06v0 ad=1.3p pd=5.52u as=1.3p ps=5.52u w=5u l=1u
X1454 a_49862_70553# a_48550_70437# VDD VDD pfet_06v0 ad=2.5p pd=10.5u as=4.4p ps=20.88u w=10u l=1u
X1455 VDD VSS VDD VDD pfet_06v0 ad=7.92p pd=36.88u as=0 ps=0 w=18u l=2u
X1456 a_25194_11728# a_24994_11612# a_24894_11728# VDD pfet_06v0 ad=4.4p pd=20.88u as=2.5p ps=10.5u w=10u l=1u
X1457 a_4718_13618# a_5794_4826# VSS VSS nfet_06v0 ad=0.825p pd=3.16u as=1.1p ps=5.88u w=2.5u l=1u
X1458 a_29726_53193# a_25366_53077# VDD VDD pfet_06v0 ad=2.5p pd=10.5u as=4.4p ps=20.88u w=10u l=1u
X1459 a_59190_28838# a_47282_35580# VSS VSS nfet_06v0 ad=0.25p pd=1.5u as=0.44p ps=2.88u w=1u l=1u
X1460 VDD a_56886_54123# a_55326_49723# VDD pfet_06v0 ad=2.2p pd=10.88u as=1.3p ps=5.52u w=5u l=1u
X1461 a_76478_24796# a_69642_16810# a_76686_16854# VSS nfet_06v0 ad=2.2p pd=10.88u as=1.25p ps=5.5u w=5u l=1u
X1462 a_11746_71483# a_15646_66969# a_11294_67083# VSS nfet_06v0 ad=1.1p pd=5.88u as=1.1p ps=5.88u w=2.5u l=1u
X1463 a_27930_13628# S3N a_25194_11728# VDD pfet_06v0 ad=0.22p pd=1.88u as=0.22p ps=1.88u w=0.5u l=1u
X1464 a_25568_10682# a_40986_10232# VSS ppolyf_u_1k r_width=1u r_length=76.45u
X1465 a_42790_41099# a_34818_45499# VDD VDD pfet_06v0 ad=2.6p pd=10.52u as=4.4p ps=20.88u w=10u l=1u
X1466 VSS a_10182_41099# a_8398_44499# VSS nfet_06v0 ad=1.1p pd=5.88u as=0.65p ps=3.02u w=2.5u l=1u
X1467 a_48750_44569# a_48550_44453# VDD VDD pfet_06v0 ad=2.5p pd=10.5u as=4.4p ps=20.88u w=10u l=1u
X1468 a_54078_24796# a_47242_16810# a_54286_16854# VSS nfet_06v0 ad=2.2p pd=10.88u as=1.25p ps=5.5u w=5u l=1u
X1469 a_3168_9782# a_18586_10232# VSS ppolyf_u_1k r_width=1u r_length=76.45u
X1470 a_58002_71483# a_61902_66969# a_57550_67083# VSS nfet_06v0 ad=1.1p pd=5.88u as=1.1p ps=5.88u w=2.5u l=1u
X1471 VSS VDD VSS VSS nfet_06v0 ad=7.92p pd=36.88u as=0 ps=0 w=18u l=2u
X1472 a_52850_49653# a_48510_49609# a_52550_49653# VSS nfet_06v0 ad=1.65p pd=5.66u as=1.25p ps=5.5u w=5u l=1u
X1473 VDD VSS VDD VDD pfet_06v0 ad=4.29p pd=20.38u as=0 ps=0 w=9.75u l=2u
X1474 a_31030_41099# a_25666_44453# a_34818_45499# VDD pfet_06v0 ad=2.2p pd=10.88u as=1.3p ps=5.52u w=5u l=1u
X1475 VSS VDD VSS VSS nfet_06v0 ad=0.44p pd=2.88u as=0 ps=0 w=1u l=2u
X1476 VSS VDD VSS VSS nfet_06v0 ad=7.92p pd=36.88u as=0 ps=0 w=18u l=2u
X1477 a_55770_70483# a_48510_66969# a_56438_67083# VSS nfet_06v0 ad=1.1p pd=5.88u as=0.65p ps=3.02u w=2.5u l=1u
X1478 VDD a_33702_62859# a_32142_58459# VDD pfet_06v0 ad=2.2p pd=10.88u as=1.3p ps=5.52u w=5u l=1u
X1479 a_2594_23596# a_2594_23596# VDD VDD pfet_06v0 ad=0.88p pd=4.88u as=0.88p ps=4.88u w=2u l=1u
X1480 a_65974_41099# a_57550_41099# VSS VSS nfet_06v0 ad=2.2p pd=10.88u as=1.3p ps=5.52u w=5u l=1u
X1481 a_47856_22666# a_63274_22216# VSS ppolyf_u_1k r_width=1u r_length=76.45u
X1482 XP XN VDD VDD pfet_05v0 ad=0.8052p pd=4.54u as=0.8052p ps=4.54u w=1.83u l=0.5u
X1483 a_17310_67013# a_2986_66969# VSS VSS nfet_06v0 ad=1.25p pd=5.5u as=2.2p ps=10.88u w=5u l=1u
X1484 a_4718_25602# a_12006_16854# cap_mim_2f0_m4m5_noshield c_width=25u c_length=8u
X1485 a_6342_35696# a_2594_35580# a_5250_28838# VDD pfet_06v0 ad=4.4p pd=20.88u as=4.4p ps=20.88u w=10u l=1u
X1486 a_6294_67013# a_2986_66969# VSS VSS nfet_06v0 ad=1.25p pd=5.5u as=2.2p ps=10.88u w=5u l=1u
X1487 a_3168_9782# a_18586_9332# VSS ppolyf_u_1k r_width=1u r_length=76.45u
X1488 a_70256_9782# a_85674_10232# VSS ppolyf_u_1k r_width=1u r_length=76.45u
X1489 XN a_75388_44804# VSS VSS nfet_05v0 ad=0.5808p pd=3.52u as=0.5808p ps=3.52u w=1.32u l=0.6u
X1490 a_65646_44569# a_48550_44453# VDD VDD pfet_06v0 ad=2.5p pd=10.5u as=4.4p ps=20.88u w=10u l=1u
X1491 VDD VSS VDD VDD pfet_06v0 ad=7.92p pd=36.88u as=0 ps=0 w=18u l=2u
X1492 a_50482_28794# a_47242_28794# a_50218_37596# VSS nfet_06v0 ad=1.1p pd=5.88u as=0.825p ps=3.16u w=2.5u l=1u
X1493 a_71806_25602# a_72882_16810# VSS VSS nfet_06v0 ad=0.825p pd=3.16u as=1.1p ps=5.88u w=2.5u l=1u
X1494 a_25568_9332# a_30334_4826# a_29802_4870# VSS nfet_06v0 ad=0.88p pd=4.88u as=0.88p ps=4.88u w=2u l=1u
X1495 a_78114_35580# a_69682_35580# a_78314_35696# VDD pfet_06v0 ad=3.3p pd=10.66u as=2.5p ps=10.5u w=10u l=1u
X1496 a_49406_25602# a_50482_16810# VSS VSS nfet_06v0 ad=0.825p pd=3.16u as=1.1p ps=5.88u w=2.5u l=1u
X1497 a_49938_28838# S4N a_47442_28838# VSS nfet_06v0 ad=3.74p pd=17.88u as=3.74p ps=17.88u w=8.5u l=1u
X1498 a_55714_35580# a_47282_35580# a_55914_35696# VDD pfet_06v0 ad=3.3p pd=10.66u as=2.5p ps=10.5u w=10u l=1u
X1499 VSS a_49242_49609# a_53182_49653# VSS nfet_06v0 ad=2.2p pd=10.88u as=1.25p ps=5.5u w=5u l=1u
X1500 VSS VDD VSS VSS nfet_06v0 ad=7.92p pd=36.88u as=0 ps=0 w=18u l=2u
X1501 a_70256_21316# a_69682_23596# a_71606_16854# VDD pfet_06v0 ad=4.4p pd=20.88u as=4.4p ps=20.88u w=10u l=1u
X1502 a_24694_35580# a_24994_35580# a_36902_28838# VSS nfet_06v0 ad=0.44p pd=2.88u as=0.25p ps=1.5u w=1u l=1u
X1503 a_9514_44499# a_2254_40985# a_10182_41099# VSS nfet_06v0 ad=1.1p pd=5.88u as=0.65p ps=3.02u w=2.5u l=1u
X1504 a_29666_49653# a_8870_49607# a_32142_49723# VSS nfet_06v0 ad=2.2p pd=10.88u as=1.3p ps=5.52u w=5u l=1u
X1505 a_19718_49723# a_11746_54123# VDD VDD pfet_06v0 ad=4.4p pd=20.88u as=2.6p ps=10.52u w=10u l=1u
X1506 VDD a_10630_54123# a_7958_49723# VDD pfet_06v0 ad=1.3p pd=5.52u as=1.3p ps=5.52u w=5u l=1u
X1507 a_48550_61813# a_48850_61813# a_51786_61929# VDD pfet_06v0 ad=4.4p pd=20.88u as=2.5p ps=10.5u w=10u l=1u
X1508 a_73430_35696# a_69682_35580# a_72338_28838# VDD pfet_06v0 ad=4.4p pd=20.88u as=4.4p ps=20.88u w=10u l=1u
X1509 a_32142_41099# a_33702_45499# VDD VDD pfet_06v0 ad=1.3p pd=5.52u as=1.3p ps=5.52u w=5u l=1u
X1510 a_55326_49723# a_56886_54123# VDD VDD pfet_06v0 ad=1.3p pd=5.52u as=2.2p ps=10.88u w=5u l=1u
X1511 a_25326_49609# a_25666_53077# a_25566_53193# VDD pfet_06v0 ad=4.4p pd=20.88u as=2.5p ps=10.5u w=10u l=1u
X1512 VSS VDD VSS VSS nfet_06v0 ad=0.44p pd=2.88u as=0 ps=0 w=1u l=2u
X1513 a_31030_58459# a_33702_62859# VDD VDD pfet_06v0 ad=1.3p pd=5.52u as=1.3p ps=5.52u w=5u l=1u
X1514 a_42462_61929# a_25366_61813# VDD VDD pfet_06v0 ad=2.5p pd=10.5u as=4.4p ps=20.88u w=10u l=1u
X1515 a_29802_16854# a_31790_24796# a_25568_21316# VDD pfet_06v0 ad=1.76p pd=8.88u as=1.76p ps=8.88u w=4u l=1u
X1516 VDD a_56886_45499# a_54214_41099# VDD pfet_06v0 ad=1.3p pd=5.52u as=1.3p ps=5.52u w=5u l=1u
X1517 a_2294_53077# a_2594_53077# a_4218_49653# VSS nfet_06v0 ad=0.44p pd=2.88u as=0.25p ps=1.5u w=1u l=1u
X1518 a_58158_4870# a_46942_4826# VSS VSS nfet_06v0 ad=1.25p pd=5.5u as=2.2p ps=10.88u w=5u l=1u
X1519 a_64202_61929# a_64002_61813# VDD VDD pfet_06v0 ad=2.5p pd=10.5u as=4.4p ps=20.88u w=10u l=1u
X1520 a_7402_16854# a_9390_24796# a_3168_21316# VDD pfet_06v0 ad=1.76p pd=8.88u as=1.76p ps=8.88u w=4u l=1u
X1521 a_48174_16854# a_46942_16810# VSS VSS nfet_06v0 ad=1.25p pd=5.5u as=2.2p ps=10.88u w=5u l=1u
X1522 a_69682_35580# a_69682_35580# a_82622_28838# VSS nfet_06v0 ad=0.44p pd=2.88u as=0.25p ps=1.5u w=1u l=1u
X1523 a_26006_23712# a_24694_23596# VDD VDD pfet_06v0 ad=2.5p pd=10.5u as=4.4p ps=20.88u w=10u l=1u
X1524 a_9070_49723# a_8870_49607# a_6594_49653# VSS nfet_06v0 ad=1.3p pd=5.52u as=2.2p ps=10.88u w=5u l=1u
X1525 a_5250_4870# a_6342_11728# VDD VDD pfet_06v0 ad=2.2p pd=10.88u as=2.2p ps=10.88u w=5u l=1u
X1526 a_47282_35580# a_47282_35580# a_60222_28838# VSS nfet_06v0 ad=0.44p pd=2.88u as=0.25p ps=1.5u w=1u l=1u
X1527 a_25366_44453# a_25666_44453# a_28602_44569# VDD pfet_06v0 ad=4.4p pd=20.88u as=2.5p ps=10.5u w=10u l=1u
X1528 a_9070_41099# a_2594_44453# a_10630_45499# VDD pfet_06v0 ad=2.2p pd=10.88u as=1.3p ps=5.52u w=5u l=1u
X1529 a_74068_58616# a_72104_58500# a_73768_58616# VSS nfet_06v0 ad=0.175p pd=1.2u as=0.175p ps=1.2u w=0.7u l=1u
X1530 a_6954_70553# a_2594_70437# a_6654_70553# VDD pfet_06v0 ad=3.3p pd=10.66u as=2.5p ps=10.5u w=10u l=1u
X1531 a_57550_58459# a_48510_58345# a_54654_61859# VSS nfet_06v0 ad=0.65p pd=3.02u as=1.1p ps=5.88u w=2.5u l=1u
X1532 a_54654_61859# a_30830_58343# a_53210_61929# VDD pfet_06v0 ad=2.6p pd=10.52u as=4.4p ps=20.88u w=10u l=1u
X1533 a_26058_58345# a_25666_61813# a_26678_61929# VDD pfet_06v0 ad=4.4p pd=20.88u as=2.5p ps=10.5u w=10u l=1u
X1534 VSS VDD VSS VSS nfet_06v0 ad=4.29p pd=20.38u as=0 ps=0 w=9.75u l=2u
X1535 a_2986_49609# a_2254_49609# a_3186_49653# VSS nfet_06v0 ad=2.2p pd=10.88u as=1.25p ps=5.5u w=5u l=1u
X1536 a_29998_58389# a_25326_58345# a_29666_58389# VSS nfet_06v0 ad=1.25p pd=5.5u as=1.65p ps=5.66u w=5u l=1u
X1537 a_7758_40983# a_4518_4870# cap_mim_2f0_m4m5_noshield c_width=25u c_length=8u
X1538 a_69382_35580# a_69682_35580# a_81590_28838# VSS nfet_06v0 ad=0.44p pd=2.88u as=0.25p ps=1.5u w=1u l=1u
X1539 a_72104_58500# a_72104_58500# VDD VDD pfet_06v0 ad=0.88p pd=4.88u as=0.88p ps=4.88u w=2u l=1u
X1540 a_72338_4870# a_73430_11728# VDD VDD pfet_06v0 ad=2.2p pd=10.88u as=2.2p ps=10.88u w=5u l=1u
X1541 a_79758_11728# a_69382_11612# VDD VDD pfet_06v0 ad=2.5p pd=10.5u as=4.4p ps=20.88u w=10u l=1u
X1542 a_25326_66969# a_25326_66969# VSS VSS nfet_06v0 ad=0.44p pd=2.88u as=0.44p ps=2.88u w=1u l=1u
X1543 a_57358_11728# a_46982_11612# VDD VDD pfet_06v0 ad=2.5p pd=10.5u as=4.4p ps=20.88u w=10u l=1u
X1544 a_49938_4870# a_51030_11728# VDD VDD pfet_06v0 ad=2.2p pd=10.88u as=2.2p ps=10.88u w=5u l=1u
X1545 a_3168_21766# a_18586_21316# VSS ppolyf_u_1k r_width=1u r_length=76.45u
X1546 a_18154_49609# a_2254_49609# a_18354_49653# VSS nfet_06v0 ad=1.65p pd=5.66u as=1.25p ps=5.5u w=5u l=1u
X1547 a_75010_42464# X X VSS nfet_06v0 ad=0.88p pd=4.88u as=0.52p ps=2.52u w=2u l=1u
X1548 a_25568_10682# a_30830_40983# VSS ppolyf_u_1k r_width=1u r_length=76.45u
X1549 a_4518_28838# a_6342_35696# VDD VDD pfet_06v0 ad=2.2p pd=10.88u as=2.2p ps=10.88u w=5u l=1u
X1550 a_3606_44569# a_2294_44453# VDD VDD pfet_06v0 ad=2.5p pd=10.5u as=4.4p ps=20.88u w=10u l=1u
X1551 a_85230_23712# a_69382_23596# VDD VDD pfet_06v0 ad=2.5p pd=10.5u as=4.4p ps=20.88u w=10u l=1u
X1552 YN a_75388_53540# VDD VDD pfet_05v0 ad=0.8052p pd=4.54u as=0.8052p ps=4.54u w=1.83u l=0.5u
X1553 a_64410_49609# a_48510_49609# a_64610_49653# VSS nfet_06v0 ad=1.65p pd=5.66u as=1.25p ps=5.5u w=5u l=1u
X1554 a_33702_45499# a_38718_40985# a_33254_41099# VSS nfet_06v0 ad=1.1p pd=5.88u as=1.1p ps=5.88u w=2.5u l=1u
X1555 VDD a_2294_70437# a_7286_70553# VDD pfet_06v0 ad=4.4p pd=20.88u as=2.5p ps=10.5u w=10u l=1u
X1556 VSS a_19718_67083# a_76086_67000# VSS nfet_06v0 ad=0.44p pd=2.88u as=0.25p ps=1.5u w=1u l=1u
X1557 a_32842_28794# a_24954_28794# a_33042_28838# VSS nfet_06v0 ad=1.65p pd=5.66u as=1.25p ps=5.5u w=5u l=1u
X1558 a_49862_44569# a_48550_44453# VDD VDD pfet_06v0 ad=2.5p pd=10.5u as=4.4p ps=20.88u w=10u l=1u
X1559 a_40818_70437# a_25666_70437# a_41018_70553# VDD pfet_06v0 ad=3.3p pd=10.66u as=2.5p ps=10.5u w=10u l=1u
X1560 VDD VSS VDD VDD pfet_06v0 ad=7.92p pd=36.88u as=0 ps=0 w=18u l=2u
X1561 a_7758_49607# a_71606_4870# cap_mim_2f0_m4m5_noshield c_width=25u c_length=8u
X1562 VSS VDD VSS VSS nfet_06v0 ad=4.29p pd=20.38u as=0 ps=0 w=9.75u l=2u
X1563 VSS a_56438_49723# a_55770_53123# VSS nfet_06v0 ad=1.1p pd=5.88u as=0.65p ps=3.02u w=2.5u l=1u
X1564 a_77154_51200# a_77242_51084# Y VSS nfet_06v0 ad=1.0912p pd=5.84u as=0.6448p ps=3u w=2.48u l=1u
X1565 a_70256_21766# a_85674_21316# VSS ppolyf_u_1k r_width=1u r_length=76.45u
X1566 a_74490_16854# a_69642_16810# a_71806_25602# VSS nfet_06v0 ad=1.1p pd=5.88u as=0.825p ps=3.16u w=2.5u l=1u
X1567 a_30830_40983# a_29802_4870# VSS VSS nfet_06v0 ad=0.44p pd=2.88u as=0.44p ps=2.88u w=1u l=1u
X1568 a_47856_22666# a_7758_58343# VSS ppolyf_u_1k r_width=1u r_length=76.45u
X1569 VSS a_33254_58459# a_31470_61859# VSS nfet_06v0 ad=1.1p pd=5.88u as=0.65p ps=3.02u w=2.5u l=1u
X1570 a_71606_28838# a_73430_35696# VDD VDD pfet_06v0 ad=2.2p pd=10.88u as=2.2p ps=10.88u w=5u l=1u
X1571 a_80558_4870# a_69342_4826# VSS VSS nfet_06v0 ad=1.25p pd=5.5u as=2.2p ps=10.88u w=5u l=1u
X1572 a_54654_70483# a_48510_66969# a_57550_67083# VSS nfet_06v0 ad=1.1p pd=5.88u as=0.65p ps=3.02u w=2.5u l=1u
X1573 VSS a_65974_58459# a_85566_58376# VSS nfet_06v0 ad=0.44p pd=2.88u as=0.25p ps=1.5u w=1u l=1u
X1574 a_53210_70553# a_30830_66967# a_54654_70483# VDD pfet_06v0 ad=4.4p pd=20.88u as=2.6p ps=10.52u w=10u l=1u
X1575 a_49206_28838# a_51030_35696# VDD VDD pfet_06v0 ad=2.2p pd=10.88u as=2.2p ps=10.88u w=5u l=1u
X1576 a_2294_23596# a_2594_23596# a_14502_16854# VSS nfet_06v0 ad=0.44p pd=2.88u as=0.25p ps=1.5u w=1u l=1u
X1577 a_48550_53077# a_48850_53077# a_51786_53193# VDD pfet_06v0 ad=4.4p pd=20.88u as=2.5p ps=10.5u w=10u l=1u
X1578 a_37934_28838# a_24994_35580# VSS VSS nfet_06v0 ad=0.25p pd=1.5u as=0.44p ps=2.88u w=1u l=1u
X1579 a_8398_53123# a_7758_49607# a_6954_53193# VDD pfet_06v0 ad=2.6p pd=10.52u as=4.4p ps=20.88u w=10u l=1u
X1580 a_2754_16854# a_2554_16810# a_3486_16854# VSS nfet_06v0 ad=2.2p pd=10.88u as=1.25p ps=5.5u w=5u l=1u
X1581 a_54654_61859# a_56438_58459# VSS VSS nfet_06v0 ad=0.65p pd=3.02u as=0.65p ps=3.02u w=2.5u l=1u
X1582 a_24994_11612# a_24994_11612# VDD VDD pfet_06v0 ad=0.88p pd=4.88u as=0.88p ps=4.88u w=2u l=1u
X1583 a_49406_13618# S1P a_47482_11728# VDD pfet_06v0 ad=0.242p pd=1.98u as=0.242p ps=1.98u w=0.55u l=1u
X1584 a_72882_4826# a_76478_12812# a_73430_11728# VDD pfet_06v0 ad=1.76p pd=8.88u as=1.76p ps=8.88u w=4u l=1u
X1585 a_15534_28838# a_2594_35580# VSS VSS nfet_06v0 ad=0.25p pd=1.5u as=0.44p ps=2.88u w=1u l=1u
X1586 a_42462_53193# a_25366_53077# VDD VDD pfet_06v0 ad=2.5p pd=10.5u as=4.4p ps=20.88u w=10u l=1u
X1587 a_50482_4826# a_54078_12812# a_51030_11728# VDD pfet_06v0 ad=1.76p pd=8.88u as=1.76p ps=8.88u w=4u l=1u
X1588 a_64202_53193# a_64002_53077# VDD VDD pfet_06v0 ad=2.5p pd=10.5u as=4.4p ps=20.88u w=10u l=1u
X1589 a_27118_13618# a_28194_4826# VSS VSS nfet_06v0 ad=0.825p pd=3.16u as=1.1p ps=5.88u w=2.5u l=1u
X1590 VDD VSS VDD VDD pfet_06v0 ad=4.29p pd=20.38u as=0 ps=0 w=9.75u l=2u
X1591 a_19718_67083# a_11294_67083# VSS VSS nfet_06v0 ad=1.3p pd=5.52u as=2.2p ps=10.88u w=5u l=1u
X1592 a_49206_4870# S1P a_47442_4870# VSS nfet_06v0 ad=3.3p pd=15.88u as=3.3p ps=15.88u w=7.5u l=1u
X1593 a_82622_4870# a_69682_11612# VSS VSS nfet_06v0 ad=0.25p pd=1.5u as=0.44p ps=2.88u w=1u l=1u
X1594 a_77242_59708# a_65974_41099# VSS VSS nfet_06v0 ad=0.33p pd=1.66u as=0.44p ps=2.88u w=1u l=1u
X1595 a_42790_49723# a_34818_54123# VDD VDD pfet_06v0 ad=4.4p pd=20.88u as=2.6p ps=10.52u w=10u l=1u
X1596 VSS a_34366_49723# a_42790_49723# VSS nfet_06v0 ad=1.3p pd=5.52u as=1.3p ps=5.52u w=5u l=1u
X1597 a_24654_16810# a_24954_16810# a_35870_16854# VSS nfet_06v0 ad=2.2p pd=10.88u as=1.25p ps=5.5u w=5u l=1u
X1598 a_3168_9332# a_7934_4826# a_7402_4870# VSS nfet_06v0 ad=0.88p pd=4.88u as=0.88p ps=4.88u w=2u l=1u
X1599 a_6926_41029# a_2254_40985# a_6594_41029# VSS nfet_06v0 ad=1.25p pd=5.5u as=1.65p ps=5.66u w=5u l=1u
X1600 a_8398_44499# a_2254_40985# a_11294_41099# VSS nfet_06v0 ad=1.1p pd=5.88u as=0.65p ps=3.02u w=2.5u l=1u
X1601 a_32586_53123# a_25326_49609# a_33254_49723# VSS nfet_06v0 ad=1.1p pd=5.88u as=0.65p ps=3.02u w=2.5u l=1u
X1602 a_2254_16810# a_2554_16810# a_13470_16854# VSS nfet_06v0 ad=2.2p pd=10.88u as=1.25p ps=5.5u w=5u l=1u
X1603 a_40382_41029# a_26058_40985# VSS VSS nfet_06v0 ad=1.25p pd=5.5u as=2.2p ps=10.88u w=5u l=1u
X1604 a_69842_16854# a_69642_16810# a_70574_16854# VSS nfet_06v0 ad=2.2p pd=10.88u as=1.25p ps=5.5u w=5u l=1u
X1605 a_55130_4826# a_47242_4826# a_55330_4870# VSS nfet_06v0 ad=1.65p pd=5.66u as=1.25p ps=5.5u w=5u l=1u
X1606 a_69842_28838# a_69642_28794# a_69542_28838# VSS nfet_06v0 ad=2.2p pd=10.88u as=1.25p ps=5.5u w=5u l=1u
X1607 a_26058_49609# a_25666_53077# a_26678_53193# VDD pfet_06v0 ad=4.4p pd=20.88u as=2.5p ps=10.5u w=10u l=1u
X1608 VDD VSS VDD VDD pfet_06v0 ad=4.29p pd=20.38u as=0 ps=0 w=9.75u l=2u
X1609 a_9390_36780# a_2554_28794# a_9598_28838# VSS nfet_06v0 ad=2.2p pd=10.88u as=1.25p ps=5.5u w=5u l=1u
X1610 VSS a_10182_58459# a_9514_61859# VSS nfet_06v0 ad=1.1p pd=5.88u as=0.65p ps=3.02u w=2.5u l=1u
X1611 a_75022_4826# a_75022_4826# a_77530_4826# VSS nfet_06v0 ad=2.2p pd=10.88u as=1.65p ps=5.66u w=5u l=1u
X1612 a_47442_28838# a_47242_28794# a_47142_28838# VSS nfet_06v0 ad=2.2p pd=10.88u as=1.25p ps=5.5u w=5u l=1u
X1613 a_5250_28838# S3N a_2754_28838# VSS nfet_06v0 ad=3.74p pd=17.88u as=3.74p ps=17.88u w=8.5u l=1u
X1614 VDD VSS VDD VDD pfet_06v0 ad=7.92p pd=36.88u as=0 ps=0 w=18u l=2u
X1615 a_85566_49640# a_83814_49640# a_84634_49596# VSS nfet_06v0 ad=0.25p pd=1.5u as=0.44p ps=2.88u w=1u l=1u
X1616 a_31790_24796# a_24954_16810# a_31998_16854# VSS nfet_06v0 ad=2.2p pd=10.88u as=1.25p ps=5.5u w=5u l=1u
X1617 Z Z VDD VDD pfet_06v0 ad=0.52p pd=2.52u as=0.88p ps=4.88u w=2u l=1u
X1618 a_10442_4826# a_2554_4826# a_10642_4870# VSS nfet_06v0 ad=1.65p pd=5.66u as=1.25p ps=5.5u w=5u l=1u
X1619 a_39430_35696# a_24694_35580# VDD VDD pfet_06v0 ad=2.5p pd=10.5u as=4.4p ps=20.88u w=10u l=1u
X1620 a_10182_49723# a_2254_49609# a_9514_53123# VSS nfet_06v0 ad=0.65p pd=3.02u as=1.1p ps=5.88u w=2.5u l=1u
X1621 a_30334_4826# a_30334_4826# a_32842_4826# VSS nfet_06v0 ad=2.2p pd=10.88u as=1.65p ps=5.66u w=5u l=1u
X1622 a_7758_58343# a_47856_21316# VDD VDD pfet_06v0 ad=0.44p pd=2.88u as=0.44p ps=2.88u w=1u l=1u
X1623 a_30830_66967# a_47856_33300# VDD VDD pfet_06v0 ad=0.44p pd=2.88u as=0.44p ps=2.88u w=1u l=1u
X1624 a_52910_70553# a_48550_70437# VDD VDD pfet_06v0 ad=2.5p pd=10.5u as=4.4p ps=20.88u w=10u l=1u
X1625 a_7934_16810# a_2594_23596# a_12670_23712# VDD pfet_06v0 ad=4.4p pd=20.88u as=2.5p ps=10.5u w=10u l=1u
X1626 a_86922_42428# a_65974_41099# a_77242_59708# VDD pfet_06v0 ad=0.75p pd=3.5u as=1.32p ps=6.88u w=3u l=1u
X1627 a_31470_70483# a_30830_66967# a_30026_70553# VDD pfet_06v0 ad=2.6p pd=10.52u as=4.4p ps=20.88u w=10u l=1u
X1628 a_10630_71483# a_15646_66969# a_10182_67083# VSS nfet_06v0 ad=1.1p pd=5.88u as=1.1p ps=5.88u w=2.5u l=1u
X1629 a_74068_49992# a_72104_49876# a_73768_49992# VSS nfet_06v0 ad=0.175p pd=1.2u as=0.175p ps=1.2u w=0.7u l=1u
X1630 a_25666_70437# a_25666_70437# a_28322_67013# VSS nfet_06v0 ad=0.44p pd=2.88u as=0.25p ps=1.5u w=1u l=1u
X1631 a_55770_61859# a_56438_58459# VSS VSS nfet_06v0 ad=0.65p pd=3.02u as=1.1p ps=5.88u w=2.5u l=1u
X1632 VSS a_26058_58345# a_29998_58389# VSS nfet_06v0 ad=2.2p pd=10.88u as=1.25p ps=5.5u w=5u l=1u
X1633 a_76478_36780# a_69642_28794# a_76686_28838# VSS nfet_06v0 ad=2.2p pd=10.88u as=1.25p ps=5.5u w=5u l=1u
X1634 a_56886_71483# a_61902_66969# a_56438_67083# VSS nfet_06v0 ad=1.1p pd=5.88u as=1.1p ps=5.88u w=2.5u l=1u
X1635 a_27118_37586# a_7758_66967# cap_mim_2f0_m4m5_noshield c_width=25u c_length=8u
X1636 a_25568_22666# a_40986_22216# VSS ppolyf_u_1k r_width=1u r_length=76.45u
X1637 VDD VSS VDD VDD pfet_06v0 ad=7.92p pd=36.88u as=0 ps=0 w=18u l=2u
X1638 a_54078_36780# a_47242_28794# a_54286_28838# VSS nfet_06v0 ad=2.2p pd=10.88u as=1.25p ps=5.5u w=5u l=1u
X1639 a_28742_11728# a_24994_11612# a_27650_4870# VDD pfet_06v0 ad=4.4p pd=20.88u as=4.4p ps=20.88u w=10u l=1u
X1640 a_3168_21766# a_18586_22216# VSS ppolyf_u_1k r_width=1u r_length=76.45u
X1641 a_10442_16810# a_2554_16810# a_10642_16854# VSS nfet_06v0 ad=1.65p pd=5.66u as=1.25p ps=5.5u w=5u l=1u
X1642 VDD VSS VDD VDD pfet_06v0 ad=7.92p pd=36.88u as=0 ps=0 w=18u l=2u
X1643 a_69582_11728# a_69382_11612# VDD VDD pfet_06v0 ad=2.5p pd=10.5u as=4.4p ps=20.88u w=10u l=1u
X1644 VSS VDD VSS VSS nfet_06v0 ad=7.92p pd=36.88u as=0 ps=0 w=18u l=2u
X1645 a_47442_4870# a_47242_4826# a_48174_4870# VSS nfet_06v0 ad=2.2p pd=10.88u as=1.25p ps=5.5u w=5u l=1u
X1646 a_69382_11612# a_69682_11612# a_81590_4870# VSS nfet_06v0 ad=0.44p pd=2.88u as=0.25p ps=1.5u w=1u l=1u
X1647 a_7958_58459# a_2594_61813# a_11746_62859# VDD pfet_06v0 ad=2.2p pd=10.88u as=1.3p ps=5.52u w=5u l=1u
X1648 VSS VDD VSS VSS nfet_06v0 ad=7.92p pd=36.88u as=0 ps=0 w=18u l=2u
X1649 a_55914_23712# a_55714_23596# VDD VDD pfet_06v0 ad=2.5p pd=10.5u as=4.4p ps=20.88u w=10u l=1u
X1650 a_26918_16854# S4P a_25154_16854# VSS nfet_06v0 ad=3.3p pd=15.88u as=3.3p ps=15.88u w=7.5u l=1u
X1651 a_6954_44569# a_2594_44453# a_6654_44569# VDD pfet_06v0 ad=3.3p pd=10.66u as=2.5p ps=10.5u w=10u l=1u
X1652 VSS VDD VSS VSS nfet_06v0 ad=7.92p pd=36.88u as=0 ps=0 w=18u l=2u
X1653 Y Y VDD VDD pfet_06v0 ad=0.52p pd=2.52u as=0.52p ps=2.52u w=2u l=1u
X1654 a_8870_66967# a_71606_28838# cap_mim_2f0_m4m5_noshield c_width=25u c_length=8u
X1655 a_25366_70437# a_25666_70437# a_27290_67013# VSS nfet_06v0 ad=0.44p pd=2.88u as=0.25p ps=1.5u w=1u l=1u
X1656 a_69342_28794# a_69682_35580# a_85230_35696# VDD pfet_06v0 ad=4.4p pd=20.88u as=2.5p ps=10.5u w=10u l=1u
X1657 a_87474_49596# a_19718_49723# VDD VDD pfet_06v0 ad=0.99p pd=3.66u as=1.32p ps=6.88u w=3u l=1u
X1658 a_74602_68412# a_65974_67083# a_72142_59708# VDD pfet_06v0 ad=0.75p pd=3.5u as=1.32p ps=6.88u w=3u l=1u
X1659 a_47242_16810# a_47282_23596# a_61718_23712# VDD pfet_06v0 ad=4.4p pd=20.88u as=2.5p ps=10.5u w=10u l=1u
X1660 a_53542_70553# a_48850_70437# a_53210_70553# VDD pfet_06v0 ad=2.5p pd=10.5u as=3.3p ps=10.66u w=10u l=1u
X1661 a_65974_67083# a_58002_71483# VDD VDD pfet_06v0 ad=4.4p pd=20.88u as=2.6p ps=10.52u w=10u l=1u
X1662 VSS a_2986_66969# a_6926_67013# VSS nfet_06v0 ad=2.2p pd=10.88u as=1.25p ps=5.5u w=5u l=1u
X1663 a_70256_21766# a_85674_22216# VSS ppolyf_u_1k r_width=1u r_length=76.45u
X1664 VDD VSS VDD VDD pfet_06v0 ad=7.92p pd=36.88u as=0 ps=0 w=18u l=2u
X1665 a_71806_37586# a_72882_28794# VSS VSS nfet_06v0 ad=0.825p pd=3.16u as=1.1p ps=5.88u w=2.5u l=1u
X1666 a_25568_33300# a_24994_35580# a_26918_28838# VDD pfet_06v0 ad=4.4p pd=20.88u as=4.4p ps=20.88u w=10u l=1u
X1667 a_25886_16854# a_24654_16810# VSS VSS nfet_06v0 ad=1.25p pd=5.5u as=2.2p ps=10.88u w=5u l=1u
X1668 VDD a_33702_71483# a_31030_67083# VDD pfet_06v0 ad=1.3p pd=5.52u as=1.3p ps=5.52u w=5u l=1u
X1669 a_49406_37586# a_50482_28794# VSS VSS nfet_06v0 ad=0.825p pd=3.16u as=1.1p ps=5.88u w=2.5u l=1u
X1670 VDD a_33702_54123# a_31030_49723# VDD pfet_06v0 ad=2.2p pd=10.88u as=1.3p ps=5.52u w=5u l=1u
X1671 a_76478_24796# a_76478_24796# a_78114_23596# VDD pfet_06v0 ad=4.4p pd=20.88u as=3.3p ps=10.66u w=10u l=1u
X1672 Z a_79086_59708# a_72304_58616# VSS nfet_06v0 ad=0.6448p pd=3u as=1.0912p ps=5.84u w=2.48u l=1u
X1673 a_52850_41029# a_48510_40985# a_52550_41029# VSS nfet_06v0 ad=1.65p pd=5.66u as=1.25p ps=5.5u w=5u l=1u
X1674 VSS VDD VSS VSS nfet_06v0 ad=7.92p pd=36.88u as=0 ps=0 w=18u l=2u
X1675 a_54078_24796# a_54078_24796# a_55714_23596# VDD pfet_06v0 ad=4.4p pd=20.88u as=3.3p ps=10.66u w=10u l=1u
X1676 VSS a_56438_67083# a_55770_70483# VSS nfet_06v0 ad=0.65p pd=3.02u as=0.65p ps=3.02u w=2.5u l=1u
X1677 a_9070_58459# a_10630_62859# VDD VDD pfet_06v0 ad=1.3p pd=5.52u as=1.3p ps=5.52u w=5u l=1u
X1678 a_7758_49607# a_70256_9332# VDD VDD pfet_06v0 ad=0.44p pd=2.88u as=0.44p ps=2.88u w=1u l=1u
X1679 VDD a_2294_44453# a_7286_44569# VDD pfet_06v0 ad=4.4p pd=20.88u as=2.5p ps=10.5u w=10u l=1u
X1680 a_54286_4870# a_46942_4826# VSS VSS nfet_06v0 ad=1.25p pd=5.5u as=2.2p ps=10.88u w=5u l=1u
X1681 a_40818_44453# a_25666_44453# a_41018_44569# VDD pfet_06v0 ad=3.3p pd=10.66u as=2.5p ps=10.5u w=10u l=1u
X1682 a_28322_58389# a_25666_61813# VSS VSS nfet_06v0 ad=0.25p pd=1.5u as=0.44p ps=2.88u w=1u l=1u
X1683 a_5530_70553# a_2294_70437# VDD VDD pfet_06v0 ad=2.5p pd=10.5u as=4.4p ps=20.88u w=10u l=1u
X1684 VDD VSS VDD VDD pfet_06v0 ad=0.44p pd=2.88u as=0 ps=0 w=1u l=2u
X1685 VSS VDD VSS VSS nfet_06v0 ad=4.29p pd=20.38u as=0 ps=0 w=9.75u l=2u
X1686 a_24954_4826# a_24994_11612# a_39430_11728# VDD pfet_06v0 ad=4.4p pd=20.88u as=2.5p ps=10.5u w=10u l=1u
X1687 a_41226_58345# a_25326_58345# a_41426_58389# VSS nfet_06v0 ad=1.65p pd=5.66u as=1.25p ps=5.5u w=5u l=1u
X1688 a_2554_4826# a_2594_11612# a_17030_11728# VDD pfet_06v0 ad=4.4p pd=20.88u as=2.5p ps=10.5u w=10u l=1u
X1689 a_48174_28838# a_46942_28794# VSS VSS nfet_06v0 ad=1.25p pd=5.5u as=2.2p ps=10.88u w=5u l=1u
X1690 a_53210_44569# a_30830_40983# a_54654_44499# VDD pfet_06v0 ad=4.4p pd=20.88u as=2.6p ps=10.52u w=10u l=1u
X1691 a_56438_58459# a_62366_62813# a_56886_62859# VDD pfet_06v0 ad=2.2p pd=10.88u as=2.2p ps=10.88u w=5u l=1u
X1692 a_74068_41256# a_72104_41140# a_73768_41256# VSS nfet_06v0 ad=0.175p pd=1.2u as=0.175p ps=1.2u w=0.7u l=1u
X1693 VDD Z Z VDD pfet_06v0 ad=0.88p pd=4.88u as=0.52p ps=2.52u w=2u l=1u
X1694 a_27650_4870# a_28742_11728# VDD VDD pfet_06v0 ad=2.2p pd=10.88u as=2.2p ps=10.88u w=5u l=1u
X1695 a_57550_41099# a_48510_40985# a_54654_44499# VSS nfet_06v0 ad=0.65p pd=3.02u as=1.1p ps=5.88u w=2.5u l=1u
X1696 VDD Y Y VDD pfet_06v0 ad=0.52p pd=2.52u as=0.52p ps=2.52u w=2u l=1u
X1697 VSS a_49242_40985# a_53182_41029# VSS nfet_06v0 ad=2.2p pd=10.88u as=1.25p ps=5.5u w=5u l=1u
X1698 a_27290_58389# a_25666_61813# VSS VSS nfet_06v0 ad=0.25p pd=1.5u as=0.44p ps=2.88u w=1u l=1u
X1699 a_69542_4870# a_69342_4826# VSS VSS nfet_06v0 ad=1.25p pd=5.5u as=2.2p ps=10.88u w=5u l=1u
X1700 a_11294_67083# a_16110_71437# a_11746_71483# VDD pfet_06v0 ad=2.2p pd=10.88u as=2.2p ps=10.88u w=5u l=1u
X1701 a_2494_61929# a_2294_61813# VDD VDD pfet_06v0 ad=2.5p pd=10.5u as=4.4p ps=20.88u w=10u l=1u
X1702 a_47856_33750# a_63274_33300# VSS ppolyf_u_1k r_width=1u r_length=76.45u
X1703 a_31470_61859# a_25326_58345# a_34366_58459# VSS nfet_06v0 ad=1.1p pd=5.88u as=0.65p ps=3.02u w=2.5u l=1u
X1704 a_30026_61929# a_30830_58343# a_31470_61859# VDD pfet_06v0 ad=4.4p pd=20.88u as=2.6p ps=10.52u w=10u l=1u
X1705 a_24854_4870# a_24654_4826# VSS VSS nfet_06v0 ad=1.25p pd=5.5u as=2.2p ps=10.88u w=5u l=1u
X1706 a_2294_44453# a_2594_44453# a_4218_41029# VSS nfet_06v0 ad=0.44p pd=2.88u as=0.25p ps=1.5u w=1u l=1u
X1707 VDD a_10630_71483# a_9070_67083# VDD pfet_06v0 ad=2.2p pd=10.88u as=1.3p ps=5.52u w=5u l=1u
X1708 VSS VDD VSS VSS nfet_06v0 ad=0.44p pd=2.88u as=0 ps=0 w=1u l=2u
X1709 a_41426_49653# a_41226_49609# VSS VSS nfet_06v0 ad=1.25p pd=5.5u as=2.2p ps=10.88u w=5u l=1u
X1710 a_31030_49723# a_33702_54123# VDD VDD pfet_06v0 ad=1.3p pd=5.52u as=2.2p ps=10.88u w=5u l=1u
X1711 VSS a_10182_58459# a_9514_61859# VSS nfet_06v0 ad=0.65p pd=3.02u as=0.65p ps=3.02u w=2.5u l=1u
X1712 a_8398_44499# a_19718_41099# cap_mim_2f0_m4m5_noshield c_width=20u c_length=10u
X1713 a_55770_70483# a_7758_66967# a_53210_70553# VDD pfet_06v0 ad=2.6p pd=10.52u as=4.4p ps=20.88u w=10u l=1u
X1714 a_25568_22666# a_8870_49607# VSS ppolyf_u_1k r_width=1u r_length=76.45u
X1715 a_77242_42348# a_87474_40972# VDD VDD pfet_06v0 ad=1.32p pd=6.88u as=1.32p ps=6.88u w=3u l=1u
X1716 a_3168_21316# a_2594_23596# a_4518_16854# VDD pfet_06v0 ad=4.4p pd=20.88u as=4.4p ps=20.88u w=10u l=1u
X1717 a_48850_53077# a_48850_53077# VDD VDD pfet_06v0 ad=0.88p pd=4.88u as=0.88p ps=4.88u w=2u l=1u
X1718 a_7758_49607# a_70256_9332# VDD VDD pfet_06v0 ad=0.44p pd=2.88u as=0.44p ps=2.88u w=1u l=1u
X1719 a_74490_4870# a_76478_12812# a_70256_9332# VDD pfet_06v0 ad=1.76p pd=8.88u as=1.76p ps=8.88u w=4u l=1u
X1720 a_50482_4826# a_47242_4826# a_50218_13628# VSS nfet_06v0 ad=1.1p pd=5.88u as=0.825p ps=3.16u w=2.5u l=1u
X1721 a_34818_71483# a_38718_66969# a_34366_67083# VSS nfet_06v0 ad=1.1p pd=5.88u as=1.1p ps=5.88u w=2.5u l=1u
X1722 Z a_77242_59708# a_77154_59824# VSS nfet_06v0 ad=0.6448p pd=3u as=1.0912p ps=5.84u w=2.48u l=1u
X1723 a_8870_40983# a_47856_9332# VDD VDD pfet_06v0 ad=0.44p pd=2.88u as=0.44p ps=2.88u w=1u l=1u
X1724 a_2986_40985# a_2254_40985# a_3186_41029# VSS nfet_06v0 ad=2.2p pd=10.88u as=1.25p ps=5.5u w=5u l=1u
X1725 a_33702_54123# a_25666_53077# a_32142_49723# VDD pfet_06v0 ad=1.3p pd=5.52u as=2.2p ps=10.88u w=5u l=1u
X1726 a_48294_11728# a_46982_11612# VDD VDD pfet_06v0 ad=2.5p pd=10.5u as=4.4p ps=20.88u w=10u l=1u
X1727 VSS a_33254_41099# a_31470_44499# VSS nfet_06v0 ad=1.1p pd=5.88u as=0.65p ps=3.02u w=2.5u l=1u
X1728 a_52910_44569# a_48550_44453# VDD VDD pfet_06v0 ad=2.5p pd=10.5u as=4.4p ps=20.88u w=10u l=1u
X1729 a_31470_44499# a_30830_40983# a_30026_44569# VDD pfet_06v0 ad=2.6p pd=10.52u as=4.4p ps=20.88u w=10u l=1u
X1730 VDD a_25366_61813# a_30358_61929# VDD pfet_06v0 ad=4.4p pd=20.88u as=2.5p ps=10.5u w=10u l=1u
X1731 a_74490_28838# a_69642_28794# a_71806_37586# VSS nfet_06v0 ad=1.1p pd=5.88u as=0.825p ps=3.16u w=2.5u l=1u
X1732 a_69382_23596# a_69682_23596# a_87154_23712# VDD pfet_06v0 ad=4.4p pd=20.88u as=2.5p ps=10.5u w=10u l=1u
X1733 a_46942_16810# a_47242_16810# a_58158_16854# VSS nfet_06v0 ad=2.2p pd=10.88u as=1.25p ps=5.5u w=5u l=1u
X1734 VDD VSS VDD VDD pfet_06v0 ad=7.92p pd=36.88u as=0 ps=0 w=18u l=2u
X1735 a_18154_40985# a_2254_40985# a_18354_41029# VSS nfet_06v0 ad=1.65p pd=5.66u as=1.25p ps=5.5u w=5u l=1u
X1736 X X VDD VDD pfet_06v0 ad=0.52p pd=2.52u as=0.52p ps=2.52u w=2u l=1u
X1737 a_72142_42348# a_75154_66956# VDD VDD pfet_06v0 ad=1.32p pd=6.88u as=1.32p ps=6.88u w=3u l=1u
X1738 a_47856_21316# a_47282_23596# a_49206_16854# VDD pfet_06v0 ad=4.4p pd=20.88u as=4.4p ps=20.88u w=10u l=1u
X1739 a_2294_35580# a_2594_35580# a_14502_28838# VSS nfet_06v0 ad=0.44p pd=2.88u as=0.25p ps=1.5u w=1u l=1u
X1740 a_54654_44499# a_56438_41099# VSS VSS nfet_06v0 ad=0.65p pd=3.02u as=0.65p ps=3.02u w=2.5u l=1u
X1741 a_2754_28838# a_2554_28794# a_3486_28838# VSS nfet_06v0 ad=2.2p pd=10.88u as=1.25p ps=5.5u w=5u l=1u
X1742 a_51030_35696# a_47282_35580# a_49938_28838# VDD pfet_06v0 ad=4.4p pd=20.88u as=4.4p ps=20.88u w=10u l=1u
X1743 a_17946_61929# a_17746_61813# VDD VDD pfet_06v0 ad=2.5p pd=10.5u as=4.4p ps=20.88u w=10u l=1u
X1744 a_47242_4826# a_47242_4826# VSS VSS nfet_06v0 ad=0.44p pd=2.88u as=0.44p ps=2.88u w=1u l=1u
X1745 a_8398_53123# a_10182_49723# VSS VSS nfet_06v0 ad=0.65p pd=3.02u as=0.65p ps=3.02u w=2.5u l=1u
X1746 a_64410_40985# a_48510_40985# a_64610_41029# VSS nfet_06v0 ad=1.65p pd=5.66u as=1.25p ps=5.5u w=5u l=1u
X1747 a_54214_67083# a_56886_71483# VDD VDD pfet_06v0 ad=1.3p pd=5.52u as=1.3p ps=5.52u w=5u l=1u
X1748 VDD VSS VDD VDD pfet_06v0 ad=0.44p pd=2.88u as=0 ps=0 w=1u l=2u
X1749 a_8870_66967# a_70256_33300# VDD VDD pfet_06v0 ad=0.44p pd=2.88u as=0.44p ps=2.88u w=1u l=1u
X1750 a_48850_61813# a_48850_61813# VDD VDD pfet_06v0 ad=0.88p pd=4.88u as=0.88p ps=4.88u w=2u l=1u
X1751 a_2554_4826# a_2554_4826# VSS VSS nfet_06v0 ad=0.44p pd=2.88u as=0.44p ps=2.88u w=1u l=1u
X1752 a_56438_49723# a_62366_54077# a_56886_54123# VDD pfet_06v0 ad=2.2p pd=10.88u as=2.2p ps=10.88u w=5u l=1u
X1753 a_9514_70483# a_10182_67083# VSS VSS nfet_06v0 ad=0.65p pd=3.02u as=0.65p ps=3.02u w=2.5u l=1u
X1754 a_87154_11728# a_69382_11612# VDD VDD pfet_06v0 ad=2.5p pd=10.5u as=4.4p ps=20.88u w=10u l=1u
X1755 a_4518_4870# S2P a_2754_4870# VSS nfet_06v0 ad=3.3p pd=15.88u as=3.3p ps=15.88u w=7.5u l=1u
X1756 a_75022_16810# a_69682_23596# a_79758_23712# VDD pfet_06v0 ad=4.4p pd=20.88u as=2.5p ps=10.5u w=10u l=1u
X1757 VSS a_57550_67083# a_65974_67083# VSS nfet_06v0 ad=1.3p pd=5.52u as=1.3p ps=5.52u w=5u l=1u
X1758 a_64754_11728# a_46982_11612# VDD VDD pfet_06v0 ad=2.5p pd=10.5u as=4.4p ps=20.88u w=10u l=1u
X1759 a_53542_44569# a_48850_44453# a_53210_44569# VDD pfet_06v0 ad=2.5p pd=10.5u as=3.3p ps=10.66u w=10u l=1u
X1760 a_52622_16810# a_47282_23596# a_57358_23712# VDD pfet_06v0 ad=4.4p pd=20.88u as=2.5p ps=10.5u w=10u l=1u
X1761 a_24654_28794# a_24954_28794# a_35870_28838# VSS nfet_06v0 ad=2.2p pd=10.88u as=1.25p ps=5.5u w=5u l=1u
X1762 a_65974_41099# a_58002_45499# VDD VDD pfet_06v0 ad=4.4p pd=20.88u as=2.6p ps=10.52u w=10u l=1u
X1763 a_2254_28794# a_2554_28794# a_13470_28838# VSS nfet_06v0 ad=2.2p pd=10.88u as=1.25p ps=5.5u w=5u l=1u
X1764 a_69842_28838# a_69642_28794# a_70574_28838# VSS nfet_06v0 ad=2.2p pd=10.88u as=1.25p ps=5.5u w=5u l=1u
X1765 VSS VDD VSS VSS nfet_06v0 ad=7.92p pd=36.88u as=0 ps=0 w=18u l=2u
X1766 a_6594_67013# a_7758_66967# a_7958_67083# VSS nfet_06v0 ad=2.2p pd=10.88u as=1.3p ps=5.52u w=5u l=1u
X1767 a_29802_16854# a_24954_16810# a_27118_25602# VSS nfet_06v0 ad=1.1p pd=5.88u as=0.825p ps=3.16u w=2.5u l=1u
X1768 VSS a_10182_41099# a_9514_44499# VSS nfet_06v0 ad=1.1p pd=5.88u as=0.65p ps=3.02u w=2.5u l=1u
X1769 VSS a_84634_49596# a_73254_51084# VSS nfet_06v0 ad=0.44p pd=2.88u as=0.44p ps=2.88u w=1u l=1u
X1770 a_62366_54077# a_48510_49609# a_63566_49653# VSS nfet_06v0 ad=2.2p pd=10.88u as=1.25p ps=5.5u w=5u l=1u
X1771 a_2294_11612# a_2594_11612# a_14502_4870# VSS nfet_06v0 ad=0.44p pd=2.88u as=0.25p ps=1.5u w=1u l=1u
X1772 a_2494_53193# a_2294_53077# VDD VDD pfet_06v0 ad=2.5p pd=10.5u as=4.4p ps=20.88u w=10u l=1u
X1773 a_54214_58459# a_30830_58343# a_52850_58389# VSS nfet_06v0 ad=1.3p pd=5.52u as=2.2p ps=10.88u w=5u l=1u
X1774 a_16110_62813# a_16110_62813# a_17746_61813# VDD pfet_06v0 ad=4.4p pd=20.88u as=3.3p ps=10.66u w=10u l=1u
X1775 VDD a_33702_45499# a_31030_41099# VDD pfet_06v0 ad=1.3p pd=5.52u as=1.3p ps=5.52u w=5u l=1u
X1776 a_31790_36780# a_24954_28794# a_31998_28838# VSS nfet_06v0 ad=2.2p pd=10.88u as=1.25p ps=5.5u w=5u l=1u
X1777 a_2254_4826# a_2594_11612# a_18142_11728# VDD pfet_06v0 ad=4.4p pd=20.88u as=2.5p ps=10.5u w=10u l=1u
X1778 VSS VDD VSS VSS nfet_06v0 ad=4.29p pd=20.38u as=0 ps=0 w=9.75u l=2u
X1779 a_62366_62813# a_62366_62813# a_64002_61813# VDD pfet_06v0 ad=4.4p pd=20.88u as=3.3p ps=10.66u w=10u l=1u
X1780 a_33626_23712# a_33426_23596# VDD VDD pfet_06v0 ad=2.5p pd=10.5u as=4.4p ps=20.88u w=10u l=1u
X1781 a_34366_67083# a_39182_71437# a_34818_71483# VDD pfet_06v0 ad=2.2p pd=10.88u as=2.2p ps=10.88u w=5u l=1u
X1782 a_5530_44569# a_2294_44453# VDD VDD pfet_06v0 ad=2.5p pd=10.5u as=4.4p ps=20.88u w=10u l=1u
X1783 a_11226_23712# a_11026_23596# VDD VDD pfet_06v0 ad=2.5p pd=10.5u as=4.4p ps=20.88u w=10u l=1u
X1784 a_55770_44499# a_56438_41099# VSS VSS nfet_06v0 ad=0.65p pd=3.02u as=1.1p ps=5.88u w=2.5u l=1u
X1785 a_47856_33750# a_63274_34200# VSS ppolyf_u_1k r_width=1u r_length=76.45u
X1786 a_62830_23712# a_46982_23596# VDD VDD pfet_06v0 ad=2.5p pd=10.5u as=4.4p ps=20.88u w=10u l=1u
X1787 a_49442_67013# a_49242_66969# VSS VSS nfet_06v0 ad=1.25p pd=5.5u as=2.2p ps=10.88u w=5u l=1u
X1788 a_8870_40983# a_52090_4870# VSS VSS nfet_06v0 ad=0.44p pd=2.88u as=0.44p ps=2.88u w=1u l=1u
X1789 VSS VDD VSS VSS nfet_06v0 ad=7.92p pd=36.88u as=0 ps=0 w=18u l=2u
X1790 a_29366_67013# a_26058_66969# VSS VSS nfet_06v0 ad=1.25p pd=5.5u as=2.2p ps=10.88u w=5u l=1u
X1791 VDD VSS VDD VDD pfet_06v0 ad=7.92p pd=36.88u as=0 ps=0 w=18u l=2u
X1792 a_53210_61929# a_7758_58343# a_55770_61859# VDD pfet_06v0 ad=4.4p pd=20.88u as=2.6p ps=10.52u w=10u l=1u
X1793 a_10442_28794# a_2554_28794# a_10642_28838# VSS nfet_06v0 ad=1.65p pd=5.66u as=1.25p ps=5.5u w=5u l=1u
X1794 VDD VSS VDD VDD pfet_06v0 ad=7.92p pd=36.88u as=0 ps=0 w=18u l=2u
X1795 VSS a_33254_58459# a_32586_61859# VSS nfet_06v0 ad=0.65p pd=3.02u as=0.65p ps=3.02u w=2.5u l=1u
X1796 VSS VDD VSS VSS nfet_06v0 ad=7.92p pd=36.88u as=0 ps=0 w=18u l=2u
X1797 a_2754_4870# a_2554_4826# a_3486_4870# VSS nfet_06v0 ad=2.2p pd=10.88u as=1.25p ps=5.5u w=5u l=1u
X1798 a_26918_28838# S3P a_25154_28838# VSS nfet_06v0 ad=3.3p pd=15.88u as=3.3p ps=15.88u w=7.5u l=1u
X1799 a_85566_41016# a_83814_41016# a_84634_40972# VSS nfet_06v0 ad=0.25p pd=1.5u as=0.44p ps=2.88u w=1u l=1u
X1800 VDD a_25366_53077# a_30358_53193# VDD pfet_06v0 ad=4.4p pd=20.88u as=2.5p ps=10.5u w=10u l=1u
X1801 VSS VDD VSS VSS nfet_06v0 ad=7.92p pd=36.88u as=0 ps=0 w=18u l=2u
X1802 a_52090_16854# a_47242_16810# a_49406_25602# VSS nfet_06v0 ad=1.1p pd=5.88u as=0.825p ps=3.16u w=2.5u l=1u
X1803 a_11294_41099# a_16110_45453# a_11746_45499# VDD pfet_06v0 ad=2.2p pd=10.88u as=2.2p ps=10.88u w=5u l=1u
X1804 a_31790_24796# a_31790_24796# a_33426_23596# VDD pfet_06v0 ad=4.4p pd=20.88u as=3.3p ps=10.66u w=10u l=1u
X1805 a_52850_67013# a_30830_66967# a_54214_67083# VSS nfet_06v0 ad=2.2p pd=10.88u as=1.3p ps=5.52u w=5u l=1u
X1806 a_77730_16854# a_77530_16810# VSS VSS nfet_06v0 ad=1.25p pd=5.5u as=2.2p ps=10.88u w=5u l=1u
X1807 a_4718_37586# S3P a_2794_35696# VDD pfet_06v0 ad=0.242p pd=1.98u as=0.242p ps=1.98u w=0.55u l=1u
X1808 a_17946_53193# a_17746_53077# VDD VDD pfet_06v0 ad=2.5p pd=10.5u as=4.4p ps=20.88u w=10u l=1u
X1809 a_55330_16854# a_55130_16810# VSS VSS nfet_06v0 ad=1.25p pd=5.5u as=2.2p ps=10.88u w=5u l=1u
X1810 VSS VDD VSS VSS nfet_06v0 ad=0.44p pd=2.88u as=0 ps=0 w=1u l=2u
X1811 a_76478_12812# a_69642_4826# a_76686_4870# VSS nfet_06v0 ad=2.2p pd=10.88u as=1.25p ps=5.5u w=5u l=1u
X1812 a_25154_16854# a_24954_16810# a_24854_16854# VSS nfet_06v0 ad=2.2p pd=10.88u as=1.25p ps=5.5u w=5u l=1u
X1813 VDD a_10630_45499# a_9070_41099# VDD pfet_06v0 ad=2.2p pd=10.88u as=1.3p ps=5.52u w=5u l=1u
X1814 a_5794_16810# a_9390_24796# a_6342_23712# VDD pfet_06v0 ad=1.76p pd=8.88u as=1.76p ps=8.88u w=4u l=1u
X1815 a_58002_54123# a_48850_53077# a_54214_49723# VDD pfet_06v0 ad=1.3p pd=5.52u as=2.2p ps=10.88u w=5u l=1u
X1816 VDD VSS VDD VDD pfet_06v0 ad=4.29p pd=20.38u as=0 ps=0 w=9.75u l=2u
X1817 a_55770_44499# a_7758_40983# a_53210_44569# VDD pfet_06v0 ad=2.6p pd=10.52u as=4.4p ps=20.88u w=10u l=1u
X1818 VDD a_10630_62859# a_7958_58459# VDD pfet_06v0 ad=2.2p pd=10.88u as=1.3p ps=5.52u w=5u l=1u
X1819 X a_79086_42348# a_72304_41256# VSS nfet_06v0 ad=0.6448p pd=3u as=1.0912p ps=5.84u w=2.48u l=1u
X1820 a_25886_28838# a_24654_28794# VSS VSS nfet_06v0 ad=1.25p pd=5.5u as=2.2p ps=10.88u w=5u l=1u
X1821 a_73246_67000# a_71494_67000# a_72314_66956# VSS nfet_06v0 ad=0.25p pd=1.5u as=0.44p ps=2.88u w=1u l=1u
X1822 VDD a_56886_62859# a_54214_58459# VDD pfet_06v0 ad=2.2p pd=10.88u as=1.3p ps=5.52u w=5u l=1u
X1823 a_37934_4870# a_24994_11612# VSS VSS nfet_06v0 ad=0.25p pd=1.5u as=0.44p ps=2.88u w=1u l=1u
X1824 a_30026_70553# a_25666_70437# a_29726_70553# VDD pfet_06v0 ad=3.3p pd=10.66u as=2.5p ps=10.5u w=10u l=1u
X1825 a_71806_37586# S2P a_69882_35696# VDD pfet_06v0 ad=0.242p pd=1.98u as=0.242p ps=1.98u w=0.55u l=1u
X1826 VDD a_42790_49723# a_86922_51052# VDD pfet_06v0 ad=1.32p pd=6.88u as=0.75p ps=3.5u w=3u l=1u
X1827 a_32586_70483# a_33254_67083# VSS VSS nfet_06v0 ad=0.65p pd=3.02u as=0.65p ps=3.02u w=2.5u l=1u
X1828 a_30830_58343# a_70256_21316# VDD VDD pfet_06v0 ad=0.44p pd=2.88u as=0.44p ps=2.88u w=1u l=1u
X1829 a_26058_49609# a_25326_49609# a_26258_49653# VSS nfet_06v0 ad=2.2p pd=10.88u as=1.25p ps=5.5u w=5u l=1u
X1830 VDD a_58002_62859# a_65974_58459# VDD pfet_06v0 ad=2.6p pd=10.52u as=2.6p ps=10.52u w=10u l=1u
X1831 a_75022_16810# a_75022_16810# a_77530_16810# VSS nfet_06v0 ad=2.2p pd=10.88u as=1.65p ps=5.66u w=5u l=1u
X1832 a_25568_33750# a_40986_33300# VSS ppolyf_u_1k r_width=1u r_length=76.45u
X1833 a_16110_54077# a_16110_54077# a_17746_53077# VDD pfet_06v0 ad=4.4p pd=20.88u as=3.3p ps=10.66u w=10u l=1u
X1834 a_34818_62859# a_25666_61813# a_31030_58459# VDD pfet_06v0 ad=1.3p pd=5.52u as=2.2p ps=10.88u w=5u l=1u
X1835 a_19718_67083# a_11294_67083# VSS VSS nfet_06v0 ad=2.2p pd=10.88u as=1.3p ps=5.52u w=5u l=1u
X1836 a_48510_58345# a_48850_61813# a_48750_61929# VDD pfet_06v0 ad=4.4p pd=20.88u as=2.5p ps=10.5u w=10u l=1u
X1837 a_5530_25612# a_5794_16810# VSS VSS nfet_06v0 ad=0.825p pd=3.16u as=1.1p ps=5.88u w=2.5u l=1u
X1838 a_3168_33300# a_18586_33300# VSS ppolyf_u_1k r_width=1u r_length=76.45u
X1839 VDD VSS VDD VDD pfet_06v0 ad=4.29p pd=20.38u as=0 ps=0 w=9.75u l=2u
X1840 a_69882_23712# a_69682_23596# a_69582_23712# VDD pfet_06v0 ad=4.4p pd=20.88u as=2.5p ps=10.5u w=10u l=1u
X1841 a_62366_54077# a_62366_54077# a_64002_53077# VDD pfet_06v0 ad=4.4p pd=20.88u as=3.3p ps=10.66u w=10u l=1u
X1842 a_8398_70483# a_10182_67083# VSS VSS nfet_06v0 ad=0.65p pd=3.02u as=1.1p ps=5.88u w=2.5u l=1u
X1843 a_17030_35696# a_2294_35580# VDD VDD pfet_06v0 ad=2.5p pd=10.5u as=4.4p ps=20.88u w=10u l=1u
X1844 a_47482_23712# a_47282_23596# a_47182_23712# VDD pfet_06v0 ad=4.4p pd=20.88u as=2.5p ps=10.5u w=10u l=1u
X1845 VDD a_56886_54123# a_55326_49723# VDD pfet_06v0 ad=1.3p pd=5.52u as=1.3p ps=5.52u w=5u l=1u
X1846 a_54214_41099# a_56886_45499# VDD VDD pfet_06v0 ad=1.3p pd=5.52u as=1.3p ps=5.52u w=5u l=1u
X1847 a_72618_37596# S2N a_69882_35696# VDD pfet_06v0 ad=0.22p pd=1.88u as=0.22p ps=1.88u w=0.5u l=1u
X1848 a_6594_67013# a_8870_66967# a_9070_67083# VSS nfet_06v0 ad=2.2p pd=10.88u as=1.3p ps=5.52u w=5u l=1u
X1849 a_10182_58459# a_16110_62813# a_10630_62859# VDD pfet_06v0 ad=2.2p pd=10.88u as=2.2p ps=10.88u w=5u l=1u
X1850 VSS VDD VSS VSS nfet_06v0 ad=0.44p pd=2.88u as=0 ps=0 w=1u l=2u
X1851 a_50218_37596# S4N a_47482_35696# VDD pfet_06v0 ad=0.22p pd=1.88u as=0.22p ps=1.88u w=0.5u l=1u
X1852 a_31470_44499# a_25326_40985# a_34366_41099# VSS nfet_06v0 ad=1.1p pd=5.88u as=0.65p ps=3.02u w=2.5u l=1u
X1853 a_55326_58459# a_7758_58343# a_52850_58389# VSS nfet_06v0 ad=1.3p pd=5.52u as=2.2p ps=10.88u w=5u l=1u
X1854 a_72618_25612# a_72882_16810# VSS VSS nfet_06v0 ad=0.825p pd=3.16u as=1.1p ps=5.88u w=2.5u l=1u
X1855 a_9070_49723# a_10630_54123# VDD VDD pfet_06v0 ad=1.3p pd=5.52u as=2.2p ps=10.88u w=5u l=1u
X1856 a_70256_33300# a_85674_33300# VSS ppolyf_u_1k r_width=1u r_length=76.45u
X1857 a_2494_35696# a_2294_35580# VDD VDD pfet_06v0 ad=2.5p pd=10.5u as=4.4p ps=20.88u w=10u l=1u
X1858 a_39182_71437# a_39182_71437# a_40818_70437# VDD pfet_06v0 ad=4.4p pd=20.88u as=3.3p ps=10.66u w=10u l=1u
X1859 a_50218_25612# a_50482_16810# VSS VSS nfet_06v0 ad=0.825p pd=3.16u as=1.1p ps=5.88u w=2.5u l=1u
X1860 a_47182_11728# a_46982_11612# VDD VDD pfet_06v0 ad=2.5p pd=10.5u as=4.4p ps=20.88u w=10u l=1u
X1861 a_2594_70437# a_2594_70437# VDD VDD pfet_06v0 ad=0.88p pd=4.88u as=0.88p ps=4.88u w=2u l=1u
X1862 a_61902_58345# a_48850_61813# a_65646_61929# VDD pfet_06v0 ad=4.4p pd=20.88u as=2.5p ps=10.5u w=10u l=1u
X1863 a_9514_61859# a_8870_58343# a_6954_61929# VDD pfet_06v0 ad=2.6p pd=10.52u as=4.4p ps=20.88u w=10u l=1u
X1864 VSS a_10182_41099# a_9514_44499# VSS nfet_06v0 ad=0.65p pd=3.02u as=0.65p ps=3.02u w=2.5u l=1u
X1865 VDD a_33702_62859# a_32142_58459# VDD pfet_06v0 ad=1.3p pd=5.52u as=1.3p ps=5.52u w=5u l=1u
X1866 a_33426_35580# a_24994_35580# a_33626_35696# VDD pfet_06v0 ad=3.3p pd=10.66u as=2.5p ps=10.5u w=10u l=1u
X1867 a_53210_61929# a_48850_61813# a_52910_61929# VDD pfet_06v0 ad=3.3p pd=10.66u as=2.5p ps=10.5u w=10u l=1u
X1868 a_11294_49723# a_2254_49609# a_8398_53123# VSS nfet_06v0 ad=0.65p pd=3.02u as=1.1p ps=5.88u w=2.5u l=1u
X1869 a_73166_51200# a_72104_49876# VSS VSS nfet_06v0 ad=0.5456p pd=3.36u as=0.5456p ps=3.36u w=1.24u l=1u
X1870 a_11026_35580# a_2594_35580# a_11226_35696# VDD pfet_06v0 ad=3.3p pd=10.66u as=2.5p ps=10.5u w=10u l=1u
X1871 a_5250_67013# a_2594_70437# VSS VSS nfet_06v0 ad=0.25p pd=1.5u as=0.44p ps=2.88u w=1u l=1u
X1872 a_46942_28794# a_47282_35580# a_62830_35696# VDD pfet_06v0 ad=4.4p pd=20.88u as=2.5p ps=10.5u w=10u l=1u
X1873 a_30026_70553# a_8870_66967# a_32586_70483# VDD pfet_06v0 ad=4.4p pd=20.88u as=2.6p ps=10.52u w=10u l=1u
X1874 VDD a_56886_62859# a_55326_58459# VDD pfet_06v0 ad=2.2p pd=10.88u as=1.3p ps=5.52u w=5u l=1u
X1875 VSS VDD VSS VSS nfet_06v0 ad=7.92p pd=36.88u as=0 ps=0 w=18u l=2u
X1876 VSS VDD VSS VSS nfet_06v0 ad=7.92p pd=36.88u as=0 ps=0 w=18u l=2u
X1877 a_33702_62859# a_38718_58345# a_33254_58459# VSS nfet_06v0 ad=1.1p pd=5.88u as=1.1p ps=5.88u w=2.5u l=1u
X1878 a_39182_71437# a_25326_66969# a_40382_67013# VSS nfet_06v0 ad=2.2p pd=10.88u as=1.25p ps=5.5u w=5u l=1u
X1879 X a_77242_42348# a_77154_42464# VSS nfet_06v0 ad=0.6448p pd=3u as=1.0912p ps=5.84u w=2.48u l=1u
X1880 a_34366_41099# a_39182_45453# a_34818_45499# VDD pfet_06v0 ad=2.2p pd=10.88u as=2.2p ps=10.88u w=5u l=1u
X1881 VSS VDD VSS VSS nfet_06v0 ad=0.44p pd=2.88u as=0 ps=0 w=1u l=2u
X1882 a_19718_49723# a_11746_54123# VDD VDD pfet_06v0 ad=2.6p pd=10.52u as=4.4p ps=20.88u w=10u l=1u
X1883 a_42466_11728# a_24694_11612# VDD VDD pfet_06v0 ad=2.5p pd=10.5u as=4.4p ps=20.88u w=10u l=1u
X1884 a_32842_4826# a_24954_4826# a_33042_4870# VSS nfet_06v0 ad=1.65p pd=5.66u as=1.25p ps=5.5u w=5u l=1u
X1885 a_46942_28794# a_47242_28794# a_58158_28838# VSS nfet_06v0 ad=2.2p pd=10.88u as=1.25p ps=5.5u w=5u l=1u
X1886 a_55326_67083# a_48850_70437# a_56886_71483# VDD pfet_06v0 ad=2.2p pd=10.88u as=1.3p ps=5.52u w=5u l=1u
X1887 a_8870_40983# a_47856_9332# VDD VDD pfet_06v0 ad=0.44p pd=2.88u as=0.44p ps=2.88u w=1u l=1u
X1888 a_41426_41029# a_41226_40985# VSS VSS nfet_06v0 ad=1.25p pd=5.5u as=2.2p ps=10.88u w=5u l=1u
X1889 a_52850_49653# a_7758_49607# a_55326_49723# VSS nfet_06v0 ad=2.2p pd=10.88u as=1.3p ps=5.52u w=5u l=1u
X1890 a_19390_61929# a_2294_61813# VDD VDD pfet_06v0 ad=2.5p pd=10.5u as=4.4p ps=20.88u w=10u l=1u
X1891 VSS a_56438_49723# a_54654_53123# VSS nfet_06v0 ad=1.1p pd=5.88u as=0.65p ps=3.02u w=2.5u l=1u
X1892 a_48510_49609# a_48850_53077# a_48750_53193# VDD pfet_06v0 ad=4.4p pd=20.88u as=2.5p ps=10.5u w=10u l=1u
X1893 a_6954_70553# a_8870_66967# a_9514_70483# VDD pfet_06v0 ad=4.4p pd=20.88u as=2.6p ps=10.52u w=10u l=1u
X1894 a_30830_58343# a_74490_16854# VSS VSS nfet_06v0 ad=0.44p pd=2.88u as=0.44p ps=2.88u w=1u l=1u
X1895 a_82622_16854# a_69682_23596# VSS VSS nfet_06v0 ad=0.25p pd=1.5u as=0.44p ps=2.88u w=1u l=1u
X1896 a_7758_58343# a_52090_16854# VSS VSS nfet_06v0 ad=0.44p pd=2.88u as=0.44p ps=2.88u w=1u l=1u
X1897 a_60222_16854# a_47282_23596# VSS VSS nfet_06v0 ad=0.25p pd=1.5u as=0.44p ps=2.88u w=1u l=1u
X1898 a_79086_59708# a_65974_58459# VSS VSS nfet_06v0 ad=0.33p pd=1.66u as=0.44p ps=2.88u w=1u l=1u
X1899 VSS a_19718_49723# a_83814_49640# VSS nfet_06v0 ad=0.44p pd=2.88u as=0.44p ps=2.88u w=1u l=1u
X1900 a_51506_67013# a_48850_70437# VSS VSS nfet_06v0 ad=0.25p pd=1.5u as=0.44p ps=2.88u w=1u l=1u
X1901 a_25568_33750# a_40986_34200# VSS ppolyf_u_1k r_width=1u r_length=76.45u
X1902 a_42790_67083# a_34366_67083# VSS VSS nfet_06v0 ad=2.2p pd=10.88u as=1.3p ps=5.52u w=5u l=1u
X1903 a_2986_58345# a_2594_61813# a_3606_61929# VDD pfet_06v0 ad=4.4p pd=20.88u as=2.5p ps=10.5u w=10u l=1u
X1904 a_29802_28838# a_24954_28794# a_27118_37586# VSS nfet_06v0 ad=1.1p pd=5.88u as=0.825p ps=3.16u w=2.5u l=1u
X1905 a_54214_41099# a_30830_40983# a_52850_41029# VSS nfet_06v0 ad=1.3p pd=5.52u as=2.2p ps=10.88u w=5u l=1u
X1906 a_40542_23712# a_24694_23596# VDD VDD pfet_06v0 ad=2.5p pd=10.5u as=4.4p ps=20.88u w=10u l=1u
X1907 a_10182_49723# a_16110_54077# a_10630_54123# VDD pfet_06v0 ad=2.2p pd=10.88u as=2.2p ps=10.88u w=5u l=1u
X1908 VDD a_10630_62859# a_7958_58459# VDD pfet_06v0 ad=1.3p pd=5.52u as=1.3p ps=5.52u w=5u l=1u
X1909 a_19718_58459# a_11746_62859# VDD VDD pfet_06v0 ad=4.4p pd=20.88u as=2.6p ps=10.52u w=10u l=1u
X1910 a_31470_70483# a_33254_67083# VSS VSS nfet_06v0 ad=0.65p pd=3.02u as=1.1p ps=5.88u w=2.5u l=1u
X1911 a_2794_11728# a_2594_11612# a_2494_11728# VDD pfet_06v0 ad=4.4p pd=20.88u as=2.5p ps=10.5u w=10u l=1u
X1912 a_6926_58389# a_2254_58345# a_6594_58389# VSS nfet_06v0 ad=1.25p pd=5.5u as=1.65p ps=5.66u w=5u l=1u
X1913 a_32586_53123# a_8870_49607# a_30026_53193# VDD pfet_06v0 ad=2.6p pd=10.52u as=4.4p ps=20.88u w=10u l=1u
X1914 a_55326_58459# a_56886_62859# VDD VDD pfet_06v0 ad=1.3p pd=5.52u as=2.2p ps=10.88u w=5u l=1u
X1915 a_40382_58389# a_26058_58345# VSS VSS nfet_06v0 ad=1.25p pd=5.5u as=2.2p ps=10.88u w=5u l=1u
X1916 VSS VDD VSS VSS nfet_06v0 ad=4.29p pd=20.38u as=0 ps=0 w=9.75u l=2u
X1917 a_49242_58345# a_48850_61813# a_49862_61929# VDD pfet_06v0 ad=4.4p pd=20.88u as=2.5p ps=10.5u w=10u l=1u
X1918 VSS VDD VSS VSS nfet_06v0 ad=0.44p pd=2.88u as=0 ps=0 w=1u l=2u
X1919 a_81590_16854# a_69682_23596# VSS VSS nfet_06v0 ad=0.25p pd=1.5u as=0.44p ps=2.88u w=1u l=1u
X1920 a_16110_54077# a_2254_49609# a_17310_49653# VSS nfet_06v0 ad=2.2p pd=10.88u as=1.25p ps=5.5u w=5u l=1u
X1921 a_29666_58389# a_30830_58343# a_31030_58459# VSS nfet_06v0 ad=2.2p pd=10.88u as=1.3p ps=5.52u w=5u l=1u
X1922 a_8870_49607# a_25568_21316# VDD VDD pfet_06v0 ad=0.44p pd=2.88u as=0.44p ps=2.88u w=1u l=1u
X1923 a_18142_35696# a_2294_35580# VDD VDD pfet_06v0 ad=2.5p pd=10.5u as=4.4p ps=20.88u w=10u l=1u
X1924 a_61902_49609# a_48850_53077# a_65646_53193# VDD pfet_06v0 ad=4.4p pd=20.88u as=2.5p ps=10.5u w=10u l=1u
X1925 a_30026_44569# a_25666_44453# a_29726_44569# VDD pfet_06v0 ad=3.3p pd=10.66u as=2.5p ps=10.5u w=10u l=1u
X1926 a_6594_49653# a_2254_49609# a_6294_49653# VSS nfet_06v0 ad=1.65p pd=5.66u as=1.25p ps=5.5u w=5u l=1u
X1927 a_33254_58459# a_39182_62813# a_33702_62859# VDD pfet_06v0 ad=2.2p pd=10.88u as=2.2p ps=10.88u w=5u l=1u
X1928 a_7758_66967# a_25568_33300# VDD VDD pfet_06v0 ad=0.44p pd=2.88u as=0.44p ps=2.88u w=1u l=1u
X1929 a_7958_49723# a_7758_49607# a_6594_49653# VSS nfet_06v0 ad=1.3p pd=5.52u as=2.2p ps=10.88u w=5u l=1u
X1930 a_47482_23712# a_47282_23596# a_48294_23712# VDD pfet_06v0 ad=4.4p pd=20.88u as=2.5p ps=10.5u w=10u l=1u
X1931 a_12006_16854# a_3168_21316# VDD VDD pfet_06v0 ad=0.44p pd=2.88u as=0.44p ps=2.88u w=1u l=1u
X1932 a_5530_13628# S2N a_2794_11728# VDD pfet_06v0 ad=0.22p pd=1.88u as=0.22p ps=1.88u w=0.5u l=1u
X1933 a_53210_53193# a_48850_53077# a_52910_53193# VDD pfet_06v0 ad=3.3p pd=10.66u as=2.5p ps=10.5u w=10u l=1u
X1934 a_3168_10682# a_18586_10232# VSS ppolyf_u_1k r_width=1u r_length=76.45u
X1935 a_65974_58459# a_57550_58459# VSS VSS nfet_06v0 ad=1.3p pd=5.52u as=2.2p ps=10.88u w=5u l=1u
X1936 a_48510_66969# a_48510_66969# VSS VSS nfet_06v0 ad=0.44p pd=2.88u as=0.44p ps=2.88u w=1u l=1u
X1937 a_8870_58343# a_3168_33300# VDD VDD pfet_06v0 ad=0.44p pd=2.88u as=0.44p ps=2.88u w=1u l=1u
X1938 ZN a_75388_62164# VDD VDD pfet_05v0 ad=0.8052p pd=4.54u as=0.8052p ps=4.54u w=1.83u l=0.5u
X1939 a_50474_67013# a_48850_70437# VSS VSS nfet_06v0 ad=0.25p pd=1.5u as=0.44p ps=2.88u w=1u l=1u
X1940 a_26918_28838# a_28742_35696# VDD VDD pfet_06v0 ad=2.2p pd=10.88u as=2.2p ps=10.88u w=5u l=1u
X1941 a_56886_54123# a_48850_53077# a_55326_49723# VDD pfet_06v0 ad=1.3p pd=5.52u as=2.2p ps=10.88u w=5u l=1u
X1942 VDD a_42790_49723# a_87474_49596# VDD pfet_06v0 ad=1.32p pd=6.88u as=0.99p ps=3.66u w=3u l=1u
X1943 a_56438_58459# a_48510_58345# a_55770_61859# VSS nfet_06v0 ad=0.65p pd=3.02u as=1.1p ps=5.88u w=2.5u l=1u
X1944 VSS a_33254_41099# a_32586_44499# VSS nfet_06v0 ad=0.65p pd=3.02u as=0.65p ps=3.02u w=2.5u l=1u
X1945 a_86922_59788# a_65974_58459# a_79086_59708# VDD pfet_06v0 ad=0.75p pd=3.5u as=1.32p ps=6.88u w=3u l=1u
X1946 a_52090_4870# a_54078_12812# a_47856_9332# VDD pfet_06v0 ad=1.76p pd=8.88u as=1.76p ps=8.88u w=4u l=1u
X1947 VDD VSS VDD VDD pfet_06v0 ad=4.29p pd=20.38u as=0 ps=0 w=9.75u l=2u
X1948 a_27118_13618# S3P a_25194_11728# VDD pfet_06v0 ad=0.242p pd=1.98u as=0.242p ps=1.98u w=0.55u l=1u
X1949 a_17746_70437# a_2594_70437# a_17946_70553# VDD pfet_06v0 ad=3.3p pd=10.66u as=2.5p ps=10.5u w=10u l=1u
X1950 VSS a_84634_40972# a_77242_51084# VSS nfet_06v0 ad=0.44p pd=2.88u as=0.44p ps=2.88u w=1u l=1u
X1951 a_62366_45453# a_48510_40985# a_63566_41029# VSS nfet_06v0 ad=2.2p pd=10.88u as=1.25p ps=5.5u w=5u l=1u
X1952 a_38718_66969# a_25666_70437# a_42462_70553# VDD pfet_06v0 ad=4.4p pd=20.88u as=2.5p ps=10.5u w=10u l=1u
X1953 VSS a_33254_58459# a_31470_61859# VSS nfet_06v0 ad=0.65p pd=3.02u as=0.65p ps=3.02u w=2.5u l=1u
X1954 a_64002_70437# a_48850_70437# a_64202_70553# VDD pfet_06v0 ad=3.3p pd=10.66u as=2.5p ps=10.5u w=10u l=1u
X1955 a_70256_10682# a_85674_10232# VSS ppolyf_u_1k r_width=1u r_length=76.45u
X1956 a_8870_49607# a_26918_16854# cap_mim_2f0_m4m5_noshield c_width=25u c_length=8u
X1957 a_52090_28838# a_47242_28794# a_49406_37586# VSS nfet_06v0 ad=1.1p pd=5.88u as=0.825p ps=3.16u w=2.5u l=1u
X1958 a_7958_67083# a_10630_71483# VDD VDD pfet_06v0 ad=1.3p pd=5.52u as=1.3p ps=5.52u w=5u l=1u
X1959 a_46982_23596# a_47282_23596# a_64754_23712# VDD pfet_06v0 ad=4.4p pd=20.88u as=2.5p ps=10.5u w=10u l=1u
X1960 a_38718_49609# a_38718_49609# a_41226_49609# VSS nfet_06v0 ad=2.2p pd=10.88u as=1.65p ps=5.66u w=5u l=1u
X1961 a_54654_61859# a_56438_58459# VSS VSS nfet_06v0 ad=0.65p pd=3.02u as=1.1p ps=5.88u w=2.5u l=1u
X1962 a_25666_53077# a_25666_53077# VDD VDD pfet_06v0 ad=0.88p pd=4.88u as=0.88p ps=4.88u w=2u l=1u
X1963 a_77730_28838# a_77530_28794# VSS VSS nfet_06v0 ad=1.25p pd=5.5u as=2.2p ps=10.88u w=5u l=1u
X1964 VSS VDD VSS VSS nfet_06v0 ad=0.44p pd=2.88u as=0 ps=0 w=1u l=2u
X1965 VDD a_83814_49640# a_84634_49596# VDD pfet_06v0 ad=1.32p pd=6.88u as=0.99p ps=3.66u w=3u l=1u
X1966 a_28602_70553# a_25366_70437# VDD VDD pfet_06v0 ad=2.5p pd=10.5u as=4.4p ps=20.88u w=10u l=1u
X1967 a_39182_45453# a_39182_45453# a_40818_44453# VDD pfet_06v0 ad=4.4p pd=20.88u as=3.3p ps=10.66u w=10u l=1u
.ends
