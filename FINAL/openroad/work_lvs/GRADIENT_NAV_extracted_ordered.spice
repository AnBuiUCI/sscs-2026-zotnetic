* NGSPICE file created from GRADIENT_NAV.ext - technology: gf180mcuD

.subckt GRADIENT_NAV S1N VDD XN VSS S1P S2N S2P S3N S3P S4N S4P XP YN YP ZN ZP X Y Z
X0 a_27480_4860# a_23302_4744# a_25466_8260# VSS nfet_06v0 ad=1.1p pd=5.88u as=1.1p ps=5.88u w=2.5u l=1u
X1 a_31310_31016# a_26982_30900# VSS VSS nfet_06v0 ad=1.25p pd=5.5u as=2.2p ps=10.88u w=5u l=1u
X2 a_6648_57052# a_9306_60336# a_7070_60452# VDD pfet_06v0 ad=2.2p pd=10.88u as=2.2p ps=10.88u w=5u l=1u
X3 a_6498_65848# a_9174_65732# a_9374_65848# VSS nfet_06v0 ad=2.2p pd=10.88u as=1.3p ps=5.52u w=5u l=1u
X4 a_20242_69248# a_2210_69132# VDD VDD pfet_06v0 ad=2.5p pd=10.5u as=4.4p ps=20.88u w=10u l=1u
X5 a_54718_69248# a_50370_69132# VDD VDD pfet_06v0 ad=2.5p pd=10.5u as=4.4p ps=20.88u w=10u l=1u
X6 a_6648_22332# a_2470_22216# a_4634_25732# VSS nfet_06v0 ad=1.1p pd=5.88u as=1.1p ps=5.88u w=2.5u l=1u
X7 a_52716_57052# a_44134_56936# a_53736_57052# VSS nfet_06v0 ad=2.2p pd=10.88u as=1.25p ps=5.5u w=5u l=1u
X8 VDD a_60290_69248# a_23622_74260# VDD pfet_06v0 ad=2.6p pd=10.52u as=2.6p ps=10.52u w=10u l=1u
X9 a_57264_39692# a_44174_42976# VSS VSS nfet_06v0 ad=0.25p pd=1.5u as=0.44p ps=2.88u w=1u l=1u
X10 a_4634_8260# a_5916_4860# VSS VSS nfet_06v0 ad=1.1p pd=5.88u as=1.1p ps=5.88u w=2.5u l=1u
X11 a_23502_4860# a_23302_4744# a_23202_4860# VSS nfet_06v0 ad=2.2p pd=10.88u as=1.25p ps=5.5u w=5u l=1u
X12 a_47922_43092# a_44174_42976# a_46830_39692# VDD pfet_06v0 ad=2.2p pd=10.88u as=2.2p ps=10.88u w=5u l=1u
X13 a_65840_41360# a_2030_74376# Z VSS nfet_06v0 ad=1.0912p pd=5.84u as=0.6448p ps=3u w=2.48u l=1u
X14 a_48312_57052# a_44134_56936# a_46298_60452# VSS nfet_06v0 ad=1.1p pd=5.88u as=1.1p ps=5.88u w=2.5u l=1u
X15 a_57534_13656# a_59174_17056# VDD VDD pfet_06v0 ad=1.3p pd=5.52u as=1.3p ps=5.52u w=5u l=1u
X16 a_53326_65848# a_50670_69132# VSS VSS nfet_06v0 ad=0.25p pd=1.5u as=0.44p ps=2.88u w=1u l=1u
X17 a_30138_42976# a_30138_42976# a_31762_42976# VDD pfet_06v0 ad=4.4p pd=20.88u as=4.4p ps=20.88u w=10u l=1u
X18 a_8644_4744# a_8644_4744# a_11052_4860# VSS nfet_06v0 ad=2.2p pd=10.88u as=2.2p ps=10.88u w=5u l=1u
X19 a_3102_13656# a_2902_13540# VSS VSS nfet_06v0 ad=1.25p pd=5.5u as=2.2p ps=10.88u w=5u l=1u
X20 a_56422_31016# a_59174_34416# VDD VDD pfet_06v0 ad=1.3p pd=5.52u as=1.3p ps=5.52u w=5u l=1u
X21 a_8782_34416# a_10486_31016# VSS VSS nfet_06v0 ad=0.65p pd=3.02u as=0.65p ps=3.02u w=2.5u l=1u
X22 a_60290_17056# a_50670_16940# a_56422_13656# VDD pfet_06v0 ad=1.3p pd=5.52u as=2.2p ps=10.88u w=5u l=1u
X23 a_40574_16940# a_26250_13540# a_41694_13656# VSS nfet_06v0 ad=2.2p pd=10.88u as=1.25p ps=5.5u w=5u l=1u
X24 a_14334_74260# a_12130_51776# VDD VDD pfet_06v0 ad=2.6p pd=10.52u as=4.4p ps=20.88u w=10u l=1u
X25 a_44334_57052# a_44134_56936# a_44034_57052# VSS nfet_06v0 ad=2.2p pd=10.88u as=1.25p ps=5.5u w=5u l=1u
X26 a_11014_17056# a_2510_16940# a_9374_13656# VDD pfet_06v0 ad=1.3p pd=5.52u as=2.2p ps=10.88u w=5u l=1u
X27 a_16632_22332# a_2510_25616# VSS VSS nfet_06v0 ad=0.25p pd=1.5u as=0.44p ps=2.88u w=1u l=1u
X28 a_6258_60452# a_2510_60336# a_5166_57052# VDD pfet_06v0 ad=2.2p pd=10.88u as=2.2p ps=10.88u w=5u l=1u
X29 a_67842_40152# a_66178_40036# VSS VSS nfet_06v0 ad=0.175p pd=1.2u as=0.308p ps=2.28u w=0.7u l=1u
X30 a_2710_60452# a_2510_60336# a_2410_60452# VDD pfet_06v0 ad=4.4p pd=20.88u as=2.5p ps=10.5u w=10u l=1u
X31 VSS a_4314_74260# a_4226_74376# VSS nfet_06v0 ad=0.44p pd=2.88u as=0.44p ps=2.88u w=1u l=1u
X32 a_56942_17056# a_58646_13656# VSS VSS nfet_06v0 ad=0.65p pd=3.02u as=0.65p ps=3.02u w=2.5u l=1u
X33 a_46298_60452# a_32142_65732# cap_mim_2f0_m4m5_noshield c_width=20u c_length=10u
X34 a_30938_69248# a_26590_69132# a_30638_69248# VDD pfet_06v0 ad=4.4p pd=20.88u as=2.5p ps=10.5u w=10u l=1u
X35 a_8062_30900# a_27480_22332# VSS VSS nfet_06v0 ad=0.44p pd=2.88u as=0.44p ps=2.88u w=1u l=1u
X36 a_52294_65848# a_50670_69132# VSS VSS nfet_06v0 ad=0.25p pd=1.5u as=0.44p ps=2.88u w=1u l=1u
X37 a_2510_69132# a_2510_69132# VDD VDD pfet_06v0 ad=0.88p pd=4.88u as=0.88p ps=4.88u w=2u l=1u
X38 a_6858_34416# a_8062_30900# a_8782_34416# VDD pfet_06v0 ad=4.4p pd=20.88u as=2.6p ps=10.52u w=10u l=1u
X39 a_3402_22332# a_2170_22216# VSS VSS nfet_06v0 ad=1.25p pd=5.5u as=2.2p ps=10.88u w=5u l=1u
X40 VDD a_13282_75936# a_16830_74260# VDD pfet_06v0 ad=1.32p pd=6.88u as=1.32p ps=6.88u w=3u l=1u
X41 X a_16742_74376# a_64728_5320# VSS nfet_06v0 ad=0.6448p pd=3u as=1.0912p ps=5.84u w=2.48u l=1u
X42 a_50570_17056# a_50370_16940# VDD VDD pfet_06v0 ad=2.5p pd=10.5u as=4.4p ps=20.88u w=10u l=1u
X43 a_33978_34416# a_26250_30900# a_34566_31016# VSS nfet_06v0 ad=1.1p pd=5.88u as=0.65p ps=3.02u w=2.5u l=1u
X44 a_2170_56936# a_2470_56936# a_14568_57052# VSS nfet_06v0 ad=2.2p pd=10.88u as=1.25p ps=5.5u w=5u l=1u
X45 a_26278_25732# a_26748_22332# VSS VSS nfet_06v0 ad=1.1p pd=5.88u as=1.1p ps=5.88u w=2.5u l=1u
X46 a_33454_48376# a_35094_51776# VDD VDD pfet_06v0 ad=1.3p pd=5.52u as=1.3p ps=5.52u w=5u l=1u
X47 a_68598_57016# a_68686_56900# VDD VDD pfet_06v0 ad=1.32p pd=6.88u as=1.32p ps=6.88u w=3u l=1u
X48 VDD a_59174_69248# a_56422_65848# VDD pfet_06v0 ad=2.2p pd=10.88u as=1.3p ps=5.52u w=5u l=1u
X49 a_33978_17056# a_34566_13656# VSS VSS nfet_06v0 ad=0.65p pd=3.02u as=0.65p ps=3.02u w=2.5u l=1u
X50 a_23542_60452# a_23342_60336# a_23242_60452# VDD pfet_06v0 ad=4.4p pd=20.88u as=2.5p ps=10.5u w=10u l=1u
X51 VDD a_59174_17056# a_56422_13656# VDD pfet_06v0 ad=1.3p pd=5.52u as=1.3p ps=5.52u w=5u l=1u
X52 a_47580_57052# a_50970_60336# a_47922_60452# VDD pfet_06v0 ad=2.2p pd=10.88u as=2.2p ps=10.88u w=5u l=1u
X53 a_10308_57052# a_2170_56936# VSS VSS nfet_06v0 ad=1.25p pd=5.5u as=2.2p ps=10.88u w=5u l=1u
X54 a_27494_74376# a_27582_74260# VDD VDD pfet_06v0 ad=1.32p pd=6.88u as=1.32p ps=6.88u w=3u l=1u
X55 VSS a_44490_13656# a_64638_57016# VSS nfet_06v0 ad=0.44p pd=2.88u as=0.44p ps=2.88u w=1u l=1u
X56 a_24234_22332# a_23002_22216# VSS VSS nfet_06v0 ad=1.25p pd=5.5u as=2.2p ps=10.88u w=5u l=1u
X57 a_28214_13656# a_26590_16940# VSS VSS nfet_06v0 ad=0.25p pd=1.5u as=0.44p ps=2.88u w=1u l=1u
X58 a_8262_13656# a_2510_16940# a_12130_17056# VDD pfet_06v0 ad=2.2p pd=10.88u as=1.3p ps=5.52u w=5u l=1u
X59 a_2530_75936# a_36210_34416# VDD VDD pfet_06v0 ad=2.6p pd=10.52u as=4.4p ps=20.88u w=10u l=1u
X60 a_2210_51660# a_2510_51660# a_5446_51776# VDD pfet_06v0 ad=4.4p pd=20.88u as=2.5p ps=10.5u w=10u l=1u
X61 VSS a_59758_65848# a_23622_74260# VSS nfet_06v0 ad=1.3p pd=5.52u as=1.3p ps=5.52u w=5u l=1u
X62 a_46098_22332# S4P a_44334_22332# VSS nfet_06v0 ad=2.2p pd=10.88u as=2.2p ps=10.88u w=5u l=1u
X63 a_32142_13540# a_48312_4860# VSS VSS nfet_06v0 ad=0.44p pd=2.88u as=0.44p ps=2.88u w=1u l=1u
X64 VSS a_58646_31016# a_56942_34416# VSS nfet_06v0 ad=1.1p pd=5.88u as=0.65p ps=3.02u w=2.5u l=1u
X65 a_10486_31016# a_2170_30900# a_9898_34416# VSS nfet_06v0 ad=0.65p pd=3.02u as=1.1p ps=5.88u w=2.5u l=1u
X66 a_2370_22332# a_2170_22216# VSS VSS nfet_06v0 ad=1.25p pd=5.5u as=2.2p ps=10.88u w=5u l=1u
X67 a_36210_51776# a_40030_48260# a_35678_48376# VSS nfet_06v0 ad=1.1p pd=5.88u as=1.1p ps=5.88u w=2.5u l=1u
X68 a_5916_39692# a_9306_42976# a_6258_43092# VDD pfet_06v0 ad=2.2p pd=10.88u as=2.2p ps=10.88u w=5u l=1u
X69 a_15600_57052# a_2510_60336# VSS VSS nfet_06v0 ad=0.25p pd=1.5u as=0.44p ps=2.88u w=1u l=1u
X70 a_8782_17056# a_8062_13540# a_6858_17056# VDD pfet_06v0 ad=2.6p pd=10.52u as=4.4p ps=20.88u w=10u l=1u
X71 a_26490_51776# a_26290_51660# VDD VDD pfet_06v0 ad=2.5p pd=10.5u as=4.4p ps=20.88u w=10u l=1u
X72 a_9898_51776# a_9174_48260# a_6858_51776# VDD pfet_06v0 ad=2.6p pd=10.52u as=4.4p ps=20.88u w=10u l=1u
X73 a_31762_60336# a_23342_60336# a_31962_60452# VDD pfet_06v0 ad=4.4p pd=20.88u as=2.5p ps=10.5u w=10u l=1u
X74 VDD a_35094_51776# a_32342_48376# VDD pfet_06v0 ad=1.3p pd=5.52u as=1.3p ps=5.52u w=5u l=1u
X75 a_32904_57052# a_31884_57052# VSS VSS nfet_06v0 ad=1.25p pd=5.5u as=2.2p ps=10.88u w=5u l=1u
X76 a_59174_17056# a_64110_13540# a_58646_13656# VSS nfet_06v0 ad=1.1p pd=5.88u as=1.1p ps=5.88u w=2.5u l=1u
X77 a_23302_4744# a_23342_8144# a_34998_8260# VDD pfet_06v0 ad=4.4p pd=20.88u as=2.5p ps=10.5u w=10u l=1u
X78 a_64654_34300# a_64654_34300# a_66278_34300# VDD pfet_06v0 ad=4.4p pd=20.88u as=4.4p ps=20.88u w=10u l=1u
X79 a_12870_74260# a_59758_48376# VSS VSS nfet_06v0 ad=2.2p pd=10.88u as=1.3p ps=5.52u w=5u l=1u
X80 a_6858_34416# a_9174_30900# a_9898_34416# VDD pfet_06v0 ad=4.4p pd=20.88u as=2.6p ps=10.52u w=10u l=1u
X81 a_46830_22332# S4N a_44334_22332# VSS nfet_06v0 ad=2.2p pd=10.88u as=2.2p ps=10.88u w=5u l=1u
X82 a_32862_34416# a_2530_75936# cap_mim_2f0_m4m5_noshield c_width=20u c_length=10u
X83 a_47110_60452# a_47580_57052# VSS VSS nfet_06v0 ad=1.1p pd=5.88u as=1.1p ps=5.88u w=2.5u l=1u
X84 a_44174_25616# a_44174_25616# VDD VDD pfet_06v0 ad=0.88p pd=4.88u as=0.88p ps=4.88u w=2u l=1u
X85 a_56942_69248# a_23622_74260# cap_mim_2f0_m4m5_noshield c_width=20u c_length=10u
X86 a_50970_60336# a_50970_60336# a_52594_60336# VDD pfet_06v0 ad=4.4p pd=20.88u as=4.4p ps=20.88u w=10u l=1u
X87 a_26748_4860# a_30138_8144# a_27090_8260# VDD pfet_06v0 ad=2.2p pd=10.88u as=2.2p ps=10.88u w=5u l=1u
X88 a_2170_22216# a_2510_25616# a_15278_25732# VDD pfet_06v0 ad=4.4p pd=20.88u as=2.5p ps=10.5u w=10u l=1u
X89 a_23202_57052# a_23002_56936# VSS VSS nfet_06v0 ad=1.25p pd=5.5u as=2.2p ps=10.88u w=5u l=1u
X90 VSS a_2118_74260# a_2030_74376# VSS nfet_06v0 ad=0.44p pd=2.88u as=0.44p ps=2.88u w=1u l=1u
X91 a_56422_65848# a_32142_65732# a_54658_65848# VSS nfet_06v0 ad=1.3p pd=5.52u as=2.2p ps=10.88u w=5u l=1u
X92 a_45066_57052# a_43834_56936# VSS VSS nfet_06v0 ad=1.25p pd=5.5u as=2.2p ps=10.88u w=5u l=1u
X93 a_20410_65848# a_12130_69248# VDD VDD pfet_06v0 ad=2.6p pd=10.52u as=4.4p ps=20.88u w=10u l=1u
X94 a_31750_51776# a_26290_51660# VDD VDD pfet_06v0 ad=2.5p pd=10.5u as=4.4p ps=20.88u w=10u l=1u
X95 a_4634_25732# a_5916_22332# VSS VSS nfet_06v0 ad=1.1p pd=5.88u as=1.1p ps=5.88u w=2.5u l=1u
X96 a_50670_34300# a_50670_34300# a_53326_31016# VSS nfet_06v0 ad=0.44p pd=2.88u as=0.25p ps=1.5u w=1u l=1u
X97 VSS a_34566_48376# a_32862_51776# VSS nfet_06v0 ad=1.1p pd=5.88u as=0.65p ps=3.02u w=2.5u l=1u
X98 a_51972_4860# a_43834_4744# VSS VSS nfet_06v0 ad=1.25p pd=5.5u as=2.2p ps=10.88u w=5u l=1u
X99 a_36432_4860# a_23342_8144# VSS VSS nfet_06v0 ad=0.25p pd=1.5u as=0.44p ps=2.88u w=1u l=1u
X100 a_29476_39576# a_23342_42976# a_33886_43092# VDD pfet_06v0 ad=4.4p pd=20.88u as=2.5p ps=10.5u w=10u l=1u
X101 a_5166_39692# a_6258_43092# VDD VDD pfet_06v0 ad=2.2p pd=10.88u as=2.2p ps=10.88u w=5u l=1u
X102 a_19378_13656# a_18358_13656# VSS VSS nfet_06v0 ad=1.25p pd=5.5u as=2.2p ps=10.88u w=5u l=1u
X103 a_54658_48376# a_32142_48260# a_56422_48376# VSS nfet_06v0 ad=2.2p pd=10.88u as=1.3p ps=5.52u w=5u l=1u
X104 a_25466_25732# a_26748_22332# VSS VSS nfet_06v0 ad=1.1p pd=5.88u as=1.1p ps=5.88u w=2.5u l=1u
X105 a_55390_65848# a_51062_65732# VSS VSS nfet_06v0 ad=1.25p pd=5.5u as=2.2p ps=10.88u w=5u l=1u
X106 a_33454_65848# a_35094_69248# VDD VDD pfet_06v0 ad=1.3p pd=5.52u as=1.3p ps=5.52u w=5u l=1u
X107 a_44374_25732# a_44174_25616# a_44074_25732# VDD pfet_06v0 ad=4.4p pd=20.88u as=2.5p ps=10.5u w=10u l=1u
X108 a_33454_13656# a_35094_17056# VDD VDD pfet_06v0 ad=1.3p pd=5.52u as=2.2p ps=10.88u w=5u l=1u
X109 a_7070_43092# a_8644_39576# a_6648_39692# VSS nfet_06v0 ad=1.1p pd=5.88u as=1.1p ps=5.88u w=2.5u l=1u
X110 a_2710_60452# a_2510_60336# a_3522_60452# VDD pfet_06v0 ad=4.4p pd=20.88u as=2.5p ps=10.5u w=10u l=1u
X111 a_56422_31016# a_59174_34416# VDD VDD pfet_06v0 ad=1.3p pd=5.52u as=2.2p ps=10.88u w=5u l=1u
X112 X X VDD VDD pfet_06v0 ad=0.52p pd=2.52u as=0.52p ps=2.52u w=2u l=1u
X113 a_50370_34300# a_50670_34300# a_52294_31016# VSS nfet_06v0 ad=0.44p pd=2.88u as=0.25p ps=1.5u w=1u l=1u
X114 a_2210_69132# a_2510_69132# a_5446_69248# VDD pfet_06v0 ad=4.4p pd=20.88u as=2.5p ps=10.5u w=10u l=1u
X115 a_55830_34416# a_50370_34300# VDD VDD pfet_06v0 ad=2.5p pd=10.5u as=4.4p ps=20.88u w=10u l=1u
X116 a_26250_30900# a_26590_34300# a_26490_34416# VDD pfet_06v0 ad=4.4p pd=20.88u as=2.5p ps=10.5u w=10u l=1u
X117 a_51682_17056# a_50370_16940# VDD VDD pfet_06v0 ad=2.5p pd=10.5u as=4.4p ps=20.88u w=10u l=1u
X118 a_15278_43092# a_2210_42976# VDD VDD pfet_06v0 ad=2.5p pd=10.5u as=4.4p ps=20.88u w=10u l=1u
X119 VDD a_14246_74376# a_15066_74260# VDD pfet_06v0 ad=1.32p pd=6.88u as=1.32p ps=6.88u w=3u l=1u
X120 a_32862_34416# a_26250_30900# a_35678_31016# VSS nfet_06v0 ad=1.1p pd=5.88u as=0.65p ps=3.02u w=2.5u l=1u
X121 a_12130_34416# a_2510_34300# a_8262_31016# VDD pfet_06v0 ad=1.3p pd=5.52u as=2.2p ps=10.88u w=5u l=1u
X122 a_16494_16940# a_16494_16940# a_18118_16940# VDD pfet_06v0 ad=4.4p pd=20.88u as=4.4p ps=20.88u w=10u l=1u
X123 a_23542_60452# a_23342_60336# a_24354_60452# VDD pfet_06v0 ad=4.4p pd=20.88u as=2.5p ps=10.5u w=10u l=1u
X124 a_30138_25616# a_23302_22216# a_31140_22332# VSS nfet_06v0 ad=2.2p pd=10.88u as=1.25p ps=5.5u w=5u l=1u
X125 a_26490_69248# a_26290_69132# VDD VDD pfet_06v0 ad=2.5p pd=10.5u as=4.4p ps=20.88u w=10u l=1u
X126 a_9898_69248# a_9174_65732# a_6858_69248# VDD pfet_06v0 ad=2.6p pd=10.52u as=4.4p ps=20.88u w=10u l=1u
X127 a_55018_17056# a_32142_13540# a_56942_17056# VDD pfet_06v0 ad=4.4p pd=20.88u as=2.6p ps=10.52u w=10u l=1u
X128 a_27090_8260# a_23342_8144# a_25998_4860# VDD pfet_06v0 ad=2.2p pd=10.88u as=2.2p ps=10.88u w=5u l=1u
X129 VDD a_35094_69248# a_32342_65848# VDD pfet_06v0 ad=1.3p pd=5.52u as=1.3p ps=5.52u w=5u l=1u
X130 a_11052_57052# a_2470_56936# a_12072_57052# VSS nfet_06v0 ad=2.2p pd=10.88u as=1.25p ps=5.5u w=5u l=1u
X131 a_60290_17056# a_64110_13540# a_59758_13656# VSS nfet_06v0 ad=1.1p pd=5.88u as=1.1p ps=5.88u w=2.5u l=1u
X132 a_6858_51776# a_2510_51660# a_6558_51776# VDD pfet_06v0 ad=4.4p pd=20.88u as=2.5p ps=10.5u w=10u l=1u
X133 VSS a_66922_56900# a_66834_57016# VSS nfet_06v0 ad=0.44p pd=2.88u as=0.44p ps=2.88u w=1u l=1u
X134 a_52794_8260# a_52594_8144# VDD VDD pfet_06v0 ad=2.5p pd=10.5u as=4.4p ps=20.88u w=10u l=1u
X135 a_33978_17056# a_34566_13656# VSS VSS nfet_06v0 ad=0.65p pd=3.02u as=1.1p ps=5.88u w=2.5u l=1u
X136 a_42398_17056# a_42198_16940# VDD VDD pfet_06v0 ad=2.5p pd=10.5u as=4.4p ps=20.88u w=10u l=1u
X137 a_11598_31016# a_2170_30900# a_8782_34416# VSS nfet_06v0 ad=0.65p pd=3.02u as=1.1p ps=5.88u w=2.5u l=1u
X138 a_26590_51660# a_26590_51660# a_29246_48376# VSS nfet_06v0 ad=0.44p pd=2.88u as=0.25p ps=1.5u w=1u l=1u
X139 VSS a_12870_74260# a_15998_74376# VSS nfet_06v0 ad=0.44p pd=2.88u as=0.25p ps=1.5u w=1u l=1u
X140 a_32862_51776# a_13282_75936# cap_mim_2f0_m4m5_noshield c_width=20u c_length=10u
X141 a_47580_22332# a_44134_22216# a_47110_25732# VSS nfet_06v0 ad=1.1p pd=5.88u as=1.1p ps=5.88u w=2.5u l=1u
X142 a_30938_34416# a_26590_34300# a_31750_34416# VDD pfet_06v0 ad=4.4p pd=20.88u as=2.5p ps=10.5u w=10u l=1u
X143 a_5916_22332# a_2470_22216# a_5446_25732# VSS nfet_06v0 ad=1.1p pd=5.88u as=1.1p ps=5.88u w=2.5u l=1u
X144 a_43834_39576# a_44134_39576# a_56232_39692# VSS nfet_06v0 ad=2.2p pd=10.88u as=1.25p ps=5.5u w=5u l=1u
X145 a_9306_25616# a_2470_22216# a_10308_22332# VSS nfet_06v0 ad=2.2p pd=10.88u as=1.25p ps=5.5u w=5u l=1u
X146 a_6498_31016# a_2170_30900# a_6198_31016# VSS nfet_06v0 ad=2.2p pd=10.88u as=1.25p ps=5.5u w=5u l=1u
X147 VDD a_11014_34416# a_9374_31016# VDD pfet_06v0 ad=1.3p pd=5.52u as=1.3p ps=5.52u w=5u l=1u
X148 a_66178_40036# a_66178_40036# a_68442_40152# VSS nfet_06v0 ad=0.308p pd=2.28u as=0.175p ps=1.2u w=0.7u l=1u
X149 a_27902_43092# a_23342_42976# a_25266_39692# VDD pfet_06v0 ad=2.2p pd=10.88u as=2.2p ps=10.88u w=5u l=1u
X150 X a_27494_74376# a_64728_6528# VSS nfet_06v0 ad=0.6448p pd=3u as=1.0912p ps=5.84u w=2.48u l=1u
X151 a_2410_25732# a_2210_25616# VDD VDD pfet_06v0 ad=2.5p pd=10.5u as=4.4p ps=20.88u w=10u l=1u
X152 a_31750_69248# a_26290_69132# VDD VDD pfet_06v0 ad=2.5p pd=10.5u as=4.4p ps=20.88u w=10u l=1u
X153 a_29526_34416# a_26290_34300# VDD VDD pfet_06v0 ad=2.5p pd=10.5u as=4.4p ps=20.88u w=10u l=1u
X154 a_44174_8144# a_44174_8144# VDD VDD pfet_06v0 ad=0.88p pd=4.88u as=0.88p ps=4.88u w=2u l=1u
X155 a_26748_22332# a_23302_22216# a_26278_25732# VSS nfet_06v0 ad=1.1p pd=5.88u as=1.1p ps=5.88u w=2.5u l=1u
X156 a_13054_43092# a_2210_42976# VDD VDD pfet_06v0 ad=2.5p pd=10.5u as=4.4p ps=20.88u w=10u l=1u
X157 a_8062_13540# a_27480_4860# VSS VSS nfet_06v0 ad=0.44p pd=2.88u as=0.44p ps=2.88u w=1u l=1u
X158 a_43874_25616# a_44174_25616# a_58866_25732# VDD pfet_06v0 ad=4.4p pd=20.88u as=2.5p ps=10.5u w=10u l=1u
X159 a_50308_56936# a_44174_60336# a_54718_60452# VDD pfet_06v0 ad=4.4p pd=20.88u as=2.5p ps=10.5u w=10u l=1u
X160 a_2210_25616# a_2510_25616# a_15600_22332# VSS nfet_06v0 ad=0.44p pd=2.88u as=0.25p ps=1.5u w=1u l=1u
X161 a_23242_25732# a_23042_25616# VDD VDD pfet_06v0 ad=2.5p pd=10.5u as=4.4p ps=20.88u w=10u l=1u
X162 a_64728_41360# a_66178_40036# VSS VSS nfet_06v0 ad=0.5456p pd=3.36u as=0.5456p ps=3.36u w=1.24u l=1u
X163 a_64728_22792# a_14978_74376# Y VSS nfet_06v0 ad=1.0912p pd=5.84u as=0.6448p ps=3u w=2.48u l=1u
X164 a_57534_65848# a_8062_65732# a_54658_65848# VSS nfet_06v0 ad=1.3p pd=5.52u as=2.2p ps=10.88u w=5u l=1u
X165 a_64726_56900# a_60290_17056# VDD VDD pfet_06v0 ad=4.4p pd=20.88u as=2.6p ps=10.52u w=10u l=1u
X166 a_7230_31016# a_2902_30900# VSS VSS nfet_06v0 ad=1.25p pd=5.5u as=2.2p ps=10.88u w=5u l=1u
X167 a_32862_51776# a_32142_48260# a_30938_51776# VDD pfet_06v0 ad=2.6p pd=10.52u as=4.4p ps=20.88u w=10u l=1u
X168 a_51062_65732# a_50330_65732# a_51262_65848# VSS nfet_06v0 ad=2.2p pd=10.88u as=1.25p ps=5.5u w=5u l=1u
X169 a_2470_4744# a_2510_8144# a_14166_8260# VDD pfet_06v0 ad=4.4p pd=20.88u as=2.5p ps=10.5u w=10u l=1u
X170 Y a_25730_74376# a_64728_24000# VSS nfet_06v0 ad=0.6448p pd=3u as=1.0912p ps=5.84u w=2.48u l=1u
X171 a_27090_8260# a_29476_4744# a_26748_4860# VSS nfet_06v0 ad=1.1p pd=5.88u as=1.1p ps=5.88u w=2.5u l=1u
X172 a_46830_57052# a_47922_60452# VDD VDD pfet_06v0 ad=2.2p pd=10.88u as=2.2p ps=10.88u w=5u l=1u
X173 a_67538_65848# a_66518_65848# VSS VSS nfet_06v0 ad=1.25p pd=5.5u as=2.2p ps=10.88u w=5u l=1u
X174 a_59174_17056# a_50670_16940# a_57534_13656# VDD pfet_06v0 ad=1.3p pd=5.52u as=2.2p ps=10.88u w=5u l=1u
X175 a_30638_17056# a_26290_16940# VDD VDD pfet_06v0 ad=2.5p pd=10.5u as=4.4p ps=20.88u w=10u l=1u
X176 VDD a_36210_17056# a_44490_13656# VDD pfet_06v0 ad=2.6p pd=10.52u as=2.6p ps=10.52u w=10u l=1u
X177 a_32142_48260# a_48734_43092# VDD VDD pfet_06v0 ad=0.308p pd=2.28u as=0.308p ps=2.28u w=0.7u l=20u
X178 a_28514_74376# a_24034_75936# a_27582_74260# VSS nfet_06v0 ad=0.25p pd=1.5u as=0.44p ps=2.88u w=1u l=1u
X179 a_54658_31016# a_50330_30900# a_55390_31016# VSS nfet_06v0 ad=2.2p pd=10.88u as=1.25p ps=5.5u w=5u l=1u
X180 a_54658_48376# a_8062_48260# a_57534_48376# VSS nfet_06v0 ad=2.2p pd=10.88u as=1.3p ps=5.52u w=5u l=1u
X181 a_2530_75936# a_35678_31016# VSS VSS nfet_06v0 ad=1.3p pd=5.52u as=2.2p ps=10.88u w=5u l=1u
X182 a_44374_25732# a_44174_25616# a_45186_25732# VDD pfet_06v0 ad=4.4p pd=20.88u as=2.5p ps=10.5u w=10u l=1u
X183 a_27480_57052# a_30138_60336# a_27902_60452# VDD pfet_06v0 ad=2.2p pd=10.88u as=2.2p ps=10.88u w=5u l=1u
X184 a_23302_39576# a_23302_39576# VSS VSS nfet_06v0 ad=0.44p pd=2.88u as=0.44p ps=2.88u w=1u l=1u
X185 a_23502_22332# a_23302_22216# a_23202_22332# VSS nfet_06v0 ad=2.2p pd=10.88u as=1.25p ps=5.5u w=5u l=1u
X186 VSS a_64726_56900# a_64638_57016# VSS nfet_06v0 ad=0.44p pd=2.88u as=0.44p ps=2.88u w=1u l=1u
X187 a_29476_22216# a_29476_22216# a_31884_22332# VSS nfet_06v0 ad=2.2p pd=10.88u as=2.2p ps=10.88u w=5u l=1u
X188 a_9174_48260# a_7070_43092# VDD VDD pfet_06v0 ad=0.308p pd=2.28u as=0.308p ps=2.28u w=0.7u l=20u
X189 a_58866_43092# a_43874_42976# VDD VDD pfet_06v0 ad=2.5p pd=10.5u as=4.4p ps=20.88u w=10u l=1u
X190 a_30938_51776# a_9174_48260# a_33978_51776# VDD pfet_06v0 ad=4.4p pd=20.88u as=2.6p ps=10.52u w=10u l=1u
X191 a_11598_48376# a_16494_51660# a_12130_51776# VDD pfet_06v0 ad=2.2p pd=10.88u as=2.2p ps=10.88u w=5u l=1u
X192 a_6858_69248# a_2510_69132# a_6558_69248# VDD pfet_06v0 ad=4.4p pd=20.88u as=2.5p ps=10.5u w=10u l=1u
X193 a_56942_34416# a_32142_30900# a_55018_34416# VDD pfet_06v0 ad=2.6p pd=10.52u as=4.4p ps=20.88u w=10u l=1u
X194 a_50670_16940# a_50670_16940# VDD VDD pfet_06v0 ad=0.88p pd=4.88u as=0.88p ps=4.88u w=2u l=1u
X195 a_9174_13540# a_4434_4860# cap_mim_2f0_m4m5_noshield c_width=20u c_length=10u
X196 VSS a_58646_48376# a_58058_51776# VSS nfet_06v0 ad=1.1p pd=5.88u as=0.65p ps=3.02u w=2.5u l=1u
X197 a_31140_4860# a_23002_4744# VSS VSS nfet_06v0 ad=1.25p pd=5.5u as=2.2p ps=10.88u w=5u l=1u
X198 VSS a_34566_31016# a_33978_34416# VSS nfet_06v0 ad=0.65p pd=3.02u as=0.65p ps=3.02u w=2.5u l=1u
X199 a_8782_51776# a_10486_48376# VSS VSS nfet_06v0 ad=0.65p pd=3.02u as=1.1p ps=5.88u w=2.5u l=1u
X200 a_2510_25616# a_2510_25616# VDD VDD pfet_06v0 ad=0.88p pd=4.88u as=0.88p ps=4.88u w=2u l=1u
X201 a_42438_65848# a_26250_65732# a_43458_65848# VSS nfet_06v0 ad=2.2p pd=10.88u as=1.25p ps=5.5u w=5u l=1u
X202 a_15600_4860# a_2510_8144# VSS VSS nfet_06v0 ad=0.25p pd=1.5u as=0.44p ps=2.88u w=1u l=1u
X203 VDD a_44490_13656# a_65038_58692# VDD pfet_06v0 ad=1.32p pd=6.88u as=0.75p ps=3.5u w=3u l=1u
X204 a_9306_60336# a_9306_60336# a_10930_60336# VDD pfet_06v0 ad=4.4p pd=20.88u as=4.4p ps=20.88u w=10u l=1u
X205 a_35400_39692# a_23002_39576# VSS VSS nfet_06v0 ad=1.25p pd=5.5u as=2.2p ps=10.88u w=5u l=1u
X206 a_2510_69132# a_2510_69132# a_5166_65848# VSS nfet_06v0 ad=0.44p pd=2.88u as=0.25p ps=1.5u w=1u l=1u
X207 a_9174_48260# a_4434_39692# cap_mim_2f0_m4m5_noshield c_width=20u c_length=10u
X208 a_26250_13540# a_26250_13540# VSS VSS nfet_06v0 ad=0.44p pd=2.88u as=0.44p ps=2.88u w=1u l=1u
X209 a_8062_13540# a_27902_8260# VDD VDD pfet_06v0 ad=0.308p pd=2.28u as=0.308p ps=2.28u w=0.7u l=20u
X210 VDD a_24034_75936# a_23934_76052# VDD pfet_06v0 ad=1.32p pd=6.88u as=0.75p ps=3.5u w=3u l=1u
X211 a_8062_13540# a_25266_4860# cap_mim_2f0_m4m5_noshield c_width=20u c_length=10u
X212 VSS a_10486_65848# a_9898_69248# VSS nfet_06v0 ad=1.1p pd=5.88u as=0.65p ps=3.02u w=2.5u l=1u
X213 a_4634_8260# S1P a_2710_8260# VDD pfet_06v0 ad=4.4p pd=20.88u as=4.4p ps=20.88u w=10u l=1u
X214 a_64110_48260# a_50670_51660# a_68402_51776# VDD pfet_06v0 ad=4.4p pd=20.88u as=2.5p ps=10.5u w=10u l=1u
X215 a_2370_4860# a_2170_4744# VSS VSS nfet_06v0 ad=1.25p pd=5.5u as=2.2p ps=10.88u w=5u l=1u
X216 a_69828_6528# a_68598_57016# X VSS nfet_06v0 ad=1.0912p pd=5.84u as=0.6448p ps=3u w=2.48u l=1u
X217 a_23002_39576# a_23342_42976# a_36110_43092# VDD pfet_06v0 ad=4.4p pd=20.88u as=2.5p ps=10.5u w=10u l=1u
X218 a_17762_74376# a_13282_75936# a_16830_74260# VSS nfet_06v0 ad=0.25p pd=1.5u as=0.44p ps=2.88u w=1u l=1u
X219 a_38034_25732# a_23042_25616# VDD VDD pfet_06v0 ad=2.5p pd=10.5u as=4.4p ps=20.88u w=10u l=1u
X220 a_55018_34416# a_8062_30900# a_58058_34416# VDD pfet_06v0 ad=4.4p pd=20.88u as=2.6p ps=10.52u w=10u l=1u
X221 a_31140_57052# a_23002_56936# VSS VSS nfet_06v0 ad=1.25p pd=5.5u as=2.2p ps=10.88u w=5u l=1u
X222 a_3582_74260# a_12130_34416# VDD VDD pfet_06v0 ad=4.4p pd=20.88u as=2.6p ps=10.52u w=10u l=1u
X223 VDD Z Z VDD pfet_06v0 ad=0.88p pd=4.88u as=0.52p ps=2.52u w=2u l=1u
X224 VSS a_35678_13656# a_44490_13656# VSS nfet_06v0 ad=1.3p pd=5.52u as=1.3p ps=5.52u w=5u l=1u
X225 a_17202_8260# a_2210_8144# VDD VDD pfet_06v0 ad=2.5p pd=10.5u as=4.4p ps=20.88u w=10u l=1u
X226 a_24354_8260# a_23042_8144# VDD VDD pfet_06v0 ad=2.5p pd=10.5u as=4.4p ps=20.88u w=10u l=1u
X227 a_8062_48260# a_25266_39692# cap_mim_2f0_m4m5_noshield c_width=20u c_length=10u
X228 a_3522_25732# a_2210_25616# VDD VDD pfet_06v0 ad=2.5p pd=10.5u as=4.4p ps=20.88u w=10u l=1u
X229 a_32862_69248# a_32142_65732# a_30938_69248# VDD pfet_06v0 ad=2.6p pd=10.52u as=4.4p ps=20.88u w=10u l=1u
X230 a_64728_6528# a_66178_5204# VSS VSS nfet_06v0 ad=0.5456p pd=3.36u as=0.5456p ps=3.36u w=1.24u l=1u
X231 a_2902_30900# a_2170_30900# a_3102_31016# VSS nfet_06v0 ad=2.2p pd=10.88u as=1.25p ps=5.5u w=5u l=1u
X232 a_31962_8260# a_31762_8144# VDD VDD pfet_06v0 ad=2.5p pd=10.5u as=4.4p ps=20.88u w=10u l=1u
X233 a_15950_13540# a_15950_13540# a_18358_13656# VSS nfet_06v0 ad=2.2p pd=10.88u as=2.2p ps=10.88u w=5u l=1u
X234 a_14166_43092# a_2210_42976# VDD VDD pfet_06v0 ad=2.5p pd=10.5u as=4.4p ps=20.88u w=10u l=1u
X235 VDD a_11014_51776# a_8262_48376# VDD pfet_06v0 ad=2.2p pd=10.88u as=1.3p ps=5.52u w=5u l=1u
X236 a_6258_43092# a_8644_39576# a_5916_39692# VSS nfet_06v0 ad=1.1p pd=5.88u as=1.1p ps=5.88u w=2.5u l=1u
X237 VDD a_13282_75936# a_13182_76052# VDD pfet_06v0 ad=1.32p pd=6.88u as=0.75p ps=3.5u w=3u l=1u
X238 a_24354_25732# a_23042_25616# VDD VDD pfet_06v0 ad=2.5p pd=10.5u as=4.4p ps=20.88u w=10u l=1u
X239 a_58646_65848# a_50330_65732# a_58058_69248# VSS nfet_06v0 ad=0.65p pd=3.02u as=1.1p ps=5.88u w=2.5u l=1u
X240 a_69084_6528# X VSS VSS nfet_06v0 ad=0.5p pd=2.5u as=0.88p ps=4.88u w=2u l=1u
X241 a_54358_48376# a_51062_48260# VSS VSS nfet_06v0 ad=1.25p pd=5.5u as=2.2p ps=10.88u w=5u l=1u
X242 VDD a_2118_74260# a_4314_74260# VDD pfet_06v0 ad=1.32p pd=6.88u as=1.32p ps=6.88u w=3u l=1u
X243 a_48312_22332# a_50970_25616# a_48734_25732# VDD pfet_06v0 ad=2.2p pd=10.88u as=2.2p ps=10.88u w=5u l=1u
X244 a_7670_51776# a_2210_51660# VDD VDD pfet_06v0 ad=2.5p pd=10.5u as=4.4p ps=20.88u w=10u l=1u
X245 Y a_4226_74376# a_65840_24000# VSS nfet_06v0 ad=0.6448p pd=3u as=1.0912p ps=5.84u w=2.48u l=1u
X246 a_2170_30900# a_2170_30900# VSS VSS nfet_06v0 ad=0.44p pd=2.88u as=0.44p ps=2.88u w=1u l=1u
X247 a_23342_42976# a_23342_42976# a_37464_39692# VSS nfet_06v0 ad=0.44p pd=2.88u as=0.25p ps=1.5u w=1u l=1u
X248 VSS a_20410_65848# a_24998_74376# VSS nfet_06v0 ad=0.44p pd=2.88u as=0.44p ps=2.88u w=1u l=1u
X249 a_66518_31016# a_50330_30900# a_67538_31016# VSS nfet_06v0 ad=2.2p pd=10.88u as=1.25p ps=5.5u w=5u l=1u
X250 VDD a_11014_34416# a_9374_31016# VDD pfet_06v0 ad=2.2p pd=10.88u as=1.3p ps=5.52u w=5u l=1u
X251 a_27090_43092# a_29476_39576# a_26748_39692# VSS nfet_06v0 ad=1.1p pd=5.88u as=1.1p ps=5.88u w=2.5u l=1u
X252 a_47110_60452# S2N a_44374_60452# VDD pfet_06v0 ad=4.4p pd=20.88u as=4.4p ps=20.88u w=10u l=1u
X253 a_31884_39692# a_23302_39576# a_32904_39692# VSS nfet_06v0 ad=2.2p pd=10.88u as=1.25p ps=5.5u w=5u l=1u
X254 a_32342_13656# a_32142_13540# a_30578_13656# VSS nfet_06v0 ad=1.3p pd=5.52u as=2.2p ps=10.88u w=5u l=1u
X255 a_11598_65848# a_16494_69132# a_12130_69248# VDD pfet_06v0 ad=2.2p pd=10.88u as=2.2p ps=10.88u w=5u l=1u
X256 a_30938_69248# a_9174_65732# a_33978_69248# VDD pfet_06v0 ad=4.4p pd=20.88u as=2.6p ps=10.52u w=10u l=1u
X257 a_26982_48260# a_26590_51660# a_27602_51776# VDD pfet_06v0 ad=4.4p pd=20.88u as=2.5p ps=10.5u w=10u l=1u
X258 a_56942_69248# a_58646_65848# VSS VSS nfet_06v0 ad=0.65p pd=3.02u as=1.1p ps=5.88u w=2.5u l=1u
X259 VSS a_34566_31016# a_33978_34416# VSS nfet_06v0 ad=1.1p pd=5.88u as=0.65p ps=3.02u w=2.5u l=1u
X260 a_9174_13540# a_6648_4860# VSS VSS nfet_06v0 ad=0.44p pd=2.88u as=0.44p ps=2.88u w=1u l=1u
X261 a_5446_17056# a_2210_16940# VDD VDD pfet_06v0 ad=2.5p pd=10.5u as=4.4p ps=20.88u w=10u l=1u
X262 VDD a_35094_34416# a_32342_31016# VDD pfet_06v0 ad=2.2p pd=10.88u as=1.3p ps=5.52u w=5u l=1u
X263 a_47922_43092# a_50308_39576# a_47580_39692# VSS nfet_06v0 ad=1.1p pd=5.88u as=1.1p ps=5.88u w=2.5u l=1u
X264 a_9174_65732# a_4434_57052# cap_mim_2f0_m4m5_noshield c_width=20u c_length=10u
X265 a_58646_13656# a_64654_16940# a_59174_17056# VDD pfet_06v0 ad=2.2p pd=10.88u as=2.2p ps=10.88u w=5u l=1u
X266 a_6198_65848# a_2902_65732# VSS VSS nfet_06v0 ad=1.25p pd=5.5u as=2.2p ps=10.88u w=5u l=1u
X267 a_27182_13656# a_26982_13540# VSS VSS nfet_06v0 ad=1.25p pd=5.5u as=2.2p ps=10.88u w=5u l=1u
X268 a_30578_48376# a_26250_48260# a_30278_48376# VSS nfet_06v0 ad=2.2p pd=10.88u as=1.25p ps=5.5u w=5u l=1u
X269 a_17614_48376# a_2902_48260# VSS VSS nfet_06v0 ad=1.25p pd=5.5u as=2.2p ps=10.88u w=5u l=1u
X270 a_18118_51660# a_2510_51660# a_18318_51776# VDD pfet_06v0 ad=4.4p pd=20.88u as=2.5p ps=10.5u w=10u l=1u
X271 a_66178_5204# a_66178_5204# VDD VDD pfet_06v0 ad=0.88p pd=4.88u as=0.88p ps=4.88u w=2u l=1u
X272 a_64110_65732# a_50670_69132# a_68402_69248# VDD pfet_06v0 ad=4.4p pd=20.88u as=2.5p ps=10.5u w=10u l=1u
X273 a_32862_17056# a_34566_13656# VSS VSS nfet_06v0 ad=0.65p pd=3.02u as=1.1p ps=5.88u w=2.5u l=1u
X274 a_9374_13656# a_11014_17056# VDD VDD pfet_06v0 ad=1.3p pd=5.52u as=1.3p ps=5.52u w=5u l=1u
X275 a_9898_34416# a_10486_31016# VSS VSS nfet_06v0 ad=0.65p pd=3.02u as=0.65p ps=3.02u w=2.5u l=1u
X276 a_44334_39692# a_44134_39576# a_45066_39692# VSS nfet_06v0 ad=2.2p pd=10.88u as=1.25p ps=5.5u w=5u l=1u
X277 VSS a_58646_48376# a_56942_51776# VSS nfet_06v0 ad=0.65p pd=3.02u as=0.65p ps=3.02u w=2.5u l=1u
X278 a_55830_60452# a_43874_60336# VDD VDD pfet_06v0 ad=2.5p pd=10.5u as=4.4p ps=20.88u w=10u l=1u
X279 a_8262_31016# a_11014_34416# VDD VDD pfet_06v0 ad=1.3p pd=5.52u as=1.3p ps=5.52u w=5u l=1u
X280 a_54718_25732# a_43874_25616# VDD VDD pfet_06v0 ad=2.5p pd=10.5u as=4.4p ps=20.88u w=10u l=1u
X281 a_8644_56936# a_2510_60336# a_13054_60452# VDD pfet_06v0 ad=4.4p pd=20.88u as=2.5p ps=10.5u w=10u l=1u
X282 a_58296_57052# a_44174_60336# VSS VSS nfet_06v0 ad=0.25p pd=1.5u as=0.44p ps=2.88u w=1u l=1u
X283 a_57534_48376# a_59174_51776# VDD VDD pfet_06v0 ad=1.3p pd=5.52u as=1.3p ps=5.52u w=5u l=1u
X284 a_58058_17056# a_58646_13656# VSS VSS nfet_06v0 ad=0.65p pd=3.02u as=0.65p ps=3.02u w=2.5u l=1u
X285 a_48734_8260# a_50308_4744# a_48312_4860# VSS nfet_06v0 ad=1.1p pd=5.88u as=1.1p ps=5.88u w=2.5u l=1u
X286 a_2530_75936# a_35678_31016# VSS VSS nfet_06v0 ad=2.2p pd=10.88u as=1.3p ps=5.52u w=5u l=1u
X287 a_8062_65732# a_25266_57052# cap_mim_2f0_m4m5_noshield c_width=20u c_length=10u
X288 VSS a_10486_65848# a_8782_69248# VSS nfet_06v0 ad=0.65p pd=3.02u as=0.65p ps=3.02u w=2.5u l=1u
X289 a_31310_48376# a_26982_48260# VSS VSS nfet_06v0 ad=1.25p pd=5.5u as=2.2p ps=10.88u w=5u l=1u
X290 a_60290_51776# a_50670_51660# a_56422_48376# VDD pfet_06v0 ad=1.3p pd=5.52u as=2.2p ps=10.88u w=5u l=1u
X291 a_8782_17056# a_20410_13656# cap_mim_2f0_m4m5_noshield c_width=20u c_length=10u
X292 a_6648_39692# a_2470_39576# a_4634_43092# VSS nfet_06v0 ad=1.1p pd=5.88u as=1.1p ps=5.88u w=2.5u l=1u
X293 a_11014_51776# a_2510_51660# a_9374_48376# VDD pfet_06v0 ad=1.3p pd=5.52u as=2.2p ps=10.88u w=5u l=1u
X294 a_4134_31016# a_2510_34300# VSS VSS nfet_06v0 ad=0.25p pd=1.5u as=0.44p ps=2.88u w=1u l=1u
X295 a_46298_43092# S1P a_44374_43092# VDD pfet_06v0 ad=4.4p pd=20.88u as=4.4p ps=20.88u w=10u l=1u
X296 VDD a_11014_69248# a_8262_65848# VDD pfet_06v0 ad=2.2p pd=10.88u as=1.3p ps=5.52u w=5u l=1u
X297 VDD a_11014_17056# a_8262_13656# VDD pfet_06v0 ad=1.3p pd=5.52u as=1.3p ps=5.52u w=5u l=1u
X298 a_6858_34416# a_2510_34300# a_7670_34416# VDD pfet_06v0 ad=4.4p pd=20.88u as=2.5p ps=10.5u w=10u l=1u
X299 XP a_68062_8632# VDD VDD pfet_05v0 ad=0.8052p pd=4.54u as=0.8052p ps=4.54u w=1.83u l=0.5u
X300 a_8782_51776# a_10486_48376# VSS VSS nfet_06v0 ad=0.65p pd=3.02u as=0.65p ps=3.02u w=2.5u l=1u
X301 a_50570_51776# a_50370_51660# VDD VDD pfet_06v0 ad=2.5p pd=10.5u as=4.4p ps=20.88u w=10u l=1u
X302 a_4634_25732# S1P a_2710_25732# VDD pfet_06v0 ad=4.4p pd=20.88u as=4.4p ps=20.88u w=10u l=1u
X303 a_9174_13540# a_7070_8260# VDD VDD pfet_06v0 ad=0.308p pd=2.28u as=0.308p ps=2.28u w=0.7u l=20u
X304 a_16632_39692# a_2510_42976# VSS VSS nfet_06v0 ad=0.25p pd=1.5u as=0.44p ps=2.88u w=1u l=1u
X305 a_64110_65732# a_64110_65732# a_66518_65848# VSS nfet_06v0 ad=2.2p pd=10.88u as=2.2p ps=10.88u w=5u l=1u
X306 a_7670_69248# a_2210_69132# VDD VDD pfet_06v0 ad=2.5p pd=10.5u as=4.4p ps=20.88u w=10u l=1u
X307 VDD a_59174_51776# a_56422_48376# VDD pfet_06v0 ad=1.3p pd=5.52u as=1.3p ps=5.52u w=5u l=1u
X308 VSS a_10486_31016# a_8782_34416# VSS nfet_06v0 ad=1.1p pd=5.88u as=0.65p ps=3.02u w=2.5u l=1u
X309 a_25266_57052# a_27090_60452# VDD VDD pfet_06v0 ad=2.2p pd=10.88u as=2.2p ps=10.88u w=5u l=1u
X310 a_47110_8260# S3N a_44374_8260# VDD pfet_06v0 ad=4.4p pd=20.88u as=4.4p ps=20.88u w=10u l=1u
X311 VDD Z Z VDD pfet_06v0 ad=0.52p pd=2.52u as=0.52p ps=2.52u w=2u l=1u
X312 a_51262_13656# a_51062_13540# VSS VSS nfet_06v0 ad=1.25p pd=5.5u as=2.2p ps=10.88u w=5u l=1u
X313 a_8062_48260# a_27480_39692# VSS VSS nfet_06v0 ad=0.44p pd=2.88u as=0.44p ps=2.88u w=1u l=1u
X314 a_26982_65732# a_26590_69132# a_27602_69248# VDD pfet_06v0 ad=4.4p pd=20.88u as=2.5p ps=10.5u w=10u l=1u
X315 a_30578_31016# a_32142_30900# a_32342_31016# VSS nfet_06v0 ad=2.2p pd=10.88u as=1.3p ps=5.52u w=5u l=1u
X316 a_8262_48376# a_2510_51660# a_12130_51776# VDD pfet_06v0 ad=2.2p pd=10.88u as=1.3p ps=5.52u w=5u l=1u
X317 a_11130_60452# a_10930_60336# VDD VDD pfet_06v0 ad=2.5p pd=10.5u as=4.4p ps=20.88u w=10u l=1u
X318 a_25466_25732# S2P a_23542_25732# VDD pfet_06v0 ad=4.4p pd=20.88u as=4.4p ps=20.88u w=10u l=1u
X319 a_3402_39692# a_2170_39576# VSS VSS nfet_06v0 ad=1.25p pd=5.5u as=2.2p ps=10.88u w=5u l=1u
X320 a_59758_65848# a_50330_65732# a_56942_69248# VSS nfet_06v0 ad=0.65p pd=3.02u as=1.1p ps=5.88u w=2.5u l=1u
X321 a_52594_25616# a_44174_25616# a_52794_25732# VDD pfet_06v0 ad=4.4p pd=20.88u as=2.5p ps=10.5u w=10u l=1u
X322 a_8062_30900# a_27902_25732# VDD VDD pfet_06v0 ad=0.308p pd=2.28u as=0.308p ps=2.28u w=0.7u l=20u
X323 a_33978_51776# a_26250_48260# a_34566_48376# VSS nfet_06v0 ad=1.1p pd=5.88u as=0.65p ps=3.02u w=2.5u l=1u
X324 a_26278_43092# a_26748_39692# VSS VSS nfet_06v0 ad=1.1p pd=5.88u as=1.1p ps=5.88u w=2.5u l=1u
X325 a_29246_31016# a_26590_34300# VSS VSS nfet_06v0 ad=0.25p pd=1.5u as=0.44p ps=2.88u w=1u l=1u
X326 a_69828_41360# a_64638_57016# Z VSS nfet_06v0 ad=1.0912p pd=5.84u as=0.6448p ps=3u w=2.48u l=1u
X327 a_8782_51776# a_8062_48260# a_6858_51776# VDD pfet_06v0 ad=2.6p pd=10.52u as=4.4p ps=20.88u w=10u l=1u
X328 a_8782_17056# a_2170_13540# a_11598_13656# VSS nfet_06v0 ad=1.1p pd=5.88u as=0.65p ps=3.02u w=2.5u l=1u
X329 a_65774_65848# a_51062_65732# VSS VSS nfet_06v0 ad=1.25p pd=5.5u as=2.2p ps=10.88u w=5u l=1u
X330 a_26750_74376# a_24998_74376# a_25818_74260# VSS nfet_06v0 ad=0.25p pd=1.5u as=0.44p ps=2.88u w=1u l=1u
X331 a_33454_13656# a_9174_13540# a_30578_13656# VSS nfet_06v0 ad=1.3p pd=5.52u as=2.2p ps=10.88u w=5u l=1u
X332 a_24234_39692# a_23002_39576# VSS VSS nfet_06v0 ad=1.25p pd=5.5u as=2.2p ps=10.88u w=5u l=1u
X333 a_18118_69132# a_2510_69132# a_18318_69248# VDD pfet_06v0 ad=4.4p pd=20.88u as=2.5p ps=10.5u w=10u l=1u
X334 a_44074_43092# a_43874_42976# VDD VDD pfet_06v0 ad=2.5p pd=10.5u as=4.4p ps=20.88u w=10u l=1u
X335 a_56232_22332# a_43834_22216# VSS VSS nfet_06v0 ad=1.25p pd=5.5u as=2.2p ps=10.88u w=5u l=1u
X336 a_46098_39692# S1P a_44334_39692# VSS nfet_06v0 ad=2.2p pd=10.88u as=2.2p ps=10.88u w=5u l=1u
X337 a_11130_8260# a_10930_8144# VDD VDD pfet_06v0 ad=2.5p pd=10.5u as=4.4p ps=20.88u w=10u l=1u
X338 VSS a_58646_48376# a_56942_51776# VSS nfet_06v0 ad=1.1p pd=5.88u as=0.65p ps=3.02u w=2.5u l=1u
X339 a_10486_48376# a_2170_48260# a_9898_51776# VSS nfet_06v0 ad=0.65p pd=3.02u as=1.1p ps=5.88u w=2.5u l=1u
X340 a_6558_17056# a_2210_16940# VDD VDD pfet_06v0 ad=2.5p pd=10.5u as=4.4p ps=20.88u w=10u l=1u
X341 VSS a_34566_31016# a_32862_34416# VSS nfet_06v0 ad=0.65p pd=3.02u as=0.65p ps=3.02u w=2.5u l=1u
X342 a_66178_40036# a_66178_40036# VDD VDD pfet_06v0 ad=0.88p pd=4.88u as=0.88p ps=4.88u w=2u l=1u
X343 a_2370_39692# a_2170_39576# VSS VSS nfet_06v0 ad=1.25p pd=5.5u as=2.2p ps=10.88u w=5u l=1u
X344 a_7070_60452# a_2510_60336# a_4434_57052# VDD pfet_06v0 ad=2.2p pd=10.88u as=2.2p ps=10.88u w=5u l=1u
X345 a_54658_13656# a_50330_13540# a_54358_13656# VSS nfet_06v0 ad=2.2p pd=10.88u as=1.25p ps=5.5u w=5u l=1u
X346 a_2410_34416# a_2210_34300# VDD VDD pfet_06v0 ad=2.5p pd=10.5u as=4.4p ps=20.88u w=10u l=1u
X347 a_43458_13656# a_42438_13656# VSS VSS nfet_06v0 ad=1.25p pd=5.5u as=2.2p ps=10.88u w=5u l=1u
X348 a_32342_31016# a_26590_34300# a_36210_34416# VDD pfet_06v0 ad=2.2p pd=10.88u as=1.3p ps=5.52u w=5u l=1u
X349 a_57534_65848# a_59174_69248# VDD VDD pfet_06v0 ad=1.3p pd=5.52u as=1.3p ps=5.52u w=5u l=1u
X350 a_20410_13656# a_8262_13656# cap_mim_2f0_m4m5_noshield c_width=20u c_length=10u
X351 a_57534_13656# a_59174_17056# VDD VDD pfet_06v0 ad=1.3p pd=5.52u as=2.2p ps=10.88u w=5u l=1u
X352 a_31884_4860# a_23302_4744# a_32904_4860# VSS nfet_06v0 ad=2.2p pd=10.88u as=1.25p ps=5.5u w=5u l=1u
X353 VSS a_16830_74260# a_16742_74376# VSS nfet_06v0 ad=0.44p pd=2.88u as=0.44p ps=2.88u w=1u l=1u
X354 a_3102_65848# a_2902_65732# VSS VSS nfet_06v0 ad=1.25p pd=5.5u as=2.2p ps=10.88u w=5u l=1u
X355 a_60290_69248# a_50670_69132# a_56422_65848# VDD pfet_06v0 ad=1.3p pd=5.52u as=2.2p ps=10.88u w=5u l=1u
X356 a_40574_69132# a_26250_65732# a_41694_65848# VSS nfet_06v0 ad=2.2p pd=10.88u as=1.25p ps=5.5u w=5u l=1u
X357 Y Y VDD VDD pfet_06v0 ad=0.52p pd=2.52u as=0.52p ps=2.52u w=2u l=1u
X358 Z Z VDD VDD pfet_06v0 ad=0.52p pd=2.52u as=0.88p ps=4.88u w=2u l=1u
X359 a_56942_60452# a_43874_60336# VDD VDD pfet_06v0 ad=2.5p pd=10.5u as=4.4p ps=20.88u w=10u l=1u
X360 a_11014_69248# a_2510_69132# a_9374_65848# VDD pfet_06v0 ad=1.3p pd=5.52u as=2.2p ps=10.88u w=5u l=1u
X361 a_46830_39692# S1N a_44334_39692# VSS nfet_06v0 ad=2.2p pd=10.88u as=2.2p ps=10.88u w=5u l=1u
X362 a_52794_43092# a_52594_42976# VDD VDD pfet_06v0 ad=2.5p pd=10.5u as=4.4p ps=20.88u w=10u l=1u
X363 a_50330_30900# a_50670_34300# a_50570_34416# VDD pfet_06v0 ad=4.4p pd=20.88u as=2.5p ps=10.5u w=10u l=1u
X364 a_2470_56936# a_2510_60336# a_14166_60452# VDD pfet_06v0 ad=4.4p pd=20.88u as=2.5p ps=10.5u w=10u l=1u
X365 a_56942_69248# a_58646_65848# VSS VSS nfet_06v0 ad=0.65p pd=3.02u as=0.65p ps=3.02u w=2.5u l=1u
X366 a_40574_16940# a_40574_16940# a_42198_16940# VDD pfet_06v0 ad=4.4p pd=20.88u as=4.4p ps=20.88u w=10u l=1u
X367 a_9898_34416# a_10486_31016# VSS VSS nfet_06v0 ad=0.65p pd=3.02u as=1.1p ps=5.88u w=2.5u l=1u
X368 a_8262_31016# a_11014_34416# VDD VDD pfet_06v0 ad=1.3p pd=5.52u as=2.2p ps=10.88u w=5u l=1u
X369 a_50570_69248# a_50370_69132# VDD VDD pfet_06v0 ad=2.5p pd=10.5u as=4.4p ps=20.88u w=10u l=1u
X370 a_16494_16940# a_2170_13540# a_17614_13656# VSS nfet_06v0 ad=2.2p pd=10.88u as=1.25p ps=5.5u w=5u l=1u
X371 a_36210_17056# a_26590_16940# a_32342_13656# VDD pfet_06v0 ad=1.3p pd=5.52u as=2.2p ps=10.88u w=5u l=1u
X372 a_8782_34416# a_3582_74260# cap_mim_2f0_m4m5_noshield c_width=20u c_length=10u
X373 a_33454_48376# a_35094_51776# VDD VDD pfet_06v0 ad=1.3p pd=5.52u as=2.2p ps=10.88u w=5u l=1u
X374 a_33978_69248# a_34566_65848# VSS VSS nfet_06v0 ad=0.65p pd=3.02u as=0.65p ps=3.02u w=2.5u l=1u
X375 VDD a_59174_69248# a_56422_65848# VDD pfet_06v0 ad=1.3p pd=5.52u as=1.3p ps=5.52u w=5u l=1u
X376 a_4634_43092# a_5916_39692# VSS VSS nfet_06v0 ad=1.1p pd=5.88u as=1.1p ps=5.88u w=2.5u l=1u
X377 a_35678_31016# a_40574_34300# a_36210_34416# VDD pfet_06v0 ad=2.2p pd=10.88u as=2.2p ps=10.88u w=5u l=1u
X378 a_58058_17056# a_58646_13656# VSS VSS nfet_06v0 ad=0.65p pd=3.02u as=1.1p ps=5.88u w=2.5u l=1u
X379 a_50670_51660# a_50670_51660# a_53326_48376# VSS nfet_06v0 ad=0.44p pd=2.88u as=0.25p ps=1.5u w=1u l=1u
X380 a_67684_41360# Z a_69084_41360# VSS nfet_06v0 ad=0.88p pd=4.88u as=0.5p ps=2.5u w=2u l=1u
X381 a_32862_17056# a_34566_13656# VSS VSS nfet_06v0 ad=0.65p pd=3.02u as=0.65p ps=3.02u w=2.5u l=1u
X382 a_31962_25732# a_31762_25616# VDD VDD pfet_06v0 ad=2.5p pd=10.5u as=4.4p ps=20.88u w=10u l=1u
X383 a_8262_65848# a_2510_69132# a_12130_69248# VDD pfet_06v0 ad=2.2p pd=10.88u as=1.3p ps=5.52u w=5u l=1u
X384 a_28214_65848# a_26590_69132# VSS VSS nfet_06v0 ad=0.25p pd=1.5u as=0.44p ps=2.88u w=1u l=1u
X385 a_44174_25616# a_44174_25616# a_58296_22332# VSS nfet_06v0 ad=0.44p pd=2.88u as=0.25p ps=1.5u w=1u l=1u
X386 a_51682_51776# a_50370_51660# VDD VDD pfet_06v0 ad=2.5p pd=10.5u as=4.4p ps=20.88u w=10u l=1u
X387 VSS a_24034_75936# a_23534_74376# VSS nfet_06v0 ad=0.44p pd=2.88u as=0.44p ps=2.88u w=1u l=1u
X388 a_25466_43092# a_26748_39692# VSS VSS nfet_06v0 ad=1.1p pd=5.88u as=1.1p ps=5.88u w=2.5u l=1u
X389 a_12130_17056# a_15950_13540# a_11598_13656# VSS nfet_06v0 ad=1.1p pd=5.88u as=1.1p ps=5.88u w=2.5u l=1u
X390 a_30578_13656# a_26250_13540# a_31310_13656# VSS nfet_06v0 ad=2.2p pd=10.88u as=1.25p ps=5.5u w=5u l=1u
X391 a_16494_51660# a_16494_51660# a_18118_51660# VDD pfet_06v0 ad=4.4p pd=20.88u as=4.4p ps=20.88u w=10u l=1u
X392 a_8782_69248# a_8062_65732# a_6858_69248# VDD pfet_06v0 ad=2.6p pd=10.52u as=4.4p ps=20.88u w=10u l=1u
X393 a_20410_13656# a_11598_13656# VSS VSS nfet_06v0 ad=1.3p pd=5.52u as=2.2p ps=10.88u w=5u l=1u
X394 a_55018_51776# a_32142_48260# a_56942_51776# VDD pfet_06v0 ad=4.4p pd=20.88u as=2.6p ps=10.52u w=10u l=1u
X395 a_53606_34416# a_50370_34300# VDD VDD pfet_06v0 ad=2.5p pd=10.5u as=4.4p ps=20.88u w=10u l=1u
X396 a_50370_51660# a_50670_51660# a_52294_48376# VSS nfet_06v0 ad=0.44p pd=2.88u as=0.25p ps=1.5u w=1u l=1u
X397 a_58058_17056# a_50330_13540# a_58646_13656# VSS nfet_06v0 ad=1.1p pd=5.88u as=0.65p ps=3.02u w=2.5u l=1u
X398 a_30578_31016# a_9174_30900# a_33454_31016# VSS nfet_06v0 ad=2.2p pd=10.88u as=1.3p ps=5.52u w=5u l=1u
X399 a_59174_69248# a_64110_65732# a_58646_65848# VSS nfet_06v0 ad=1.1p pd=5.88u as=1.1p ps=5.88u w=2.5u l=1u
X400 a_42398_51776# a_42198_51660# VDD VDD pfet_06v0 ad=2.5p pd=10.5u as=4.4p ps=20.88u w=10u l=1u
X401 a_32862_51776# a_26250_48260# a_35678_48376# VSS nfet_06v0 ad=1.1p pd=5.88u as=0.65p ps=3.02u w=2.5u l=1u
X402 a_14978_74376# a_15066_74260# VDD VDD pfet_06v0 ad=1.32p pd=6.88u as=1.32p ps=6.88u w=3u l=1u
X403 a_64654_34300# a_50330_30900# a_65774_31016# VSS nfet_06v0 ad=2.2p pd=10.88u as=1.25p ps=5.5u w=5u l=1u
X404 VSS a_10486_13656# a_9898_17056# VSS nfet_06v0 ad=0.65p pd=3.02u as=0.65p ps=3.02u w=2.5u l=1u
X405 a_56942_8260# a_43874_8144# VDD VDD pfet_06v0 ad=2.5p pd=10.5u as=4.4p ps=20.88u w=10u l=1u
X406 a_30138_42976# a_23302_39576# a_31140_39692# VSS nfet_06v0 ad=2.2p pd=10.88u as=1.25p ps=5.5u w=5u l=1u
X407 a_24234_4860# a_23002_4744# VSS VSS nfet_06v0 ad=1.25p pd=5.5u as=2.2p ps=10.88u w=5u l=1u
X408 a_64728_5320# a_66178_5204# VSS VSS nfet_06v0 ad=0.5456p pd=3.36u as=0.5456p ps=3.36u w=1.24u l=1u
X409 a_6258_8260# a_8644_4744# a_5916_4860# VSS nfet_06v0 ad=1.1p pd=5.88u as=1.1p ps=5.88u w=2.5u l=1u
X410 a_34566_13656# a_26250_13540# a_33978_17056# VSS nfet_06v0 ad=0.65p pd=3.02u as=1.1p ps=5.88u w=2.5u l=1u
X411 a_68142_22792# a_66178_22676# a_67842_22792# VSS nfet_06v0 ad=0.175p pd=1.2u as=0.175p ps=1.2u w=0.7u l=1u
X412 a_45186_43092# a_43874_42976# VDD VDD pfet_06v0 ad=2.5p pd=10.5u as=4.4p ps=20.88u w=10u l=1u
X413 a_8262_13656# a_8062_13540# a_6498_13656# VSS nfet_06v0 ad=1.3p pd=5.52u as=2.2p ps=10.88u w=5u l=1u
X414 a_11598_48376# a_2170_48260# a_8782_51776# VSS nfet_06v0 ad=0.65p pd=3.02u as=1.1p ps=5.88u w=2.5u l=1u
X415 a_43874_60336# a_44174_60336# a_57264_57052# VSS nfet_06v0 ad=0.44p pd=2.88u as=0.25p ps=1.5u w=1u l=1u
X416 a_47580_39692# a_44134_39576# a_47110_43092# VSS nfet_06v0 ad=1.1p pd=5.88u as=1.1p ps=5.88u w=2.5u l=1u
X417 a_68402_17056# a_50370_16940# VDD VDD pfet_06v0 ad=2.5p pd=10.5u as=4.4p ps=20.88u w=10u l=1u
X418 a_5446_43092# S3N a_2710_43092# VDD pfet_06v0 ad=4.4p pd=20.88u as=4.4p ps=20.88u w=10u l=1u
X419 a_23302_22216# a_23342_25616# a_34998_25732# VDD pfet_06v0 ad=4.4p pd=20.88u as=2.5p ps=10.5u w=10u l=1u
X420 a_68442_5320# a_66178_5204# a_68142_5320# VSS nfet_06v0 ad=0.175p pd=1.2u as=0.175p ps=1.2u w=0.7u l=1u
X421 a_3522_34416# a_2210_34300# VDD VDD pfet_06v0 ad=2.5p pd=10.5u as=4.4p ps=20.88u w=10u l=1u
X422 a_8644_4744# a_2510_8144# a_13054_8260# VDD pfet_06v0 ad=4.4p pd=20.88u as=2.5p ps=10.5u w=10u l=1u
X423 a_5916_39692# a_2470_39576# a_5446_43092# VSS nfet_06v0 ad=1.1p pd=5.88u as=1.1p ps=5.88u w=2.5u l=1u
X424 a_66478_34416# a_66278_34300# VDD VDD pfet_06v0 ad=2.5p pd=10.5u as=4.4p ps=20.88u w=10u l=1u
X425 a_9306_42976# a_2470_39576# a_10308_39692# VSS nfet_06v0 ad=2.2p pd=10.88u as=1.25p ps=5.5u w=5u l=1u
X426 a_2210_42976# a_2510_42976# a_17202_43092# VDD pfet_06v0 ad=4.4p pd=20.88u as=2.5p ps=10.5u w=10u l=1u
X427 a_6498_48376# a_2170_48260# a_6198_48376# VSS nfet_06v0 ad=2.2p pd=10.88u as=1.25p ps=5.5u w=5u l=1u
X428 a_8782_51776# a_14334_74260# cap_mim_2f0_m4m5_noshield c_width=20u c_length=10u
X429 a_33978_34416# a_9174_30900# a_30938_34416# VDD pfet_06v0 ad=2.6p pd=10.52u as=4.4p ps=20.88u w=10u l=1u
X430 a_19378_65848# a_18358_65848# VSS VSS nfet_06v0 ad=1.25p pd=5.5u as=2.2p ps=10.88u w=5u l=1u
X431 a_26278_43092# S4N a_23542_43092# VDD pfet_06v0 ad=4.4p pd=20.88u as=4.4p ps=20.88u w=10u l=1u
X432 a_12870_74260# a_60290_51776# VDD VDD pfet_06v0 ad=4.4p pd=20.88u as=2.6p ps=10.52u w=10u l=1u
X433 a_44174_60336# a_44174_60336# VDD VDD pfet_06v0 ad=0.88p pd=4.88u as=0.88p ps=4.88u w=2u l=1u
X434 a_33454_65848# a_35094_69248# VDD VDD pfet_06v0 ad=1.3p pd=5.52u as=2.2p ps=10.88u w=5u l=1u
X435 a_51062_30900# a_50670_34300# a_51682_34416# VDD pfet_06v0 ad=4.4p pd=20.88u as=2.5p ps=10.5u w=10u l=1u
X436 a_2170_56936# a_2510_60336# a_15278_60452# VDD pfet_06v0 ad=4.4p pd=20.88u as=2.5p ps=10.5u w=10u l=1u
X437 a_10308_4860# a_2170_4744# VSS VSS nfet_06v0 ad=1.25p pd=5.5u as=2.2p ps=10.88u w=5u l=1u
X438 a_26748_39692# a_23302_39576# a_26278_43092# VSS nfet_06v0 ad=1.1p pd=5.88u as=1.1p ps=5.88u w=2.5u l=1u
X439 VSS a_58646_31016# a_58058_34416# VSS nfet_06v0 ad=0.65p pd=3.02u as=0.65p ps=3.02u w=2.5u l=1u
X440 a_37464_22332# a_23342_25616# VSS VSS nfet_06v0 ad=0.25p pd=1.5u as=0.44p ps=2.88u w=1u l=1u
X441 a_59174_51776# a_50670_51660# a_57534_48376# VDD pfet_06v0 ad=1.3p pd=5.52u as=2.2p ps=10.88u w=5u l=1u
X442 a_2210_42976# a_2510_42976# a_15600_39692# VSS nfet_06v0 ad=0.44p pd=2.88u as=0.25p ps=1.5u w=1u l=1u
X443 a_40030_13540# a_26590_16940# a_44322_17056# VDD pfet_06v0 ad=4.4p pd=20.88u as=2.5p ps=10.5u w=10u l=1u
X444 a_69828_24000# a_66178_22676# VSS VSS nfet_06v0 ad=0.5456p pd=3.36u as=0.5456p ps=3.36u w=1.24u l=1u
X445 a_30638_51776# a_26290_51660# VDD VDD pfet_06v0 ad=2.5p pd=10.5u as=4.4p ps=20.88u w=10u l=1u
X446 VDD a_36210_51776# a_13282_75936# VDD pfet_06v0 ad=2.6p pd=10.52u as=2.6p ps=10.52u w=10u l=1u
X447 a_51682_69248# a_50370_69132# VDD VDD pfet_06v0 ad=2.5p pd=10.5u as=4.4p ps=20.88u w=10u l=1u
X448 a_7230_48376# a_2902_48260# VSS VSS nfet_06v0 ad=1.25p pd=5.5u as=2.2p ps=10.88u w=5u l=1u
X449 a_50330_13540# a_50330_13540# VSS VSS nfet_06v0 ad=0.44p pd=2.88u as=0.44p ps=2.88u w=1u l=1u
X450 a_32142_30900# a_48312_22332# VSS VSS nfet_06v0 ad=0.44p pd=2.88u as=0.44p ps=2.88u w=1u l=1u
X451 a_16494_69132# a_16494_69132# a_18118_69132# VDD pfet_06v0 ad=4.4p pd=20.88u as=4.4p ps=20.88u w=10u l=1u
X452 a_47922_25732# a_44174_25616# a_46830_22332# VDD pfet_06v0 ad=2.2p pd=10.88u as=2.2p ps=10.88u w=5u l=1u
X453 a_42198_34300# a_26590_34300# a_42398_34416# VDD pfet_06v0 ad=4.4p pd=20.88u as=2.5p ps=10.5u w=10u l=1u
X454 VSS a_11598_31016# a_3582_74260# VSS nfet_06v0 ad=1.3p pd=5.52u as=1.3p ps=5.52u w=5u l=1u
X455 a_55018_69248# a_32142_65732# a_56942_69248# VDD pfet_06v0 ad=4.4p pd=20.88u as=2.6p ps=10.52u w=10u l=1u
X456 a_33454_31016# a_26590_34300# a_35094_34416# VDD pfet_06v0 ad=2.2p pd=10.88u as=1.3p ps=5.52u w=5u l=1u
X457 a_44374_60452# a_44174_60336# a_44074_60452# VDD pfet_06v0 ad=4.4p pd=20.88u as=2.5p ps=10.5u w=10u l=1u
X458 a_26290_34300# a_26590_34300# a_28214_31016# VSS nfet_06v0 ad=0.44p pd=2.88u as=0.25p ps=1.5u w=1u l=1u
X459 a_54718_8260# a_43874_8144# VDD VDD pfet_06v0 ad=2.5p pd=10.5u as=4.4p ps=20.88u w=10u l=1u
X460 a_30138_25616# a_30138_25616# a_31762_25616# VDD pfet_06v0 ad=4.4p pd=20.88u as=4.4p ps=20.88u w=10u l=1u
X461 a_30278_31016# a_26982_30900# VSS VSS nfet_06v0 ad=1.25p pd=5.5u as=2.2p ps=10.88u w=5u l=1u
X462 a_60290_69248# a_64110_65732# a_59758_65848# VSS nfet_06v0 ad=1.1p pd=5.88u as=1.1p ps=5.88u w=2.5u l=1u
X463 a_3522_8260# a_2210_8144# VDD VDD pfet_06v0 ad=2.5p pd=10.5u as=4.4p ps=20.88u w=10u l=1u
X464 a_64728_24000# a_25730_74376# Y VSS nfet_06v0 ad=1.0912p pd=5.84u as=0.6448p ps=3u w=2.48u l=1u
X465 a_54658_48376# a_50330_48260# a_55390_48376# VSS nfet_06v0 ad=2.2p pd=10.88u as=1.25p ps=5.5u w=5u l=1u
X466 a_33978_69248# a_34566_65848# VSS VSS nfet_06v0 ad=0.65p pd=3.02u as=1.1p ps=5.88u w=2.5u l=1u
X467 a_42398_69248# a_42198_69132# VDD VDD pfet_06v0 ad=2.5p pd=10.5u as=4.4p ps=20.88u w=10u l=1u
X468 a_27602_17056# a_26290_16940# VDD VDD pfet_06v0 ad=2.5p pd=10.5u as=4.4p ps=20.88u w=10u l=1u
X469 a_13282_75936# a_35678_48376# VSS VSS nfet_06v0 ad=1.3p pd=5.52u as=2.2p ps=10.88u w=5u l=1u
X470 a_50670_51660# a_50670_51660# VDD VDD pfet_06v0 ad=0.88p pd=4.88u as=0.88p ps=4.88u w=2u l=1u
X471 a_43874_8144# a_44174_8144# a_57264_4860# VSS nfet_06v0 ad=0.44p pd=2.88u as=0.25p ps=1.5u w=1u l=1u
X472 a_23502_39692# a_23302_39576# a_23202_39692# VSS nfet_06v0 ad=2.2p pd=10.88u as=1.25p ps=5.5u w=5u l=1u
X473 a_25466_60452# a_8062_65732# cap_mim_2f0_m4m5_noshield c_width=20u c_length=10u
X474 a_44134_4744# a_44134_4744# VSS VSS nfet_06v0 ad=0.44p pd=2.88u as=0.44p ps=2.88u w=1u l=1u
X475 a_44134_22216# a_44134_22216# VSS VSS nfet_06v0 ad=0.44p pd=2.88u as=0.44p ps=2.88u w=1u l=1u
X476 a_29476_39576# a_29476_39576# a_31884_39692# VSS nfet_06v0 ad=2.2p pd=10.88u as=2.2p ps=10.88u w=5u l=1u
X477 a_13282_75936# a_32342_48376# cap_mim_2f0_m4m5_noshield c_width=20u c_length=10u
X478 a_54718_34416# a_50370_34300# VDD VDD pfet_06v0 ad=2.5p pd=10.5u as=4.4p ps=20.88u w=10u l=1u
X479 a_20242_34416# a_2210_34300# VDD VDD pfet_06v0 ad=2.5p pd=10.5u as=4.4p ps=20.88u w=10u l=1u
X480 VDD a_60290_34416# a_2118_74260# VDD pfet_06v0 ad=2.6p pd=10.52u as=2.6p ps=10.52u w=10u l=1u
X481 a_36432_57052# a_23342_60336# VSS VSS nfet_06v0 ad=0.25p pd=1.5u as=0.44p ps=2.88u w=1u l=1u
X482 a_56942_17056# a_50330_13540# a_59758_13656# VSS nfet_06v0 ad=1.1p pd=5.88u as=0.65p ps=3.02u w=2.5u l=1u
X483 VDD a_2530_75936# a_6078_74260# VDD pfet_06v0 ad=1.32p pd=6.88u as=1.32p ps=6.88u w=3u l=1u
X484 a_26982_30900# a_26250_30900# a_27182_31016# VSS nfet_06v0 ad=2.2p pd=10.88u as=1.25p ps=5.5u w=5u l=1u
X485 a_23242_8260# a_23042_8144# VDD VDD pfet_06v0 ad=2.5p pd=10.5u as=4.4p ps=20.88u w=10u l=1u
X486 a_6498_31016# a_8062_30900# a_8262_31016# VSS nfet_06v0 ad=2.2p pd=10.88u as=1.3p ps=5.52u w=5u l=1u
X487 a_40030_13540# a_40030_13540# a_42438_13656# VSS nfet_06v0 ad=2.2p pd=10.88u as=2.2p ps=10.88u w=5u l=1u
X488 a_18318_17056# a_18118_16940# VDD VDD pfet_06v0 ad=2.5p pd=10.5u as=4.4p ps=20.88u w=10u l=1u
X489 VSS a_34566_48376# a_33978_51776# VSS nfet_06v0 ad=0.65p pd=3.02u as=0.65p ps=3.02u w=2.5u l=1u
X490 a_2210_16940# a_2510_16940# a_4134_13656# VSS nfet_06v0 ad=0.44p pd=2.88u as=0.25p ps=1.5u w=1u l=1u
X491 a_2530_75936# a_32342_31016# cap_mim_2f0_m4m5_noshield c_width=20u c_length=10u
X492 a_53736_57052# a_52716_57052# VSS VSS nfet_06v0 ad=1.25p pd=5.5u as=2.2p ps=10.88u w=5u l=1u
X493 a_67684_24000# Y Y VSS nfet_06v0 ad=0.88p pd=4.88u as=0.52p ps=2.52u w=2u l=1u
X494 YP a_68062_26104# VDD VDD pfet_05v0 ad=0.8052p pd=4.54u as=0.8052p ps=4.54u w=1.83u l=0.5u
X495 a_35678_13656# a_26250_13540# a_32862_17056# VSS nfet_06v0 ad=0.65p pd=3.02u as=1.1p ps=5.88u w=2.5u l=1u
X496 a_9374_13656# a_9174_13540# a_6498_13656# VSS nfet_06v0 ad=1.3p pd=5.52u as=2.2p ps=10.88u w=5u l=1u
X497 X X a_67684_6528# VSS nfet_06v0 ad=0.52p pd=2.52u as=0.88p ps=4.88u w=2u l=1u
X498 a_23622_74260# a_60290_69248# VDD VDD pfet_06v0 ad=4.4p pd=20.88u as=2.6p ps=10.52u w=10u l=1u
X499 a_20410_13656# a_11598_13656# VSS VSS nfet_06v0 ad=2.2p pd=10.88u as=1.3p ps=5.52u w=5u l=1u
X500 a_64726_56900# a_60290_17056# VDD VDD pfet_06v0 ad=2.6p pd=10.52u as=4.4p ps=20.88u w=10u l=1u
X501 a_5916_22332# a_9306_25616# a_6258_25732# VDD pfet_06v0 ad=2.2p pd=10.88u as=2.2p ps=10.88u w=5u l=1u
X502 a_41694_13656# a_26982_13540# VSS VSS nfet_06v0 ad=1.25p pd=5.5u as=2.2p ps=10.88u w=5u l=1u
X503 a_30938_34416# a_26590_34300# a_30638_34416# VDD pfet_06v0 ad=4.4p pd=20.88u as=2.5p ps=10.5u w=10u l=1u
X504 VDD a_35094_17056# a_33454_13656# VDD pfet_06v0 ad=2.2p pd=10.88u as=1.3p ps=5.52u w=5u l=1u
X505 a_2510_34300# a_2510_34300# VDD VDD pfet_06v0 ad=0.88p pd=4.88u as=0.88p ps=4.88u w=2u l=1u
X506 a_6258_8260# a_2510_8144# a_5166_4860# VDD pfet_06v0 ad=2.2p pd=10.88u as=2.2p ps=10.88u w=5u l=1u
X507 a_2410_60452# a_2210_60336# VDD VDD pfet_06v0 ad=2.5p pd=10.5u as=4.4p ps=20.88u w=10u l=1u
X508 a_59174_69248# a_50670_69132# a_57534_65848# VDD pfet_06v0 ad=1.3p pd=5.52u as=2.2p ps=10.88u w=5u l=1u
X509 VDD a_59174_34416# a_56422_31016# VDD pfet_06v0 ad=2.2p pd=10.88u as=1.3p ps=5.52u w=5u l=1u
X510 a_18358_31016# a_2170_30900# a_19378_31016# VSS nfet_06v0 ad=2.2p pd=10.88u as=1.25p ps=5.5u w=5u l=1u
X511 a_30638_69248# a_26290_69132# VDD VDD pfet_06v0 ad=2.5p pd=10.5u as=4.4p ps=20.88u w=10u l=1u
X512 VDD a_36210_69248# a_24034_75936# VDD pfet_06v0 ad=2.6p pd=10.52u as=2.6p ps=10.52u w=10u l=1u
X513 a_36110_8260# a_23042_8144# VDD VDD pfet_06v0 ad=2.5p pd=10.5u as=4.4p ps=20.88u w=10u l=1u
X514 a_43874_60336# a_44174_60336# a_58866_60452# VDD pfet_06v0 ad=4.4p pd=20.88u as=2.5p ps=10.5u w=10u l=1u
X515 a_5916_4860# a_9306_8144# a_6258_8260# VDD pfet_06v0 ad=2.2p pd=10.88u as=2.2p ps=10.88u w=5u l=1u
X516 a_2902_48260# a_2170_48260# a_3102_48376# VSS nfet_06v0 ad=2.2p pd=10.88u as=1.25p ps=5.5u w=5u l=1u
X517 a_14568_57052# a_2170_56936# VSS VSS nfet_06v0 ad=1.25p pd=5.5u as=2.2p ps=10.88u w=5u l=1u
X518 a_23242_60452# a_23042_60336# VDD VDD pfet_06v0 ad=2.5p pd=10.5u as=4.4p ps=20.88u w=10u l=1u
X519 VSS a_23622_74260# a_23534_74376# VSS nfet_06v0 ad=0.44p pd=2.88u as=0.44p ps=2.88u w=1u l=1u
X520 a_46298_25732# a_47580_22332# VSS VSS nfet_06v0 ad=1.1p pd=5.88u as=1.1p ps=5.88u w=2.5u l=1u
X521 a_11014_17056# a_15950_13540# a_10486_13656# VSS nfet_06v0 ad=1.1p pd=5.88u as=1.1p ps=5.88u w=2.5u l=1u
X522 a_10486_13656# a_16494_16940# a_11014_17056# VDD pfet_06v0 ad=2.2p pd=10.88u as=2.2p ps=10.88u w=5u l=1u
X523 a_50670_69132# a_50670_69132# VDD VDD pfet_06v0 ad=0.88p pd=4.88u as=0.88p ps=4.88u w=2u l=1u
X524 a_50308_4744# a_50308_4744# a_52716_4860# VSS nfet_06v0 ad=2.2p pd=10.88u as=2.2p ps=10.88u w=5u l=1u
X525 a_5446_51776# a_2210_51660# VDD VDD pfet_06v0 ad=2.5p pd=10.5u as=4.4p ps=20.88u w=10u l=1u
X526 a_2170_48260# a_2170_48260# VSS VSS nfet_06v0 ad=0.44p pd=2.88u as=0.44p ps=2.88u w=1u l=1u
X527 a_58646_48376# a_64654_51660# a_59174_51776# VDD pfet_06v0 ad=2.2p pd=10.88u as=2.2p ps=10.88u w=5u l=1u
X528 a_66518_48376# a_50330_48260# a_67538_48376# VSS nfet_06v0 ad=2.2p pd=10.88u as=1.25p ps=5.5u w=5u l=1u
X529 a_26250_65732# a_26250_65732# VSS VSS nfet_06v0 ad=0.44p pd=2.88u as=0.44p ps=2.88u w=1u l=1u
X530 a_44374_60452# a_44174_60336# a_45186_60452# VDD pfet_06v0 ad=4.4p pd=20.88u as=2.5p ps=10.5u w=10u l=1u
X531 a_29476_22216# a_23342_25616# a_33886_25732# VDD pfet_06v0 ad=4.4p pd=20.88u as=2.5p ps=10.5u w=10u l=1u
X532 a_64726_56900# a_59758_13656# VSS VSS nfet_06v0 ad=1.3p pd=5.52u as=2.2p ps=10.88u w=5u l=1u
X533 a_65840_24000# a_4226_74376# Y VSS nfet_06v0 ad=1.0912p pd=5.84u as=0.6448p ps=3u w=2.48u l=1u
X534 a_50970_25616# a_44134_22216# a_51972_22332# VSS nfet_06v0 ad=2.2p pd=10.88u as=1.25p ps=5.5u w=5u l=1u
X535 a_5166_22332# a_6258_25732# VDD VDD pfet_06v0 ad=2.2p pd=10.88u as=2.2p ps=10.88u w=5u l=1u
X536 a_9898_34416# a_2170_30900# a_10486_31016# VSS nfet_06v0 ad=1.1p pd=5.88u as=0.65p ps=3.02u w=2.5u l=1u
X537 a_9374_48376# a_11014_51776# VDD VDD pfet_06v0 ad=1.3p pd=5.52u as=1.3p ps=5.52u w=5u l=1u
X538 a_26590_16940# a_26590_16940# VDD VDD pfet_06v0 ad=0.88p pd=4.88u as=0.88p ps=4.88u w=2u l=1u
X539 VSS a_34566_48376# a_33978_51776# VSS nfet_06v0 ad=1.1p pd=5.88u as=0.65p ps=3.02u w=2.5u l=1u
X540 a_5166_13656# a_2510_16940# VSS VSS nfet_06v0 ad=0.25p pd=1.5u as=0.44p ps=2.88u w=1u l=1u
X541 VDD X X VDD pfet_06v0 ad=0.88p pd=4.88u as=0.52p ps=2.52u w=2u l=1u
X542 a_6498_13656# a_2170_13540# a_7230_13656# VSS nfet_06v0 ad=2.2p pd=10.88u as=1.25p ps=5.5u w=5u l=1u
X543 a_3582_74260# a_12130_34416# VDD VDD pfet_06v0 ad=2.6p pd=10.52u as=4.4p ps=20.88u w=10u l=1u
X544 VSS a_35678_65848# a_24034_75936# VSS nfet_06v0 ad=1.3p pd=5.52u as=1.3p ps=5.52u w=5u l=1u
X545 a_2510_60336# a_2510_60336# VDD VDD pfet_06v0 ad=0.88p pd=4.88u as=0.88p ps=4.88u w=2u l=1u
X546 VSS a_12870_74260# a_12782_74376# VSS nfet_06v0 ad=0.44p pd=2.88u as=0.44p ps=2.88u w=1u l=1u
X547 a_4634_8260# a_9174_13540# cap_mim_2f0_m4m5_noshield c_width=20u c_length=10u
X548 a_23302_4744# a_23302_4744# VSS VSS nfet_06v0 ad=0.44p pd=2.88u as=0.44p ps=2.88u w=1u l=1u
X549 a_9898_51776# a_10486_48376# VSS VSS nfet_06v0 ad=0.65p pd=3.02u as=0.65p ps=3.02u w=2.5u l=1u
X550 a_6498_31016# a_9174_30900# a_9374_31016# VSS nfet_06v0 ad=2.2p pd=10.88u as=1.3p ps=5.52u w=5u l=1u
X551 a_15278_25732# a_2210_25616# VDD VDD pfet_06v0 ad=2.5p pd=10.5u as=4.4p ps=20.88u w=10u l=1u
X552 a_25730_74376# a_25818_74260# VDD VDD pfet_06v0 ad=1.32p pd=6.88u as=1.32p ps=6.88u w=3u l=1u
X553 a_48734_43092# a_44174_42976# a_46098_39692# VDD pfet_06v0 ad=2.2p pd=10.88u as=2.2p ps=10.88u w=5u l=1u
X554 a_15950_65732# a_15950_65732# a_18358_65848# VSS nfet_06v0 ad=2.2p pd=10.88u as=2.2p ps=10.88u w=5u l=1u
X555 VDD a_11014_51776# a_8262_48376# VDD pfet_06v0 ad=1.3p pd=5.52u as=1.3p ps=5.52u w=5u l=1u
X556 a_4634_43092# a_9174_48260# cap_mim_2f0_m4m5_noshield c_width=20u c_length=10u
X557 a_53326_31016# a_50670_34300# VSS VSS nfet_06v0 ad=0.25p pd=1.5u as=0.44p ps=2.88u w=1u l=1u
X558 a_33454_31016# a_35094_34416# VDD VDD pfet_06v0 ad=1.3p pd=5.52u as=1.3p ps=5.52u w=5u l=1u
X559 a_35094_17056# a_40030_13540# a_34566_13656# VSS nfet_06v0 ad=1.1p pd=5.88u as=1.1p ps=5.88u w=2.5u l=1u
X560 a_23042_8144# a_23342_8144# a_36432_4860# VSS nfet_06v0 ad=0.44p pd=2.88u as=0.25p ps=1.5u w=1u l=1u
X561 a_13282_75936# a_35678_48376# VSS VSS nfet_06v0 ad=2.2p pd=10.88u as=1.3p ps=5.52u w=5u l=1u
X562 a_38034_60452# a_23042_60336# VDD VDD pfet_06v0 ad=2.5p pd=10.5u as=4.4p ps=20.88u w=10u l=1u
X563 a_33886_43092# a_23042_42976# VDD VDD pfet_06v0 ad=2.5p pd=10.5u as=4.4p ps=20.88u w=10u l=1u
X564 VSS a_3582_74260# a_7010_74376# VSS nfet_06v0 ad=0.44p pd=2.88u as=0.25p ps=1.5u w=1u l=1u
X565 a_48734_60452# a_50308_56936# a_48312_57052# VSS nfet_06v0 ad=1.1p pd=5.88u as=1.1p ps=5.88u w=2.5u l=1u
X566 a_23042_25616# a_23342_25616# a_36432_22332# VSS nfet_06v0 ad=0.44p pd=2.88u as=0.25p ps=1.5u w=1u l=1u
X567 a_4634_25732# a_9174_30900# cap_mim_2f0_m4m5_noshield c_width=20u c_length=10u
X568 a_4134_48376# a_2510_51660# VSS VSS nfet_06v0 ad=0.25p pd=1.5u as=0.44p ps=2.88u w=1u l=1u
X569 a_2210_34300# a_2510_34300# a_5446_34416# VDD pfet_06v0 ad=4.4p pd=20.88u as=2.5p ps=10.5u w=10u l=1u
X570 a_3522_60452# a_2210_60336# VDD VDD pfet_06v0 ad=2.5p pd=10.5u as=4.4p ps=20.88u w=10u l=1u
X571 a_52716_22332# a_44134_22216# a_53736_22332# VSS nfet_06v0 ad=2.2p pd=10.88u as=1.25p ps=5.5u w=5u l=1u
X572 a_32342_65848# a_32142_65732# a_30578_65848# VSS nfet_06v0 ad=1.3p pd=5.52u as=2.2p ps=10.88u w=5u l=1u
X573 a_55018_17056# a_50670_16940# a_55830_17056# VDD pfet_06v0 ad=4.4p pd=20.88u as=2.5p ps=10.5u w=10u l=1u
X574 a_46098_4860# S3P a_44334_4860# VSS nfet_06v0 ad=2.2p pd=10.88u as=2.2p ps=10.88u w=5u l=1u
X575 a_44034_4860# a_43834_4744# VSS VSS nfet_06v0 ad=1.25p pd=5.5u as=2.2p ps=10.88u w=5u l=1u
X576 a_52294_31016# a_50670_34300# VSS VSS nfet_06v0 ad=0.25p pd=1.5u as=0.44p ps=2.88u w=1u l=1u
X577 a_5446_69248# a_2210_69132# VDD VDD pfet_06v0 ad=2.5p pd=10.5u as=4.4p ps=20.88u w=10u l=1u
X578 a_27902_25732# a_23342_25616# a_25266_22332# VDD pfet_06v0 ad=2.2p pd=10.88u as=2.2p ps=10.88u w=5u l=1u
X579 a_26490_34416# a_26290_34300# VDD VDD pfet_06v0 ad=2.5p pd=10.5u as=4.4p ps=20.88u w=10u l=1u
X580 VDD a_35094_17056# a_33454_13656# VDD pfet_06v0 ad=1.3p pd=5.52u as=1.3p ps=5.52u w=5u l=1u
X581 a_48312_22332# a_44134_22216# a_46298_25732# VSS nfet_06v0 ad=1.1p pd=5.88u as=1.1p ps=5.88u w=2.5u l=1u
X582 a_9898_34416# a_9174_30900# a_6858_34416# VDD pfet_06v0 ad=2.6p pd=10.52u as=4.4p ps=20.88u w=10u l=1u
X583 a_10930_42976# a_2510_42976# a_11130_43092# VDD pfet_06v0 ad=4.4p pd=20.88u as=2.5p ps=10.5u w=10u l=1u
X584 a_4434_57052# S3P a_2670_57052# VSS nfet_06v0 ad=2.2p pd=10.88u as=2.2p ps=10.88u w=5u l=1u
X585 VDD a_35094_34416# a_32342_31016# VDD pfet_06v0 ad=1.3p pd=5.52u as=1.3p ps=5.52u w=5u l=1u
X586 VSS a_10486_48376# a_8782_51776# VSS nfet_06v0 ad=1.1p pd=5.88u as=0.65p ps=3.02u w=2.5u l=1u
X587 a_27902_60452# a_29476_56936# a_27480_57052# VSS nfet_06v0 ad=1.1p pd=5.88u as=1.1p ps=5.88u w=2.5u l=1u
X588 a_23042_8144# a_23342_8144# a_38034_8260# VDD pfet_06v0 ad=4.4p pd=20.88u as=2.5p ps=10.5u w=10u l=1u
X589 a_44374_8260# a_44174_8144# a_45186_8260# VDD pfet_06v0 ad=4.4p pd=20.88u as=2.5p ps=10.5u w=10u l=1u
X590 a_24354_60452# a_23042_60336# VDD VDD pfet_06v0 ad=2.5p pd=10.5u as=4.4p ps=20.88u w=10u l=1u
X591 a_58646_65848# a_64654_69132# a_59174_69248# VDD pfet_06v0 ad=2.2p pd=10.88u as=2.2p ps=10.88u w=5u l=1u
X592 a_13054_25732# a_2210_25616# VDD VDD pfet_06v0 ad=2.5p pd=10.5u as=4.4p ps=20.88u w=10u l=1u
X593 a_48312_57052# a_50970_60336# a_48734_60452# VDD pfet_06v0 ad=2.2p pd=10.88u as=2.2p ps=10.88u w=5u l=1u
X594 a_27182_65848# a_26982_65732# VSS VSS nfet_06v0 ad=1.25p pd=5.5u as=2.2p ps=10.88u w=5u l=1u
X595 VDD a_20410_65848# a_27582_74260# VDD pfet_06v0 ad=1.32p pd=6.88u as=1.32p ps=6.88u w=3u l=1u
X596 a_56942_17056# a_64726_56900# cap_mim_2f0_m4m5_noshield c_width=20u c_length=10u
X597 a_44334_22332# a_44134_22216# a_44034_22332# VSS nfet_06v0 ad=2.2p pd=10.88u as=1.25p ps=5.5u w=5u l=1u
X598 a_68062_8632# X VDD VDD pfet_05v0 ad=0.8052p pd=4.54u as=0.8052p ps=4.54u w=1.83u l=0.5u
X599 a_30578_48376# a_32142_48260# a_32342_48376# VSS nfet_06v0 ad=2.2p pd=10.88u as=1.3p ps=5.52u w=5u l=1u
X600 a_5446_60452# a_5916_57052# VSS VSS nfet_06v0 ad=1.1p pd=5.88u as=1.1p ps=5.88u w=2.5u l=1u
X601 a_52594_8144# a_44174_8144# a_52794_8260# VDD pfet_06v0 ad=4.4p pd=20.88u as=2.5p ps=10.5u w=10u l=1u
X602 VSS a_59758_31016# a_2118_74260# VSS nfet_06v0 ad=1.3p pd=5.52u as=1.3p ps=5.52u w=5u l=1u
X603 a_32862_69248# a_34566_65848# VSS VSS nfet_06v0 ad=0.65p pd=3.02u as=1.1p ps=5.88u w=2.5u l=1u
X604 a_9374_65848# a_11014_69248# VDD VDD pfet_06v0 ad=1.3p pd=5.52u as=1.3p ps=5.52u w=5u l=1u
X605 a_48734_8260# a_44174_8144# a_46098_4860# VDD pfet_06v0 ad=2.2p pd=10.88u as=2.2p ps=10.88u w=5u l=1u
X606 a_9374_13656# a_11014_17056# VDD VDD pfet_06v0 ad=1.3p pd=5.52u as=2.2p ps=10.88u w=5u l=1u
X607 a_8062_48260# a_27902_43092# VDD VDD pfet_06v0 ad=0.308p pd=2.28u as=0.308p ps=2.28u w=0.7u l=20u
X608 a_6558_51776# a_2210_51660# VDD VDD pfet_06v0 ad=2.5p pd=10.5u as=4.4p ps=20.88u w=10u l=1u
X609 a_25266_57052# S4P a_23502_57052# VSS nfet_06v0 ad=2.2p pd=10.88u as=2.2p ps=10.88u w=5u l=1u
X610 a_29246_48376# a_26590_51660# VSS VSS nfet_06v0 ad=0.25p pd=1.5u as=0.44p ps=2.88u w=1u l=1u
X611 a_23002_56936# a_23302_56936# a_35400_57052# VSS nfet_06v0 ad=2.2p pd=10.88u as=1.25p ps=5.5u w=5u l=1u
X612 a_2170_22216# a_2470_22216# a_14568_22332# VSS nfet_06v0 ad=2.2p pd=10.88u as=1.25p ps=5.5u w=5u l=1u
X613 a_31750_34416# a_26290_34300# VDD VDD pfet_06v0 ad=2.5p pd=10.5u as=4.4p ps=20.88u w=10u l=1u
X614 a_57534_48376# a_59174_51776# VDD VDD pfet_06v0 ad=1.3p pd=5.52u as=2.2p ps=10.88u w=5u l=1u
X615 a_58058_69248# a_58646_65848# VSS VSS nfet_06v0 ad=0.65p pd=3.02u as=0.65p ps=3.02u w=2.5u l=1u
X616 a_50308_56936# a_50308_56936# a_52716_57052# VSS nfet_06v0 ad=2.2p pd=10.88u as=2.2p ps=10.88u w=5u l=1u
X617 a_56232_39692# a_43834_39576# VSS VSS nfet_06v0 ad=1.25p pd=5.5u as=2.2p ps=10.88u w=5u l=1u
X618 a_10308_22332# a_2170_22216# VSS VSS nfet_06v0 ad=1.25p pd=5.5u as=2.2p ps=10.88u w=5u l=1u
X619 a_26290_16940# a_26590_16940# a_29526_17056# VDD pfet_06v0 ad=4.4p pd=20.88u as=2.5p ps=10.5u w=10u l=1u
X620 VSS a_34566_48376# a_32862_51776# VSS nfet_06v0 ad=0.65p pd=3.02u as=0.65p ps=3.02u w=2.5u l=1u
X621 a_68442_40152# a_66178_40036# a_68142_40152# VSS nfet_06v0 ad=0.175p pd=1.2u as=0.175p ps=1.2u w=0.7u l=1u
X622 a_43834_39576# a_44174_42976# a_56942_43092# VDD pfet_06v0 ad=4.4p pd=20.88u as=2.5p ps=10.5u w=10u l=1u
X623 a_67842_5320# a_66178_5204# VSS VSS nfet_06v0 ad=0.175p pd=1.2u as=0.308p ps=2.28u w=0.7u l=1u
X624 VDD a_11014_69248# a_8262_65848# VDD pfet_06v0 ad=1.3p pd=5.52u as=1.3p ps=5.52u w=5u l=1u
X625 a_36210_17056# a_40030_13540# a_35678_13656# VSS nfet_06v0 ad=1.1p pd=5.88u as=1.1p ps=5.88u w=2.5u l=1u
X626 a_58866_25732# a_43874_25616# VDD VDD pfet_06v0 ad=2.5p pd=10.5u as=4.4p ps=20.88u w=10u l=1u
X627 a_40574_51660# a_40574_51660# a_42198_51660# VDD pfet_06v0 ad=4.4p pd=20.88u as=4.4p ps=20.88u w=10u l=1u
X628 a_54718_60452# a_43874_60336# VDD VDD pfet_06v0 ad=2.5p pd=10.5u as=4.4p ps=20.88u w=10u l=1u
X629 a_15600_22332# a_2510_25616# VSS VSS nfet_06v0 ad=0.25p pd=1.5u as=0.44p ps=2.88u w=1u l=1u
X630 a_56422_31016# a_32142_30900# a_54658_31016# VSS nfet_06v0 ad=1.3p pd=5.52u as=2.2p ps=10.88u w=5u l=1u
X631 a_36210_51776# a_26590_51660# a_32342_48376# VDD pfet_06v0 ad=1.3p pd=5.52u as=2.2p ps=10.88u w=5u l=1u
X632 a_51972_57052# a_43834_56936# VSS VSS nfet_06v0 ad=1.25p pd=5.5u as=2.2p ps=10.88u w=5u l=1u
X633 a_5446_8260# a_5916_4860# VSS VSS nfet_06v0 ad=1.1p pd=5.88u as=1.1p ps=5.88u w=2.5u l=1u
X634 a_32904_22332# a_31884_22332# VSS VSS nfet_06v0 ad=1.25p pd=5.5u as=2.2p ps=10.88u w=5u l=1u
X635 VDD Z Z VDD pfet_06v0 ad=0.52p pd=2.52u as=0.52p ps=2.52u w=2u l=1u
X636 a_3402_4860# a_2170_4744# VSS VSS nfet_06v0 ad=1.25p pd=5.5u as=2.2p ps=10.88u w=5u l=1u
X637 a_51262_65848# a_51062_65732# VSS VSS nfet_06v0 ad=1.25p pd=5.5u as=2.2p ps=10.88u w=5u l=1u
X638 a_64726_56900# a_59758_13656# VSS VSS nfet_06v0 ad=2.2p pd=10.88u as=1.3p ps=5.52u w=5u l=1u
X639 a_9898_51776# a_10486_48376# VSS VSS nfet_06v0 ad=0.65p pd=3.02u as=1.1p ps=5.88u w=2.5u l=1u
X640 a_2470_56936# a_2470_56936# VSS VSS nfet_06v0 ad=0.44p pd=2.88u as=0.44p ps=2.88u w=1u l=1u
X641 a_34998_43092# a_23042_42976# VDD VDD pfet_06v0 ad=2.5p pd=10.5u as=4.4p ps=20.88u w=10u l=1u
X642 a_23002_22216# a_23342_25616# a_36110_25732# VDD pfet_06v0 ad=4.4p pd=20.88u as=2.5p ps=10.5u w=10u l=1u
X643 a_47110_25732# a_47580_22332# VSS VSS nfet_06v0 ad=1.1p pd=5.88u as=1.1p ps=5.88u w=2.5u l=1u
X644 a_4434_39692# a_6258_43092# VDD VDD pfet_06v0 ad=2.2p pd=10.88u as=2.2p ps=10.88u w=5u l=1u
X645 a_55390_31016# a_51062_30900# VSS VSS nfet_06v0 ad=1.25p pd=5.5u as=2.2p ps=10.88u w=5u l=1u
X646 a_5166_4860# a_6258_8260# VDD VDD pfet_06v0 ad=2.2p pd=10.88u as=2.2p ps=10.88u w=5u l=1u
X647 a_5166_57052# S3N a_2670_57052# VSS nfet_06v0 ad=2.2p pd=10.88u as=2.2p ps=10.88u w=5u l=1u
X648 a_8782_69248# a_2170_65732# a_11598_65848# VSS nfet_06v0 ad=1.1p pd=5.88u as=0.65p ps=3.02u w=2.5u l=1u
X649 a_2470_4744# a_2470_4744# VSS VSS nfet_06v0 ad=0.44p pd=2.88u as=0.44p ps=2.88u w=1u l=1u
X650 a_55830_8260# a_43874_8144# VDD VDD pfet_06v0 ad=2.5p pd=10.5u as=4.4p ps=20.88u w=10u l=1u
X651 a_23202_22332# a_23002_22216# VSS VSS nfet_06v0 ad=1.25p pd=5.5u as=2.2p ps=10.88u w=5u l=1u
X652 a_6858_34416# a_2510_34300# a_6558_34416# VDD pfet_06v0 ad=4.4p pd=20.88u as=2.5p ps=10.5u w=10u l=1u
X653 a_4634_60452# S3P a_2710_60452# VDD pfet_06v0 ad=4.4p pd=20.88u as=4.4p ps=20.88u w=10u l=1u
X654 a_45066_22332# a_43834_22216# VSS VSS nfet_06v0 ad=1.25p pd=5.5u as=2.2p ps=10.88u w=5u l=1u
X655 a_33454_65848# a_9174_65732# a_30578_65848# VSS nfet_06v0 ad=1.3p pd=5.52u as=2.2p ps=10.88u w=5u l=1u
X656 YN YP VSS VSS nfet_05v0 ad=0.5808p pd=3.52u as=0.5808p ps=3.52u w=1.32u l=0.6u
X657 a_44490_13656# a_36210_17056# VDD VDD pfet_06v0 ad=4.4p pd=20.88u as=2.6p ps=10.52u w=10u l=1u
X658 a_44174_42976# a_44174_42976# a_58296_39692# VSS nfet_06v0 ad=0.44p pd=2.88u as=0.25p ps=1.5u w=1u l=1u
X659 a_25998_57052# S4N a_23502_57052# VSS nfet_06v0 ad=2.2p pd=10.88u as=2.2p ps=10.88u w=5u l=1u
X660 a_6558_69248# a_2210_69132# VDD VDD pfet_06v0 ad=2.5p pd=10.5u as=4.4p ps=20.88u w=10u l=1u
X661 VSS a_34566_13656# a_32862_17056# VSS nfet_06v0 ad=1.1p pd=5.88u as=0.65p ps=3.02u w=2.5u l=1u
X662 a_16742_74376# a_16830_74260# VDD VDD pfet_06v0 ad=1.32p pd=6.88u as=1.32p ps=6.88u w=3u l=1u
X663 a_2210_8144# a_2510_8144# a_15600_4860# VSS nfet_06v0 ad=0.44p pd=2.88u as=0.25p ps=1.5u w=1u l=1u
X664 VDD a_64726_56900# a_66922_56900# VDD pfet_06v0 ad=1.32p pd=6.88u as=1.32p ps=6.88u w=3u l=1u
X665 a_25466_60452# S4P a_23542_60452# VDD pfet_06v0 ad=4.4p pd=20.88u as=4.4p ps=20.88u w=10u l=1u
X666 a_54658_65848# a_50330_65732# a_54358_65848# VSS nfet_06v0 ad=2.2p pd=10.88u as=1.25p ps=5.5u w=5u l=1u
X667 ZN ZP VDD VDD pfet_05v0 ad=0.8052p pd=4.54u as=0.8052p ps=4.54u w=1.83u l=0.5u
X668 a_43458_65848# a_42438_65848# VSS VSS nfet_06v0 ad=1.25p pd=5.5u as=2.2p ps=10.88u w=5u l=1u
X669 a_9306_8144# a_9306_8144# a_10930_8144# VDD pfet_06v0 ad=4.4p pd=20.88u as=4.4p ps=20.88u w=10u l=1u
X670 X a_68598_57016# a_69828_6528# VSS nfet_06v0 ad=0.6448p pd=3u as=1.0912p ps=5.84u w=2.48u l=1u
X671 a_35094_17056# a_26590_16940# a_33454_13656# VDD pfet_06v0 ad=1.3p pd=5.52u as=2.2p ps=10.88u w=5u l=1u
X672 a_14166_25732# a_2210_25616# VDD VDD pfet_06v0 ad=2.5p pd=10.5u as=4.4p ps=20.88u w=10u l=1u
X673 a_46098_39692# a_47922_43092# VDD VDD pfet_06v0 ad=2.2p pd=10.88u as=2.2p ps=10.88u w=5u l=1u
X674 a_52594_60336# a_44174_60336# a_52794_60452# VDD pfet_06v0 ad=4.4p pd=20.88u as=2.5p ps=10.5u w=10u l=1u
X675 a_54658_13656# a_32142_13540# a_56422_13656# VSS nfet_06v0 ad=2.2p pd=10.88u as=1.3p ps=5.52u w=5u l=1u
X676 a_57534_65848# a_59174_69248# VDD VDD pfet_06v0 ad=1.3p pd=5.52u as=2.2p ps=10.88u w=5u l=1u
X677 a_56942_34416# a_2118_74260# cap_mim_2f0_m4m5_noshield c_width=20u c_length=10u
X678 VDD a_23622_74260# a_25818_74260# VDD pfet_06v0 ad=1.32p pd=6.88u as=1.32p ps=6.88u w=3u l=1u
X679 VDD a_12130_17056# a_20410_13656# VDD pfet_06v0 ad=2.6p pd=10.52u as=2.6p ps=10.52u w=10u l=1u
X680 a_30578_48376# a_9174_48260# a_33454_48376# VSS nfet_06v0 ad=2.2p pd=10.88u as=1.3p ps=5.52u w=5u l=1u
X681 a_2670_4860# a_2470_4744# a_2370_4860# VSS nfet_06v0 ad=2.2p pd=10.88u as=1.25p ps=5.5u w=5u l=1u
X682 a_68402_51776# a_50370_51660# VDD VDD pfet_06v0 ad=2.5p pd=10.5u as=4.4p ps=20.88u w=10u l=1u
X683 a_65840_6528# a_66178_5204# VSS VSS nfet_06v0 ad=0.5456p pd=3.36u as=0.5456p ps=3.36u w=1.24u l=1u
X684 a_64654_51660# a_50330_48260# a_65774_48376# VSS nfet_06v0 ad=2.2p pd=10.88u as=1.25p ps=5.5u w=5u l=1u
X685 a_24034_75936# a_32342_65848# cap_mim_2f0_m4m5_noshield c_width=20u c_length=10u
X686 a_32862_34416# a_32142_30900# a_30938_34416# VDD pfet_06v0 ad=2.6p pd=10.52u as=4.4p ps=20.88u w=10u l=1u
X687 a_40574_69132# a_40574_69132# a_42198_69132# VDD pfet_06v0 ad=4.4p pd=20.88u as=4.4p ps=20.88u w=10u l=1u
X688 a_44034_57052# a_43834_56936# VSS VSS nfet_06v0 ad=1.25p pd=5.5u as=2.2p ps=10.88u w=5u l=1u
X689 a_46298_43092# a_32142_48260# cap_mim_2f0_m4m5_noshield c_width=20u c_length=10u
X690 a_23542_8260# a_23342_8144# a_24354_8260# VDD pfet_06v0 ad=4.4p pd=20.88u as=2.5p ps=10.5u w=10u l=1u
X691 a_36210_69248# a_26590_69132# a_32342_65848# VDD pfet_06v0 ad=1.3p pd=5.52u as=2.2p ps=10.88u w=5u l=1u
X692 a_2210_8144# a_2510_8144# a_17202_8260# VDD pfet_06v0 ad=4.4p pd=20.88u as=2.5p ps=10.5u w=10u l=1u
X693 a_16494_69132# a_2170_65732# a_17614_65848# VSS nfet_06v0 ad=2.2p pd=10.88u as=1.25p ps=5.5u w=5u l=1u
X694 a_46098_4860# a_47922_8260# VDD VDD pfet_06v0 ad=2.2p pd=10.88u as=2.2p ps=10.88u w=5u l=1u
X695 a_25998_39692# a_27090_43092# VDD VDD pfet_06v0 ad=2.2p pd=10.88u as=2.2p ps=10.88u w=5u l=1u
X696 a_46298_25732# a_32142_30900# cap_mim_2f0_m4m5_noshield c_width=20u c_length=10u
X697 a_11052_22332# a_2470_22216# a_12072_22332# VSS nfet_06v0 ad=2.2p pd=10.88u as=1.25p ps=5.5u w=5u l=1u
X698 a_58058_69248# a_58646_65848# VSS VSS nfet_06v0 ad=0.65p pd=3.02u as=1.1p ps=5.88u w=2.5u l=1u
X699 a_27902_8260# a_23342_8144# a_25266_4860# VDD pfet_06v0 ad=2.2p pd=10.88u as=2.2p ps=10.88u w=5u l=1u
X700 a_26590_16940# a_26590_16940# a_29246_13656# VSS nfet_06v0 ad=0.44p pd=2.88u as=0.25p ps=1.5u w=1u l=1u
X701 a_32862_69248# a_34566_65848# VSS VSS nfet_06v0 ad=0.65p pd=3.02u as=0.65p ps=3.02u w=2.5u l=1u
X702 a_40030_48260# a_26590_51660# a_44322_51776# VDD pfet_06v0 ad=4.4p pd=20.88u as=2.5p ps=10.5u w=10u l=1u
X703 a_2410_8260# a_2210_8144# VDD VDD pfet_06v0 ad=2.5p pd=10.5u as=4.4p ps=20.88u w=10u l=1u
X704 a_57534_31016# a_8062_30900# a_54658_31016# VSS nfet_06v0 ad=1.3p pd=5.52u as=2.2p ps=10.88u w=5u l=1u
X705 a_2510_60336# a_2510_60336# a_16632_57052# VSS nfet_06v0 ad=0.44p pd=2.88u as=0.25p ps=1.5u w=1u l=1u
X706 a_12130_69248# a_15950_65732# a_11598_65848# VSS nfet_06v0 ad=1.1p pd=5.88u as=1.1p ps=5.88u w=2.5u l=1u
X707 a_30578_65848# a_26250_65732# a_31310_65848# VSS nfet_06v0 ad=2.2p pd=10.88u as=1.25p ps=5.5u w=5u l=1u
X708 a_20410_65848# a_11598_65848# VSS VSS nfet_06v0 ad=1.3p pd=5.52u as=2.2p ps=10.88u w=5u l=1u
X709 a_30938_34416# a_9174_30900# a_33978_34416# VDD pfet_06v0 ad=4.4p pd=20.88u as=2.6p ps=10.52u w=10u l=1u
X710 a_11598_31016# a_16494_34300# a_12130_34416# VDD pfet_06v0 ad=2.2p pd=10.88u as=2.2p ps=10.88u w=5u l=1u
X711 a_51062_30900# a_50330_30900# a_51262_31016# VSS nfet_06v0 ad=2.2p pd=10.88u as=1.25p ps=5.5u w=5u l=1u
X712 a_32342_13656# a_35094_17056# VDD VDD pfet_06v0 ad=1.3p pd=5.52u as=1.3p ps=5.52u w=5u l=1u
X713 VSS a_58646_48376# a_58058_51776# VSS nfet_06v0 ad=0.65p pd=3.02u as=0.65p ps=3.02u w=2.5u l=1u
X714 a_37464_39692# a_23342_42976# VSS VSS nfet_06v0 ad=0.25p pd=1.5u as=0.44p ps=2.88u w=1u l=1u
X715 a_67538_31016# a_66518_31016# VSS VSS nfet_06v0 ad=1.25p pd=5.5u as=2.2p ps=10.88u w=5u l=1u
X716 a_2670_57052# a_2470_56936# a_3402_57052# VSS nfet_06v0 ad=2.2p pd=10.88u as=1.25p ps=5.5u w=5u l=1u
X717 a_58058_69248# a_50330_65732# a_58646_65848# VSS nfet_06v0 ad=1.1p pd=5.88u as=0.65p ps=3.02u w=2.5u l=1u
X718 a_27602_51776# a_26290_51660# VDD VDD pfet_06v0 ad=2.5p pd=10.5u as=4.4p ps=20.88u w=10u l=1u
X719 a_32142_48260# a_48312_39692# VSS VSS nfet_06v0 ad=0.44p pd=2.88u as=0.44p ps=2.88u w=1u l=1u
X720 a_31962_60452# a_31762_60336# VDD VDD pfet_06v0 ad=2.5p pd=10.5u as=4.4p ps=20.88u w=10u l=1u
X721 a_46298_25732# S4P a_44374_25732# VDD pfet_06v0 ad=4.4p pd=20.88u as=4.4p ps=20.88u w=10u l=1u
X722 VSS a_10486_65848# a_9898_69248# VSS nfet_06v0 ad=0.65p pd=3.02u as=0.65p ps=3.02u w=2.5u l=1u
X723 a_64110_30900# a_50670_34300# a_68402_34416# VDD pfet_06v0 ad=4.4p pd=20.88u as=2.5p ps=10.5u w=10u l=1u
X724 VSS a_11598_48376# a_14334_74260# VSS nfet_06v0 ad=1.3p pd=5.52u as=1.3p ps=5.52u w=5u l=1u
X725 a_8644_56936# a_8644_56936# a_11052_57052# VSS nfet_06v0 ad=2.2p pd=10.88u as=2.2p ps=10.88u w=5u l=1u
X726 a_56942_51776# a_12870_74260# cap_mim_2f0_m4m5_noshield c_width=20u c_length=10u
X727 a_23502_57052# a_23302_56936# a_24234_57052# VSS nfet_06v0 ad=2.2p pd=10.88u as=1.25p ps=5.5u w=5u l=1u
X728 YP a_68062_26104# VSS VSS nfet_05v0 ad=0.5808p pd=3.52u as=0.5808p ps=3.52u w=1.32u l=0.6u
X729 a_26290_51660# a_26590_51660# a_28214_48376# VSS nfet_06v0 ad=0.44p pd=2.88u as=0.25p ps=1.5u w=1u l=1u
X730 a_34566_65848# a_26250_65732# a_33978_69248# VSS nfet_06v0 ad=0.65p pd=3.02u as=1.1p ps=5.88u w=2.5u l=1u
X731 VSS a_15066_74260# a_14978_74376# VSS nfet_06v0 ad=0.44p pd=2.88u as=0.44p ps=2.88u w=1u l=1u
X732 VDD a_59174_17056# a_57534_13656# VDD pfet_06v0 ad=2.2p pd=10.88u as=1.3p ps=5.52u w=5u l=1u
X733 a_30278_48376# a_26982_48260# VSS VSS nfet_06v0 ad=1.25p pd=5.5u as=2.2p ps=10.88u w=5u l=1u
X734 a_8262_65848# a_8062_65732# a_6498_65848# VSS nfet_06v0 ad=1.3p pd=5.52u as=2.2p ps=10.88u w=5u l=1u
X735 a_44134_39576# a_44174_42976# a_55830_43092# VDD pfet_06v0 ad=4.4p pd=20.88u as=2.5p ps=10.5u w=10u l=1u
X736 a_27090_43092# a_23342_42976# a_25998_39692# VDD pfet_06v0 ad=2.2p pd=10.88u as=2.2p ps=10.88u w=5u l=1u
X737 a_18318_51776# a_18118_51660# VDD VDD pfet_06v0 ad=2.5p pd=10.5u as=4.4p ps=20.88u w=10u l=1u
X738 a_2670_57052# a_2470_56936# a_2370_57052# VSS nfet_06v0 ad=2.2p pd=10.88u as=1.25p ps=5.5u w=5u l=1u
X739 a_34998_8260# a_23042_8144# VDD VDD pfet_06v0 ad=2.5p pd=10.5u as=4.4p ps=20.88u w=10u l=1u
X740 a_68402_69248# a_50370_69132# VDD VDD pfet_06v0 ad=2.5p pd=10.5u as=4.4p ps=20.88u w=10u l=1u
X741 VDD Y Y VDD pfet_06v0 ad=0.88p pd=4.88u as=0.52p ps=2.52u w=2u l=1u
X742 a_27480_57052# a_23302_56936# a_25466_60452# VSS nfet_06v0 ad=1.1p pd=5.88u as=1.1p ps=5.88u w=2.5u l=1u
X743 a_9374_13656# a_2510_16940# a_11014_17056# VDD pfet_06v0 ad=2.2p pd=10.88u as=1.3p ps=5.52u w=5u l=1u
X744 a_42438_31016# a_26250_30900# a_43458_31016# VSS nfet_06v0 ad=2.2p pd=10.88u as=1.25p ps=5.5u w=5u l=1u
X745 a_44134_39576# a_44134_39576# VSS VSS nfet_06v0 ad=0.44p pd=2.88u as=0.44p ps=2.88u w=1u l=1u
X746 a_2510_34300# a_2510_34300# a_5166_31016# VSS nfet_06v0 ad=0.44p pd=2.88u as=0.25p ps=1.5u w=1u l=1u
X747 a_54658_13656# a_8062_13540# a_57534_13656# VSS nfet_06v0 ad=2.2p pd=10.88u as=1.3p ps=5.52u w=5u l=1u
X748 Z a_12782_74376# a_64728_40152# VSS nfet_06v0 ad=0.6448p pd=3u as=1.0912p ps=5.84u w=2.48u l=1u
X749 VSS a_10486_31016# a_9898_34416# VSS nfet_06v0 ad=1.1p pd=5.88u as=0.65p ps=3.02u w=2.5u l=1u
X750 a_26982_48260# a_26250_48260# a_27182_48376# VSS nfet_06v0 ad=2.2p pd=10.88u as=1.25p ps=5.5u w=5u l=1u
X751 a_6498_48376# a_8062_48260# a_8262_48376# VSS nfet_06v0 ad=2.2p pd=10.88u as=1.3p ps=5.52u w=5u l=1u
X752 VDD a_11014_34416# a_8262_31016# VDD pfet_06v0 ad=2.2p pd=10.88u as=1.3p ps=5.52u w=5u l=1u
X753 a_12870_74260# a_60290_51776# VDD VDD pfet_06v0 ad=2.6p pd=10.52u as=4.4p ps=20.88u w=10u l=1u
X754 a_34566_13656# a_40574_16940# a_35094_17056# VDD pfet_06v0 ad=2.2p pd=10.88u as=2.2p ps=10.88u w=5u l=1u
X755 a_23342_42976# a_23342_42976# VDD VDD pfet_06v0 ad=0.88p pd=4.88u as=0.88p ps=4.88u w=2u l=1u
X756 VDD a_35094_51776# a_33454_48376# VDD pfet_06v0 ad=2.2p pd=10.88u as=1.3p ps=5.52u w=5u l=1u
X757 VSS a_58646_13656# a_58058_17056# VSS nfet_06v0 ad=1.1p pd=5.88u as=0.65p ps=3.02u w=2.5u l=1u
X758 a_40030_65732# a_26590_69132# a_44322_69248# VDD pfet_06v0 ad=4.4p pd=20.88u as=2.5p ps=10.5u w=10u l=1u
X759 a_8782_17056# a_10486_13656# VSS VSS nfet_06v0 ad=0.65p pd=3.02u as=1.1p ps=5.88u w=2.5u l=1u
X760 a_44074_25732# a_43874_25616# VDD VDD pfet_06v0 ad=2.5p pd=10.5u as=4.4p ps=20.88u w=10u l=1u
X761 a_7670_34416# a_2210_34300# VDD VDD pfet_06v0 ad=2.5p pd=10.5u as=4.4p ps=20.88u w=10u l=1u
X762 a_23302_56936# a_23342_60336# a_34998_60452# VDD pfet_06v0 ad=4.4p pd=20.88u as=2.5p ps=10.5u w=10u l=1u
X763 a_68062_26104# Y VSS VSS nfet_05v0 ad=0.5808p pd=3.52u as=0.5808p ps=3.52u w=1.32u l=0.6u
X764 a_44334_4860# a_44134_4744# a_45066_4860# VSS nfet_06v0 ad=2.2p pd=10.88u as=1.25p ps=5.5u w=5u l=1u
X765 a_50330_65732# a_50330_65732# VSS VSS nfet_06v0 ad=0.44p pd=2.88u as=0.44p ps=2.88u w=1u l=1u
X766 a_9174_65732# a_6648_57052# VSS VSS nfet_06v0 ad=0.44p pd=2.88u as=0.44p ps=2.88u w=1u l=1u
X767 a_26982_30900# a_26590_34300# a_27602_34416# VDD pfet_06v0 ad=4.4p pd=20.88u as=2.5p ps=10.5u w=10u l=1u
X768 a_10486_48376# a_16494_51660# a_11014_51776# VDD pfet_06v0 ad=2.2p pd=10.88u as=2.2p ps=10.88u w=5u l=1u
X769 a_18358_48376# a_2170_48260# a_19378_48376# VSS nfet_06v0 ad=2.2p pd=10.88u as=1.25p ps=5.5u w=5u l=1u
X770 a_58646_31016# a_50330_30900# a_58058_34416# VSS nfet_06v0 ad=0.65p pd=3.02u as=1.1p ps=5.88u w=2.5u l=1u
X771 a_27602_69248# a_26290_69132# VDD VDD pfet_06v0 ad=2.5p pd=10.5u as=4.4p ps=20.88u w=10u l=1u
X772 a_31140_22332# a_23002_22216# VSS VSS nfet_06v0 ad=1.25p pd=5.5u as=2.2p ps=10.88u w=5u l=1u
X773 VDD a_3494_74376# a_4314_74260# VDD pfet_06v0 ad=1.32p pd=6.88u as=1.32p ps=6.88u w=3u l=1u
X774 a_52794_25732# a_52594_25616# VDD VDD pfet_06v0 ad=2.5p pd=10.5u as=4.4p ps=20.88u w=10u l=1u
X775 a_18118_34300# a_2510_34300# a_18318_34416# VDD pfet_06v0 ad=4.4p pd=20.88u as=2.5p ps=10.5u w=10u l=1u
X776 a_12072_57052# a_11052_57052# VSS VSS nfet_06v0 ad=1.25p pd=5.5u as=2.2p ps=10.88u w=5u l=1u
X777 a_46298_43092# a_47580_39692# VSS VSS nfet_06v0 ad=1.1p pd=5.88u as=1.1p ps=5.88u w=2.5u l=1u
X778 a_15998_74376# a_14246_74376# a_15066_74260# VSS nfet_06v0 ad=0.25p pd=1.5u as=0.44p ps=2.88u w=1u l=1u
X779 a_64728_22792# a_66178_22676# VSS VSS nfet_06v0 ad=0.5456p pd=3.36u as=0.5456p ps=3.36u w=1.24u l=1u
X780 a_7070_8260# a_8644_4744# a_6648_4860# VSS nfet_06v0 ad=1.1p pd=5.88u as=1.1p ps=5.88u w=2.5u l=1u
X781 a_47922_60452# a_44174_60336# a_46830_57052# VDD pfet_06v0 ad=2.2p pd=10.88u as=2.2p ps=10.88u w=5u l=1u
X782 a_56942_69248# a_50330_65732# a_59758_65848# VSS nfet_06v0 ad=1.1p pd=5.88u as=0.65p ps=3.02u w=2.5u l=1u
X783 a_18318_69248# a_18118_69132# VDD VDD pfet_06v0 ad=2.5p pd=10.5u as=4.4p ps=20.88u w=10u l=1u
X784 a_56942_34416# a_58646_31016# VSS VSS nfet_06v0 ad=0.65p pd=3.02u as=1.1p ps=5.88u w=2.5u l=1u
X785 a_40030_65732# a_40030_65732# a_42438_65848# VSS nfet_06v0 ad=2.2p pd=10.88u as=2.2p ps=10.88u w=5u l=1u
X786 a_26590_51660# a_26590_51660# VDD VDD pfet_06v0 ad=0.88p pd=4.88u as=0.88p ps=4.88u w=2u l=1u
X787 a_2210_69132# a_2510_69132# a_4134_65848# VSS nfet_06v0 ad=0.44p pd=2.88u as=0.25p ps=1.5u w=1u l=1u
X788 a_57534_31016# a_59174_34416# VDD VDD pfet_06v0 ad=1.3p pd=5.52u as=1.3p ps=5.52u w=5u l=1u
X789 a_32342_13656# a_35094_17056# VDD VDD pfet_06v0 ad=1.3p pd=5.52u as=2.2p ps=10.88u w=5u l=1u
X790 a_2170_13540# a_2510_16940# a_2410_17056# VDD pfet_06v0 ad=4.4p pd=20.88u as=2.5p ps=10.5u w=10u l=1u
X791 a_26748_39692# a_30138_42976# a_27090_43092# VDD pfet_06v0 ad=2.2p pd=10.88u as=2.2p ps=10.88u w=5u l=1u
X792 a_30138_60336# a_30138_60336# a_31762_60336# VDD pfet_06v0 ad=4.4p pd=20.88u as=4.4p ps=20.88u w=10u l=1u
X793 a_69828_6528# a_66178_5204# VSS VSS nfet_06v0 ad=0.5456p pd=3.36u as=0.5456p ps=3.36u w=1.24u l=1u
X794 a_6198_31016# a_2902_30900# VSS VSS nfet_06v0 ad=1.25p pd=5.5u as=2.2p ps=10.88u w=5u l=1u
X795 a_60290_34416# a_50670_34300# a_56422_31016# VDD pfet_06v0 ad=1.3p pd=5.52u as=2.2p ps=10.88u w=5u l=1u
X796 a_54358_13656# a_51062_13540# VSS VSS nfet_06v0 ad=1.25p pd=5.5u as=2.2p ps=10.88u w=5u l=1u
X797 a_59758_13656# a_64654_16940# a_60290_17056# VDD pfet_06v0 ad=2.2p pd=10.88u as=2.2p ps=10.88u w=5u l=1u
X798 a_11014_34416# a_2510_34300# a_9374_31016# VDD pfet_06v0 ad=1.3p pd=5.52u as=2.2p ps=10.88u w=5u l=1u
X799 a_35678_65848# a_26250_65732# a_32862_69248# VSS nfet_06v0 ad=0.65p pd=3.02u as=1.1p ps=5.88u w=2.5u l=1u
X800 a_30938_17056# a_32142_13540# a_32862_17056# VDD pfet_06v0 ad=4.4p pd=20.88u as=2.6p ps=10.52u w=10u l=1u
X801 a_50970_42976# a_44134_39576# a_51972_39692# VSS nfet_06v0 ad=2.2p pd=10.88u as=1.25p ps=5.5u w=5u l=1u
X802 a_9898_51776# a_2170_48260# a_10486_48376# VSS nfet_06v0 ad=1.1p pd=5.88u as=0.65p ps=3.02u w=2.5u l=1u
X803 a_9374_65848# a_9174_65732# a_6498_65848# VSS nfet_06v0 ad=1.3p pd=5.52u as=2.2p ps=10.88u w=5u l=1u
X804 a_20410_65848# a_11598_65848# VSS VSS nfet_06v0 ad=2.2p pd=10.88u as=1.3p ps=5.52u w=5u l=1u
X805 a_23622_74260# a_60290_69248# VDD VDD pfet_06v0 ad=2.6p pd=10.52u as=4.4p ps=20.88u w=10u l=1u
X806 a_41694_65848# a_26982_65732# VSS VSS nfet_06v0 ad=1.25p pd=5.5u as=2.2p ps=10.88u w=5u l=1u
X807 a_32142_48260# a_46098_39692# cap_mim_2f0_m4m5_noshield c_width=20u c_length=10u
X808 VDD a_35094_69248# a_33454_65848# VDD pfet_06v0 ad=2.2p pd=10.88u as=1.3p ps=5.52u w=5u l=1u
X809 VDD X X VDD pfet_06v0 ad=0.52p pd=2.52u as=0.52p ps=2.52u w=2u l=1u
X810 a_50570_34416# a_50370_34300# VDD VDD pfet_06v0 ad=2.5p pd=10.5u as=4.4p ps=20.88u w=10u l=1u
X811 VDD a_59174_17056# a_57534_13656# VDD pfet_06v0 ad=1.3p pd=5.52u as=1.3p ps=5.52u w=5u l=1u
X812 VDD a_59174_34416# a_56422_31016# VDD pfet_06v0 ad=1.3p pd=5.52u as=1.3p ps=5.52u w=5u l=1u
X813 VSS a_10486_31016# a_8782_34416# VSS nfet_06v0 ad=0.65p pd=3.02u as=0.65p ps=3.02u w=2.5u l=1u
X814 VDD Y Y VDD pfet_06v0 ad=0.52p pd=2.52u as=0.52p ps=2.52u w=2u l=1u
X815 a_6498_48376# a_9174_48260# a_9374_48376# VSS nfet_06v0 ad=2.2p pd=10.88u as=1.3p ps=5.52u w=5u l=1u
X816 a_17614_13656# a_2902_13540# VSS VSS nfet_06v0 ad=1.25p pd=5.5u as=2.2p ps=10.88u w=5u l=1u
X817 a_30578_13656# a_26250_13540# a_30278_13656# VSS nfet_06v0 ad=2.2p pd=10.88u as=1.25p ps=5.5u w=5u l=1u
X818 a_23042_42976# a_23342_42976# a_38034_43092# VDD pfet_06v0 ad=4.4p pd=20.88u as=2.5p ps=10.5u w=10u l=1u
X819 a_8262_31016# a_2510_34300# a_12130_34416# VDD pfet_06v0 ad=2.2p pd=10.88u as=1.3p ps=5.52u w=5u l=1u
X820 a_23342_8144# a_23342_8144# VDD VDD pfet_06v0 ad=0.88p pd=4.88u as=0.88p ps=4.88u w=2u l=1u
X821 a_44374_8260# a_44174_8144# a_44074_8260# VDD pfet_06v0 ad=4.4p pd=20.88u as=2.5p ps=10.5u w=10u l=1u
X822 a_14166_8260# a_2210_8144# VDD VDD pfet_06v0 ad=2.5p pd=10.5u as=4.4p ps=20.88u w=10u l=1u
X823 VSS a_58646_13656# a_56942_17056# VSS nfet_06v0 ad=0.65p pd=3.02u as=0.65p ps=3.02u w=2.5u l=1u
X824 a_53326_48376# a_50670_51660# VSS VSS nfet_06v0 ad=0.25p pd=1.5u as=0.44p ps=2.88u w=1u l=1u
X825 a_5916_57052# a_9306_60336# a_6258_60452# VDD pfet_06v0 ad=2.2p pd=10.88u as=2.2p ps=10.88u w=5u l=1u
X826 a_11014_69248# a_15950_65732# a_10486_65848# VSS nfet_06v0 ad=1.1p pd=5.88u as=1.1p ps=5.88u w=2.5u l=1u
X827 a_10486_65848# a_16494_69132# a_11014_69248# VDD pfet_06v0 ad=2.2p pd=10.88u as=2.2p ps=10.88u w=5u l=1u
X828 a_69828_24000# a_66834_57016# Y VSS nfet_06v0 ad=1.0912p pd=5.84u as=0.6448p ps=3u w=2.48u l=1u
X829 a_45186_25732# a_43874_25616# VDD VDD pfet_06v0 ad=2.5p pd=10.5u as=4.4p ps=20.88u w=10u l=1u
X830 a_55018_51776# a_50670_51660# a_55830_51776# VDD pfet_06v0 ad=4.4p pd=20.88u as=2.5p ps=10.5u w=10u l=1u
X831 a_8782_34416# a_8062_30900# a_6858_34416# VDD pfet_06v0 ad=2.6p pd=10.52u as=4.4p ps=20.88u w=10u l=1u
X832 a_48312_4860# a_50970_8144# a_48734_8260# VDD pfet_06v0 ad=2.2p pd=10.88u as=2.2p ps=10.88u w=5u l=1u
X833 a_58296_22332# a_44174_25616# VSS VSS nfet_06v0 ad=0.25p pd=1.5u as=0.44p ps=2.88u w=1u l=1u
X834 VDD a_35094_51776# a_33454_48376# VDD pfet_06v0 ad=1.3p pd=5.52u as=1.3p ps=5.52u w=5u l=1u
X835 a_23042_42976# a_23342_42976# a_36432_39692# VSS nfet_06v0 ad=0.44p pd=2.88u as=0.25p ps=1.5u w=1u l=1u
X836 a_64110_30900# a_64110_30900# a_66518_31016# VSS nfet_06v0 ad=2.2p pd=10.88u as=2.2p ps=10.88u w=5u l=1u
X837 a_5446_25732# S1N a_2710_25732# VDD pfet_06v0 ad=4.4p pd=20.88u as=4.4p ps=20.88u w=10u l=1u
X838 a_31310_13656# a_26982_13540# VSS VSS nfet_06v0 ad=1.25p pd=5.5u as=2.2p ps=10.88u w=5u l=1u
X839 a_58296_4860# a_44174_8144# VSS VSS nfet_06v0 ad=0.25p pd=1.5u as=0.44p ps=2.88u w=1u l=1u
X840 a_50370_16940# a_50670_16940# a_53606_17056# VDD pfet_06v0 ad=4.4p pd=20.88u as=2.5p ps=10.5u w=10u l=1u
X841 a_56232_4860# a_43834_4744# VSS VSS nfet_06v0 ad=1.25p pd=5.5u as=2.2p ps=10.88u w=5u l=1u
X842 a_66178_22676# a_66178_22676# VDD VDD pfet_06v0 ad=0.88p pd=4.88u as=0.88p ps=4.88u w=2u l=1u
X843 a_52716_39692# a_44134_39576# a_53736_39692# VSS nfet_06v0 ad=2.2p pd=10.88u as=1.25p ps=5.5u w=5u l=1u
X844 a_2210_25616# a_2510_25616# a_17202_25732# VDD pfet_06v0 ad=4.4p pd=20.88u as=2.5p ps=10.5u w=10u l=1u
X845 a_23622_74260# a_59758_65848# VSS VSS nfet_06v0 ad=1.3p pd=5.52u as=2.2p ps=10.88u w=5u l=1u
X846 a_52294_48376# a_50670_51660# VSS VSS nfet_06v0 ad=0.25p pd=1.5u as=0.44p ps=2.88u w=1u l=1u
X847 a_59758_31016# a_50330_30900# a_56942_34416# VSS nfet_06v0 ad=0.65p pd=3.02u as=1.1p ps=5.88u w=2.5u l=1u
X848 a_65038_58692# a_64726_56900# a_64638_57016# VDD pfet_06v0 ad=0.75p pd=3.5u as=1.32p ps=6.88u w=3u l=1u
X849 a_26590_69132# a_26590_69132# VDD VDD pfet_06v0 ad=0.88p pd=4.88u as=0.88p ps=4.88u w=2u l=1u
X850 a_9374_48376# a_11014_51776# VDD VDD pfet_06v0 ad=1.3p pd=5.52u as=2.2p ps=10.88u w=5u l=1u
X851 a_5166_65848# a_2510_69132# VSS VSS nfet_06v0 ad=0.25p pd=1.5u as=0.44p ps=2.88u w=1u l=1u
X852 a_26278_25732# S2N a_23542_25732# VDD pfet_06v0 ad=4.4p pd=20.88u as=4.4p ps=20.88u w=10u l=1u
X853 a_48312_39692# a_44134_39576# a_46298_43092# VSS nfet_06v0 ad=1.1p pd=5.88u as=1.1p ps=5.88u w=2.5u l=1u
X854 a_58058_17056# a_8062_13540# a_55018_17056# VDD pfet_06v0 ad=2.6p pd=10.52u as=4.4p ps=20.88u w=10u l=1u
X855 a_3494_74376# a_3582_74260# VDD VDD pfet_06v0 ad=1.32p pd=6.88u as=1.32p ps=6.88u w=3u l=1u
X856 a_23934_76052# a_23622_74260# a_23534_74376# VDD pfet_06v0 ad=0.75p pd=3.5u as=1.32p ps=6.88u w=3u l=1u
X857 VSS a_14334_74260# a_14246_74376# VSS nfet_06v0 ad=0.44p pd=2.88u as=0.44p ps=2.88u w=1u l=1u
X858 a_6498_65848# a_2170_65732# a_7230_65848# VSS nfet_06v0 ad=2.2p pd=10.88u as=1.25p ps=5.5u w=5u l=1u
X859 a_65774_31016# a_51062_30900# VSS VSS nfet_06v0 ad=1.25p pd=5.5u as=2.2p ps=10.88u w=5u l=1u
X860 a_8782_17056# a_10486_13656# VSS VSS nfet_06v0 ad=0.65p pd=3.02u as=0.65p ps=3.02u w=2.5u l=1u
X861 a_23502_4860# a_23302_4744# a_24234_4860# VSS nfet_06v0 ad=2.2p pd=10.88u as=1.25p ps=5.5u w=5u l=1u
X862 Y Y VDD VDD pfet_06v0 ad=0.52p pd=2.52u as=0.88p ps=4.88u w=2u l=1u
X863 a_44334_39692# a_44134_39576# a_44034_39692# VSS nfet_06v0 ad=2.2p pd=10.88u as=1.25p ps=5.5u w=5u l=1u
X864 a_36110_43092# a_23042_42976# VDD VDD pfet_06v0 ad=2.5p pd=10.5u as=4.4p ps=20.88u w=10u l=1u
X865 VSS a_59758_48376# a_12870_74260# VSS nfet_06v0 ad=1.3p pd=5.52u as=1.3p ps=5.52u w=5u l=1u
X866 a_67842_22792# a_66178_22676# VSS VSS nfet_06v0 ad=0.175p pd=1.2u as=0.308p ps=2.28u w=0.7u l=1u
X867 a_11052_4860# a_2470_4744# a_12072_4860# VSS nfet_06v0 ad=2.2p pd=10.88u as=1.25p ps=5.5u w=5u l=1u
X868 a_26290_51660# a_26590_51660# a_29526_51776# VDD pfet_06v0 ad=4.4p pd=20.88u as=2.5p ps=10.5u w=10u l=1u
X869 a_32142_65732# a_46098_57052# cap_mim_2f0_m4m5_noshield c_width=20u c_length=10u
X870 a_57264_57052# a_44174_60336# VSS VSS nfet_06v0 ad=0.25p pd=1.5u as=0.44p ps=2.88u w=1u l=1u
X871 a_29476_56936# a_23342_60336# a_33886_60452# VDD pfet_06v0 ad=4.4p pd=20.88u as=2.5p ps=10.5u w=10u l=1u
X872 a_66178_5204# a_66178_5204# a_68442_5320# VSS nfet_06v0 ad=0.308p pd=2.28u as=0.175p ps=1.2u w=0.7u l=1u
X873 a_2902_13540# a_2510_16940# a_3522_17056# VDD pfet_06v0 ad=4.4p pd=20.88u as=2.5p ps=10.5u w=10u l=1u
X874 a_5166_57052# a_6258_60452# VDD VDD pfet_06v0 ad=2.2p pd=10.88u as=2.2p ps=10.88u w=5u l=1u
X875 a_26748_4860# a_23302_4744# a_26278_8260# VSS nfet_06v0 ad=1.1p pd=5.88u as=1.1p ps=5.88u w=2.5u l=1u
X876 a_66278_16940# a_50670_16940# a_66478_17056# VDD pfet_06v0 ad=4.4p pd=20.88u as=2.5p ps=10.5u w=10u l=1u
X877 a_33978_17056# a_26250_13540# a_34566_13656# VSS nfet_06v0 ad=1.1p pd=5.88u as=0.65p ps=3.02u w=2.5u l=1u
X878 a_2170_39576# a_2470_39576# a_14568_39692# VSS nfet_06v0 ad=2.2p pd=10.88u as=1.25p ps=5.5u w=5u l=1u
X879 a_33454_31016# a_35094_34416# VDD VDD pfet_06v0 ad=1.3p pd=5.52u as=2.2p ps=10.88u w=5u l=1u
X880 a_35094_69248# a_40030_65732# a_34566_65848# VSS nfet_06v0 ad=1.1p pd=5.88u as=1.1p ps=5.88u w=2.5u l=1u
X881 a_57534_13656# a_50670_16940# a_59174_17056# VDD pfet_06v0 ad=2.2p pd=10.88u as=1.3p ps=5.52u w=5u l=1u
X882 a_3102_31016# a_2902_30900# VSS VSS nfet_06v0 ad=1.25p pd=5.5u as=2.2p ps=10.88u w=5u l=1u
X883 a_10308_39692# a_2170_39576# VSS VSS nfet_06v0 ad=1.25p pd=5.5u as=2.2p ps=10.88u w=5u l=1u
X884 VDD a_20410_13656# a_68686_56900# VDD pfet_06v0 ad=1.32p pd=6.88u as=1.32p ps=6.88u w=3u l=1u
X885 a_17202_43092# a_2210_42976# VDD VDD pfet_06v0 ad=2.5p pd=10.5u as=4.4p ps=20.88u w=10u l=1u
X886 VSS a_25818_74260# a_25730_74376# VSS nfet_06v0 ad=0.44p pd=2.88u as=0.44p ps=2.88u w=1u l=1u
X887 a_40574_34300# a_26250_30900# a_41694_31016# VSS nfet_06v0 ad=2.2p pd=10.88u as=1.25p ps=5.5u w=5u l=1u
X888 a_67684_24000# Y a_69084_24000# VSS nfet_06v0 ad=0.88p pd=4.88u as=0.5p ps=2.5u w=2u l=1u
X889 a_65840_41360# a_66178_40036# VSS VSS nfet_06v0 ad=0.5456p pd=3.36u as=0.5456p ps=3.36u w=1.24u l=1u
X890 a_9306_8144# a_2470_4744# a_10308_4860# VSS nfet_06v0 ad=2.2p pd=10.88u as=1.25p ps=5.5u w=5u l=1u
X891 a_13182_76052# a_12870_74260# a_12782_74376# VDD pfet_06v0 ad=0.75p pd=3.5u as=1.32p ps=6.88u w=3u l=1u
X892 a_10486_13656# a_2170_13540# a_9898_17056# VSS nfet_06v0 ad=0.65p pd=3.02u as=1.1p ps=5.88u w=2.5u l=1u
X893 VSS a_58646_13656# a_56942_17056# VSS nfet_06v0 ad=1.1p pd=5.88u as=0.65p ps=3.02u w=2.5u l=1u
X894 a_51682_34416# a_50370_34300# VDD VDD pfet_06v0 ad=2.5p pd=10.5u as=4.4p ps=20.88u w=10u l=1u
X895 a_15278_60452# a_2210_60336# VDD VDD pfet_06v0 ad=2.5p pd=10.5u as=4.4p ps=20.88u w=10u l=1u
X896 a_55018_69248# a_50670_69132# a_55830_69248# VDD pfet_06v0 ad=4.4p pd=20.88u as=2.5p ps=10.5u w=10u l=1u
X897 a_56942_34416# a_58646_31016# VSS VSS nfet_06v0 ad=0.65p pd=3.02u as=0.65p ps=3.02u w=2.5u l=1u
X898 a_16494_34300# a_16494_34300# a_18118_34300# VDD pfet_06v0 ad=4.4p pd=20.88u as=4.4p ps=20.88u w=10u l=1u
X899 a_15600_39692# a_2510_42976# VSS VSS nfet_06v0 ad=0.25p pd=1.5u as=0.44p ps=2.88u w=1u l=1u
X900 a_44322_17056# a_26290_16940# VDD VDD pfet_06v0 ad=2.5p pd=10.5u as=4.4p ps=20.88u w=10u l=1u
X901 a_56422_48376# a_32142_48260# a_54658_48376# VSS nfet_06v0 ad=1.3p pd=5.52u as=2.2p ps=10.88u w=5u l=1u
X902 VDD a_35094_69248# a_33454_65848# VDD pfet_06v0 ad=1.3p pd=5.52u as=1.3p ps=5.52u w=5u l=1u
X903 a_55018_34416# a_32142_30900# a_56942_34416# VDD pfet_06v0 ad=4.4p pd=20.88u as=2.6p ps=10.52u w=10u l=1u
X904 a_12870_74260# a_56422_48376# cap_mim_2f0_m4m5_noshield c_width=20u c_length=10u
X905 a_33978_34416# a_34566_31016# VSS VSS nfet_06v0 ad=0.65p pd=3.02u as=0.65p ps=3.02u w=2.5u l=1u
X906 a_53736_4860# a_52716_4860# VSS VSS nfet_06v0 ad=1.25p pd=5.5u as=2.2p ps=10.88u w=5u l=1u
X907 a_32904_39692# a_31884_39692# VSS VSS nfet_06v0 ad=1.25p pd=5.5u as=2.2p ps=10.88u w=5u l=1u
X908 a_42398_34416# a_42198_34300# VDD VDD pfet_06v0 ad=2.5p pd=10.5u as=4.4p ps=20.88u w=10u l=1u
X909 a_2118_74260# a_56422_31016# cap_mim_2f0_m4m5_noshield c_width=20u c_length=10u
X910 a_50308_4744# a_44174_8144# a_54718_8260# VDD pfet_06v0 ad=4.4p pd=20.88u as=2.5p ps=10.5u w=10u l=1u
X911 a_2710_8260# a_2510_8144# a_3522_8260# VDD pfet_06v0 ad=4.4p pd=20.88u as=2.5p ps=10.5u w=10u l=1u
X912 a_13282_75936# a_36210_51776# VDD VDD pfet_06v0 ad=4.4p pd=20.88u as=2.6p ps=10.52u w=10u l=1u
X913 a_28214_31016# a_26590_34300# VSS VSS nfet_06v0 ad=0.25p pd=1.5u as=0.44p ps=2.88u w=1u l=1u
X914 a_9374_65848# a_11014_69248# VDD VDD pfet_06v0 ad=1.3p pd=5.52u as=2.2p ps=10.88u w=5u l=1u
X915 a_9174_30900# a_4434_22332# cap_mim_2f0_m4m5_noshield c_width=20u c_length=10u
X916 a_47110_43092# a_47580_39692# VSS VSS nfet_06v0 ad=1.1p pd=5.88u as=1.1p ps=5.88u w=2.5u l=1u
X917 a_55390_48376# a_51062_48260# VSS VSS nfet_06v0 ad=1.25p pd=5.5u as=2.2p ps=10.88u w=5u l=1u
X918 a_23202_39692# a_23002_39576# VSS VSS nfet_06v0 ad=1.25p pd=5.5u as=2.2p ps=10.88u w=5u l=1u
X919 a_35094_51776# a_26590_51660# a_33454_48376# VDD pfet_06v0 ad=1.3p pd=5.52u as=2.2p ps=10.88u w=5u l=1u
X920 a_55018_17056# a_50670_16940# a_54718_17056# VDD pfet_06v0 ad=4.4p pd=20.88u as=2.5p ps=10.5u w=10u l=1u
X921 a_15950_13540# a_2510_16940# a_20242_17056# VDD pfet_06v0 ad=4.4p pd=20.88u as=2.5p ps=10.5u w=10u l=1u
X922 a_27902_60452# a_23342_60336# a_25266_57052# VDD pfet_06v0 ad=2.2p pd=10.88u as=2.2p ps=10.88u w=5u l=1u
X923 a_56422_13656# a_50670_16940# a_60290_17056# VDD pfet_06v0 ad=2.2p pd=10.88u as=1.3p ps=5.52u w=5u l=1u
X924 a_45066_39692# a_43834_39576# VSS VSS nfet_06v0 ad=1.25p pd=5.5u as=2.2p ps=10.88u w=5u l=1u
X925 VDD a_12130_51776# a_14334_74260# VDD pfet_06v0 ad=2.6p pd=10.52u as=2.6p ps=10.52u w=10u l=1u
X926 a_23542_8260# a_23342_8144# a_23242_8260# VDD pfet_06v0 ad=4.4p pd=20.88u as=2.5p ps=10.5u w=10u l=1u
X927 a_59174_34416# a_64110_30900# a_58646_31016# VSS nfet_06v0 ad=1.1p pd=5.88u as=1.1p ps=5.88u w=2.5u l=1u
X928 a_26290_69132# a_26590_69132# a_29526_69248# VDD pfet_06v0 ad=4.4p pd=20.88u as=2.5p ps=10.5u w=10u l=1u
X929 a_13054_60452# a_2210_60336# VDD VDD pfet_06v0 ad=2.5p pd=10.5u as=4.4p ps=20.88u w=10u l=1u
X930 a_6648_39692# a_9306_42976# a_7070_43092# VDD pfet_06v0 ad=2.2p pd=10.88u as=2.2p ps=10.88u w=5u l=1u
X931 a_50670_16940# a_50670_16940# a_53326_13656# VSS nfet_06v0 ad=0.44p pd=2.88u as=0.25p ps=1.5u w=1u l=1u
X932 a_27480_4860# a_30138_8144# a_27902_8260# VDD pfet_06v0 ad=2.2p pd=10.88u as=2.2p ps=10.88u w=5u l=1u
X933 a_8062_30900# a_25266_22332# cap_mim_2f0_m4m5_noshield c_width=20u c_length=10u
X934 a_2118_74260# a_60290_34416# VDD VDD pfet_06v0 ad=4.4p pd=20.88u as=2.6p ps=10.52u w=10u l=1u
X935 a_36210_69248# a_40030_65732# a_35678_65848# VSS nfet_06v0 ad=1.1p pd=5.88u as=1.1p ps=5.88u w=2.5u l=1u
X936 a_56422_13656# a_59174_17056# VDD VDD pfet_06v0 ad=1.3p pd=5.52u as=1.3p ps=5.52u w=5u l=1u
X937 a_37464_4860# a_23342_8144# VSS VSS nfet_06v0 ad=0.25p pd=1.5u as=0.44p ps=2.88u w=1u l=1u
X938 a_35400_4860# a_23002_4744# VSS VSS nfet_06v0 ad=1.25p pd=5.5u as=2.2p ps=10.88u w=5u l=1u
X939 a_59174_34416# a_50670_34300# a_57534_31016# VDD pfet_06v0 ad=1.3p pd=5.52u as=2.2p ps=10.88u w=5u l=1u
X940 a_50370_16940# a_50670_16940# a_52294_13656# VSS nfet_06v0 ad=0.44p pd=2.88u as=0.25p ps=1.5u w=1u l=1u
X941 Z Z a_67684_41360# VSS nfet_06v0 ad=0.52p pd=2.52u as=0.88p ps=4.88u w=2u l=1u
X942 a_30638_34416# a_26290_34300# VDD VDD pfet_06v0 ad=2.5p pd=10.5u as=4.4p ps=20.88u w=10u l=1u
X943 a_6258_43092# a_2510_42976# a_5166_39692# VDD pfet_06v0 ad=2.2p pd=10.88u as=2.2p ps=10.88u w=5u l=1u
X944 VDD a_36210_34416# a_2530_75936# VDD pfet_06v0 ad=2.6p pd=10.52u as=2.6p ps=10.52u w=10u l=1u
X945 a_2710_43092# a_2510_42976# a_2410_43092# VDD pfet_06v0 ad=4.4p pd=20.88u as=2.5p ps=10.5u w=10u l=1u
X946 a_23622_74260# a_59758_65848# VSS VSS nfet_06v0 ad=2.2p pd=10.88u as=1.3p ps=5.52u w=5u l=1u
X947 a_32862_17056# a_26250_13540# a_35678_13656# VSS nfet_06v0 ad=1.1p pd=5.88u as=0.65p ps=3.02u w=2.5u l=1u
X948 a_6858_17056# a_8062_13540# a_8782_17056# VDD pfet_06v0 ad=4.4p pd=20.88u as=2.6p ps=10.52u w=10u l=1u
X949 a_19378_31016# a_18358_31016# VSS VSS nfet_06v0 ad=1.25p pd=5.5u as=2.2p ps=10.88u w=5u l=1u
X950 a_58866_60452# a_43874_60336# VDD VDD pfet_06v0 ad=2.5p pd=10.5u as=4.4p ps=20.88u w=10u l=1u
X951 a_23542_43092# a_23342_42976# a_23242_43092# VDD pfet_06v0 ad=4.4p pd=20.88u as=2.5p ps=10.5u w=10u l=1u
X952 a_7070_60452# a_8644_56936# a_6648_57052# VSS nfet_06v0 ad=1.1p pd=5.88u as=1.1p ps=5.88u w=2.5u l=1u
X953 a_11052_39692# a_2470_39576# a_12072_39692# VSS nfet_06v0 ad=2.2p pd=10.88u as=1.25p ps=5.5u w=5u l=1u
X954 a_32342_48376# a_35094_51776# VDD VDD pfet_06v0 ad=1.3p pd=5.52u as=1.3p ps=5.52u w=5u l=1u
X955 a_47580_39692# a_50970_42976# a_47922_43092# VDD pfet_06v0 ad=2.2p pd=10.88u as=2.2p ps=10.88u w=5u l=1u
X956 a_26278_8260# S2N a_23542_8260# VDD pfet_06v0 ad=4.4p pd=20.88u as=4.4p ps=20.88u w=10u l=1u
X957 a_50670_34300# a_50670_34300# VDD VDD pfet_06v0 ad=0.88p pd=4.88u as=0.88p ps=4.88u w=2u l=1u
X958 a_11598_13656# a_2170_13540# a_8782_17056# VSS nfet_06v0 ad=0.65p pd=3.02u as=1.1p ps=5.88u w=2.5u l=1u
X959 a_68062_43464# Z VDD VDD pfet_05v0 ad=0.8052p pd=4.54u as=0.8052p ps=4.54u w=1.83u l=0.5u
X960 a_43874_25616# a_44174_25616# a_57264_22332# VSS nfet_06v0 ad=0.44p pd=2.88u as=0.25p ps=1.5u w=1u l=1u
X961 a_24034_75936# a_36210_69248# VDD VDD pfet_06v0 ad=4.4p pd=20.88u as=2.6p ps=10.52u w=10u l=1u
X962 a_44490_13656# a_36210_17056# VDD VDD pfet_06v0 ad=2.6p pd=10.52u as=4.4p ps=20.88u w=10u l=1u
X963 a_46830_4860# S3N a_44334_4860# VSS nfet_06v0 ad=2.2p pd=10.88u as=2.2p ps=10.88u w=5u l=1u
X964 a_57534_48376# a_8062_48260# a_54658_48376# VSS nfet_06v0 ad=1.3p pd=5.52u as=2.2p ps=10.88u w=5u l=1u
X965 a_33886_8260# a_23042_8144# VDD VDD pfet_06v0 ad=2.5p pd=10.5u as=4.4p ps=20.88u w=10u l=1u
X966 VSS a_34566_65848# a_32862_69248# VSS nfet_06v0 ad=1.1p pd=5.88u as=0.65p ps=3.02u w=2.5u l=1u
X967 a_25266_4860# a_27090_8260# VDD VDD pfet_06v0 ad=2.2p pd=10.88u as=2.2p ps=10.88u w=5u l=1u
X968 a_6498_13656# a_2170_13540# a_6198_13656# VSS nfet_06v0 ad=2.2p pd=10.88u as=1.25p ps=5.5u w=5u l=1u
X969 a_51062_48260# a_50330_48260# a_51262_48376# VSS nfet_06v0 ad=2.2p pd=10.88u as=1.25p ps=5.5u w=5u l=1u
X970 a_35094_69248# a_26590_69132# a_33454_65848# VDD pfet_06v0 ad=1.3p pd=5.52u as=2.2p ps=10.88u w=5u l=1u
X971 a_66178_22676# a_66178_22676# a_68442_22792# VSS nfet_06v0 ad=0.308p pd=2.28u as=0.175p ps=1.2u w=0.7u l=1u
X972 a_48734_25732# a_44174_25616# a_46098_22332# VDD pfet_06v0 ad=2.2p pd=10.88u as=2.2p ps=10.88u w=5u l=1u
X973 a_23002_56936# a_23342_60336# a_36110_60452# VDD pfet_06v0 ad=4.4p pd=20.88u as=2.5p ps=10.5u w=10u l=1u
X974 a_54658_65848# a_32142_65732# a_56422_65848# VSS nfet_06v0 ad=2.2p pd=10.88u as=1.3p ps=5.52u w=5u l=1u
X975 a_67538_48376# a_66518_48376# VSS VSS nfet_06v0 ad=1.25p pd=5.5u as=2.2p ps=10.88u w=5u l=1u
X976 a_31762_42976# a_23342_42976# a_31962_43092# VDD pfet_06v0 ad=4.4p pd=20.88u as=2.5p ps=10.5u w=10u l=1u
X977 VDD a_12130_69248# a_20410_65848# VDD pfet_06v0 ad=2.6p pd=10.52u as=2.6p ps=10.52u w=10u l=1u
X978 VSS a_13282_75936# a_12782_74376# VSS nfet_06v0 ad=0.44p pd=2.88u as=0.44p ps=2.88u w=1u l=1u
X979 VDD a_59174_51776# a_57534_48376# VDD pfet_06v0 ad=2.2p pd=10.88u as=1.3p ps=5.52u w=5u l=1u
X980 a_33886_25732# a_23042_25616# VDD VDD pfet_06v0 ad=2.5p pd=10.5u as=4.4p ps=20.88u w=10u l=1u
X981 a_60290_34416# a_64110_30900# a_59758_31016# VSS nfet_06v0 ad=1.1p pd=5.88u as=1.1p ps=5.88u w=2.5u l=1u
X982 a_47110_8260# a_47580_4860# VSS VSS nfet_06v0 ad=1.1p pd=5.88u as=1.1p ps=5.88u w=2.5u l=1u
X983 a_64654_16940# a_64654_16940# a_66278_16940# VDD pfet_06v0 ad=4.4p pd=20.88u as=4.4p ps=20.88u w=10u l=1u
X984 a_33978_34416# a_34566_31016# VSS VSS nfet_06v0 ad=0.65p pd=3.02u as=1.1p ps=5.88u w=2.5u l=1u
X985 a_6858_17056# a_9174_13540# a_9898_17056# VDD pfet_06v0 ad=4.4p pd=20.88u as=2.6p ps=10.52u w=10u l=1u
X986 a_9374_48376# a_2510_51660# a_11014_51776# VDD pfet_06v0 ad=2.2p pd=10.88u as=1.3p ps=5.52u w=5u l=1u
X987 a_64728_24000# a_66178_22676# VSS VSS nfet_06v0 ad=0.5456p pd=3.36u as=0.5456p ps=3.36u w=1.24u l=1u
X988 a_7230_13656# a_2902_13540# VSS VSS nfet_06v0 ad=1.25p pd=5.5u as=2.2p ps=10.88u w=5u l=1u
X989 a_50970_42976# a_50970_42976# a_52594_42976# VDD pfet_06v0 ad=4.4p pd=20.88u as=4.4p ps=20.88u w=10u l=1u
X990 a_43834_56936# a_44134_56936# a_56232_57052# VSS nfet_06v0 ad=2.2p pd=10.88u as=1.25p ps=5.5u w=5u l=1u
X991 a_32904_4860# a_31884_4860# VSS VSS nfet_06v0 ad=1.25p pd=5.5u as=2.2p ps=10.88u w=5u l=1u
X992 VSS a_6078_74260# a_5990_74376# VSS nfet_06v0 ad=0.44p pd=2.88u as=0.44p ps=2.88u w=1u l=1u
X993 a_14166_60452# a_2210_60336# VDD VDD pfet_06v0 ad=2.5p pd=10.5u as=4.4p ps=20.88u w=10u l=1u
X994 Z a_64638_57016# a_69828_41360# VSS nfet_06v0 ad=0.6448p pd=3u as=1.0912p ps=5.84u w=2.48u l=1u
X995 a_34566_48376# a_40574_51660# a_35094_51776# VDD pfet_06v0 ad=2.2p pd=10.88u as=2.2p ps=10.88u w=5u l=1u
X996 a_10930_25616# a_2510_25616# a_11130_25732# VDD pfet_06v0 ad=4.4p pd=20.88u as=2.5p ps=10.5u w=10u l=1u
X997 a_42438_48376# a_26250_48260# a_43458_48376# VSS nfet_06v0 ad=2.2p pd=10.88u as=1.25p ps=5.5u w=5u l=1u
X998 a_2510_51660# a_2510_51660# a_5166_48376# VSS nfet_06v0 ad=0.44p pd=2.88u as=0.25p ps=1.5u w=1u l=1u
X999 a_54658_13656# a_50330_13540# a_55390_13656# VSS nfet_06v0 ad=2.2p pd=10.88u as=1.25p ps=5.5u w=5u l=1u
X1000 Z Z VDD VDD pfet_06v0 ad=0.52p pd=2.52u as=0.52p ps=2.52u w=2u l=1u
X1001 a_26590_69132# a_26590_69132# a_29246_65848# VSS nfet_06v0 ad=0.44p pd=2.88u as=0.25p ps=1.5u w=1u l=1u
X1002 a_44490_13656# a_35678_13656# VSS VSS nfet_06v0 ad=1.3p pd=5.52u as=2.2p ps=10.88u w=5u l=1u
X1003 VSS a_10486_48376# a_9898_51776# VSS nfet_06v0 ad=1.1p pd=5.88u as=0.65p ps=3.02u w=2.5u l=1u
X1004 a_64728_40152# a_12782_74376# Z VSS nfet_06v0 ad=1.0912p pd=5.84u as=0.6448p ps=3u w=2.48u l=1u
X1005 a_69084_41360# Z VSS VSS nfet_06v0 ad=0.5p pd=2.5u as=0.88p ps=4.88u w=2u l=1u
X1006 a_36432_22332# a_23342_25616# VSS VSS nfet_06v0 ad=0.25p pd=1.5u as=0.44p ps=2.88u w=1u l=1u
X1007 a_32342_65848# a_35094_69248# VDD VDD pfet_06v0 ad=1.3p pd=5.52u as=1.3p ps=5.52u w=5u l=1u
X1008 a_2710_43092# a_2510_42976# a_3522_43092# VDD pfet_06v0 ad=4.4p pd=20.88u as=2.5p ps=10.5u w=10u l=1u
X1009 a_5446_34416# a_2210_34300# VDD VDD pfet_06v0 ad=2.5p pd=10.5u as=4.4p ps=20.88u w=10u l=1u
X1010 VSS a_34566_13656# a_33978_17056# VSS nfet_06v0 ad=0.65p pd=3.02u as=0.65p ps=3.02u w=2.5u l=1u
X1011 a_14568_4860# a_2170_4744# VSS VSS nfet_06v0 ad=1.25p pd=5.5u as=2.2p ps=10.88u w=5u l=1u
X1012 a_56422_13656# a_59174_17056# VDD VDD pfet_06v0 ad=1.3p pd=5.52u as=2.2p ps=10.88u w=5u l=1u
X1013 a_53736_22332# a_52716_22332# VSS VSS nfet_06v0 ad=1.25p pd=5.5u as=2.2p ps=10.88u w=5u l=1u
X1014 a_55830_17056# a_50370_16940# VDD VDD pfet_06v0 ad=2.5p pd=10.5u as=4.4p ps=20.88u w=10u l=1u
X1015 a_26250_13540# a_26590_16940# a_26490_17056# VDD pfet_06v0 ad=4.4p pd=20.88u as=2.5p ps=10.5u w=10u l=1u
X1016 a_58646_31016# a_64654_34300# a_59174_34416# VDD pfet_06v0 ad=2.2p pd=10.88u as=2.2p ps=10.88u w=5u l=1u
X1017 a_32142_65732# a_48734_60452# VDD VDD pfet_06v0 ad=0.308p pd=2.28u as=0.308p ps=2.28u w=0.7u l=20u
X1018 a_23302_56936# a_23302_56936# VSS VSS nfet_06v0 ad=0.44p pd=2.88u as=0.44p ps=2.88u w=1u l=1u
X1019 a_12130_17056# a_2510_16940# a_8262_13656# VDD pfet_06v0 ad=1.3p pd=5.52u as=2.2p ps=10.88u w=5u l=1u
X1020 a_23542_43092# a_23342_42976# a_24354_43092# VDD pfet_06v0 ad=4.4p pd=20.88u as=2.5p ps=10.5u w=10u l=1u
X1021 a_29476_4744# a_29476_4744# a_31884_4860# VSS nfet_06v0 ad=2.2p pd=10.88u as=2.2p ps=10.88u w=5u l=1u
X1022 a_43834_22216# a_44174_25616# a_56942_25732# VDD pfet_06v0 ad=4.4p pd=20.88u as=2.5p ps=10.5u w=10u l=1u
X1023 a_9374_31016# a_11014_34416# VDD VDD pfet_06v0 ad=1.3p pd=5.52u as=1.3p ps=5.52u w=5u l=1u
X1024 a_16632_4860# a_2510_8144# VSS VSS nfet_06v0 ad=0.25p pd=1.5u as=0.44p ps=2.88u w=1u l=1u
X1025 a_9174_65732# a_7070_60452# VDD VDD pfet_06v0 ad=0.308p pd=2.28u as=0.308p ps=2.28u w=0.7u l=20u
X1026 VDD a_59174_69248# a_57534_65848# VDD pfet_06v0 ad=2.2p pd=10.88u as=1.3p ps=5.52u w=5u l=1u
X1027 a_58646_48376# a_50330_48260# a_58058_51776# VSS nfet_06v0 ad=0.65p pd=3.02u as=1.1p ps=5.88u w=2.5u l=1u
X1028 a_31140_39692# a_23002_39576# VSS VSS nfet_06v0 ad=1.25p pd=5.5u as=2.2p ps=10.88u w=5u l=1u
X1029 a_32342_48376# a_35094_51776# VDD VDD pfet_06v0 ad=1.3p pd=5.52u as=2.2p ps=10.88u w=5u l=1u
X1030 a_2170_48260# a_2510_51660# a_2410_51776# VDD pfet_06v0 ad=4.4p pd=20.88u as=2.5p ps=10.5u w=10u l=1u
X1031 a_9374_65848# a_2510_69132# a_11014_69248# VDD pfet_06v0 ad=2.2p pd=10.88u as=1.3p ps=5.52u w=5u l=1u
X1032 a_35400_57052# a_23002_56936# VSS VSS nfet_06v0 ad=1.25p pd=5.5u as=2.2p ps=10.88u w=5u l=1u
X1033 a_25998_4860# S2N a_23502_4860# VSS nfet_06v0 ad=2.2p pd=10.88u as=2.2p ps=10.88u w=5u l=1u
X1034 a_30938_17056# a_26590_16940# a_31750_17056# VDD pfet_06v0 ad=4.4p pd=20.88u as=2.5p ps=10.5u w=10u l=1u
X1035 a_26250_30900# a_26250_30900# VSS VSS nfet_06v0 ad=0.44p pd=2.88u as=0.44p ps=2.88u w=1u l=1u
X1036 a_59758_48376# a_64654_51660# a_60290_51776# VDD pfet_06v0 ad=2.2p pd=10.88u as=2.2p ps=10.88u w=5u l=1u
X1037 a_54658_65848# a_8062_65732# a_57534_65848# VSS nfet_06v0 ad=2.2p pd=10.88u as=1.3p ps=5.52u w=5u l=1u
X1038 a_30938_51776# a_32142_48260# a_32862_51776# VDD pfet_06v0 ad=4.4p pd=20.88u as=2.6p ps=10.52u w=10u l=1u
X1039 a_2902_13540# a_2170_13540# a_3102_13656# VSS nfet_06v0 ad=2.2p pd=10.88u as=1.25p ps=5.5u w=5u l=1u
X1040 a_14568_22332# a_2170_22216# VSS VSS nfet_06v0 ad=1.25p pd=5.5u as=2.2p ps=10.88u w=5u l=1u
X1041 a_46298_60452# S2P a_44374_60452# VDD pfet_06v0 ad=4.4p pd=20.88u as=4.4p ps=20.88u w=10u l=1u
X1042 VDD a_11014_17056# a_9374_13656# VDD pfet_06v0 ad=1.3p pd=5.52u as=1.3p ps=5.52u w=5u l=1u
X1043 a_34998_25732# a_23042_25616# VDD VDD pfet_06v0 ad=2.5p pd=10.5u as=4.4p ps=20.88u w=10u l=1u
X1044 a_56942_51776# a_58646_48376# VSS VSS nfet_06v0 ad=0.65p pd=3.02u as=1.1p ps=5.88u w=2.5u l=1u
X1045 a_4434_22332# a_6258_25732# VDD VDD pfet_06v0 ad=2.2p pd=10.88u as=2.2p ps=10.88u w=5u l=1u
X1046 VDD a_11014_34416# a_8262_31016# VDD pfet_06v0 ad=1.3p pd=5.52u as=1.3p ps=5.52u w=5u l=1u
X1047 a_34566_65848# a_40574_69132# a_35094_69248# VDD pfet_06v0 ad=2.2p pd=10.88u as=2.2p ps=10.88u w=5u l=1u
X1048 a_29526_17056# a_26290_16940# VDD VDD pfet_06v0 ad=2.5p pd=10.5u as=4.4p ps=20.88u w=10u l=1u
X1049 a_6198_48376# a_2902_48260# VSS VSS nfet_06v0 ad=1.25p pd=5.5u as=2.2p ps=10.88u w=5u l=1u
X1050 a_68142_5320# a_66178_5204# a_67842_5320# VSS nfet_06v0 ad=0.175p pd=1.2u as=0.175p ps=1.2u w=0.7u l=1u
X1051 VSS a_58646_65848# a_58058_69248# VSS nfet_06v0 ad=1.1p pd=5.88u as=0.65p ps=3.02u w=2.5u l=1u
X1052 a_13054_8260# a_2210_8144# VDD VDD pfet_06v0 ad=2.5p pd=10.5u as=4.4p ps=20.88u w=10u l=1u
X1053 VDD a_59174_51776# a_57534_48376# VDD pfet_06v0 ad=1.3p pd=5.52u as=1.3p ps=5.52u w=5u l=1u
X1054 VSS a_35678_31016# a_2530_75936# VSS nfet_06v0 ad=1.3p pd=5.52u as=1.3p ps=5.52u w=5u l=1u
X1055 a_50308_39576# a_44174_42976# a_54718_43092# VDD pfet_06v0 ad=4.4p pd=20.88u as=2.5p ps=10.5u w=10u l=1u
X1056 a_8782_69248# a_10486_65848# VSS VSS nfet_06v0 ad=0.65p pd=3.02u as=1.1p ps=5.88u w=2.5u l=1u
X1057 a_2170_13540# a_2170_13540# VSS VSS nfet_06v0 ad=0.44p pd=2.88u as=0.44p ps=2.88u w=1u l=1u
X1058 a_66518_13656# a_50330_13540# a_67538_13656# VSS nfet_06v0 ad=2.2p pd=10.88u as=1.25p ps=5.5u w=5u l=1u
X1059 VSS a_20410_13656# a_69618_57016# VSS nfet_06v0 ad=0.44p pd=2.88u as=0.25p ps=1.5u w=1u l=1u
X1060 a_5990_74376# a_6078_74260# VDD VDD pfet_06v0 ad=1.32p pd=6.88u as=1.32p ps=6.88u w=3u l=1u
X1061 a_66102_57016# a_20410_13656# VDD VDD pfet_06v0 ad=1.32p pd=6.88u as=1.32p ps=6.88u w=3u l=1u
X1062 a_2670_4860# a_2470_4744# a_3402_4860# VSS nfet_06v0 ad=2.2p pd=10.88u as=1.25p ps=5.5u w=5u l=1u
X1063 a_15950_30900# a_15950_30900# a_18358_31016# VSS nfet_06v0 ad=2.2p pd=10.88u as=2.2p ps=10.88u w=5u l=1u
X1064 a_46098_22332# a_47922_25732# VDD VDD pfet_06v0 ad=2.2p pd=10.88u as=2.2p ps=10.88u w=5u l=1u
X1065 VSS a_34566_13656# a_33978_17056# VSS nfet_06v0 ad=1.1p pd=5.88u as=0.65p ps=3.02u w=2.5u l=1u
X1066 a_46830_39692# a_47922_43092# VDD VDD pfet_06v0 ad=2.2p pd=10.88u as=2.2p ps=10.88u w=5u l=1u
X1067 VSS a_10486_48376# a_8782_51776# VSS nfet_06v0 ad=0.65p pd=3.02u as=0.65p ps=3.02u w=2.5u l=1u
X1068 a_6258_60452# a_8644_56936# a_5916_57052# VSS nfet_06v0 ad=1.1p pd=5.88u as=1.1p ps=5.88u w=2.5u l=1u
X1069 a_27480_39692# a_30138_42976# a_27902_43092# VDD pfet_06v0 ad=2.2p pd=10.88u as=2.2p ps=10.88u w=5u l=1u
X1070 VSS a_68686_56900# a_68598_57016# VSS nfet_06v0 ad=0.44p pd=2.88u as=0.44p ps=2.88u w=1u l=1u
X1071 a_44074_60452# a_43874_60336# VDD VDD pfet_06v0 ad=2.5p pd=10.5u as=4.4p ps=20.88u w=10u l=1u
X1072 a_44134_4744# a_44174_8144# a_55830_8260# VDD pfet_06v0 ad=4.4p pd=20.88u as=2.5p ps=10.5u w=10u l=1u
X1073 a_25466_43092# a_8062_48260# cap_mim_2f0_m4m5_noshield c_width=20u c_length=10u
X1074 a_5916_4860# a_2470_4744# a_5446_8260# VSS nfet_06v0 ad=1.1p pd=5.88u as=1.1p ps=5.88u w=2.5u l=1u
X1075 a_50370_51660# a_50670_51660# a_53606_51776# VDD pfet_06v0 ad=4.4p pd=20.88u as=2.5p ps=10.5u w=10u l=1u
X1076 a_23342_60336# a_23342_60336# a_37464_57052# VSS nfet_06v0 ad=0.44p pd=2.88u as=0.25p ps=1.5u w=1u l=1u
X1077 a_9898_17056# a_10486_13656# VSS VSS nfet_06v0 ad=0.65p pd=3.02u as=0.65p ps=3.02u w=2.5u l=1u
X1078 a_6558_34416# a_2210_34300# VDD VDD pfet_06v0 ad=2.5p pd=10.5u as=4.4p ps=20.88u w=10u l=1u
X1079 a_27090_60452# a_29476_56936# a_26748_57052# VSS nfet_06v0 ad=1.1p pd=5.88u as=1.1p ps=5.88u w=2.5u l=1u
X1080 a_32342_31016# a_32142_30900# a_30578_31016# VSS nfet_06v0 ad=1.3p pd=5.52u as=2.2p ps=10.88u w=5u l=1u
X1081 a_31884_57052# a_23302_56936# a_32904_57052# VSS nfet_06v0 ad=2.2p pd=10.88u as=1.25p ps=5.5u w=5u l=1u
X1082 a_25466_25732# a_8062_30900# cap_mim_2f0_m4m5_noshield c_width=20u c_length=10u
X1083 a_56942_17056# a_32142_13540# a_55018_17056# VDD pfet_06v0 ad=2.6p pd=10.52u as=4.4p ps=20.88u w=10u l=1u
X1084 a_58296_39692# a_44174_42976# VSS VSS nfet_06v0 ad=0.25p pd=1.5u as=0.44p ps=2.88u w=1u l=1u
X1085 a_23622_74260# a_56422_65848# cap_mim_2f0_m4m5_noshield c_width=20u c_length=10u
X1086 a_32342_65848# a_35094_69248# VDD VDD pfet_06v0 ad=1.3p pd=5.52u as=2.2p ps=10.88u w=5u l=1u
X1087 a_25998_22332# a_27090_25732# VDD VDD pfet_06v0 ad=2.2p pd=10.88u as=2.2p ps=10.88u w=5u l=1u
X1088 a_57534_31016# a_59174_34416# VDD VDD pfet_06v0 ad=1.3p pd=5.52u as=2.2p ps=10.88u w=5u l=1u
X1089 a_64110_48260# a_64110_48260# a_66518_48376# VSS nfet_06v0 ad=2.2p pd=10.88u as=2.2p ps=10.88u w=5u l=1u
X1090 a_58058_51776# a_8062_48260# a_55018_51776# VDD pfet_06v0 ad=2.6p pd=10.52u as=4.4p ps=20.88u w=10u l=1u
X1091 a_47922_60452# a_50308_56936# a_47580_57052# VSS nfet_06v0 ad=1.1p pd=5.88u as=1.1p ps=5.88u w=2.5u l=1u
X1092 a_2170_65732# a_2510_69132# a_2410_69248# VDD pfet_06v0 ad=4.4p pd=20.88u as=2.5p ps=10.5u w=10u l=1u
X1093 a_44490_13656# a_35678_13656# VSS VSS nfet_06v0 ad=2.2p pd=10.88u as=1.3p ps=5.52u w=5u l=1u
X1094 a_9306_42976# a_9306_42976# a_10930_42976# VDD pfet_06v0 ad=4.4p pd=20.88u as=4.4p ps=20.88u w=10u l=1u
X1095 a_54358_65848# a_51062_65732# VSS VSS nfet_06v0 ad=1.25p pd=5.5u as=2.2p ps=10.88u w=5u l=1u
X1096 a_59758_65848# a_64654_69132# a_60290_69248# VDD pfet_06v0 ad=2.2p pd=10.88u as=2.2p ps=10.88u w=5u l=1u
X1097 a_48734_25732# a_50308_22216# a_48312_22332# VSS nfet_06v0 ad=1.1p pd=5.88u as=1.1p ps=5.88u w=2.5u l=1u
X1098 a_27182_31016# a_26982_30900# VSS VSS nfet_06v0 ad=1.25p pd=5.5u as=2.2p ps=10.88u w=5u l=1u
X1099 VDD a_12870_74260# a_15066_74260# VDD pfet_06v0 ad=1.32p pd=6.88u as=1.32p ps=6.88u w=3u l=1u
X1100 a_52794_60452# a_52594_60336# VDD VDD pfet_06v0 ad=2.5p pd=10.5u as=4.4p ps=20.88u w=10u l=1u
X1101 a_30938_69248# a_32142_65732# a_32862_69248# VDD pfet_06v0 ad=4.4p pd=20.88u as=2.6p ps=10.52u w=10u l=1u
X1102 a_4134_13656# a_2510_16940# VSS VSS nfet_06v0 ad=0.25p pd=1.5u as=0.44p ps=2.88u w=1u l=1u
X1103 a_59758_48376# a_50330_48260# a_56942_51776# VSS nfet_06v0 ad=0.65p pd=3.02u as=1.1p ps=5.88u w=2.5u l=1u
X1104 a_50970_8144# a_44134_4744# a_51972_4860# VSS nfet_06v0 ad=2.2p pd=10.88u as=1.25p ps=5.5u w=5u l=1u
X1105 a_32862_34416# a_34566_31016# VSS VSS nfet_06v0 ad=0.65p pd=3.02u as=1.1p ps=5.88u w=2.5u l=1u
X1106 a_44334_57052# a_44134_56936# a_45066_57052# VSS nfet_06v0 ad=2.2p pd=10.88u as=1.25p ps=5.5u w=5u l=1u
X1107 a_40574_34300# a_40574_34300# a_42198_34300# VDD pfet_06v0 ad=4.4p pd=20.88u as=4.4p ps=20.88u w=10u l=1u
X1108 a_2902_48260# a_2510_51660# a_3522_51776# VDD pfet_06v0 ad=4.4p pd=20.88u as=2.5p ps=10.5u w=10u l=1u
X1109 a_65774_48376# a_51062_48260# VSS VSS nfet_06v0 ad=1.25p pd=5.5u as=2.2p ps=10.88u w=5u l=1u
X1110 VSS a_2118_74260# a_5246_74376# VSS nfet_06v0 ad=0.44p pd=2.88u as=0.25p ps=1.5u w=1u l=1u
X1111 a_36210_34416# a_26590_34300# a_32342_31016# VDD pfet_06v0 ad=1.3p pd=5.52u as=2.2p ps=10.88u w=5u l=1u
X1112 VDD a_59174_69248# a_57534_65848# VDD pfet_06v0 ad=1.3p pd=5.52u as=1.3p ps=5.52u w=5u l=1u
X1113 a_55018_17056# a_8062_13540# a_58058_17056# VDD pfet_06v0 ad=4.4p pd=20.88u as=2.6p ps=10.52u w=10u l=1u
X1114 a_66278_51660# a_50670_51660# a_66478_51776# VDD pfet_06v0 ad=4.4p pd=20.88u as=2.5p ps=10.5u w=10u l=1u
X1115 a_20410_13656# a_12130_17056# VDD VDD pfet_06v0 ad=4.4p pd=20.88u as=2.6p ps=10.52u w=10u l=1u
X1116 a_25466_8260# a_8062_13540# cap_mim_2f0_m4m5_noshield c_width=20u c_length=10u
X1117 a_58058_34416# a_58646_31016# VSS VSS nfet_06v0 ad=0.65p pd=3.02u as=0.65p ps=3.02u w=2.5u l=1u
X1118 a_4434_22332# S1P a_2670_22332# VSS nfet_06v0 ad=2.2p pd=10.88u as=2.2p ps=10.88u w=5u l=1u
X1119 a_57534_48376# a_50670_51660# a_59174_51776# VDD pfet_06v0 ad=2.2p pd=10.88u as=1.3p ps=5.52u w=5u l=1u
X1120 VSS a_10486_13656# a_8782_17056# VSS nfet_06v0 ad=1.1p pd=5.88u as=0.65p ps=3.02u w=2.5u l=1u
X1121 a_27902_25732# a_29476_22216# a_27480_22332# VSS nfet_06v0 ad=1.1p pd=5.88u as=1.1p ps=5.88u w=2.5u l=1u
X1122 a_58866_8260# a_43874_8144# VDD VDD pfet_06v0 ad=2.5p pd=10.5u as=4.4p ps=20.88u w=10u l=1u
X1123 VDD Y Y VDD pfet_06v0 ad=0.52p pd=2.52u as=0.52p ps=2.52u w=2u l=1u
X1124 a_6648_57052# a_2470_56936# a_4634_60452# VSS nfet_06v0 ad=1.1p pd=5.88u as=1.1p ps=5.88u w=2.5u l=1u
X1125 a_17614_65848# a_2902_65732# VSS VSS nfet_06v0 ad=1.25p pd=5.5u as=2.2p ps=10.88u w=5u l=1u
X1126 a_30578_65848# a_26250_65732# a_30278_65848# VSS nfet_06v0 ad=2.2p pd=10.88u as=1.25p ps=5.5u w=5u l=1u
X1127 a_47922_8260# a_50308_4744# a_47580_4860# VSS nfet_06v0 ad=1.1p pd=5.88u as=1.1p ps=5.88u w=2.5u l=1u
X1128 a_30578_13656# a_32142_13540# a_32342_13656# VSS nfet_06v0 ad=2.2p pd=10.88u as=1.3p ps=5.52u w=5u l=1u
X1129 a_5446_25732# a_5916_22332# VSS VSS nfet_06v0 ad=1.1p pd=5.88u as=1.1p ps=5.88u w=2.5u l=1u
X1130 VSS a_58646_65848# a_56942_69248# VSS nfet_06v0 ad=0.65p pd=3.02u as=0.65p ps=3.02u w=2.5u l=1u
X1131 a_25266_22332# S2P a_23502_22332# VSS nfet_06v0 ad=2.2p pd=10.88u as=2.2p ps=10.88u w=5u l=1u
X1132 a_29246_13656# a_26590_16940# VSS VSS nfet_06v0 ad=0.25p pd=1.5u as=0.44p ps=2.88u w=1u l=1u
X1133 a_50970_8144# a_50970_8144# a_52594_8144# VDD pfet_06v0 ad=4.4p pd=20.88u as=4.4p ps=20.88u w=10u l=1u
X1134 a_23002_22216# a_23302_22216# a_35400_22332# VSS nfet_06v0 ad=2.2p pd=10.88u as=1.25p ps=5.5u w=5u l=1u
X1135 a_2710_8260# a_2510_8144# a_2410_8260# VDD pfet_06v0 ad=4.4p pd=20.88u as=2.5p ps=10.5u w=10u l=1u
X1136 a_3102_48376# a_2902_48260# VSS VSS nfet_06v0 ad=1.25p pd=5.5u as=2.2p ps=10.88u w=5u l=1u
X1137 a_44322_51776# a_26290_51660# VDD VDD pfet_06v0 ad=2.5p pd=10.5u as=4.4p ps=20.88u w=10u l=1u
X1138 a_44134_22216# a_44174_25616# a_55830_25732# VDD pfet_06v0 ad=4.4p pd=20.88u as=2.5p ps=10.5u w=10u l=1u
X1139 a_27090_25732# a_23342_25616# a_25998_22332# VDD pfet_06v0 ad=2.2p pd=10.88u as=2.2p ps=10.88u w=5u l=1u
X1140 a_40574_51660# a_26250_48260# a_41694_48376# VSS nfet_06v0 ad=2.2p pd=10.88u as=1.25p ps=5.5u w=5u l=1u
X1141 a_15278_8260# a_2210_8144# VDD VDD pfet_06v0 ad=2.5p pd=10.5u as=4.4p ps=20.88u w=10u l=1u
X1142 a_16632_57052# a_2510_60336# VSS VSS nfet_06v0 ad=0.25p pd=1.5u as=0.44p ps=2.88u w=1u l=1u
X1143 a_50308_22216# a_50308_22216# a_52716_22332# VSS nfet_06v0 ad=2.2p pd=10.88u as=2.2p ps=10.88u w=5u l=1u
X1144 a_31310_65848# a_26982_65732# VSS VSS nfet_06v0 ad=1.25p pd=5.5u as=2.2p ps=10.88u w=5u l=1u
X1145 a_50370_69132# a_50670_69132# a_53606_69248# VDD pfet_06v0 ad=4.4p pd=20.88u as=2.5p ps=10.5u w=10u l=1u
X1146 a_68062_8632# X VSS VSS nfet_05v0 ad=0.5808p pd=3.52u as=0.5808p ps=3.52u w=1.32u l=0.6u
X1147 VSS a_34566_13656# a_32862_17056# VSS nfet_06v0 ad=0.65p pd=3.02u as=0.65p ps=3.02u w=2.5u l=1u
X1148 VDD a_11014_17056# a_9374_13656# VDD pfet_06v0 ad=2.2p pd=10.88u as=1.3p ps=5.52u w=5u l=1u
X1149 a_51262_31016# a_51062_30900# VSS VSS nfet_06v0 ad=1.25p pd=5.5u as=2.2p ps=10.88u w=5u l=1u
X1150 a_56942_51776# a_58646_48376# VSS VSS nfet_06v0 ad=0.65p pd=3.02u as=0.65p ps=3.02u w=2.5u l=1u
X1151 a_47110_43092# S1N a_44374_43092# VDD pfet_06v0 ad=4.4p pd=20.88u as=4.4p ps=20.88u w=10u l=1u
X1152 a_8062_65732# a_27480_57052# VSS VSS nfet_06v0 ad=0.44p pd=2.88u as=0.44p ps=2.88u w=1u l=1u
X1153 a_6648_4860# a_9306_8144# a_7070_8260# VDD pfet_06v0 ad=2.2p pd=10.88u as=2.2p ps=10.88u w=5u l=1u
X1154 a_3402_57052# a_2170_56936# VSS VSS nfet_06v0 ad=1.25p pd=5.5u as=2.2p ps=10.88u w=5u l=1u
X1155 YN YP VDD VDD pfet_05v0 ad=0.8052p pd=4.54u as=0.8052p ps=4.54u w=1.83u l=0.5u
X1156 a_58058_69248# a_8062_65732# a_55018_69248# VDD pfet_06v0 ad=2.6p pd=10.52u as=4.4p ps=20.88u w=10u l=1u
X1157 a_48312_4860# a_44134_4744# a_46298_8260# VSS nfet_06v0 ad=1.1p pd=5.88u as=1.1p ps=5.88u w=2.5u l=1u
X1158 a_23342_25616# a_23342_25616# VDD VDD pfet_06v0 ad=0.88p pd=4.88u as=0.88p ps=4.88u w=2u l=1u
X1159 a_26278_60452# a_26748_57052# VSS VSS nfet_06v0 ad=1.1p pd=5.88u as=1.1p ps=5.88u w=2.5u l=1u
X1160 a_33978_51776# a_34566_48376# VSS VSS nfet_06v0 ad=0.65p pd=3.02u as=0.65p ps=3.02u w=2.5u l=1u
X1161 a_45186_60452# a_43874_60336# VDD VDD pfet_06v0 ad=2.5p pd=10.5u as=4.4p ps=20.88u w=10u l=1u
X1162 VDD a_35094_17056# a_32342_13656# VDD pfet_06v0 ad=2.2p pd=10.88u as=1.3p ps=5.52u w=5u l=1u
X1163 a_8782_34416# a_2170_30900# a_11598_31016# VSS nfet_06v0 ad=1.1p pd=5.88u as=0.65p ps=3.02u w=2.5u l=1u
X1164 a_8782_69248# a_10486_65848# VSS VSS nfet_06v0 ad=0.65p pd=3.02u as=0.65p ps=3.02u w=2.5u l=1u
X1165 a_55018_51776# a_50670_51660# a_54718_51776# VDD pfet_06v0 ad=4.4p pd=20.88u as=2.5p ps=10.5u w=10u l=1u
X1166 a_15950_48260# a_2510_51660# a_20242_51776# VDD pfet_06v0 ad=4.4p pd=20.88u as=2.5p ps=10.5u w=10u l=1u
X1167 a_51972_22332# a_43834_22216# VSS VSS nfet_06v0 ad=1.25p pd=5.5u as=2.2p ps=10.88u w=5u l=1u
X1168 a_68402_34416# a_50370_34300# VDD VDD pfet_06v0 ad=2.5p pd=10.5u as=4.4p ps=20.88u w=10u l=1u
X1169 a_56422_48376# a_50670_51660# a_60290_51776# VDD pfet_06v0 ad=2.2p pd=10.88u as=1.3p ps=5.52u w=5u l=1u
X1170 a_44490_13656# a_32342_13656# cap_mim_2f0_m4m5_noshield c_width=20u c_length=10u
X1171 a_24234_57052# a_23002_56936# VSS VSS nfet_06v0 ad=1.25p pd=5.5u as=2.2p ps=10.88u w=5u l=1u
X1172 a_33454_31016# a_9174_30900# a_30578_31016# VSS nfet_06v0 ad=1.3p pd=5.52u as=2.2p ps=10.88u w=5u l=1u
X1173 a_5446_60452# S3N a_2710_60452# VDD pfet_06v0 ad=4.4p pd=20.88u as=4.4p ps=20.88u w=10u l=1u
X1174 a_32862_69248# a_24034_75936# cap_mim_2f0_m4m5_noshield c_width=20u c_length=10u
X1175 a_28214_48376# a_26590_51660# VSS VSS nfet_06v0 ad=0.25p pd=1.5u as=0.44p ps=2.88u w=1u l=1u
X1176 a_46098_57052# S2P a_44334_57052# VSS nfet_06v0 ad=2.2p pd=10.88u as=2.2p ps=10.88u w=5u l=1u
X1177 VSS a_20410_13656# a_66102_57016# VSS nfet_06v0 ad=0.44p pd=2.88u as=0.44p ps=2.88u w=1u l=1u
X1178 a_55830_43092# a_43874_42976# VDD VDD pfet_06v0 ad=2.5p pd=10.5u as=4.4p ps=20.88u w=10u l=1u
X1179 a_2370_57052# a_2170_56936# VSS VSS nfet_06v0 ad=1.25p pd=5.5u as=2.2p ps=10.88u w=5u l=1u
X1180 a_2902_65732# a_2510_69132# a_3522_69248# VDD pfet_06v0 ad=4.4p pd=20.88u as=2.5p ps=10.5u w=10u l=1u
X1181 a_9898_17056# a_10486_13656# VSS VSS nfet_06v0 ad=0.65p pd=3.02u as=1.1p ps=5.88u w=2.5u l=1u
X1182 a_8262_13656# a_11014_17056# VDD VDD pfet_06v0 ad=1.3p pd=5.52u as=1.3p ps=5.52u w=5u l=1u
X1183 a_2210_60336# a_2510_60336# a_17202_60452# VDD pfet_06v0 ad=4.4p pd=20.88u as=2.5p ps=10.5u w=10u l=1u
X1184 a_2470_22216# a_2470_22216# VSS VSS nfet_06v0 ad=0.44p pd=2.88u as=0.44p ps=2.88u w=1u l=1u
X1185 VDD a_14334_74260# a_16830_74260# VDD pfet_06v0 ad=1.32p pd=6.88u as=1.32p ps=6.88u w=3u l=1u
X1186 a_54658_31016# a_50330_30900# a_54358_31016# VSS nfet_06v0 ad=2.2p pd=10.88u as=1.25p ps=5.5u w=5u l=1u
X1187 a_8644_39576# a_2510_42976# a_13054_43092# VDD pfet_06v0 ad=4.4p pd=20.88u as=2.5p ps=10.5u w=10u l=1u
X1188 a_5446_8260# S1N a_2710_8260# VDD pfet_06v0 ad=4.4p pd=20.88u as=4.4p ps=20.88u w=10u l=1u
X1189 a_43458_31016# a_42438_31016# VSS VSS nfet_06v0 ad=1.25p pd=5.5u as=2.2p ps=10.88u w=5u l=1u
X1190 a_66278_69132# a_50670_69132# a_66478_69248# VDD pfet_06v0 ad=4.4p pd=20.88u as=2.5p ps=10.5u w=10u l=1u
X1191 VDD a_66102_57016# a_66922_56900# VDD pfet_06v0 ad=1.32p pd=6.88u as=1.32p ps=6.88u w=3u l=1u
X1192 a_26278_60452# S4N a_23542_60452# VDD pfet_06v0 ad=4.4p pd=20.88u as=4.4p ps=20.88u w=10u l=1u
X1193 a_33978_69248# a_26250_65732# a_34566_65848# VSS nfet_06v0 ad=1.1p pd=5.88u as=0.65p ps=3.02u w=2.5u l=1u
X1194 a_57534_65848# a_50670_69132# a_59174_69248# VDD pfet_06v0 ad=2.2p pd=10.88u as=1.3p ps=5.52u w=5u l=1u
X1195 a_5166_22332# S1N a_2670_22332# VSS nfet_06v0 ad=2.2p pd=10.88u as=2.2p ps=10.88u w=5u l=1u
X1196 VDD a_24998_74376# a_25818_74260# VDD pfet_06v0 ad=1.32p pd=6.88u as=1.32p ps=6.88u w=3u l=1u
X1197 a_59174_51776# a_64110_48260# a_58646_48376# VSS nfet_06v0 ad=1.1p pd=5.88u as=1.1p ps=5.88u w=2.5u l=1u
X1198 a_56422_48376# a_59174_51776# VDD VDD pfet_06v0 ad=1.3p pd=5.52u as=1.3p ps=5.52u w=5u l=1u
X1199 a_46830_57052# S2N a_44334_57052# VSS nfet_06v0 ad=2.2p pd=10.88u as=2.2p ps=10.88u w=5u l=1u
X1200 a_40030_30900# a_26590_34300# a_44322_34416# VDD pfet_06v0 ad=4.4p pd=20.88u as=2.5p ps=10.5u w=10u l=1u
X1201 VSS a_58646_65848# a_56942_69248# VSS nfet_06v0 ad=1.1p pd=5.88u as=0.65p ps=3.02u w=2.5u l=1u
X1202 a_10486_65848# a_2170_65732# a_9898_69248# VSS nfet_06v0 ad=0.65p pd=3.02u as=1.1p ps=5.88u w=2.5u l=1u
X1203 a_25998_22332# S2N a_23502_22332# VSS nfet_06v0 ad=2.2p pd=10.88u as=2.2p ps=10.88u w=5u l=1u
X1204 a_7010_74376# a_2530_75936# a_6078_74260# VSS nfet_06v0 ad=0.25p pd=1.5u as=0.44p ps=2.88u w=1u l=1u
X1205 a_47580_4860# a_44134_4744# a_47110_8260# VSS nfet_06v0 ad=1.1p pd=5.88u as=1.1p ps=5.88u w=2.5u l=1u
X1206 a_6858_17056# a_2510_16940# a_7670_17056# VDD pfet_06v0 ad=4.4p pd=20.88u as=2.5p ps=10.5u w=10u l=1u
X1207 a_44322_69248# a_26290_69132# VDD VDD pfet_06v0 ad=2.5p pd=10.5u as=4.4p ps=20.88u w=10u l=1u
X1208 a_6858_51776# a_8062_48260# a_8782_51776# VDD pfet_06v0 ad=4.4p pd=20.88u as=2.6p ps=10.52u w=10u l=1u
X1209 a_16494_34300# a_2170_30900# a_17614_31016# VSS nfet_06v0 ad=2.2p pd=10.88u as=1.25p ps=5.5u w=5u l=1u
X1210 a_26748_22332# a_30138_25616# a_27090_25732# VDD pfet_06v0 ad=2.2p pd=10.88u as=2.2p ps=10.88u w=5u l=1u
X1211 a_4634_60452# a_5916_57052# VSS VSS nfet_06v0 ad=1.1p pd=5.88u as=1.1p ps=5.88u w=2.5u l=1u
X1212 a_30578_13656# a_9174_13540# a_33454_13656# VSS nfet_06v0 ad=2.2p pd=10.88u as=1.3p ps=5.52u w=5u l=1u
X1213 a_25266_39692# a_27090_43092# VDD VDD pfet_06v0 ad=2.2p pd=10.88u as=2.2p ps=10.88u w=5u l=1u
X1214 a_30138_8144# a_23302_4744# a_31140_4860# VSS nfet_06v0 ad=2.2p pd=10.88u as=1.25p ps=5.5u w=5u l=1u
X1215 a_58058_34416# a_58646_31016# VSS VSS nfet_06v0 ad=0.65p pd=3.02u as=1.1p ps=5.88u w=2.5u l=1u
X1216 a_27602_34416# a_26290_34300# VDD VDD pfet_06v0 ad=2.5p pd=10.5u as=4.4p ps=20.88u w=10u l=1u
X1217 VDD X X VDD pfet_06v0 ad=0.52p pd=2.52u as=0.52p ps=2.52u w=2u l=1u
X1218 a_32862_34416# a_34566_31016# VSS VSS nfet_06v0 ad=0.65p pd=3.02u as=0.65p ps=3.02u w=2.5u l=1u
X1219 a_64654_16940# a_50330_13540# a_65774_13656# VSS nfet_06v0 ad=2.2p pd=10.88u as=1.25p ps=5.5u w=5u l=1u
X1220 VSS a_64726_56900# a_67854_57016# VSS nfet_06v0 ad=0.44p pd=2.88u as=0.25p ps=1.5u w=1u l=1u
X1221 a_11130_43092# a_10930_42976# VDD VDD pfet_06v0 ad=2.5p pd=10.5u as=4.4p ps=20.88u w=10u l=1u
X1222 a_13282_75936# a_36210_51776# VDD VDD pfet_06v0 ad=2.6p pd=10.52u as=4.4p ps=20.88u w=10u l=1u
X1223 a_19378_48376# a_18358_48376# VSS VSS nfet_06v0 ad=1.25p pd=5.5u as=2.2p ps=10.88u w=5u l=1u
X1224 a_25466_60452# a_26748_57052# VSS VSS nfet_06v0 ad=1.1p pd=5.88u as=1.1p ps=5.88u w=2.5u l=1u
X1225 VDD a_2530_75936# a_2430_76052# VDD pfet_06v0 ad=1.32p pd=6.88u as=0.75p ps=3.5u w=3u l=1u
X1226 a_12130_34416# a_15950_30900# a_11598_31016# VSS nfet_06v0 ad=1.1p pd=5.88u as=1.1p ps=5.88u w=2.5u l=1u
X1227 a_30578_31016# a_26250_30900# a_31310_31016# VSS nfet_06v0 ad=2.2p pd=10.88u as=1.25p ps=5.5u w=5u l=1u
X1228 XN XP VSS VSS nfet_05v0 ad=0.5808p pd=3.52u as=0.5808p ps=3.52u w=1.32u l=0.6u
X1229 a_44034_22332# a_43834_22216# VSS VSS nfet_06v0 ad=1.25p pd=5.5u as=2.2p ps=10.88u w=5u l=1u
X1230 a_3582_74260# a_11598_31016# VSS VSS nfet_06v0 ad=1.3p pd=5.52u as=2.2p ps=10.88u w=5u l=1u
X1231 a_15950_65732# a_2510_69132# a_20242_69248# VDD pfet_06v0 ad=4.4p pd=20.88u as=2.5p ps=10.5u w=10u l=1u
X1232 a_55018_69248# a_50670_69132# a_54718_69248# VDD pfet_06v0 ad=4.4p pd=20.88u as=2.5p ps=10.5u w=10u l=1u
X1233 a_38034_8260# a_23042_8144# VDD VDD pfet_06v0 ad=2.5p pd=10.5u as=4.4p ps=20.88u w=10u l=1u
X1234 a_45186_8260# a_43874_8144# VDD VDD pfet_06v0 ad=2.5p pd=10.5u as=4.4p ps=20.88u w=10u l=1u
X1235 a_18318_34416# a_18118_34300# VDD VDD pfet_06v0 ad=2.5p pd=10.5u as=4.4p ps=20.88u w=10u l=1u
X1236 a_43874_42976# a_44174_42976# a_57264_39692# VSS nfet_06v0 ad=0.44p pd=2.88u as=0.25p ps=1.5u w=1u l=1u
X1237 a_56422_65848# a_50670_69132# a_60290_69248# VDD pfet_06v0 ad=2.2p pd=10.88u as=1.3p ps=5.52u w=5u l=1u
X1238 a_25266_4860# S2P a_23502_4860# VSS nfet_06v0 ad=2.2p pd=10.88u as=2.2p ps=10.88u w=5u l=1u
X1239 a_23202_4860# a_23002_4744# VSS VSS nfet_06v0 ad=1.25p pd=5.5u as=2.2p ps=10.88u w=5u l=1u
X1240 a_58058_34416# a_50330_30900# a_58646_31016# VSS nfet_06v0 ad=1.1p pd=5.88u as=0.65p ps=3.02u w=2.5u l=1u
X1241 a_64654_51660# a_64654_51660# a_66278_51660# VDD pfet_06v0 ad=4.4p pd=20.88u as=4.4p ps=20.88u w=10u l=1u
X1242 a_50670_69132# a_50670_69132# a_53326_65848# VSS nfet_06v0 ad=0.44p pd=2.88u as=0.25p ps=1.5u w=1u l=1u
X1243 a_6858_51776# a_9174_48260# a_9898_51776# VDD pfet_06v0 ad=4.4p pd=20.88u as=2.6p ps=10.52u w=10u l=1u
X1244 a_23042_25616# a_23342_25616# a_38034_25732# VDD pfet_06v0 ad=4.4p pd=20.88u as=2.5p ps=10.5u w=10u l=1u
X1245 a_7070_43092# a_2510_42976# a_4434_39692# VDD pfet_06v0 ad=2.2p pd=10.88u as=2.2p ps=10.88u w=5u l=1u
X1246 VSS a_10486_31016# a_9898_34416# VSS nfet_06v0 ad=0.65p pd=3.02u as=0.65p ps=3.02u w=2.5u l=1u
X1247 a_2410_17056# a_2210_16940# VDD VDD pfet_06v0 ad=2.5p pd=10.5u as=4.4p ps=20.88u w=10u l=1u
X1248 a_30138_60336# a_23302_56936# a_31140_57052# VSS nfet_06v0 ad=2.2p pd=10.88u as=1.25p ps=5.5u w=5u l=1u
X1249 a_32342_13656# a_26590_16940# a_36210_17056# VDD pfet_06v0 ad=2.2p pd=10.88u as=1.3p ps=5.52u w=5u l=1u
X1250 a_2510_25616# a_2510_25616# a_16632_22332# VSS nfet_06v0 ad=0.44p pd=2.88u as=0.25p ps=1.5u w=1u l=1u
X1251 a_2118_74260# a_60290_34416# VDD VDD pfet_06v0 ad=2.6p pd=10.52u as=4.4p ps=20.88u w=10u l=1u
X1252 a_34566_31016# a_26250_30900# a_33978_34416# VSS nfet_06v0 ad=0.65p pd=3.02u as=1.1p ps=5.88u w=2.5u l=1u
X1253 a_68142_40152# a_66178_40036# a_67842_40152# VSS nfet_06v0 ad=0.175p pd=1.2u as=0.175p ps=1.2u w=0.7u l=1u
X1254 VDD a_35094_34416# a_33454_31016# VDD pfet_06v0 ad=2.2p pd=10.88u as=1.3p ps=5.52u w=5u l=1u
X1255 a_56422_65848# a_59174_69248# VDD VDD pfet_06v0 ad=1.3p pd=5.52u as=1.3p ps=5.52u w=5u l=1u
X1256 a_8262_31016# a_8062_30900# a_6498_31016# VSS nfet_06v0 ad=1.3p pd=5.52u as=2.2p ps=10.88u w=5u l=1u
X1257 a_60290_51776# a_64110_48260# a_59758_48376# VSS nfet_06v0 ad=1.1p pd=5.88u as=1.1p ps=5.88u w=2.5u l=1u
X1258 a_31762_8144# a_23342_8144# a_31962_8260# VDD pfet_06v0 ad=4.4p pd=20.88u as=2.5p ps=10.5u w=10u l=1u
X1259 a_33978_51776# a_34566_48376# VSS VSS nfet_06v0 ad=0.65p pd=3.02u as=1.1p ps=5.88u w=2.5u l=1u
X1260 VSS a_58646_13656# a_58058_17056# VSS nfet_06v0 ad=0.65p pd=3.02u as=0.65p ps=3.02u w=2.5u l=1u
X1261 a_56942_43092# a_43874_42976# VDD VDD pfet_06v0 ad=2.5p pd=10.5u as=4.4p ps=20.88u w=10u l=1u
X1262 a_47580_57052# a_44134_56936# a_47110_60452# VSS nfet_06v0 ad=1.1p pd=5.88u as=1.1p ps=5.88u w=2.5u l=1u
X1263 a_50370_69132# a_50670_69132# a_52294_65848# VSS nfet_06v0 ad=0.44p pd=2.88u as=0.25p ps=1.5u w=1u l=1u
X1264 a_2670_22332# a_2470_22216# a_3402_22332# VSS nfet_06v0 ad=2.2p pd=10.88u as=1.25p ps=5.5u w=5u l=1u
X1265 a_50330_13540# a_50670_16940# a_50570_17056# VDD pfet_06v0 ad=4.4p pd=20.88u as=2.5p ps=10.5u w=10u l=1u
X1266 a_67684_6528# X a_69084_6528# VSS nfet_06v0 ad=0.88p pd=4.88u as=0.5p ps=2.5u w=2u l=1u
X1267 a_2470_39576# a_2510_42976# a_14166_43092# VDD pfet_06v0 ad=4.4p pd=20.88u as=2.5p ps=10.5u w=10u l=1u
X1268 a_5916_57052# a_2470_56936# a_5446_60452# VSS nfet_06v0 ad=1.1p pd=5.88u as=1.1p ps=5.88u w=2.5u l=1u
X1269 a_32862_69248# a_26250_65732# a_35678_65848# VSS nfet_06v0 ad=1.1p pd=5.88u as=0.65p ps=3.02u w=2.5u l=1u
X1270 a_9306_60336# a_2470_56936# a_10308_57052# VSS nfet_06v0 ad=2.2p pd=10.88u as=1.25p ps=5.5u w=5u l=1u
X1271 a_6858_69248# a_8062_65732# a_8782_69248# VDD pfet_06v0 ad=4.4p pd=20.88u as=2.6p ps=10.52u w=10u l=1u
X1272 VSS a_11598_13656# a_20410_13656# VSS nfet_06v0 ad=1.3p pd=5.52u as=1.3p ps=5.52u w=5u l=1u
X1273 a_8262_13656# a_11014_17056# VDD VDD pfet_06v0 ad=1.3p pd=5.52u as=2.2p ps=10.88u w=5u l=1u
X1274 a_8644_22216# a_8644_22216# a_11052_22332# VSS nfet_06v0 ad=2.2p pd=10.88u as=2.2p ps=10.88u w=5u l=1u
X1275 a_23502_22332# a_23302_22216# a_24234_22332# VSS nfet_06v0 ad=2.2p pd=10.88u as=1.25p ps=5.5u w=5u l=1u
X1276 VSS a_3582_74260# a_3494_74376# VSS nfet_06v0 ad=0.44p pd=2.88u as=0.44p ps=2.88u w=1u l=1u
X1277 a_26290_16940# a_26590_16940# a_28214_13656# VSS nfet_06v0 ad=0.44p pd=2.88u as=0.25p ps=1.5u w=1u l=1u
X1278 a_10486_31016# a_16494_34300# a_11014_34416# VDD pfet_06v0 ad=2.2p pd=10.88u as=2.2p ps=10.88u w=5u l=1u
X1279 a_30278_13656# a_26982_13540# VSS VSS nfet_06v0 ad=1.25p pd=5.5u as=2.2p ps=10.88u w=5u l=1u
X1280 a_35678_13656# a_40574_16940# a_36210_17056# VDD pfet_06v0 ad=2.2p pd=10.88u as=2.2p ps=10.88u w=5u l=1u
X1281 a_26748_57052# a_23302_56936# a_26278_60452# VSS nfet_06v0 ad=1.1p pd=5.88u as=1.1p ps=5.88u w=2.5u l=1u
X1282 a_5166_4860# S1N a_2670_4860# VSS nfet_06v0 ad=2.2p pd=10.88u as=2.2p ps=10.88u w=5u l=1u
X1283 a_2670_22332# a_2470_22216# a_2370_22332# VSS nfet_06v0 ad=2.2p pd=10.88u as=1.25p ps=5.5u w=5u l=1u
X1284 a_11598_65848# a_2170_65732# a_8782_69248# VSS nfet_06v0 ad=0.65p pd=3.02u as=1.1p ps=5.88u w=2.5u l=1u
X1285 a_36110_25732# a_23042_25616# VDD VDD pfet_06v0 ad=2.5p pd=10.5u as=4.4p ps=20.88u w=10u l=1u
X1286 a_56422_48376# a_59174_51776# VDD VDD pfet_06v0 ad=1.3p pd=5.52u as=2.2p ps=10.88u w=5u l=1u
X1287 a_27480_22332# a_23302_22216# a_25466_25732# VSS nfet_06v0 ad=1.1p pd=5.88u as=1.1p ps=5.88u w=2.5u l=1u
X1288 a_2210_60336# a_2510_60336# a_15600_57052# VSS nfet_06v0 ad=0.44p pd=2.88u as=0.25p ps=1.5u w=1u l=1u
X1289 a_24034_75936# a_36210_69248# VDD VDD pfet_06v0 ad=2.6p pd=10.52u as=4.4p ps=20.88u w=10u l=1u
X1290 a_55830_51776# a_50370_51660# VDD VDD pfet_06v0 ad=2.5p pd=10.5u as=4.4p ps=20.88u w=10u l=1u
X1291 a_26250_48260# a_26590_51660# a_26490_51776# VDD pfet_06v0 ad=4.4p pd=20.88u as=2.5p ps=10.5u w=10u l=1u
X1292 a_47922_8260# a_44174_8144# a_46830_4860# VDD pfet_06v0 ad=2.2p pd=10.88u as=2.2p ps=10.88u w=5u l=1u
X1293 a_50330_30900# a_50330_30900# VSS VSS nfet_06v0 ad=0.44p pd=2.88u as=0.44p ps=2.88u w=1u l=1u
X1294 a_12130_51776# a_2510_51660# a_8262_48376# VDD pfet_06v0 ad=1.3p pd=5.52u as=2.2p ps=10.88u w=5u l=1u
X1295 a_36432_39692# a_23342_42976# VSS VSS nfet_06v0 ad=0.25p pd=1.5u as=0.44p ps=2.88u w=1u l=1u
X1296 a_6498_65848# a_2170_65732# a_6198_65848# VSS nfet_06v0 ad=2.2p pd=10.88u as=1.25p ps=5.5u w=5u l=1u
X1297 a_26982_13540# a_26250_13540# a_27182_13656# VSS nfet_06v0 ad=2.2p pd=10.88u as=1.25p ps=5.5u w=5u l=1u
X1298 a_44174_8144# a_44174_8144# a_58296_4860# VSS nfet_06v0 ad=0.44p pd=2.88u as=0.25p ps=1.5u w=1u l=1u
X1299 a_43834_4744# a_44134_4744# a_56232_4860# VSS nfet_06v0 ad=2.2p pd=10.88u as=1.25p ps=5.5u w=5u l=1u
X1300 a_6498_13656# a_8062_13540# a_8262_13656# VSS nfet_06v0 ad=2.2p pd=10.88u as=1.3p ps=5.52u w=5u l=1u
X1301 a_26590_34300# a_26590_34300# VDD VDD pfet_06v0 ad=0.88p pd=4.88u as=0.88p ps=4.88u w=2u l=1u
X1302 a_53606_17056# a_50370_16940# VDD VDD pfet_06v0 ad=2.5p pd=10.5u as=4.4p ps=20.88u w=10u l=1u
X1303 a_53736_39692# a_52716_39692# VSS VSS nfet_06v0 ad=1.25p pd=5.5u as=2.2p ps=10.88u w=5u l=1u
X1304 a_17202_25732# a_2210_25616# VDD VDD pfet_06v0 ad=2.5p pd=10.5u as=4.4p ps=20.88u w=10u l=1u
X1305 a_64654_69132# a_64654_69132# a_66278_69132# VDD pfet_06v0 ad=4.4p pd=20.88u as=4.4p ps=20.88u w=10u l=1u
X1306 a_6858_69248# a_9174_65732# a_9898_69248# VDD pfet_06v0 ad=4.4p pd=20.88u as=2.6p ps=10.52u w=10u l=1u
X1307 a_14334_74260# a_8262_48376# cap_mim_2f0_m4m5_noshield c_width=20u c_length=10u
X1308 a_23502_57052# a_23302_56936# a_23202_57052# VSS nfet_06v0 ad=2.2p pd=10.88u as=1.25p ps=5.5u w=5u l=1u
X1309 VDD a_24034_75936# a_27582_74260# VDD pfet_06v0 ad=1.32p pd=6.88u as=1.32p ps=6.88u w=3u l=1u
X1310 a_29476_56936# a_29476_56936# a_31884_57052# VSS nfet_06v0 ad=2.2p pd=10.88u as=2.2p ps=10.88u w=5u l=1u
X1311 a_7230_65848# a_2902_65732# VSS VSS nfet_06v0 ad=1.25p pd=5.5u as=2.2p ps=10.88u w=5u l=1u
X1312 a_30938_51776# a_26590_51660# a_31750_51776# VDD pfet_06v0 ad=4.4p pd=20.88u as=2.5p ps=10.5u w=10u l=1u
X1313 a_3582_74260# a_8262_31016# cap_mim_2f0_m4m5_noshield c_width=20u c_length=10u
X1314 a_9174_30900# a_6648_22332# VSS VSS nfet_06v0 ad=0.44p pd=2.88u as=0.44p ps=2.88u w=1u l=1u
X1315 a_56942_34416# a_50330_30900# a_59758_31016# VSS nfet_06v0 ad=1.1p pd=5.88u as=0.65p ps=3.02u w=2.5u l=1u
X1316 VDD a_11014_51776# a_9374_48376# VDD pfet_06v0 ad=1.3p pd=5.52u as=1.3p ps=5.52u w=5u l=1u
X1317 a_48734_60452# a_44174_60336# a_46098_57052# VDD pfet_06v0 ad=2.2p pd=10.88u as=2.2p ps=10.88u w=5u l=1u
X1318 a_40030_30900# a_40030_30900# a_42438_31016# VSS nfet_06v0 ad=2.2p pd=10.88u as=2.2p ps=10.88u w=5u l=1u
X1319 a_2210_34300# a_2510_34300# a_4134_31016# VSS nfet_06v0 ad=0.44p pd=2.88u as=0.25p ps=1.5u w=1u l=1u
X1320 a_29526_51776# a_26290_51660# VDD VDD pfet_06v0 ad=2.5p pd=10.5u as=4.4p ps=20.88u w=10u l=1u
X1321 a_18358_13656# a_2170_13540# a_19378_13656# VSS nfet_06v0 ad=2.2p pd=10.88u as=1.25p ps=5.5u w=5u l=1u
X1322 a_33886_60452# a_23042_60336# VDD VDD pfet_06v0 ad=2.5p pd=10.5u as=4.4p ps=20.88u w=10u l=1u
X1323 a_3522_17056# a_2210_16940# VDD VDD pfet_06v0 ad=2.5p pd=10.5u as=4.4p ps=20.88u w=10u l=1u
X1324 a_54658_65848# a_50330_65732# a_55390_65848# VSS nfet_06v0 ad=2.2p pd=10.88u as=1.25p ps=5.5u w=5u l=1u
X1325 a_32142_13540# a_46098_4860# cap_mim_2f0_m4m5_noshield c_width=20u c_length=10u
X1326 a_26250_48260# a_26250_48260# VSS VSS nfet_06v0 ad=0.44p pd=2.88u as=0.44p ps=2.88u w=1u l=1u
X1327 a_65840_6528# a_5990_74376# X VSS nfet_06v0 ad=1.0912p pd=5.84u as=0.6448p ps=3u w=2.48u l=1u
X1328 a_24034_75936# a_35678_65848# VSS VSS nfet_06v0 ad=1.3p pd=5.52u as=2.2p ps=10.88u w=5u l=1u
X1329 a_66478_17056# a_66278_16940# VDD VDD pfet_06v0 ad=2.5p pd=10.5u as=4.4p ps=20.88u w=10u l=1u
X1330 a_35678_31016# a_26250_30900# a_32862_34416# VSS nfet_06v0 ad=0.65p pd=3.02u as=1.1p ps=5.88u w=2.5u l=1u
X1331 a_14568_39692# a_2170_39576# VSS VSS nfet_06v0 ad=1.25p pd=5.5u as=2.2p ps=10.88u w=5u l=1u
X1332 a_9374_31016# a_9174_30900# a_6498_31016# VSS nfet_06v0 ad=1.3p pd=5.52u as=2.2p ps=10.88u w=5u l=1u
X1333 a_33978_17056# a_9174_13540# a_30938_17056# VDD pfet_06v0 ad=2.6p pd=10.52u as=4.4p ps=20.88u w=10u l=1u
X1334 a_12072_22332# a_11052_22332# VSS VSS nfet_06v0 ad=1.25p pd=5.5u as=2.2p ps=10.88u w=5u l=1u
X1335 a_3582_74260# a_11598_31016# VSS VSS nfet_06v0 ad=2.2p pd=10.88u as=1.3p ps=5.52u w=5u l=1u
X1336 a_44174_42976# a_44174_42976# VDD VDD pfet_06v0 ad=0.88p pd=4.88u as=0.88p ps=4.88u w=2u l=1u
X1337 a_41694_31016# a_26982_30900# VSS VSS nfet_06v0 ad=1.25p pd=5.5u as=2.2p ps=10.88u w=5u l=1u
X1338 a_7070_8260# a_2510_8144# a_4434_4860# VDD pfet_06v0 ad=2.2p pd=10.88u as=2.2p ps=10.88u w=5u l=1u
X1339 a_55018_34416# a_50670_34300# a_55830_34416# VDD pfet_06v0 ad=4.4p pd=20.88u as=2.5p ps=10.5u w=10u l=1u
X1340 a_51062_13540# a_50670_16940# a_51682_17056# VDD pfet_06v0 ad=4.4p pd=20.88u as=2.5p ps=10.5u w=10u l=1u
X1341 a_2170_39576# a_2510_42976# a_15278_43092# VDD pfet_06v0 ad=4.4p pd=20.88u as=2.5p ps=10.5u w=10u l=1u
X1342 Z a_23534_74376# a_64728_41360# VSS nfet_06v0 ad=0.6448p pd=3u as=1.0912p ps=5.84u w=2.48u l=1u
X1343 VDD a_35094_34416# a_33454_31016# VDD pfet_06v0 ad=1.3p pd=5.52u as=1.3p ps=5.52u w=5u l=1u
X1344 VSS a_34566_65848# a_33978_69248# VSS nfet_06v0 ad=0.65p pd=3.02u as=0.65p ps=3.02u w=2.5u l=1u
X1345 a_56422_65848# a_59174_69248# VDD VDD pfet_06v0 ad=1.3p pd=5.52u as=2.2p ps=10.88u w=5u l=1u
X1346 a_2510_8144# a_2510_8144# VDD VDD pfet_06v0 ad=0.88p pd=4.88u as=0.88p ps=4.88u w=2u l=1u
X1347 VSS a_35678_48376# a_13282_75936# VSS nfet_06v0 ad=1.3p pd=5.52u as=1.3p ps=5.52u w=5u l=1u
X1348 a_10930_60336# a_2510_60336# a_11130_60452# VDD pfet_06v0 ad=4.4p pd=20.88u as=2.5p ps=10.5u w=10u l=1u
X1349 a_26250_65732# a_26590_69132# a_26490_69248# VDD pfet_06v0 ad=4.4p pd=20.88u as=2.5p ps=10.5u w=10u l=1u
X1350 a_55830_69248# a_50370_69132# VDD VDD pfet_06v0 ad=2.5p pd=10.5u as=4.4p ps=20.88u w=10u l=1u
X1351 a_6648_22332# a_9306_25616# a_7070_25732# VDD pfet_06v0 ad=2.2p pd=10.88u as=2.2p ps=10.88u w=5u l=1u
X1352 a_12130_69248# a_2510_69132# a_8262_65848# VDD pfet_06v0 ad=1.3p pd=5.52u as=2.2p ps=10.88u w=5u l=1u
X1353 a_52716_4860# a_44134_4744# a_53736_4860# VSS nfet_06v0 ad=2.2p pd=10.88u as=1.25p ps=5.5u w=5u l=1u
X1354 a_9898_17056# a_2170_13540# a_10486_13656# VSS nfet_06v0 ad=1.1p pd=5.88u as=0.65p ps=3.02u w=2.5u l=1u
X1355 a_42198_16940# a_26590_16940# a_42398_17056# VDD pfet_06v0 ad=4.4p pd=20.88u as=2.5p ps=10.5u w=10u l=1u
X1356 a_10930_8144# a_2510_8144# a_11130_8260# VDD pfet_06v0 ad=4.4p pd=20.88u as=2.5p ps=10.5u w=10u l=1u
X1357 a_15950_48260# a_15950_48260# a_18358_48376# VSS nfet_06v0 ad=2.2p pd=10.88u as=2.2p ps=10.88u w=5u l=1u
X1358 a_9374_31016# a_11014_34416# VDD VDD pfet_06v0 ad=1.3p pd=5.52u as=2.2p ps=10.88u w=5u l=1u
X1359 a_33454_13656# a_26590_16940# a_35094_17056# VDD pfet_06v0 ad=2.2p pd=10.88u as=1.3p ps=5.52u w=5u l=1u
X1360 a_44374_43092# a_44174_42976# a_44074_43092# VDD pfet_06v0 ad=4.4p pd=20.88u as=2.5p ps=10.5u w=10u l=1u
X1361 a_11014_34416# a_15950_30900# a_10486_31016# VSS nfet_06v0 ad=1.1p pd=5.88u as=1.1p ps=5.88u w=2.5u l=1u
X1362 a_56942_51776# a_32142_48260# a_55018_51776# VDD pfet_06v0 ad=2.6p pd=10.52u as=4.4p ps=20.88u w=10u l=1u
X1363 a_46298_8260# a_47580_4860# VSS VSS nfet_06v0 ad=1.1p pd=5.88u as=1.1p ps=5.88u w=2.5u l=1u
X1364 a_6258_25732# a_2510_25616# a_5166_22332# VDD pfet_06v0 ad=2.2p pd=10.88u as=2.2p ps=10.88u w=5u l=1u
X1365 a_2710_25732# a_2510_25616# a_2410_25732# VDD pfet_06v0 ad=4.4p pd=20.88u as=2.5p ps=10.5u w=10u l=1u
X1366 a_6498_13656# a_9174_13540# a_9374_13656# VSS nfet_06v0 ad=2.2p pd=10.88u as=1.3p ps=5.52u w=5u l=1u
X1367 a_26290_34300# a_26590_34300# a_29526_34416# VDD pfet_06v0 ad=4.4p pd=20.88u as=2.5p ps=10.5u w=10u l=1u
X1368 a_30938_69248# a_26590_69132# a_31750_69248# VDD pfet_06v0 ad=4.4p pd=20.88u as=2.5p ps=10.5u w=10u l=1u
X1369 a_54718_17056# a_50370_16940# VDD VDD pfet_06v0 ad=2.5p pd=10.5u as=4.4p ps=20.88u w=10u l=1u
X1370 VDD a_60290_17056# a_64726_56900# VDD pfet_06v0 ad=2.6p pd=10.52u as=2.6p ps=10.52u w=10u l=1u
X1371 a_20242_17056# a_2210_16940# VDD VDD pfet_06v0 ad=2.5p pd=10.5u as=4.4p ps=20.88u w=10u l=1u
X1372 a_32342_48376# a_32142_48260# a_30578_48376# VSS nfet_06v0 ad=1.3p pd=5.52u as=2.2p ps=10.88u w=5u l=1u
X1373 a_2902_65732# a_2170_65732# a_3102_65848# VSS nfet_06v0 ad=2.2p pd=10.88u as=1.25p ps=5.5u w=5u l=1u
X1374 a_2118_74260# a_59758_31016# VSS VSS nfet_06v0 ad=1.3p pd=5.52u as=2.2p ps=10.88u w=5u l=1u
X1375 VDD a_11014_69248# a_9374_65848# VDD pfet_06v0 ad=1.3p pd=5.52u as=1.3p ps=5.52u w=5u l=1u
X1376 a_43834_56936# a_44174_60336# a_56942_60452# VDD pfet_06v0 ad=4.4p pd=20.88u as=2.5p ps=10.5u w=10u l=1u
X1377 a_5166_31016# a_2510_34300# VSS VSS nfet_06v0 ad=0.25p pd=1.5u as=0.44p ps=2.88u w=1u l=1u
X1378 a_29526_69248# a_26290_69132# VDD VDD pfet_06v0 ad=2.5p pd=10.5u as=4.4p ps=20.88u w=10u l=1u
X1379 a_53326_13656# a_50670_16940# VSS VSS nfet_06v0 ad=0.25p pd=1.5u as=0.44p ps=2.88u w=1u l=1u
X1380 a_23542_25732# a_23342_25616# a_23242_25732# VDD pfet_06v0 ad=4.4p pd=20.88u as=2.5p ps=10.5u w=10u l=1u
X1381 a_4226_74376# a_4314_74260# VDD VDD pfet_06v0 ad=1.32p pd=6.88u as=1.32p ps=6.88u w=3u l=1u
X1382 a_47580_22332# a_50970_25616# a_47922_25732# VDD pfet_06v0 ad=2.2p pd=10.88u as=2.2p ps=10.88u w=5u l=1u
X1383 a_6498_31016# a_2170_30900# a_7230_31016# VSS nfet_06v0 ad=2.2p pd=10.88u as=1.25p ps=5.5u w=5u l=1u
X1384 a_48734_43092# a_50308_39576# a_48312_39692# VSS nfet_06v0 ad=1.1p pd=5.88u as=1.1p ps=5.88u w=2.5u l=1u
X1385 a_27182_48376# a_26982_48260# VSS VSS nfet_06v0 ad=1.25p pd=5.5u as=2.2p ps=10.88u w=5u l=1u
X1386 a_55018_51776# a_8062_48260# a_58058_51776# VDD pfet_06v0 ad=4.4p pd=20.88u as=2.6p ps=10.52u w=10u l=1u
X1387 a_14334_74260# a_12130_51776# VDD VDD pfet_06v0 ad=4.4p pd=20.88u as=2.6p ps=10.52u w=10u l=1u
X1388 a_65840_24000# a_66178_22676# VSS VSS nfet_06v0 ad=0.5456p pd=3.36u as=0.5456p ps=3.36u w=1.24u l=1u
X1389 a_2170_65732# a_2170_65732# VSS VSS nfet_06v0 ad=0.44p pd=2.88u as=0.44p ps=2.88u w=1u l=1u
X1390 a_23342_8144# a_23342_8144# a_37464_4860# VSS nfet_06v0 ad=0.44p pd=2.88u as=0.25p ps=1.5u w=1u l=1u
X1391 a_32862_51776# a_34566_48376# VSS VSS nfet_06v0 ad=0.65p pd=3.02u as=1.1p ps=5.88u w=2.5u l=1u
X1392 a_23002_4744# a_23302_4744# a_35400_4860# VSS nfet_06v0 ad=2.2p pd=10.88u as=1.25p ps=5.5u w=5u l=1u
X1393 a_66518_65848# a_50330_65732# a_67538_65848# VSS nfet_06v0 ad=2.2p pd=10.88u as=1.25p ps=5.5u w=5u l=1u
X1394 a_30938_17056# a_26590_16940# a_30638_17056# VDD pfet_06v0 ad=4.4p pd=20.88u as=2.5p ps=10.5u w=10u l=1u
X1395 VSS a_20410_65848# a_28514_74376# VSS nfet_06v0 ad=0.44p pd=2.88u as=0.25p ps=1.5u w=1u l=1u
X1396 a_52294_13656# a_50670_16940# VSS VSS nfet_06v0 ad=0.25p pd=1.5u as=0.44p ps=2.88u w=1u l=1u
X1397 a_2510_16940# a_2510_16940# VDD VDD pfet_06v0 ad=0.88p pd=4.88u as=0.88p ps=4.88u w=2u l=1u
X1398 a_34998_60452# a_23042_60336# VDD VDD pfet_06v0 ad=2.5p pd=10.5u as=4.4p ps=20.88u w=10u l=1u
X1399 VSS a_34566_65848# a_33978_69248# VSS nfet_06v0 ad=1.1p pd=5.88u as=0.65p ps=3.02u w=2.5u l=1u
X1400 a_4434_57052# a_6258_60452# VDD VDD pfet_06v0 ad=2.2p pd=10.88u as=2.2p ps=10.88u w=5u l=1u
X1401 VSS a_2530_75936# a_2030_74376# VSS nfet_06v0 ad=0.44p pd=2.88u as=0.44p ps=2.88u w=1u l=1u
X1402 a_31762_25616# a_23342_25616# a_31962_25732# VDD pfet_06v0 ad=4.4p pd=20.88u as=2.5p ps=10.5u w=10u l=1u
X1403 a_2410_43092# a_2210_42976# VDD VDD pfet_06v0 ad=2.5p pd=10.5u as=4.4p ps=20.88u w=10u l=1u
X1404 a_35094_34416# a_40030_30900# a_34566_31016# VSS nfet_06v0 ad=1.1p pd=5.88u as=1.1p ps=5.88u w=2.5u l=1u
X1405 a_58058_51776# a_58646_48376# VSS VSS nfet_06v0 ad=0.65p pd=3.02u as=0.65p ps=3.02u w=2.5u l=1u
X1406 a_4434_39692# S3P a_2670_39692# VSS nfet_06v0 ad=2.2p pd=10.88u as=2.2p ps=10.88u w=5u l=1u
X1407 VDD a_59174_17056# a_56422_13656# VDD pfet_06v0 ad=2.2p pd=10.88u as=1.3p ps=5.52u w=5u l=1u
X1408 a_27902_43092# a_29476_39576# a_27480_39692# VSS nfet_06v0 ad=1.1p pd=5.88u as=1.1p ps=5.88u w=2.5u l=1u
X1409 a_45066_4860# a_43834_4744# VSS VSS nfet_06v0 ad=1.25p pd=5.5u as=2.2p ps=10.88u w=5u l=1u
X1410 VDD a_44490_13656# a_68686_56900# VDD pfet_06v0 ad=1.32p pd=6.88u as=1.32p ps=6.88u w=3u l=1u
X1411 a_43874_42976# a_44174_42976# a_58866_43092# VDD pfet_06v0 ad=4.4p pd=20.88u as=2.5p ps=10.5u w=10u l=1u
X1412 a_2530_75936# a_36210_34416# VDD VDD pfet_06v0 ad=4.4p pd=20.88u as=2.6p ps=10.52u w=10u l=1u
X1413 a_5446_43092# a_5916_39692# VSS VSS nfet_06v0 ad=1.1p pd=5.88u as=1.1p ps=5.88u w=2.5u l=1u
X1414 VSS a_59758_13656# a_64726_56900# VSS nfet_06v0 ad=1.3p pd=5.52u as=1.3p ps=5.52u w=5u l=1u
X1415 a_23242_43092# a_23042_42976# VDD VDD pfet_06v0 ad=2.5p pd=10.5u as=4.4p ps=20.88u w=10u l=1u
X1416 a_9898_69248# a_10486_65848# VSS VSS nfet_06v0 ad=0.65p pd=3.02u as=0.65p ps=3.02u w=2.5u l=1u
X1417 Z a_2030_74376# a_65840_41360# VSS nfet_06v0 ad=0.6448p pd=3u as=1.0912p ps=5.84u w=2.48u l=1u
X1418 a_25266_39692# S4P a_23502_39692# VSS nfet_06v0 ad=2.2p pd=10.88u as=2.2p ps=10.88u w=5u l=1u
X1419 VDD a_11014_51776# a_9374_48376# VDD pfet_06v0 ad=2.2p pd=10.88u as=1.3p ps=5.52u w=5u l=1u
X1420 VSS a_27582_74260# a_27494_74376# VSS nfet_06v0 ad=0.44p pd=2.88u as=0.44p ps=2.88u w=1u l=1u
X1421 a_50970_25616# a_50970_25616# a_52594_25616# VDD pfet_06v0 ad=4.4p pd=20.88u as=4.4p ps=20.88u w=10u l=1u
X1422 a_57264_22332# a_44174_25616# VSS VSS nfet_06v0 ad=0.25p pd=1.5u as=0.44p ps=2.88u w=1u l=1u
X1423 a_23002_39576# a_23302_39576# a_35400_39692# VSS nfet_06v0 ad=2.2p pd=10.88u as=1.25p ps=5.5u w=5u l=1u
X1424 a_43834_4744# a_44174_8144# a_56942_8260# VDD pfet_06v0 ad=4.4p pd=20.88u as=2.5p ps=10.5u w=10u l=1u
X1425 a_56942_69248# a_32142_65732# a_55018_69248# VDD pfet_06v0 ad=2.6p pd=10.52u as=4.4p ps=20.88u w=10u l=1u
X1426 a_35094_34416# a_26590_34300# a_33454_31016# VDD pfet_06v0 ad=1.3p pd=5.52u as=2.2p ps=10.88u w=5u l=1u
X1427 a_29476_4744# a_23342_8144# a_33886_8260# VDD pfet_06v0 ad=4.4p pd=20.88u as=2.5p ps=10.5u w=10u l=1u
X1428 a_46098_57052# a_47922_60452# VDD VDD pfet_06v0 ad=2.2p pd=10.88u as=2.2p ps=10.88u w=5u l=1u
X1429 VDD a_12130_34416# a_3582_74260# VDD pfet_06v0 ad=2.6p pd=10.52u as=2.6p ps=10.52u w=10u l=1u
X1430 a_50308_39576# a_50308_39576# a_52716_39692# VSS nfet_06v0 ad=2.2p pd=10.88u as=2.2p ps=10.88u w=5u l=1u
X1431 VDD a_35094_51776# a_32342_48376# VDD pfet_06v0 ad=2.2p pd=10.88u as=1.3p ps=5.52u w=5u l=1u
X1432 a_24034_75936# a_35678_65848# VSS VSS nfet_06v0 ad=2.2p pd=10.88u as=1.3p ps=5.52u w=5u l=1u
X1433 a_51262_48376# a_51062_48260# VSS VSS nfet_06v0 ad=1.25p pd=5.5u as=2.2p ps=10.88u w=5u l=1u
X1434 VSS a_14334_74260# a_17762_74376# VSS nfet_06v0 ad=0.44p pd=2.88u as=0.25p ps=1.5u w=1u l=1u
X1435 a_68442_22792# a_66178_22676# a_68142_22792# VSS nfet_06v0 ad=0.175p pd=1.2u as=0.175p ps=1.2u w=0.7u l=1u
X1436 a_4134_65848# a_2510_69132# VSS VSS nfet_06v0 ad=0.25p pd=1.5u as=0.44p ps=2.88u w=1u l=1u
X1437 a_44374_43092# a_44174_42976# a_45186_43092# VDD pfet_06v0 ad=4.4p pd=20.88u as=2.5p ps=10.5u w=10u l=1u
X1438 a_8062_65732# a_27902_60452# VDD VDD pfet_06v0 ad=0.308p pd=2.28u as=0.308p ps=2.28u w=0.7u l=20u
X1439 a_8262_48376# a_11014_51776# VDD VDD pfet_06v0 ad=1.3p pd=5.52u as=1.3p ps=5.52u w=5u l=1u
X1440 a_8782_51776# a_2170_48260# a_11598_48376# VSS nfet_06v0 ad=1.1p pd=5.88u as=0.65p ps=3.02u w=2.5u l=1u
X1441 a_2710_25732# a_2510_25616# a_3522_25732# VDD pfet_06v0 ad=4.4p pd=20.88u as=2.5p ps=10.5u w=10u l=1u
X1442 a_56422_13656# a_32142_13540# a_54658_13656# VSS nfet_06v0 ad=1.3p pd=5.52u as=2.2p ps=10.88u w=5u l=1u
X1443 a_51972_39692# a_43834_39576# VSS VSS nfet_06v0 ad=1.25p pd=5.5u as=2.2p ps=10.88u w=5u l=1u
X1444 a_55018_69248# a_8062_65732# a_58058_69248# VDD pfet_06v0 ad=4.4p pd=20.88u as=2.6p ps=10.52u w=10u l=1u
X1445 a_20410_65848# a_12130_69248# VDD VDD pfet_06v0 ad=4.4p pd=20.88u as=2.6p ps=10.52u w=10u l=1u
X1446 a_20410_13656# a_12130_17056# VDD VDD pfet_06v0 ad=2.6p pd=10.52u as=4.4p ps=20.88u w=10u l=1u
X1447 a_25998_57052# a_27090_60452# VDD VDD pfet_06v0 ad=2.2p pd=10.88u as=2.2p ps=10.88u w=5u l=1u
X1448 Y Y a_67684_24000# VSS nfet_06v0 ad=0.52p pd=2.52u as=0.88p ps=4.88u w=2u l=1u
X1449 a_33454_48376# a_9174_48260# a_30578_48376# VSS nfet_06v0 ad=1.3p pd=5.52u as=2.2p ps=10.88u w=5u l=1u
X1450 a_2510_42976# a_2510_42976# VDD VDD pfet_06v0 ad=0.88p pd=4.88u as=0.88p ps=4.88u w=2u l=1u
X1451 a_56232_57052# a_43834_56936# VSS VSS nfet_06v0 ad=1.25p pd=5.5u as=2.2p ps=10.88u w=5u l=1u
X1452 VSS a_10486_65848# a_8782_69248# VSS nfet_06v0 ad=1.1p pd=5.88u as=0.65p ps=3.02u w=2.5u l=1u
X1453 a_23542_25732# a_23342_25616# a_24354_25732# VDD pfet_06v0 ad=4.4p pd=20.88u as=2.5p ps=10.5u w=10u l=1u
X1454 a_2470_39576# a_2470_39576# VSS VSS nfet_06v0 ad=0.44p pd=2.88u as=0.44p ps=2.88u w=1u l=1u
X1455 a_30578_65848# a_32142_65732# a_32342_65848# VSS nfet_06v0 ad=2.2p pd=10.88u as=1.3p ps=5.52u w=5u l=1u
X1456 a_54658_48376# a_50330_48260# a_54358_48376# VSS nfet_06v0 ad=2.2p pd=10.88u as=1.25p ps=5.5u w=5u l=1u
X1457 a_43458_48376# a_42438_48376# VSS VSS nfet_06v0 ad=1.25p pd=5.5u as=2.2p ps=10.88u w=5u l=1u
X1458 a_64728_5320# a_16742_74376# X VSS nfet_06v0 ad=1.0912p pd=5.84u as=0.6448p ps=3u w=2.48u l=1u
X1459 a_8782_69248# a_20410_65848# cap_mim_2f0_m4m5_noshield c_width=20u c_length=10u
X1460 a_55390_13656# a_51062_13540# VSS VSS nfet_06v0 ad=1.25p pd=5.5u as=2.2p ps=10.88u w=5u l=1u
X1461 a_4434_4860# S1P a_2670_4860# VSS nfet_06v0 ad=2.2p pd=10.88u as=2.2p ps=10.88u w=5u l=1u
X1462 a_33454_13656# a_35094_17056# VDD VDD pfet_06v0 ad=1.3p pd=5.52u as=1.3p ps=5.52u w=5u l=1u
X1463 a_36210_34416# a_40030_30900# a_35678_31016# VSS nfet_06v0 ad=1.1p pd=5.88u as=1.1p ps=5.88u w=2.5u l=1u
X1464 a_6858_51776# a_2510_51660# a_7670_51776# VDD pfet_06v0 ad=4.4p pd=20.88u as=2.5p ps=10.5u w=10u l=1u
X1465 a_29246_65848# a_26590_69132# VSS VSS nfet_06v0 ad=0.25p pd=1.5u as=0.44p ps=2.88u w=1u l=1u
X1466 a_5166_39692# S3N a_2670_39692# VSS nfet_06v0 ad=2.2p pd=10.88u as=2.2p ps=10.88u w=5u l=1u
X1467 a_25466_8260# a_26748_4860# VSS VSS nfet_06v0 ad=1.1p pd=5.88u as=1.1p ps=5.88u w=2.5u l=1u
X1468 a_67684_6528# X X VSS nfet_06v0 ad=0.88p pd=4.88u as=0.52p ps=2.52u w=2u l=1u
X1469 a_38034_43092# a_23042_42976# VDD VDD pfet_06v0 ad=2.5p pd=10.5u as=4.4p ps=20.88u w=10u l=1u
X1470 a_32342_31016# a_35094_34416# VDD VDD pfet_06v0 ad=1.3p pd=5.52u as=1.3p ps=5.52u w=5u l=1u
X1471 a_68062_26104# Y VDD VDD pfet_05v0 ad=0.8052p pd=4.54u as=0.8052p ps=4.54u w=1.83u l=0.5u
X1472 a_44074_8260# a_43874_8144# VDD VDD pfet_06v0 ad=2.5p pd=10.5u as=4.4p ps=20.88u w=10u l=1u
X1473 a_2210_16940# a_2510_16940# a_5446_17056# VDD pfet_06v0 ad=4.4p pd=20.88u as=2.5p ps=10.5u w=10u l=1u
X1474 a_2118_74260# a_59758_31016# VSS VSS nfet_06v0 ad=2.2p pd=10.88u as=1.3p ps=5.52u w=5u l=1u
X1475 VSS a_34566_65848# a_32862_69248# VSS nfet_06v0 ad=0.65p pd=3.02u as=0.65p ps=3.02u w=2.5u l=1u
X1476 VDD a_11014_69248# a_9374_65848# VDD pfet_06v0 ad=2.2p pd=10.88u as=1.3p ps=5.52u w=5u l=1u
X1477 a_25998_39692# S4N a_23502_39692# VSS nfet_06v0 ad=2.2p pd=10.88u as=2.2p ps=10.88u w=5u l=1u
X1478 a_2170_4744# a_2470_4744# a_14568_4860# VSS nfet_06v0 ad=2.2p pd=10.88u as=1.25p ps=5.5u w=5u l=1u
X1479 X X VDD VDD pfet_06v0 ad=0.52p pd=2.52u as=0.88p ps=4.88u w=2u l=1u
X1480 a_3522_43092# a_2210_42976# VDD VDD pfet_06v0 ad=2.5p pd=10.5u as=4.4p ps=20.88u w=10u l=1u
X1481 a_6648_4860# a_2470_4744# a_4634_8260# VSS nfet_06v0 ad=1.1p pd=5.88u as=1.1p ps=5.88u w=2.5u l=1u
X1482 a_16494_51660# a_2170_48260# a_17614_48376# VSS nfet_06v0 ad=2.2p pd=10.88u as=1.25p ps=5.5u w=5u l=1u
X1483 a_26490_17056# a_26290_16940# VDD VDD pfet_06v0 ad=2.5p pd=10.5u as=4.4p ps=20.88u w=10u l=1u
X1484 a_9898_17056# a_9174_13540# a_6858_17056# VDD pfet_06v0 ad=2.6p pd=10.52u as=4.4p ps=20.88u w=10u l=1u
X1485 VDD a_35094_69248# a_32342_65848# VDD pfet_06v0 ad=2.2p pd=10.88u as=1.3p ps=5.52u w=5u l=1u
X1486 VDD a_59174_34416# a_57534_31016# VDD pfet_06v0 ad=2.2p pd=10.88u as=1.3p ps=5.52u w=5u l=1u
X1487 VDD a_35094_17056# a_32342_13656# VDD pfet_06v0 ad=1.3p pd=5.52u as=1.3p ps=5.52u w=5u l=1u
X1488 a_24354_43092# a_23042_42976# VDD VDD pfet_06v0 ad=2.5p pd=10.5u as=4.4p ps=20.88u w=10u l=1u
X1489 a_44134_56936# a_44174_60336# a_55830_60452# VDD pfet_06v0 ad=4.4p pd=20.88u as=2.5p ps=10.5u w=10u l=1u
X1490 a_27090_60452# a_23342_60336# a_25998_57052# VDD pfet_06v0 ad=2.2p pd=10.88u as=2.2p ps=10.88u w=5u l=1u
X1491 a_2510_8144# a_2510_8144# a_16632_4860# VSS nfet_06v0 ad=0.44p pd=2.88u as=0.25p ps=1.5u w=1u l=1u
X1492 a_58058_51776# a_58646_48376# VSS VSS nfet_06v0 ad=0.65p pd=3.02u as=1.1p ps=5.88u w=2.5u l=1u
X1493 a_48312_39692# a_50970_42976# a_48734_43092# VDD pfet_06v0 ad=2.2p pd=10.88u as=2.2p ps=10.88u w=5u l=1u
X1494 a_50308_22216# a_44174_25616# a_54718_25732# VDD pfet_06v0 ad=4.4p pd=20.88u as=2.5p ps=10.5u w=10u l=1u
X1495 a_32862_51776# a_34566_48376# VSS VSS nfet_06v0 ad=0.65p pd=3.02u as=0.65p ps=3.02u w=2.5u l=1u
X1496 ZN ZP VSS VSS nfet_05v0 ad=0.5808p pd=3.52u as=0.5808p ps=3.52u w=1.32u l=0.6u
X1497 a_9374_31016# a_2510_34300# a_11014_34416# VDD pfet_06v0 ad=2.2p pd=10.88u as=1.3p ps=5.52u w=5u l=1u
X1498 a_44174_60336# a_44174_60336# a_58296_57052# VSS nfet_06v0 ad=0.44p pd=2.88u as=0.25p ps=1.5u w=1u l=1u
X1499 VSS a_34566_31016# a_32862_34416# VSS nfet_06v0 ad=1.1p pd=5.88u as=0.65p ps=3.02u w=2.5u l=1u
X1500 a_24998_74376# a_20410_65848# VDD VDD pfet_06v0 ad=1.32p pd=6.88u as=1.32p ps=6.88u w=3u l=1u
X1501 a_8262_65848# a_11014_69248# VDD VDD pfet_06v0 ad=1.3p pd=5.52u as=1.3p ps=5.52u w=5u l=1u
X1502 a_12130_51776# a_15950_48260# a_11598_48376# VSS nfet_06v0 ad=1.1p pd=5.88u as=1.1p ps=5.88u w=2.5u l=1u
X1503 a_30578_48376# a_26250_48260# a_31310_48376# VSS nfet_06v0 ad=2.2p pd=10.88u as=1.25p ps=5.5u w=5u l=1u
X1504 a_9898_69248# a_10486_65848# VSS VSS nfet_06v0 ad=0.65p pd=3.02u as=1.1p ps=5.88u w=2.5u l=1u
X1505 a_44034_39692# a_43834_39576# VSS VSS nfet_06v0 ad=1.25p pd=5.5u as=2.2p ps=10.88u w=5u l=1u
X1506 a_14334_74260# a_11598_48376# VSS VSS nfet_06v0 ad=1.3p pd=5.52u as=2.2p ps=10.88u w=5u l=1u
X1507 a_2410_51776# a_2210_51660# VDD VDD pfet_06v0 ad=2.5p pd=10.5u as=4.4p ps=20.88u w=10u l=1u
X1508 Y a_66834_57016# a_69828_24000# VSS nfet_06v0 ad=0.6448p pd=3u as=1.0912p ps=5.84u w=2.48u l=1u
X1509 a_54658_31016# a_32142_30900# a_56422_31016# VSS nfet_06v0 ad=2.2p pd=10.88u as=1.3p ps=5.52u w=5u l=1u
X1510 a_32342_48376# a_26590_51660# a_36210_51776# VDD pfet_06v0 ad=2.2p pd=10.88u as=1.3p ps=5.52u w=5u l=1u
X1511 a_46830_22332# a_47922_25732# VDD VDD pfet_06v0 ad=2.2p pd=10.88u as=2.2p ps=10.88u w=5u l=1u
X1512 a_23342_60336# a_23342_60336# VDD VDD pfet_06v0 ad=0.88p pd=4.88u as=0.88p ps=4.88u w=2u l=1u
X1513 a_32142_30900# a_46098_22332# cap_mim_2f0_m4m5_noshield c_width=20u c_length=10u
X1514 a_31750_17056# a_26290_16940# VDD VDD pfet_06v0 ad=2.5p pd=10.5u as=4.4p ps=20.88u w=10u l=1u
X1515 a_34566_31016# a_40574_34300# a_35094_34416# VDD pfet_06v0 ad=2.2p pd=10.88u as=2.2p ps=10.88u w=5u l=1u
X1516 a_58058_51776# a_50330_48260# a_58646_48376# VSS nfet_06v0 ad=1.1p pd=5.88u as=0.65p ps=3.02u w=2.5u l=1u
X1517 a_7070_25732# a_8644_22216# a_6648_22332# VSS nfet_06v0 ad=1.1p pd=5.88u as=1.1p ps=5.88u w=2.5u l=1u
X1518 Y Y VDD VDD pfet_06v0 ad=0.52p pd=2.52u as=0.52p ps=2.52u w=2u l=1u
X1519 Z Z VDD VDD pfet_06v0 ad=0.52p pd=2.52u as=0.52p ps=2.52u w=2u l=1u
X1520 a_12072_4860# a_11052_4860# VSS VSS nfet_06v0 ad=1.25p pd=5.5u as=2.2p ps=10.88u w=5u l=1u
X1521 a_27480_22332# a_30138_25616# a_27902_25732# VDD pfet_06v0 ad=2.2p pd=10.88u as=2.2p ps=10.88u w=5u l=1u
X1522 a_20410_65848# a_8262_65848# cap_mim_2f0_m4m5_noshield c_width=20u c_length=10u
X1523 VSS a_10486_48376# a_9898_51776# VSS nfet_06v0 ad=0.65p pd=3.02u as=0.65p ps=3.02u w=2.5u l=1u
X1524 a_23002_4744# a_23342_8144# a_36110_8260# VDD pfet_06v0 ad=4.4p pd=20.88u as=2.5p ps=10.5u w=10u l=1u
X1525 a_50330_48260# a_50670_51660# a_50570_51776# VDD pfet_06v0 ad=4.4p pd=20.88u as=2.5p ps=10.5u w=10u l=1u
X1526 a_57534_13656# a_8062_13540# a_54658_13656# VSS nfet_06v0 ad=1.3p pd=5.52u as=2.2p ps=10.88u w=5u l=1u
X1527 a_2510_42976# a_2510_42976# a_16632_39692# VSS nfet_06v0 ad=0.44p pd=2.88u as=0.25p ps=1.5u w=1u l=1u
X1528 a_6858_69248# a_2510_69132# a_7670_69248# VDD pfet_06v0 ad=4.4p pd=20.88u as=2.5p ps=10.5u w=10u l=1u
X1529 a_34566_48376# a_26250_48260# a_33978_51776# VSS nfet_06v0 ad=0.65p pd=3.02u as=1.1p ps=5.88u w=2.5u l=1u
X1530 a_69084_24000# Y VSS VSS nfet_06v0 ad=0.5p pd=2.5u as=0.88p ps=4.88u w=2u l=1u
X1531 a_54718_43092# a_43874_42976# VDD VDD pfet_06v0 ad=2.5p pd=10.5u as=4.4p ps=20.88u w=10u l=1u
X1532 a_8262_48376# a_8062_48260# a_6498_48376# VSS nfet_06v0 ad=1.3p pd=5.52u as=2.2p ps=10.88u w=5u l=1u
X1533 a_51062_13540# a_50330_13540# a_51262_13656# VSS nfet_06v0 ad=2.2p pd=10.88u as=1.25p ps=5.5u w=5u l=1u
X1534 a_47580_4860# a_50970_8144# a_47922_8260# VDD pfet_06v0 ad=2.2p pd=10.88u as=2.2p ps=10.88u w=5u l=1u
X1535 a_8262_48376# a_11014_51776# VDD VDD pfet_06v0 ad=1.3p pd=5.52u as=2.2p ps=10.88u w=5u l=1u
X1536 a_46298_8260# a_32142_13540# cap_mim_2f0_m4m5_noshield c_width=20u c_length=10u
X1537 a_67538_13656# a_66518_13656# VSS VSS nfet_06v0 ad=1.25p pd=5.5u as=2.2p ps=10.88u w=5u l=1u
X1538 a_69618_57016# a_44490_13656# a_68686_56900# VSS nfet_06v0 ad=0.25p pd=1.5u as=0.44p ps=2.88u w=1u l=1u
X1539 a_2670_39692# a_2470_39576# a_3402_39692# VSS nfet_06v0 ad=2.2p pd=10.88u as=1.25p ps=5.5u w=5u l=1u
X1540 a_35678_48376# a_40574_51660# a_36210_51776# VDD pfet_06v0 ad=2.2p pd=10.88u as=2.2p ps=10.88u w=5u l=1u
X1541 a_30578_65848# a_9174_65732# a_33454_65848# VSS nfet_06v0 ad=2.2p pd=10.88u as=1.3p ps=5.52u w=5u l=1u
X1542 a_9306_25616# a_9306_25616# a_10930_25616# VDD pfet_06v0 ad=4.4p pd=20.88u as=4.4p ps=20.88u w=10u l=1u
X1543 a_14246_74376# a_14334_74260# VDD VDD pfet_06v0 ad=1.32p pd=6.88u as=1.32p ps=6.88u w=3u l=1u
X1544 a_26590_34300# a_26590_34300# a_29246_31016# VSS nfet_06v0 ad=0.44p pd=2.88u as=0.25p ps=1.5u w=1u l=1u
X1545 a_64654_69132# a_50330_65732# a_65774_65848# VSS nfet_06v0 ad=2.2p pd=10.88u as=1.25p ps=5.5u w=5u l=1u
X1546 a_8644_39576# a_8644_39576# a_11052_39692# VSS nfet_06v0 ad=2.2p pd=10.88u as=2.2p ps=10.88u w=5u l=1u
X1547 VSS a_23622_74260# a_26750_74376# VSS nfet_06v0 ad=0.44p pd=2.88u as=0.25p ps=1.5u w=1u l=1u
X1548 a_23502_39692# a_23302_39576# a_24234_39692# VSS nfet_06v0 ad=2.2p pd=10.88u as=1.25p ps=5.5u w=5u l=1u
X1549 a_43834_22216# a_44134_22216# a_56232_22332# VSS nfet_06v0 ad=2.2p pd=10.88u as=1.25p ps=5.5u w=5u l=1u
X1550 a_6858_17056# a_2510_16940# a_6558_17056# VDD pfet_06v0 ad=4.4p pd=20.88u as=2.5p ps=10.5u w=10u l=1u
X1551 a_2670_39692# a_2470_39576# a_2370_39692# VSS nfet_06v0 ad=2.2p pd=10.88u as=1.25p ps=5.5u w=5u l=1u
X1552 a_4634_43092# S3P a_2710_43092# VDD pfet_06v0 ad=4.4p pd=20.88u as=4.4p ps=20.88u w=10u l=1u
X1553 a_53606_51776# a_50370_51660# VDD VDD pfet_06v0 ad=2.5p pd=10.5u as=4.4p ps=20.88u w=10u l=1u
X1554 a_37464_57052# a_23342_60336# VSS VSS nfet_06v0 ad=0.25p pd=1.5u as=0.44p ps=2.88u w=1u l=1u
X1555 a_32342_31016# a_35094_34416# VDD VDD pfet_06v0 ad=1.3p pd=5.52u as=2.2p ps=10.88u w=5u l=1u
X1556 a_27480_39692# a_23302_39576# a_25466_43092# VSS nfet_06v0 ad=1.1p pd=5.88u as=1.1p ps=5.88u w=2.5u l=1u
X1557 a_26748_57052# a_30138_60336# a_27090_60452# VDD pfet_06v0 ad=2.2p pd=10.88u as=2.2p ps=10.88u w=5u l=1u
X1558 a_2170_30900# a_2510_34300# a_2410_34416# VDD pfet_06v0 ad=4.4p pd=20.88u as=2.5p ps=10.5u w=10u l=1u
X1559 a_42438_13656# a_26250_13540# a_43458_13656# VSS nfet_06v0 ad=2.2p pd=10.88u as=1.25p ps=5.5u w=5u l=1u
X1560 a_46298_8260# S3P a_44374_8260# VDD pfet_06v0 ad=4.4p pd=20.88u as=4.4p ps=20.88u w=10u l=1u
X1561 a_2510_16940# a_2510_16940# a_5166_13656# VSS nfet_06v0 ad=0.44p pd=2.88u as=0.25p ps=1.5u w=1u l=1u
X1562 a_50330_48260# a_50330_48260# VSS VSS nfet_06v0 ad=0.44p pd=2.88u as=0.44p ps=2.88u w=1u l=1u
X1563 Y a_14978_74376# a_64728_22792# VSS nfet_06v0 ad=0.6448p pd=3u as=1.0912p ps=5.84u w=2.48u l=1u
X1564 a_59758_31016# a_64654_34300# a_60290_34416# VDD pfet_06v0 ad=2.2p pd=10.88u as=2.2p ps=10.88u w=5u l=1u
X1565 a_32142_65732# a_48312_57052# VSS VSS nfet_06v0 ad=0.44p pd=2.88u as=0.44p ps=2.88u w=1u l=1u
X1566 a_30938_34416# a_32142_30900# a_32862_34416# VDD pfet_06v0 ad=4.4p pd=20.88u as=2.6p ps=10.52u w=10u l=1u
X1567 a_2410_69248# a_2210_69132# VDD VDD pfet_06v0 ad=2.5p pd=10.5u as=4.4p ps=20.88u w=10u l=1u
X1568 VSS a_10486_13656# a_9898_17056# VSS nfet_06v0 ad=1.1p pd=5.88u as=0.65p ps=3.02u w=2.5u l=1u
X1569 a_25466_43092# S4P a_23542_43092# VDD pfet_06v0 ad=4.4p pd=20.88u as=4.4p ps=20.88u w=10u l=1u
X1570 a_32342_65848# a_26590_69132# a_36210_69248# VDD pfet_06v0 ad=2.2p pd=10.88u as=1.3p ps=5.52u w=5u l=1u
X1571 a_46830_4860# a_47922_8260# VDD VDD pfet_06v0 ad=2.2p pd=10.88u as=2.2p ps=10.88u w=5u l=1u
X1572 a_64728_6528# a_27494_74376# X VSS nfet_06v0 ad=1.0912p pd=5.84u as=0.6448p ps=3u w=2.48u l=1u
X1573 a_52594_42976# a_44174_42976# a_52794_43092# VDD pfet_06v0 ad=4.4p pd=20.88u as=2.5p ps=10.5u w=10u l=1u
X1574 ZP a_68062_43464# VSS VSS nfet_05v0 ad=0.5808p pd=3.52u as=0.5808p ps=3.52u w=1.32u l=0.6u
X1575 VDD a_59174_34416# a_57534_31016# VDD pfet_06v0 ad=1.3p pd=5.52u as=1.3p ps=5.52u w=5u l=1u
X1576 VSS a_58646_65848# a_58058_69248# VSS nfet_06v0 ad=0.65p pd=3.02u as=0.65p ps=3.02u w=2.5u l=1u
X1577 a_50330_65732# a_50670_69132# a_50570_69248# VDD pfet_06v0 ad=4.4p pd=20.88u as=2.5p ps=10.5u w=10u l=1u
X1578 a_44134_56936# a_44134_56936# VSS VSS nfet_06v0 ad=0.44p pd=2.88u as=0.44p ps=2.88u w=1u l=1u
X1579 a_3522_51776# a_2210_51660# VDD VDD pfet_06v0 ad=2.5p pd=10.5u as=4.4p ps=20.88u w=10u l=1u
X1580 a_32142_30900# a_48734_25732# VDD VDD pfet_06v0 ad=0.308p pd=2.28u as=0.308p ps=2.28u w=0.7u l=20u
X1581 X a_5990_74376# a_65840_6528# VSS nfet_06v0 ad=0.6448p pd=3u as=1.0912p ps=5.84u w=2.48u l=1u
X1582 a_54658_31016# a_8062_30900# a_57534_31016# VSS nfet_06v0 ad=2.2p pd=10.88u as=1.3p ps=5.52u w=5u l=1u
X1583 a_5246_74376# a_3494_74376# a_4314_74260# VSS nfet_06v0 ad=0.25p pd=1.5u as=0.44p ps=2.88u w=1u l=1u
X1584 a_47110_25732# S4N a_44374_25732# VDD pfet_06v0 ad=4.4p pd=20.88u as=4.4p ps=20.88u w=10u l=1u
X1585 a_23042_60336# a_23342_60336# a_38034_60452# VDD pfet_06v0 ad=4.4p pd=20.88u as=2.5p ps=10.5u w=10u l=1u
X1586 a_32862_17056# a_32142_13540# a_30938_17056# VDD pfet_06v0 ad=2.6p pd=10.52u as=4.4p ps=20.88u w=10u l=1u
X1587 a_23302_22216# a_23302_22216# VSS VSS nfet_06v0 ad=0.44p pd=2.88u as=0.44p ps=2.88u w=1u l=1u
X1588 a_66478_51776# a_66278_51660# VDD VDD pfet_06v0 ad=2.5p pd=10.5u as=4.4p ps=20.88u w=10u l=1u
X1589 a_9174_48260# a_6648_39692# VSS VSS nfet_06v0 ad=0.44p pd=2.88u as=0.44p ps=2.88u w=1u l=1u
X1590 a_56942_51776# a_50330_48260# a_59758_48376# VSS nfet_06v0 ad=1.1p pd=5.88u as=0.65p ps=3.02u w=2.5u l=1u
X1591 a_43874_8144# a_44174_8144# a_58866_8260# VDD pfet_06v0 ad=4.4p pd=20.88u as=2.5p ps=10.5u w=10u l=1u
X1592 VSS a_11598_65848# a_20410_65848# VSS nfet_06v0 ad=1.3p pd=5.52u as=1.3p ps=5.52u w=5u l=1u
X1593 a_8262_65848# a_11014_69248# VDD VDD pfet_06v0 ad=1.3p pd=5.52u as=2.2p ps=10.88u w=5u l=1u
X1594 a_40030_48260# a_40030_48260# a_42438_48376# VSS nfet_06v0 ad=2.2p pd=10.88u as=2.2p ps=10.88u w=5u l=1u
X1595 a_33978_51776# a_9174_48260# a_30938_51776# VDD pfet_06v0 ad=2.6p pd=10.52u as=4.4p ps=20.88u w=10u l=1u
X1596 a_4634_60452# a_9174_65732# cap_mim_2f0_m4m5_noshield c_width=20u c_length=10u
X1597 a_2210_51660# a_2510_51660# a_4134_48376# VSS nfet_06v0 ad=0.44p pd=2.88u as=0.25p ps=1.5u w=1u l=1u
X1598 a_9174_30900# a_7070_25732# VDD VDD pfet_06v0 ad=0.308p pd=2.28u as=0.308p ps=2.28u w=0.7u l=20u
X1599 a_44334_4860# a_44134_4744# a_44034_4860# VSS nfet_06v0 ad=2.2p pd=10.88u as=1.25p ps=5.5u w=5u l=1u
X1600 a_26290_69132# a_26590_69132# a_28214_65848# VSS nfet_06v0 ad=0.44p pd=2.88u as=0.25p ps=1.5u w=1u l=1u
X1601 a_35678_65848# a_40574_69132# a_36210_69248# VDD pfet_06v0 ad=2.2p pd=10.88u as=2.2p ps=10.88u w=5u l=1u
X1602 a_30278_65848# a_26982_65732# VSS VSS nfet_06v0 ad=1.25p pd=5.5u as=2.2p ps=10.88u w=5u l=1u
X1603 a_51062_48260# a_50670_51660# a_51682_51776# VDD pfet_06v0 ad=4.4p pd=20.88u as=2.5p ps=10.5u w=10u l=1u
X1604 a_58646_13656# a_50330_13540# a_58058_17056# VSS nfet_06v0 ad=0.65p pd=3.02u as=1.1p ps=5.88u w=2.5u l=1u
X1605 VSS a_58646_31016# a_58058_34416# VSS nfet_06v0 ad=1.1p pd=5.88u as=0.65p ps=3.02u w=2.5u l=1u
X1606 a_35678_48376# a_26250_48260# a_32862_51776# VSS nfet_06v0 ad=0.65p pd=3.02u as=1.1p ps=5.88u w=2.5u l=1u
X1607 a_8782_34416# a_10486_31016# VSS VSS nfet_06v0 ad=0.65p pd=3.02u as=1.1p ps=5.88u w=2.5u l=1u
X1608 a_68062_43464# Z VSS VSS nfet_05v0 ad=0.5808p pd=3.52u as=0.5808p ps=3.52u w=1.32u l=0.6u
X1609 a_69828_41360# a_66178_40036# VSS VSS nfet_06v0 ad=0.5456p pd=3.36u as=0.5456p ps=3.36u w=1.24u l=1u
X1610 a_9374_48376# a_9174_48260# a_6498_48376# VSS nfet_06v0 ad=1.3p pd=5.52u as=2.2p ps=10.88u w=5u l=1u
X1611 a_2170_4744# a_2510_8144# a_15278_8260# VDD pfet_06v0 ad=4.4p pd=20.88u as=2.5p ps=10.5u w=10u l=1u
X1612 a_35400_22332# a_23002_22216# VSS VSS nfet_06v0 ad=1.25p pd=5.5u as=2.2p ps=10.88u w=5u l=1u
X1613 a_50370_34300# a_50670_34300# a_53606_34416# VDD pfet_06v0 ad=4.4p pd=20.88u as=2.5p ps=10.5u w=10u l=1u
X1614 a_12072_39692# a_11052_39692# VSS VSS nfet_06v0 ad=1.25p pd=5.5u as=2.2p ps=10.88u w=5u l=1u
X1615 a_32142_13540# a_48734_8260# VDD VDD pfet_06v0 ad=0.308p pd=2.28u as=0.308p ps=2.28u w=0.7u l=20u
X1616 a_14334_74260# a_11598_48376# VSS VSS nfet_06v0 ad=2.2p pd=10.88u as=1.3p ps=5.52u w=5u l=1u
X1617 a_55830_25732# a_43874_25616# VDD VDD pfet_06v0 ad=2.5p pd=10.5u as=4.4p ps=20.88u w=10u l=1u
X1618 a_64726_56900# a_56422_13656# cap_mim_2f0_m4m5_noshield c_width=20u c_length=10u
X1619 a_41694_48376# a_26982_48260# VSS VSS nfet_06v0 ad=1.25p pd=5.5u as=2.2p ps=10.88u w=5u l=1u
X1620 VDD a_3582_74260# a_6078_74260# VDD pfet_06v0 ad=1.32p pd=6.88u as=1.32p ps=6.88u w=3u l=1u
X1621 a_66834_57016# a_66922_56900# VDD VDD pfet_06v0 ad=1.32p pd=6.88u as=1.32p ps=6.88u w=3u l=1u
X1622 a_30938_17056# a_9174_13540# a_33978_17056# VDD pfet_06v0 ad=4.4p pd=20.88u as=2.6p ps=10.52u w=10u l=1u
X1623 a_11598_13656# a_16494_16940# a_12130_17056# VDD pfet_06v0 ad=2.2p pd=10.88u as=2.2p ps=10.88u w=5u l=1u
X1624 a_42198_51660# a_26590_51660# a_42398_51776# VDD pfet_06v0 ad=4.4p pd=20.88u as=2.5p ps=10.5u w=10u l=1u
X1625 a_8644_22216# a_2510_25616# a_13054_25732# VDD pfet_06v0 ad=4.4p pd=20.88u as=2.5p ps=10.5u w=10u l=1u
X1626 a_26982_65732# a_26250_65732# a_27182_65848# VSS nfet_06v0 ad=2.2p pd=10.88u as=1.25p ps=5.5u w=5u l=1u
X1627 a_6498_65848# a_8062_65732# a_8262_65848# VSS nfet_06v0 ad=2.2p pd=10.88u as=1.3p ps=5.52u w=5u l=1u
X1628 a_56942_17056# a_58646_13656# VSS VSS nfet_06v0 ad=0.65p pd=3.02u as=1.1p ps=5.88u w=2.5u l=1u
X1629 a_33454_48376# a_26590_51660# a_35094_51776# VDD pfet_06v0 ad=2.2p pd=10.88u as=1.3p ps=5.52u w=5u l=1u
X1630 a_53606_69248# a_50370_69132# VDD VDD pfet_06v0 ad=2.5p pd=10.5u as=4.4p ps=20.88u w=10u l=1u
X1631 a_58058_34416# a_8062_30900# a_55018_34416# VDD pfet_06v0 ad=2.6p pd=10.52u as=4.4p ps=20.88u w=10u l=1u
X1632 a_4434_4860# a_6258_8260# VDD VDD pfet_06v0 ad=2.2p pd=10.88u as=2.2p ps=10.88u w=5u l=1u
X1633 a_64728_41360# a_23534_74376# Z VSS nfet_06v0 ad=1.0912p pd=5.84u as=0.6448p ps=3u w=2.48u l=1u
X1634 a_6198_13656# a_2902_13540# VSS VSS nfet_06v0 ad=1.25p pd=5.5u as=2.2p ps=10.88u w=5u l=1u
X1635 a_27902_8260# a_29476_4744# a_27480_4860# VSS nfet_06v0 ad=1.1p pd=5.88u as=1.1p ps=5.88u w=2.5u l=1u
X1636 a_36110_60452# a_23042_60336# VDD VDD pfet_06v0 ad=2.5p pd=10.5u as=4.4p ps=20.88u w=10u l=1u
X1637 a_31962_43092# a_31762_42976# VDD VDD pfet_06v0 ad=2.5p pd=10.5u as=4.4p ps=20.88u w=10u l=1u
X1638 a_64110_13540# a_50670_16940# a_68402_17056# VDD pfet_06v0 ad=4.4p pd=20.88u as=2.5p ps=10.5u w=10u l=1u
X1639 a_46298_60452# a_47580_57052# VSS VSS nfet_06v0 ad=1.1p pd=5.88u as=1.1p ps=5.88u w=2.5u l=1u
X1640 a_11014_51776# a_15950_48260# a_10486_48376# VSS nfet_06v0 ad=1.1p pd=5.88u as=1.1p ps=5.88u w=2.5u l=1u
X1641 a_54718_51776# a_50370_51660# VDD VDD pfet_06v0 ad=2.5p pd=10.5u as=4.4p ps=20.88u w=10u l=1u
X1642 a_20242_51776# a_2210_51660# VDD VDD pfet_06v0 ad=2.5p pd=10.5u as=4.4p ps=20.88u w=10u l=1u
X1643 VDD a_60290_51776# a_12870_74260# VDD pfet_06v0 ad=2.6p pd=10.52u as=2.6p ps=10.52u w=10u l=1u
X1644 XP a_68062_8632# VSS VSS nfet_05v0 ad=0.5808p pd=3.52u as=0.5808p ps=3.52u w=1.32u l=0.6u
X1645 a_2902_30900# a_2510_34300# a_3522_34416# VDD pfet_06v0 ad=4.4p pd=20.88u as=2.5p ps=10.5u w=10u l=1u
X1646 a_64728_40152# a_66178_40036# VSS VSS nfet_06v0 ad=0.5456p pd=3.36u as=0.5456p ps=3.36u w=1.24u l=1u
X1647 X X VDD VDD pfet_06v0 ad=0.52p pd=2.52u as=0.52p ps=2.52u w=2u l=1u
X1648 a_66278_34300# a_50670_34300# a_66478_34416# VDD pfet_06v0 ad=4.4p pd=20.88u as=2.5p ps=10.5u w=10u l=1u
X1649 a_57534_31016# a_50670_34300# a_59174_34416# VDD pfet_06v0 ad=2.2p pd=10.88u as=1.3p ps=5.52u w=5u l=1u
X1650 VSS a_10486_13656# a_8782_17056# VSS nfet_06v0 ad=0.65p pd=3.02u as=0.65p ps=3.02u w=2.5u l=1u
X1651 a_25266_22332# a_27090_25732# VDD VDD pfet_06v0 ad=2.2p pd=10.88u as=2.2p ps=10.88u w=5u l=1u
X1652 a_6258_25732# a_8644_22216# a_5916_22332# VSS nfet_06v0 ad=1.1p pd=5.88u as=1.1p ps=5.88u w=2.5u l=1u
X1653 a_18358_65848# a_2170_65732# a_19378_65848# VSS nfet_06v0 ad=2.2p pd=10.88u as=1.25p ps=5.5u w=5u l=1u
X1654 a_3522_69248# a_2210_69132# VDD VDD pfet_06v0 ad=2.5p pd=10.5u as=4.4p ps=20.88u w=10u l=1u
X1655 a_67684_41360# Z Z VSS nfet_06v0 ad=0.88p pd=4.88u as=0.52p ps=2.52u w=2u l=1u
X1656 a_17202_60452# a_2210_60336# VDD VDD pfet_06v0 ad=2.5p pd=10.5u as=4.4p ps=20.88u w=10u l=1u
X1657 a_54358_31016# a_51062_30900# VSS VSS nfet_06v0 ad=1.25p pd=5.5u as=2.2p ps=10.88u w=5u l=1u
X1658 a_66478_69248# a_66278_69132# VDD VDD pfet_06v0 ad=2.5p pd=10.5u as=4.4p ps=20.88u w=10u l=1u
X1659 ZP a_68062_43464# VDD VDD pfet_05v0 ad=0.8052p pd=4.54u as=0.8052p ps=4.54u w=1.83u l=0.5u
X1660 a_12870_74260# a_59758_48376# VSS VSS nfet_06v0 ad=1.3p pd=5.52u as=2.2p ps=10.88u w=5u l=1u
X1661 a_50970_60336# a_44134_56936# a_51972_57052# VSS nfet_06v0 ad=2.2p pd=10.88u as=1.25p ps=5.5u w=5u l=1u
X1662 a_11130_25732# a_10930_25616# VDD VDD pfet_06v0 ad=2.5p pd=10.5u as=4.4p ps=20.88u w=10u l=1u
X1663 a_33978_69248# a_9174_65732# a_30938_69248# VDD pfet_06v0 ad=2.6p pd=10.52u as=4.4p ps=20.88u w=10u l=1u
X1664 a_26278_8260# a_26748_4860# VSS VSS nfet_06v0 ad=1.1p pd=5.88u as=1.1p ps=5.88u w=2.5u l=1u
X1665 a_23342_25616# a_23342_25616# a_37464_22332# VSS nfet_06v0 ad=0.44p pd=2.88u as=0.25p ps=1.5u w=1u l=1u
X1666 a_5166_48376# a_2510_51660# VSS VSS nfet_06v0 ad=0.25p pd=1.5u as=0.44p ps=2.88u w=1u l=1u
X1667 VDD a_11014_17056# a_8262_13656# VDD pfet_06v0 ad=2.2p pd=10.88u as=1.3p ps=5.52u w=5u l=1u
X1668 a_27090_25732# a_29476_22216# a_26748_22332# VSS nfet_06v0 ad=1.1p pd=5.88u as=1.1p ps=5.88u w=2.5u l=1u
X1669 a_31884_22332# a_23302_22216# a_32904_22332# VSS nfet_06v0 ad=2.2p pd=10.88u as=1.25p ps=5.5u w=5u l=1u
X1670 a_30938_51776# a_26590_51660# a_30638_51776# VDD pfet_06v0 ad=4.4p pd=20.88u as=2.5p ps=10.5u w=10u l=1u
X1671 a_51062_65732# a_50670_69132# a_51682_69248# VDD pfet_06v0 ad=4.4p pd=20.88u as=2.5p ps=10.5u w=10u l=1u
X1672 a_44322_34416# a_26290_34300# VDD VDD pfet_06v0 ad=2.5p pd=10.5u as=4.4p ps=20.88u w=10u l=1u
X1673 a_6498_48376# a_2170_48260# a_7230_48376# VSS nfet_06v0 ad=2.2p pd=10.88u as=1.25p ps=5.5u w=5u l=1u
X1674 a_25466_8260# S2P a_23542_8260# VDD pfet_06v0 ad=4.4p pd=20.88u as=4.4p ps=20.88u w=10u l=1u
X1675 a_2510_51660# a_2510_51660# VDD VDD pfet_06v0 ad=0.88p pd=4.88u as=0.88p ps=4.88u w=2u l=1u
X1676 a_64110_13540# a_64110_13540# a_66518_13656# VSS nfet_06v0 ad=2.2p pd=10.88u as=2.2p ps=10.88u w=5u l=1u
X1677 VDD a_59174_51776# a_56422_48376# VDD pfet_06v0 ad=2.2p pd=10.88u as=1.3p ps=5.52u w=5u l=1u
X1678 a_47922_25732# a_50308_22216# a_47580_22332# VSS nfet_06v0 ad=1.1p pd=5.88u as=1.1p ps=5.88u w=2.5u l=1u
X1679 a_7670_17056# a_2210_16940# VDD VDD pfet_06v0 ad=2.5p pd=10.5u as=4.4p ps=20.88u w=10u l=1u
X1680 a_23302_39576# a_23342_42976# a_34998_43092# VDD pfet_06v0 ad=4.4p pd=20.88u as=2.5p ps=10.5u w=10u l=1u
X1681 a_30138_8144# a_30138_8144# a_31762_8144# VDD pfet_06v0 ad=4.4p pd=20.88u as=4.4p ps=20.88u w=10u l=1u
X1682 a_25998_4860# a_27090_8260# VDD VDD pfet_06v0 ad=2.2p pd=10.88u as=2.2p ps=10.88u w=5u l=1u
X1683 a_30578_31016# a_26250_30900# a_30278_31016# VSS nfet_06v0 ad=2.2p pd=10.88u as=1.25p ps=5.5u w=5u l=1u
X1684 a_17614_31016# a_2902_30900# VSS VSS nfet_06v0 ad=1.25p pd=5.5u as=2.2p ps=10.88u w=5u l=1u
X1685 a_7070_25732# a_2510_25616# a_4434_22332# VDD pfet_06v0 ad=2.2p pd=10.88u as=2.2p ps=10.88u w=5u l=1u
X1686 a_42198_69132# a_26590_69132# a_42398_69248# VDD pfet_06v0 ad=4.4p pd=20.88u as=2.5p ps=10.5u w=10u l=1u
X1687 a_9898_69248# a_2170_65732# a_10486_65848# VSS nfet_06v0 ad=1.1p pd=5.88u as=0.65p ps=3.02u w=2.5u l=1u
X1688 a_26982_13540# a_26590_16940# a_27602_17056# VDD pfet_06v0 ad=4.4p pd=20.88u as=2.5p ps=10.5u w=10u l=1u
X1689 a_59758_13656# a_50330_13540# a_56942_17056# VSS nfet_06v0 ad=0.65p pd=3.02u as=1.1p ps=5.88u w=2.5u l=1u
X1690 a_33454_65848# a_26590_69132# a_35094_69248# VDD pfet_06v0 ad=2.2p pd=10.88u as=1.3p ps=5.52u w=5u l=1u
X1691 a_44334_22332# a_44134_22216# a_45066_22332# VSS nfet_06v0 ad=2.2p pd=10.88u as=1.25p ps=5.5u w=5u l=1u
X1692 VSS a_58646_31016# a_56942_34416# VSS nfet_06v0 ad=0.65p pd=3.02u as=0.65p ps=3.02u w=2.5u l=1u
X1693 a_35094_51776# a_40030_48260# a_34566_48376# VSS nfet_06v0 ad=1.1p pd=5.88u as=1.1p ps=5.88u w=2.5u l=1u
X1694 a_57264_4860# a_44174_8144# VSS VSS nfet_06v0 ad=0.25p pd=1.5u as=0.44p ps=2.88u w=1u l=1u
X1695 a_32862_17056# a_44490_13656# cap_mim_2f0_m4m5_noshield c_width=20u c_length=10u
X1696 a_65774_13656# a_51062_13540# VSS VSS nfet_06v0 ad=1.25p pd=5.5u as=2.2p ps=10.88u w=5u l=1u
X1697 a_67854_57016# a_66102_57016# a_66922_56900# VSS nfet_06v0 ad=0.25p pd=1.5u as=0.44p ps=2.88u w=1u l=1u
X1698 a_55018_34416# a_50670_34300# a_54718_34416# VDD pfet_06v0 ad=4.4p pd=20.88u as=2.5p ps=10.5u w=10u l=1u
X1699 a_15950_30900# a_2510_34300# a_20242_34416# VDD pfet_06v0 ad=4.4p pd=20.88u as=2.5p ps=10.5u w=10u l=1u
X1700 XN XP VDD VDD pfet_05v0 ad=0.8052p pd=4.54u as=0.8052p ps=4.54u w=1.83u l=0.5u
X1701 a_56942_25732# a_43874_25616# VDD VDD pfet_06v0 ad=2.5p pd=10.5u as=4.4p ps=20.88u w=10u l=1u
X1702 a_56422_31016# a_50670_34300# a_60290_34416# VDD pfet_06v0 ad=2.2p pd=10.88u as=1.3p ps=5.52u w=5u l=1u
X1703 a_23042_60336# a_23342_60336# a_36432_57052# VSS nfet_06v0 ad=0.44p pd=2.88u as=0.25p ps=1.5u w=1u l=1u
X1704 a_2430_76052# a_2118_74260# a_2030_74376# VDD pfet_06v0 ad=0.75p pd=3.5u as=1.32p ps=6.88u w=3u l=1u
X1705 a_18118_16940# a_2510_16940# a_18318_17056# VDD pfet_06v0 ad=4.4p pd=20.88u as=2.5p ps=10.5u w=10u l=1u
X1706 a_2470_22216# a_2510_25616# a_14166_25732# VDD pfet_06v0 ad=4.4p pd=20.88u as=2.5p ps=10.5u w=10u l=1u
.ends
