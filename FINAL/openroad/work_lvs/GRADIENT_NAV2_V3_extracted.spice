* NGSPICE file created from GRADIENT_NAV2_V3.ext - technology: gf180mcuD

.subckt GRADIENT_NAV2_V3 S1N S1P S2N S2P S3N S3P S4N S4P X XN XP Y YN YP Z ZN ZP VDD
+ VSS
X0 a_55330_28838# a_55130_28794# VSS VSS nfet_06v0 ad=1.25p pd=5.5u as=2.2p ps=10.88u w=5u l=1u
X1 a_42790_49723# a_34818_54123# VDD VDD pfet_06v0 ad=2.6p pd=10.52u as=4.4p ps=20.88u w=10u l=1u
X2 a_19390_53193# a_2294_53077# VDD VDD pfet_06v0 ad=2.5p pd=10.5u as=4.4p ps=20.88u w=10u l=1u
X3 VDD VSS VDD VDD pfet_06v0 ad=0.44p pd=2.88u as=1.86749n ps=8.9035m w=1u l=2u
X4 a_25154_28838# a_24954_28794# a_24854_28838# VSS nfet_06v0 ad=2.2p pd=10.88u as=1.25p ps=5.5u w=5u l=1u
X5 a_70694_35696# a_69382_35580# VDD VDD pfet_06v0 ad=2.5p pd=10.5u as=4.4p ps=20.88u w=10u l=1u
X6 a_62366_58305# a_48510_63573# a_63566_62889# VSS nfet_06v0 ad=2.2p pd=10.88u as=1.25p ps=5.5u w=5u l=1u
X7 VDD VSS VDD VDD pfet_06v0 ad=7.92p pd=36.88u as=0 ps=0 w=18u l=2u
X8 a_72054_51200# a_72142_51084# Y VSS nfet_06v0 ad=1.0912p pd=5.84u as=0.6448p ps=3u w=2.48u l=1u
X9 VSS a_72314_66956# a_72142_51084# VSS nfet_06v0 ad=0.44p pd=2.88u as=0.44p ps=2.88u w=1u l=1u
X10 a_34818_58419# a_25666_58305# a_31030_62819# VDD pfet_06v0 ad=1.3p pd=5.52u as=2.2p ps=10.88u w=5u l=1u
X11 a_72338_24088# a_73430_16930# VDD VDD pfet_06v0 ad=2.2p pd=10.88u as=2.2p ps=10.88u w=5u l=1u
X12 a_41226_45413# a_25326_46213# a_41426_45529# VSS nfet_06v0 ad=1.65p pd=5.66u as=1.25p ps=5.5u w=5u l=1u
X13 a_31030_49723# a_25666_53077# a_34818_54123# VDD pfet_06v0 ad=2.2p pd=10.88u as=1.3p ps=5.52u w=5u l=1u
X14 a_49938_24088# a_51030_16930# VDD VDD pfet_06v0 ad=2.2p pd=10.88u as=2.2p ps=10.88u w=5u l=1u
X15 a_69542_24788# a_69342_24672# VSS VSS nfet_06v0 ad=1.25p pd=5.5u as=2.2p ps=10.88u w=5u l=1u
X16 a_4718_16930# a_5794_25172# VSS VSS nfet_06v0 ad=0.825p pd=3.16u as=1.1p ps=5.88u w=2.5u l=1u
X17 a_9598_24788# a_2254_24672# VSS VSS nfet_06v0 ad=1.25p pd=5.5u as=2.2p ps=10.88u w=5u l=1u
X18 a_7758_66967# a_25568_33300# VDD VDD pfet_06v0 ad=0.44p pd=2.88u as=0.44p ps=2.88u w=1u l=1u
X19 a_76410_51130# Y VSS VSS nfet_06v0 ad=0.5p pd=2.5u as=0.88p ps=4.88u w=2u l=1u
X20 a_25666_58305# a_25666_58305# a_28322_63689# VSS nfet_06v0 ad=0.44p pd=2.88u as=0.25p ps=1.5u w=1u l=1u
X21 a_60222_4870# a_47282_11612# VSS VSS nfet_06v0 ad=0.25p pd=1.5u as=0.44p ps=2.88u w=1u l=1u
X22 a_2986_49609# a_2594_53077# a_3606_53193# VDD pfet_06v0 ad=4.4p pd=20.88u as=2.5p ps=10.5u w=10u l=1u
X23 a_8870_62775# a_3168_33300# VDD VDD pfet_06v0 ad=0.44p pd=2.88u as=0.44p ps=2.88u w=1u l=1u
X24 a_19718_62819# a_11746_58419# VDD VDD pfet_06v0 ad=4.4p pd=20.88u as=2.6p ps=10.52u w=10u l=1u
X25 VSS VDD VSS VSS nfet_06v0 ad=4.29p pd=20.38u as=1.23306n ps=6.04388m w=9.75u l=2u
X26 a_55770_53123# a_48510_49609# a_56438_49723# VSS nfet_06v0 ad=1.1p pd=5.88u as=0.65p ps=3.02u w=2.5u l=1u
X27 a_28742_16930# a_24994_16886# a_27650_24088# VDD pfet_06v0 ad=4.4p pd=20.88u as=4.4p ps=20.88u w=10u l=1u
X28 a_75022_28794# a_75022_28794# a_77530_28794# VSS nfet_06v0 ad=2.2p pd=10.88u as=1.65p ps=5.66u w=5u l=1u
X29 a_31470_70483# a_33254_67083# VSS VSS nfet_06v0 ad=0.65p pd=3.02u as=0.65p ps=3.02u w=2.5u l=1u
X30 a_5530_37596# a_5794_28794# VSS VSS nfet_06v0 ad=0.825p pd=3.16u as=1.1p ps=5.88u w=2.5u l=1u
X31 a_49242_49609# a_48850_53077# a_49862_53193# VDD pfet_06v0 ad=4.4p pd=20.88u as=2.5p ps=10.5u w=10u l=1u
X32 a_69582_16930# a_69382_16886# VDD VDD pfet_06v0 ad=2.5p pd=10.5u as=4.4p ps=20.88u w=10u l=1u
X33 VDD VSS VDD VDD pfet_06v0 ad=4.29p pd=20.38u as=0 ps=0 w=9.75u l=2u
X34 a_25194_11728# a_24994_11612# a_26006_11728# VDD pfet_06v0 ad=4.4p pd=20.88u as=2.5p ps=10.5u w=10u l=1u
X35 a_55770_70483# a_56438_67083# VSS VSS nfet_06v0 ad=0.65p pd=3.02u as=0.65p ps=3.02u w=2.5u l=1u
X36 a_72882_4826# a_69642_4826# a_72618_13628# VSS nfet_06v0 ad=1.1p pd=5.88u as=0.825p ps=3.16u w=2.5u l=1u
X37 a_24894_11728# a_24694_11612# VDD VDD pfet_06v0 ad=2.5p pd=10.5u as=4.4p ps=20.88u w=10u l=1u
X38 a_33254_49723# a_39182_54077# a_33702_54123# VDD pfet_06v0 ad=2.2p pd=10.88u as=2.2p ps=10.88u w=5u l=1u
X39 a_32586_41059# a_33254_45959# VSS VSS nfet_06v0 ad=0.65p pd=3.02u as=1.1p ps=5.88u w=2.5u l=1u
X40 a_48750_58349# a_48550_58305# VDD VDD pfet_06v0 ad=2.5p pd=10.5u as=4.4p ps=20.88u w=10u l=1u
X41 VSS a_56438_67083# a_54654_70483# VSS nfet_06v0 ad=0.65p pd=3.02u as=0.65p ps=3.02u w=2.5u l=1u
X42 a_72104_61958# a_72104_61958# a_74368_62110# VSS nfet_06v0 ad=0.308p pd=2.28u as=0.175p ps=1.2u w=0.7u l=1u
X43 a_76686_24788# a_69342_24672# VSS VSS nfet_06v0 ad=1.25p pd=5.5u as=2.2p ps=10.88u w=5u l=1u
X44 VDD a_33702_58419# a_32142_62819# VDD pfet_06v0 ad=1.3p pd=5.52u as=1.3p ps=5.52u w=5u l=1u
X45 a_25366_58305# a_25666_58305# a_27290_63689# VSS nfet_06v0 ad=0.44p pd=2.88u as=0.25p ps=1.5u w=1u l=1u
X46 VSS VDD VSS VSS nfet_06v0 ad=7.92p pd=36.88u as=0 ps=0 w=18u l=2u
X47 a_54286_24788# a_46942_24672# VSS VSS nfet_06v0 ad=1.25p pd=5.5u as=2.2p ps=10.88u w=5u l=1u
X48 a_3168_19326# a_18586_19776# VSS ppolyf_u_1k r_width=1u r_length=76.45u
X49 a_32142_49723# a_33702_54123# VDD VDD pfet_06v0 ad=1.3p pd=5.52u as=1.3p ps=5.52u w=5u l=1u
X50 a_57550_63319# a_62366_58305# a_58002_58419# VDD pfet_06v0 ad=2.2p pd=10.88u as=2.2p ps=10.88u w=5u l=1u
X51 a_32142_67083# a_33702_71483# VDD VDD pfet_06v0 ad=1.3p pd=5.52u as=2.2p ps=10.88u w=5u l=1u
X52 a_24654_28794# a_24994_35580# a_40542_35696# VDD pfet_06v0 ad=4.4p pd=20.88u as=2.5p ps=10.5u w=10u l=1u
X53 a_53210_40989# a_7758_45415# a_55770_41059# VDD pfet_06v0 ad=4.4p pd=20.88u as=2.6p ps=10.52u w=10u l=1u
X54 a_7934_4826# a_7934_4826# a_10442_4826# VSS nfet_06v0 ad=2.2p pd=10.88u as=1.65p ps=5.66u w=5u l=1u
X55 VDD a_56886_54123# a_54214_49723# VDD pfet_06v0 ad=1.3p pd=5.52u as=1.3p ps=5.52u w=5u l=1u
X56 VDD a_56886_58419# a_55326_62819# VDD pfet_06v0 ad=2.2p pd=10.88u as=1.3p ps=5.52u w=5u l=1u
X57 a_72618_37596# a_72882_28794# VSS VSS nfet_06v0 ad=0.825p pd=3.16u as=1.1p ps=5.88u w=2.5u l=1u
X58 a_3168_10682# a_7758_45415# VSS ppolyf_u_1k r_width=1u r_length=76.45u
X59 a_50218_37596# a_50482_28794# VSS VSS nfet_06v0 ad=0.825p pd=3.16u as=1.1p ps=5.88u w=2.5u l=1u
X60 a_52550_49653# a_49242_49609# VSS VSS nfet_06v0 ad=1.25p pd=5.5u as=2.2p ps=10.88u w=5u l=1u
X61 VDD VSS VDD VDD pfet_06v0 ad=0.44p pd=2.88u as=0 ps=0 w=1u l=2u
X62 a_42790_67083# a_34366_67083# VSS VSS nfet_06v0 ad=1.3p pd=5.52u as=2.2p ps=10.88u w=5u l=1u
X63 VSS a_19718_49723# a_88406_49640# VSS nfet_06v0 ad=0.44p pd=2.88u as=0.25p ps=1.5u w=1u l=1u
X64 a_9070_49723# a_2594_53077# a_10630_54123# VDD pfet_06v0 ad=2.2p pd=10.88u as=1.3p ps=5.52u w=5u l=1u
X65 a_70256_19326# a_85674_19776# VSS ppolyf_u_1k r_width=1u r_length=76.45u
X66 a_65646_58349# a_48550_58305# VDD VDD pfet_06v0 ad=2.5p pd=10.5u as=4.4p ps=20.88u w=10u l=1u
X67 a_30334_28794# a_24994_35580# a_35070_35696# VDD pfet_06v0 ad=4.4p pd=20.88u as=2.5p ps=10.5u w=10u l=1u
X68 a_33254_67083# a_25326_66969# a_32586_70483# VSS nfet_06v0 ad=0.65p pd=3.02u as=1.1p ps=5.88u w=2.5u l=1u
X69 a_69882_11728# a_69682_11612# a_70694_11728# VDD pfet_06v0 ad=4.4p pd=20.88u as=2.5p ps=10.5u w=10u l=1u
X70 a_2594_16886# a_2594_16886# a_15534_25588# VSS nfet_06v0 ad=0.44p pd=2.88u as=0.25p ps=1.5u w=1u l=1u
X71 a_72314_66956# a_65974_67083# VDD VDD pfet_06v0 ad=0.99p pd=3.66u as=1.32p ps=6.88u w=3u l=1u
X72 a_7758_62775# a_49206_24288# cap_mim_2f0_m4m5_noshield c_width=25u c_length=8u
X73 a_73254_51084# a_84634_49596# VDD VDD pfet_06v0 ad=1.32p pd=6.88u as=1.32p ps=6.88u w=3u l=1u
X74 a_24954_24672# a_24994_16886# a_39430_16930# VDD pfet_06v0 ad=4.4p pd=20.88u as=2.5p ps=10.5u w=10u l=1u
X75 a_8398_58419# a_10182_63319# VSS VSS nfet_06v0 ad=0.65p pd=3.02u as=0.65p ps=3.02u w=2.5u l=1u
X76 a_29998_67013# a_25326_66969# a_29666_67013# VSS nfet_06v0 ad=1.25p pd=5.5u as=1.65p ps=5.66u w=5u l=1u
X77 a_70256_10682# a_7758_49607# VSS ppolyf_u_1k r_width=1u r_length=76.45u
X78 a_2554_24672# a_2594_16886# a_17030_16930# VDD pfet_06v0 ad=4.4p pd=20.88u as=2.5p ps=10.5u w=10u l=1u
X79 a_54214_67083# a_48850_70437# a_58002_71483# VDD pfet_06v0 ad=2.2p pd=10.88u as=1.3p ps=5.52u w=5u l=1u
X80 a_4218_46329# a_2594_40945# VSS VSS nfet_06v0 ad=0.25p pd=1.5u as=0.44p ps=2.88u w=1u l=1u
X81 a_26058_62773# a_25326_63573# a_26258_62889# VSS nfet_06v0 ad=2.2p pd=10.88u as=1.25p ps=5.5u w=5u l=1u
X82 a_24694_11612# a_24994_11612# a_36902_4870# VSS nfet_06v0 ad=0.44p pd=2.88u as=0.25p ps=1.5u w=1u l=1u
X83 a_85566_60230# a_83814_60230# a_84634_60114# VSS nfet_06v0 ad=0.25p pd=1.5u as=0.44p ps=2.88u w=1u l=1u
X84 a_78314_35696# a_78114_35580# VDD VDD pfet_06v0 ad=2.5p pd=10.5u as=4.4p ps=20.88u w=10u l=1u
X85 VSS a_87474_49596# a_73254_43142# VSS nfet_06v0 ad=0.44p pd=2.88u as=0.44p ps=2.88u w=1u l=1u
X86 ZN a_75388_58336# VSS VSS nfet_05v0 ad=0.5808p pd=3.52u as=0.5808p ps=3.52u w=1.32u l=0.6u
X87 VSS VDD VSS VSS nfet_06v0 ad=0.44p pd=2.88u as=0 ps=0 w=1u l=2u
X88 a_9598_4870# a_2254_4826# VSS VSS nfet_06v0 ad=1.25p pd=5.5u as=2.2p ps=10.88u w=5u l=1u
X89 a_52622_25272# a_52622_25272# a_55130_24672# VSS nfet_06v0 ad=2.2p pd=10.88u as=1.65p ps=5.66u w=5u l=1u
X90 a_69642_28794# a_69682_35580# a_84118_35696# VDD pfet_06v0 ad=4.4p pd=20.88u as=2.5p ps=10.5u w=10u l=1u
X91 a_11746_71483# a_2594_70437# a_7958_67083# VDD pfet_06v0 ad=1.3p pd=5.52u as=2.2p ps=10.88u w=5u l=1u
X92 VDD a_58002_41059# a_65974_45459# VDD pfet_06v0 ad=2.6p pd=10.52u as=2.6p ps=10.52u w=10u l=1u
X93 a_48750_40989# a_48550_40945# VDD VDD pfet_06v0 ad=2.5p pd=10.5u as=4.4p ps=20.88u w=10u l=1u
X94 a_25566_53193# a_25366_53077# VDD VDD pfet_06v0 ad=2.5p pd=10.5u as=4.4p ps=20.88u w=10u l=1u
X95 a_25366_58305# a_25666_58305# a_28602_58349# VDD pfet_06v0 ad=4.4p pd=20.88u as=2.5p ps=10.5u w=10u l=1u
X96 a_8398_58419# a_7758_62775# a_6954_58349# VDD pfet_06v0 ad=2.6p pd=10.52u as=4.4p ps=20.88u w=10u l=1u
X97 VDD VSS VDD VDD pfet_06v0 ad=0.44p pd=2.88u as=0 ps=0 w=1u l=2u
X98 VDD a_10630_58419# a_7958_62819# VDD pfet_06v0 ad=1.3p pd=5.52u as=1.3p ps=5.52u w=5u l=1u
X99 a_4218_49653# a_2594_53077# VSS VSS nfet_06v0 ad=0.25p pd=1.5u as=0.44p ps=2.88u w=1u l=1u
X100 a_55326_62819# a_56886_58419# VDD VDD pfet_06v0 ad=1.3p pd=5.52u as=2.2p ps=10.88u w=5u l=1u
X101 a_8870_66967# a_74490_28838# VSS VSS nfet_06v0 ad=0.44p pd=2.88u as=0.44p ps=2.88u w=1u l=1u
X102 a_73166_51200# a_73254_51084# Y VSS nfet_06v0 ad=1.0912p pd=5.84u as=0.6448p ps=3u w=2.48u l=1u
X103 a_57550_45959# a_62366_40945# a_58002_41059# VDD pfet_06v0 ad=2.2p pd=10.88u as=2.2p ps=10.88u w=5u l=1u
X104 VSS VDD VSS VSS nfet_06v0 ad=7.92p pd=36.88u as=0 ps=0 w=18u l=2u
X105 VDD VSS VDD VDD pfet_06v0 ad=4.29p pd=20.38u as=0 ps=0 w=9.75u l=2u
X106 a_82622_28838# a_69682_35580# VSS VSS nfet_06v0 ad=0.25p pd=1.5u as=0.44p ps=2.88u w=1u l=1u
X107 a_30830_66967# a_52090_28838# VSS VSS nfet_06v0 ad=0.44p pd=2.88u as=0.44p ps=2.88u w=1u l=1u
X108 a_42790_62819# a_34818_58419# VDD VDD pfet_06v0 ad=4.4p pd=20.88u as=2.6p ps=10.52u w=10u l=1u
X109 a_60222_28838# a_47282_35580# VSS VSS nfet_06v0 ad=0.25p pd=1.5u as=0.44p ps=2.88u w=1u l=1u
X110 a_31030_67083# a_30830_66967# a_29666_67013# VSS nfet_06v0 ad=1.3p pd=5.52u as=2.2p ps=10.88u w=5u l=1u
X111 a_6654_70553# a_2294_70437# VDD VDD pfet_06v0 ad=2.5p pd=10.5u as=4.4p ps=20.88u w=10u l=1u
X112 a_54654_53123# a_48510_49609# a_57550_49723# VSS nfet_06v0 ad=1.1p pd=5.88u as=0.65p ps=3.02u w=2.5u l=1u
X113 a_2794_35696# a_2594_35580# a_3606_35696# VDD pfet_06v0 ad=4.4p pd=20.88u as=2.5p ps=10.5u w=10u l=1u
X114 a_3606_58349# a_2294_58305# VDD VDD pfet_06v0 ad=2.5p pd=10.5u as=4.4p ps=20.88u w=10u l=1u
X115 a_65646_40989# a_48550_40945# VDD VDD pfet_06v0 ad=2.5p pd=10.5u as=4.4p ps=20.88u w=10u l=1u
X116 VSS a_10182_45959# a_8398_41059# VSS nfet_06v0 ad=1.1p pd=5.88u as=0.65p ps=3.02u w=2.5u l=1u
X117 a_9514_41059# a_8870_45415# a_6954_40989# VDD pfet_06v0 ad=2.6p pd=10.52u as=4.4p ps=20.88u w=10u l=1u
X118 a_81590_28838# a_69682_35580# VSS VSS nfet_06v0 ad=0.25p pd=1.5u as=0.44p ps=2.88u w=1u l=1u
X119 a_48294_16930# a_46982_16886# VDD VDD pfet_06v0 ad=2.5p pd=10.5u as=4.4p ps=20.88u w=10u l=1u
X120 VSS VDD VSS VSS nfet_06v0 ad=0.44p pd=2.88u as=0 ps=0 w=1u l=2u
X121 a_86922_40946# a_65974_45459# a_77242_60502# VDD pfet_06v0 ad=0.75p pd=3.5u as=1.32p ps=6.88u w=3u l=1u
X122 a_18354_49653# a_18154_49609# VSS VSS nfet_06v0 ad=1.25p pd=5.5u as=2.2p ps=10.88u w=5u l=1u
X123 VDD VSS VDD VDD pfet_06v0 ad=4.29p pd=20.38u as=0 ps=0 w=9.75u l=2u
X124 a_49862_58349# a_48550_58305# VDD VDD pfet_06v0 ad=2.5p pd=10.5u as=4.4p ps=20.88u w=10u l=1u
X125 a_5794_25172# a_2554_24672# a_5530_16930# VSS nfet_06v0 ad=1.1p pd=5.88u as=0.825p ps=3.16u w=2.5u l=1u
X126 a_19718_49723# a_11294_49723# VSS VSS nfet_06v0 ad=1.3p pd=5.52u as=2.2p ps=10.88u w=5u l=1u
X127 a_6342_11728# a_2594_11612# a_5250_4870# VDD pfet_06v0 ad=4.4p pd=20.88u as=4.4p ps=20.88u w=10u l=1u
X128 VDD VSS VDD VDD pfet_06v0 ad=0.44p pd=2.88u as=0 ps=0 w=1u l=2u
X129 a_72618_13628# a_72882_4826# VSS VSS nfet_06v0 ad=0.825p pd=3.16u as=1.1p ps=5.88u w=2.5u l=1u
X130 a_64610_49653# a_64410_49609# VSS VSS nfet_06v0 ad=1.25p pd=5.5u as=2.2p ps=10.88u w=5u l=1u
X131 a_65974_62819# a_57550_63319# VSS VSS nfet_06v0 ad=2.2p pd=10.88u as=1.3p ps=5.52u w=5u l=1u
X132 a_77242_60502# a_65974_45459# VSS VSS nfet_06v0 ad=0.33p pd=1.66u as=0.44p ps=2.88u w=1u l=1u
X133 a_7286_70553# a_2594_70437# a_6954_70553# VDD pfet_06v0 ad=2.5p pd=10.5u as=3.3p ps=10.66u w=10u l=1u
X134 a_78114_11612# a_69682_11612# a_78314_11728# VDD pfet_06v0 ad=3.3p pd=10.66u as=2.5p ps=10.5u w=10u l=1u
X135 a_12006_25588# a_7402_25288# VSS VSS nfet_06v0 ad=0.44p pd=2.88u as=0.44p ps=2.88u w=1u l=1u
X136 a_55714_11612# a_47282_11612# a_55914_11728# VDD pfet_06v0 ad=3.3p pd=10.66u as=2.5p ps=10.5u w=10u l=1u
X137 VDD a_10630_41059# a_7958_45459# VDD pfet_06v0 ad=2.2p pd=10.88u as=1.3p ps=5.52u w=5u l=1u
X138 a_87154_16930# a_69382_16886# VDD VDD pfet_06v0 ad=2.5p pd=10.5u as=4.4p ps=20.88u w=10u l=1u
X139 a_25366_40945# a_25666_40945# a_28602_40989# VDD pfet_06v0 ad=4.4p pd=20.88u as=2.5p ps=10.5u w=10u l=1u
X140 Z Z VDD VDD pfet_06v0 ad=0.52p pd=2.52u as=0.88p ps=4.88u w=2u l=1u
X141 a_42790_45459# a_31030_45459# cap_mim_2f0_m4m5_noshield c_width=20u c_length=10u
X142 a_69342_4826# a_69642_4826# a_80558_4870# VSS nfet_06v0 ad=2.2p pd=10.88u as=1.25p ps=5.5u w=5u l=1u
X143 a_72882_25172# a_69642_24672# a_72618_16930# VSS nfet_06v0 ad=1.1p pd=5.88u as=0.825p ps=3.16u w=2.5u l=1u
X144 a_73430_11728# a_69682_11612# a_72338_4870# VDD pfet_06v0 ad=4.4p pd=20.88u as=4.4p ps=20.88u w=10u l=1u
X145 a_3486_24788# a_2254_24672# VSS VSS nfet_06v0 ad=1.25p pd=5.5u as=2.2p ps=10.88u w=5u l=1u
X146 VDD a_56886_41059# a_54214_45459# VDD pfet_06v0 ad=2.2p pd=10.88u as=1.3p ps=5.52u w=5u l=1u
X147 a_64754_16930# a_46982_16886# VDD VDD pfet_06v0 ad=2.5p pd=10.5u as=4.4p ps=20.88u w=10u l=1u
X148 a_27650_24088# a_28742_16930# VDD VDD pfet_06v0 ad=2.2p pd=10.88u as=2.2p ps=10.88u w=5u l=1u
X149 a_34366_67083# a_25326_66969# a_31470_70483# VSS nfet_06v0 ad=0.65p pd=3.02u as=1.1p ps=5.88u w=2.5u l=1u
X150 a_2594_35580# a_2594_35580# VDD VDD pfet_06v0 ad=0.88p pd=4.88u as=0.88p ps=4.88u w=2u l=1u
X151 a_51786_53193# a_48550_53077# VDD VDD pfet_06v0 ad=2.5p pd=10.5u as=4.4p ps=20.88u w=10u l=1u
X152 VSS a_26058_66969# a_29998_67013# VSS nfet_06v0 ad=2.2p pd=10.88u as=1.25p ps=5.5u w=5u l=1u
X153 a_9514_41059# a_2254_46213# a_10182_45959# VSS nfet_06v0 ad=1.1p pd=5.88u as=0.65p ps=3.02u w=2.5u l=1u
X154 a_75388_58336# Z VDD VDD pfet_05v0 ad=0.8052p pd=4.54u as=0.8052p ps=4.54u w=1.83u l=0.5u
X155 a_75010_43282# X X VSS nfet_06v0 ad=0.88p pd=4.88u as=0.52p ps=2.52u w=2u l=1u
X156 a_61902_49609# a_61902_49609# a_64410_49609# VSS nfet_06v0 ad=2.2p pd=10.88u as=1.65p ps=5.66u w=5u l=1u
X157 a_72338_28838# S2N a_69842_28838# VSS nfet_06v0 ad=3.74p pd=17.88u as=3.74p ps=17.88u w=8.5u l=1u
X158 a_34818_41059# a_25666_40945# a_31030_45459# VDD pfet_06v0 ad=1.3p pd=5.52u as=2.2p ps=10.88u w=5u l=1u
X159 a_69682_11612# a_69682_11612# a_82622_4870# VSS nfet_06v0 ad=0.44p pd=2.88u as=0.25p ps=1.5u w=1u l=1u
X160 a_2254_66969# a_2594_70437# a_2494_70553# VDD pfet_06v0 ad=4.4p pd=20.88u as=2.5p ps=10.5u w=10u l=1u
X161 a_9514_70483# a_10182_67083# VSS VSS nfet_06v0 ad=0.65p pd=3.02u as=1.1p ps=5.88u w=2.5u l=1u
X162 a_2254_24672# a_2594_16886# a_18142_16930# VDD pfet_06v0 ad=4.4p pd=20.88u as=2.5p ps=10.5u w=10u l=1u
X163 VSS VDD VSS VSS nfet_06v0 ad=7.92p pd=36.88u as=0 ps=0 w=18u l=2u
X164 a_35870_24788# a_24654_24672# VSS VSS nfet_06v0 ad=1.25p pd=5.5u as=2.2p ps=10.88u w=5u l=1u
X165 a_7758_62775# a_47856_21126# VDD VDD pfet_06v0 ad=0.44p pd=2.88u as=0.44p ps=2.88u w=1u l=1u
X166 VSS VDD VSS VSS nfet_06v0 ad=7.92p pd=36.88u as=0 ps=0 w=18u l=2u
X167 a_13470_24788# a_2254_24672# VSS VSS nfet_06v0 ad=1.25p pd=5.5u as=2.2p ps=10.88u w=5u l=1u
X168 a_70574_24788# a_69342_24672# VSS VSS nfet_06v0 ad=1.25p pd=5.5u as=2.2p ps=10.88u w=5u l=1u
X169 a_3606_40989# a_2294_40945# VDD VDD pfet_06v0 ad=2.5p pd=10.5u as=4.4p ps=20.88u w=10u l=1u
X170 a_16110_58305# a_2254_63573# a_17310_62889# VSS nfet_06v0 ad=2.2p pd=10.88u as=1.25p ps=5.5u w=5u l=1u
X171 a_6594_62889# a_2254_63573# a_6294_62889# VSS nfet_06v0 ad=1.65p pd=5.66u as=1.25p ps=5.5u w=5u l=1u
X172 VSS VDD VSS VSS nfet_06v0 ad=4.29p pd=20.38u as=0 ps=0 w=9.75u l=2u
X173 a_19718_45459# a_11746_41059# VDD VDD pfet_06v0 ad=4.4p pd=20.88u as=2.6p ps=10.52u w=10u l=1u
X174 a_70256_33300# a_69682_35580# a_71606_28838# VDD pfet_06v0 ad=4.4p pd=20.88u as=4.4p ps=20.88u w=10u l=1u
X175 VSS a_11294_67083# a_19718_67083# VSS nfet_06v0 ad=1.3p pd=5.52u as=1.3p ps=5.52u w=5u l=1u
X176 a_69542_28838# a_69342_28794# VSS VSS nfet_06v0 ad=1.25p pd=5.5u as=2.2p ps=10.88u w=5u l=1u
X177 a_49862_40989# a_48550_40945# VDD VDD pfet_06v0 ad=2.5p pd=10.5u as=4.4p ps=20.88u w=10u l=1u
X178 a_26678_53193# a_25366_53077# VDD VDD pfet_06v0 ad=2.5p pd=10.5u as=4.4p ps=20.88u w=10u l=1u
X179 a_27930_16930# a_28194_25172# VSS VSS nfet_06v0 ad=0.825p pd=3.16u as=1.1p ps=5.88u w=2.5u l=1u
X180 a_9598_28838# a_2254_28794# VSS VSS nfet_06v0 ad=1.25p pd=5.5u as=2.2p ps=10.88u w=5u l=1u
X181 a_75388_53540# Y VSS VSS nfet_05v0 ad=0.5808p pd=3.52u as=0.5808p ps=3.52u w=1.32u l=0.6u
X182 a_29802_28838# a_31790_36780# a_25568_33300# VDD pfet_06v0 ad=1.76p pd=8.88u as=1.76p ps=8.88u w=4u l=1u
X183 a_71806_13618# a_72882_4826# VSS VSS nfet_06v0 ad=0.825p pd=3.16u as=1.1p ps=5.88u w=2.5u l=1u
X184 VSS VDD VSS VSS nfet_06v0 ad=4.29p pd=20.38u as=0 ps=0 w=9.75u l=2u
X185 a_7402_28838# a_9390_36780# a_3168_33300# VDD pfet_06v0 ad=1.76p pd=8.88u as=1.76p ps=8.88u w=4u l=1u
X186 a_4518_4870# a_6342_11728# VDD VDD pfet_06v0 ad=2.2p pd=10.88u as=2.2p ps=10.88u w=5u l=1u
X187 VDD a_33702_41059# a_32142_45459# VDD pfet_06v0 ad=1.3p pd=5.52u as=1.3p ps=5.52u w=5u l=1u
X188 VSS VDD VSS VSS nfet_06v0 ad=4.29p pd=20.38u as=0 ps=0 w=9.75u l=2u
X189 a_26006_35696# a_24694_35580# VDD VDD pfet_06v0 ad=2.5p pd=10.5u as=4.4p ps=20.88u w=10u l=1u
X190 a_86922_58418# a_65974_62819# a_79086_60502# VDD pfet_06v0 ad=0.75p pd=3.5u as=1.32p ps=6.88u w=3u l=1u
X191 ZP ZN VDD VDD pfet_05v0 ad=0.8052p pd=4.54u as=0.8052p ps=4.54u w=1.83u l=0.5u
X192 VSS a_33254_67083# a_32586_70483# VSS nfet_06v0 ad=1.1p pd=5.88u as=0.65p ps=3.02u w=2.5u l=1u
X193 a_33042_24788# a_32842_24672# VSS VSS nfet_06v0 ad=1.25p pd=5.5u as=2.2p ps=10.88u w=5u l=1u
X194 a_32142_67083# a_8870_66967# a_29666_67013# VSS nfet_06v0 ad=1.3p pd=5.52u as=2.2p ps=10.88u w=5u l=1u
X195 a_11294_63319# a_2254_63573# a_8398_58419# VSS nfet_06v0 ad=0.65p pd=3.02u as=1.1p ps=5.88u w=2.5u l=1u
X196 a_73768_49992# a_72104_49876# VSS VSS nfet_06v0 ad=0.175p pd=1.2u as=0.308p ps=2.28u w=0.7u l=1u
X197 a_28322_67013# a_25666_70437# VSS VSS nfet_06v0 ad=0.25p pd=1.5u as=0.44p ps=2.88u w=1u l=1u
X198 a_10642_24788# a_10442_24672# VSS VSS nfet_06v0 ad=1.25p pd=5.5u as=2.2p ps=10.88u w=5u l=1u
X199 a_76686_28838# a_69342_28794# VSS VSS nfet_06v0 ad=1.25p pd=5.5u as=2.2p ps=10.88u w=5u l=1u
X200 VDD a_56886_41059# a_55326_45459# VDD pfet_06v0 ad=2.2p pd=10.88u as=1.3p ps=5.52u w=5u l=1u
X201 VSS a_56438_49723# a_55770_53123# VSS nfet_06v0 ad=0.65p pd=3.02u as=0.65p ps=3.02u w=2.5u l=1u
X202 a_72054_60546# a_72142_60502# Z VSS nfet_06v0 ad=1.0912p pd=5.84u as=0.6448p ps=3u w=2.48u l=1u
X203 a_6954_58349# a_2594_58305# a_6654_58349# VDD pfet_06v0 ad=3.3p pd=10.66u as=2.5p ps=10.5u w=10u l=1u
X204 a_38718_63273# a_38718_63273# a_41226_62773# VSS nfet_06v0 ad=2.2p pd=10.88u as=1.65p ps=5.66u w=5u l=1u
X205 VSS a_10182_67083# a_8398_70483# VSS nfet_06v0 ad=0.65p pd=3.02u as=0.65p ps=3.02u w=2.5u l=1u
X206 a_54286_28838# a_46942_28794# VSS VSS nfet_06v0 ad=1.25p pd=5.5u as=2.2p ps=10.88u w=5u l=1u
X207 a_41226_66969# a_25326_66969# a_41426_67013# VSS nfet_06v0 ad=1.65p pd=5.66u as=1.25p ps=5.5u w=5u l=1u
X208 a_2594_58305# a_2594_58305# VDD VDD pfet_06v0 ad=0.88p pd=4.88u as=0.88p ps=4.88u w=2u l=1u
X209 a_27650_4870# S3N a_25154_4870# VSS nfet_06v0 ad=3.74p pd=17.88u as=3.74p ps=17.88u w=8.5u l=1u
X210 a_75010_51200# Y Y VSS nfet_06v0 ad=0.88p pd=4.88u as=0.52p ps=2.52u w=2u l=1u
X211 a_32142_67083# a_25666_70437# a_33702_71483# VDD pfet_06v0 ad=2.2p pd=10.88u as=1.3p ps=5.52u w=5u l=1u
X212 a_71606_4870# a_73430_11728# VDD VDD pfet_06v0 ad=2.2p pd=10.88u as=2.2p ps=10.88u w=5u l=1u
X213 a_75388_40976# X VDD VDD pfet_05v0 ad=0.8052p pd=4.54u as=0.8052p ps=4.54u w=1.83u l=0.5u
X214 a_77242_43142# a_87474_42642# VDD VDD pfet_06v0 ad=1.32p pd=6.88u as=1.32p ps=6.88u w=3u l=1u
X215 a_53210_53193# a_12006_25588# a_54654_53123# VDD pfet_06v0 ad=4.4p pd=20.88u as=2.6p ps=10.52u w=10u l=1u
X216 a_49206_4870# a_51030_11728# VDD VDD pfet_06v0 ad=2.2p pd=10.88u as=2.2p ps=10.88u w=5u l=1u
X217 VDD Z Z VDD pfet_06v0 ad=0.88p pd=4.88u as=0.52p ps=2.52u w=2u l=1u
X218 VDD VSS VDD VDD pfet_06v0 ad=7.92p pd=36.88u as=0 ps=0 w=18u l=2u
X219 VDD a_48550_53077# a_53542_53193# VDD pfet_06v0 ad=4.4p pd=20.88u as=2.5p ps=10.5u w=10u l=1u
X220 a_27290_67013# a_25666_70437# VSS VSS nfet_06v0 ad=0.25p pd=1.5u as=0.44p ps=2.88u w=1u l=1u
X221 a_85230_35696# a_69382_35580# VDD VDD pfet_06v0 ad=2.5p pd=10.5u as=4.4p ps=20.88u w=10u l=1u
X222 a_47856_9332# a_63274_9332# VSS ppolyf_u_1k r_width=1u r_length=76.45u
X223 a_30334_25272# a_30334_25272# a_32842_24672# VSS nfet_06v0 ad=2.2p pd=10.88u as=1.65p ps=5.66u w=5u l=1u
X224 X a_72142_43142# a_72054_43186# VSS nfet_06v0 ad=0.6448p pd=3u as=1.0912p ps=5.84u w=2.48u l=1u
X225 a_7934_25272# a_7934_25272# a_10442_24672# VSS nfet_06v0 ad=2.2p pd=10.88u as=1.65p ps=5.66u w=5u l=1u
X226 VSS a_84634_60114# a_79086_51084# VSS nfet_06v0 ad=0.44p pd=2.88u as=0.44p ps=2.88u w=1u l=1u
X227 VDD VSS VDD VDD pfet_06v0 ad=0.44p pd=2.88u as=0 ps=0 w=1u l=2u
X228 VSS VDD VSS VSS nfet_06v0 ad=0.44p pd=2.88u as=0 ps=0 w=1u l=2u
X229 VDD a_2294_58305# a_7286_58349# VDD pfet_06v0 ad=4.4p pd=20.88u as=2.5p ps=10.5u w=10u l=1u
X230 VSS a_42790_49723# a_73254_60502# VSS nfet_06v0 ad=0.44p pd=2.88u as=0.33p ps=1.66u w=1u l=1u
X231 VSS a_56438_63319# a_54654_58419# VSS nfet_06v0 ad=1.1p pd=5.88u as=0.65p ps=3.02u w=2.5u l=1u
X232 a_40818_58305# a_25666_58305# a_41018_58349# VDD pfet_06v0 ad=3.3p pd=10.66u as=2.5p ps=10.5u w=10u l=1u
X233 a_6954_70553# a_7758_66967# a_8398_70483# VDD pfet_06v0 ad=4.4p pd=20.88u as=2.6p ps=10.52u w=10u l=1u
X234 a_54078_12812# a_47242_4826# a_54286_4870# VSS nfet_06v0 ad=2.2p pd=10.88u as=1.25p ps=5.5u w=5u l=1u
X235 a_2294_53077# a_2594_53077# a_5530_53193# VDD pfet_06v0 ad=4.4p pd=20.88u as=2.5p ps=10.5u w=10u l=1u
X236 a_47142_24788# a_46942_24672# VSS VSS nfet_06v0 ad=1.25p pd=5.5u as=2.2p ps=10.88u w=5u l=1u
X237 a_32586_70483# a_33254_67083# VSS VSS nfet_06v0 ad=0.65p pd=3.02u as=1.1p ps=5.88u w=2.5u l=1u
X238 VDD a_33702_58419# a_31030_62819# VDD pfet_06v0 ad=2.2p pd=10.88u as=1.3p ps=5.52u w=5u l=1u
X239 VSS VDD VSS VSS nfet_06v0 ad=4.29p pd=20.38u as=0 ps=0 w=9.75u l=2u
X240 a_8398_41059# a_2254_46213# a_11294_45959# VSS nfet_06v0 ad=1.1p pd=5.88u as=0.65p ps=3.02u w=2.5u l=1u
X241 VDD a_10630_41059# a_7958_45459# VDD pfet_06v0 ad=1.3p pd=5.52u as=1.3p ps=5.52u w=5u l=1u
X242 a_8398_41059# a_7758_45415# a_6954_40989# VDD pfet_06v0 ad=2.6p pd=10.52u as=4.4p ps=20.88u w=10u l=1u
X243 a_2254_46213# a_2254_46213# VSS VSS nfet_06v0 ad=0.44p pd=2.88u as=0.44p ps=2.88u w=1u l=1u
X244 XP XN VDD VDD pfet_05v0 ad=0.8052p pd=4.54u as=0.8052p ps=4.54u w=1.83u l=0.5u
X245 a_55326_45459# a_56886_41059# VDD VDD pfet_06v0 ad=1.3p pd=5.52u as=2.2p ps=10.88u w=5u l=1u
X246 a_39430_11728# a_24694_11612# VDD VDD pfet_06v0 ad=2.5p pd=10.5u as=4.4p ps=20.88u w=10u l=1u
X247 a_15534_4870# a_2594_11612# VSS VSS nfet_06v0 ad=0.25p pd=1.5u as=0.44p ps=2.88u w=1u l=1u
X248 a_52622_28794# a_52622_28794# a_55130_28794# VSS nfet_06v0 ad=2.2p pd=10.88u as=1.65p ps=5.66u w=5u l=1u
X249 a_42790_45459# a_34818_41059# VDD VDD pfet_06v0 ad=4.4p pd=20.88u as=2.6p ps=10.52u w=10u l=1u
X250 a_49242_49609# a_48510_49609# a_49442_49653# VSS nfet_06v0 ad=2.2p pd=10.88u as=1.25p ps=5.5u w=5u l=1u
X251 a_47182_16930# a_46982_16886# VDD VDD pfet_06v0 ad=2.5p pd=10.5u as=4.4p ps=20.88u w=10u l=1u
X252 a_6954_40989# a_2594_40945# a_6654_40989# VDD pfet_06v0 ad=3.3p pd=10.66u as=2.5p ps=10.5u w=10u l=1u
X253 a_8870_45415# a_47856_9332# VDD VDD pfet_06v0 ad=0.44p pd=2.88u as=0.44p ps=2.88u w=1u l=1u
X254 a_6926_45529# a_2254_46213# a_6594_45529# VSS nfet_06v0 ad=1.25p pd=5.5u as=1.65p ps=5.66u w=5u l=1u
X255 a_29666_49653# a_25326_49609# a_29366_49653# VSS nfet_06v0 ad=1.65p pd=5.66u as=1.25p ps=5.5u w=5u l=1u
X256 a_31470_53123# a_12006_25588# a_30026_53193# VDD pfet_06v0 ad=2.6p pd=10.52u as=4.4p ps=20.88u w=10u l=1u
X257 a_40382_45529# a_26058_45413# VSS VSS nfet_06v0 ad=1.25p pd=5.5u as=2.2p ps=10.88u w=5u l=1u
X258 a_2594_40945# a_2594_40945# VDD VDD pfet_06v0 ad=0.88p pd=4.88u as=0.88p ps=4.88u w=2u l=1u
X259 a_52550_62889# a_49242_62773# VSS VSS nfet_06v0 ad=1.25p pd=5.5u as=2.2p ps=10.88u w=5u l=1u
X260 VDD VSS VDD VDD pfet_06v0 ad=4.29p pd=20.38u as=0 ps=0 w=9.75u l=2u
X261 a_28194_4826# a_24954_4826# a_27930_13628# VSS nfet_06v0 ad=1.1p pd=5.88u as=0.825p ps=3.16u w=2.5u l=1u
X262 a_5250_63689# a_2594_58305# VSS VSS nfet_06v0 ad=0.25p pd=1.5u as=0.44p ps=2.88u w=1u l=1u
X263 a_69842_4870# a_69642_4826# a_69542_4870# VSS nfet_06v0 ad=2.2p pd=10.88u as=1.25p ps=5.5u w=5u l=1u
X264 a_2254_49609# a_2254_49609# VSS VSS nfet_06v0 ad=0.44p pd=2.88u as=0.44p ps=2.88u w=1u l=1u
X265 a_47856_34650# a_63274_34200# VSS ppolyf_u_1k r_width=1u r_length=76.45u
X266 a_70256_9332# a_85674_9332# VSS ppolyf_u_1k r_width=1u r_length=76.45u
X267 a_25154_4870# a_24954_4826# a_24854_4870# VSS nfet_06v0 ad=2.2p pd=10.88u as=1.25p ps=5.5u w=5u l=1u
X268 Y Y VDD VDD pfet_06v0 ad=0.52p pd=2.52u as=0.52p ps=2.52u w=2u l=1u
X269 VDD VSS VDD VDD pfet_06v0 ad=0.44p pd=2.88u as=0 ps=0 w=1u l=2u
X270 a_72304_49992# a_72104_49876# VSS VSS nfet_06v0 ad=0.5456p pd=3.36u as=0.5456p ps=3.36u w=1.24u l=1u
X271 a_69342_4826# a_69682_11612# a_85230_11728# VDD pfet_06v0 ad=4.4p pd=20.88u as=2.5p ps=10.5u w=10u l=1u
X272 a_73430_35696# a_75022_28794# a_72882_28794# VSS nfet_06v0 ad=0.88p pd=4.88u as=0.88p ps=4.88u w=2u l=1u
X273 a_2454_4870# a_2254_4826# VSS VSS nfet_06v0 ad=1.25p pd=5.5u as=2.2p ps=10.88u w=5u l=1u
X274 a_79086_43142# a_87474_60114# VDD VDD pfet_06v0 ad=1.32p pd=6.88u as=1.32p ps=6.88u w=3u l=1u
X275 VDD a_2294_40945# a_7286_40989# VDD pfet_06v0 ad=4.4p pd=20.88u as=2.5p ps=10.5u w=10u l=1u
X276 a_30830_66967# a_47856_33300# VDD VDD pfet_06v0 ad=0.44p pd=2.88u as=0.44p ps=2.88u w=1u l=1u
X277 a_65974_67083# a_58002_71483# VDD VDD pfet_06v0 ad=2.6p pd=10.52u as=4.4p ps=20.88u w=10u l=1u
X278 a_42466_16930# a_24694_16886# VDD VDD pfet_06v0 ad=2.5p pd=10.5u as=4.4p ps=20.88u w=10u l=1u
X279 a_46982_11612# a_47282_11612# a_59190_4870# VSS nfet_06v0 ad=0.44p pd=2.88u as=0.25p ps=1.5u w=1u l=1u
X280 a_40818_40945# a_25666_40945# a_41018_40989# VDD pfet_06v0 ad=3.3p pd=10.66u as=2.5p ps=10.5u w=10u l=1u
X281 a_9514_53123# a_10182_49723# VSS VSS nfet_06v0 ad=0.65p pd=3.02u as=0.65p ps=3.02u w=2.5u l=1u
X282 a_65974_49723# a_58002_54123# VDD VDD pfet_06v0 ad=4.4p pd=20.88u as=2.6p ps=10.52u w=10u l=1u
X283 VDD VSS VDD VDD pfet_06v0 ad=7.92p pd=36.88u as=0 ps=0 w=18u l=2u
X284 a_7934_28794# a_2594_35580# a_12670_35696# VDD pfet_06v0 ad=4.4p pd=20.88u as=2.5p ps=10.5u w=10u l=1u
X285 VSS a_57550_49723# a_65974_49723# VSS nfet_06v0 ad=1.3p pd=5.52u as=1.3p ps=5.52u w=5u l=1u
X286 VSS a_75154_66956# a_72142_43142# VSS nfet_06v0 ad=0.44p pd=2.88u as=0.44p ps=2.88u w=1u l=1u
X287 a_52910_58349# a_48550_58305# VDD VDD pfet_06v0 ad=2.5p pd=10.5u as=4.4p ps=20.88u w=10u l=1u
X288 a_31030_62819# a_33702_58419# VDD VDD pfet_06v0 ad=1.3p pd=5.52u as=2.2p ps=10.88u w=5u l=1u
X289 a_73166_60546# a_73254_60502# Z VSS nfet_06v0 ad=1.0912p pd=5.84u as=0.6448p ps=3u w=2.48u l=1u
X290 a_4518_28838# S1P a_2754_28838# VSS nfet_06v0 ad=3.3p pd=15.88u as=3.3p ps=15.88u w=7.5u l=1u
X291 a_25568_9332# a_24994_11612# a_26918_4870# VDD pfet_06v0 ad=4.4p pd=20.88u as=4.4p ps=20.88u w=10u l=1u
X292 a_6594_49653# a_7758_49607# a_7958_49723# VSS nfet_06v0 ad=2.2p pd=10.88u as=1.3p ps=5.52u w=5u l=1u
X293 VDD a_33702_54123# a_31030_49723# VDD pfet_06v0 ad=1.3p pd=5.52u as=1.3p ps=5.52u w=5u l=1u
X294 X X VDD VDD pfet_06v0 ad=0.52p pd=2.52u as=0.88p ps=4.88u w=2u l=1u
X295 a_52850_45529# a_7758_45415# a_55326_45459# VSS nfet_06v0 ad=2.2p pd=10.88u as=1.3p ps=5.52u w=5u l=1u
X296 a_2754_24788# a_2554_24672# a_2454_24788# VSS nfet_06v0 ad=2.2p pd=10.88u as=1.25p ps=5.5u w=5u l=1u
X297 a_55914_35696# a_55714_35580# VDD VDD pfet_06v0 ad=2.5p pd=10.5u as=4.4p ps=20.88u w=10u l=1u
X298 a_53182_49653# a_48510_49609# a_52850_49653# VSS nfet_06v0 ad=1.25p pd=5.5u as=1.65p ps=5.66u w=5u l=1u
X299 VSS VDD VSS VSS nfet_06v0 ad=4.29p pd=20.38u as=0 ps=0 w=9.75u l=2u
X300 a_36902_28838# a_24994_35580# VSS VSS nfet_06v0 ad=0.25p pd=1.5u as=0.44p ps=2.88u w=1u l=1u
X301 a_33702_58419# a_25666_58305# a_32142_62819# VDD pfet_06v0 ad=1.3p pd=5.52u as=2.2p ps=10.88u w=5u l=1u
X302 a_51506_63689# a_48850_58305# VSS VSS nfet_06v0 ad=0.25p pd=1.5u as=0.44p ps=2.88u w=1u l=1u
X303 a_72338_24088# S3N a_69842_24788# VSS nfet_06v0 ad=3.74p pd=17.88u as=3.74p ps=17.88u w=8.5u l=1u
X304 a_14502_28838# a_2594_35580# VSS VSS nfet_06v0 ad=0.25p pd=1.5u as=0.44p ps=2.88u w=1u l=1u
X305 a_71606_28838# S2P a_69842_28838# VSS nfet_06v0 ad=3.3p pd=15.88u as=3.3p ps=15.88u w=7.5u l=1u
X306 a_42790_62819# a_31030_62819# cap_mim_2f0_m4m5_noshield c_width=20u c_length=10u
X307 a_3486_28838# a_2254_28794# VSS VSS nfet_06v0 ad=1.25p pd=5.5u as=2.2p ps=10.88u w=5u l=1u
X308 a_2794_16930# a_2594_16886# a_2494_16930# VDD pfet_06v0 ad=4.4p pd=20.88u as=2.5p ps=10.5u w=10u l=1u
X309 a_47242_28794# a_47282_35580# a_61718_35696# VDD pfet_06v0 ad=4.4p pd=20.88u as=2.5p ps=10.5u w=10u l=1u
X310 a_72304_44642# a_79086_43142# X VSS nfet_06v0 ad=1.0912p pd=5.84u as=0.6448p ps=3u w=2.48u l=1u
X311 a_11746_41059# a_15646_45913# a_11294_45959# VSS nfet_06v0 ad=1.1p pd=5.88u as=1.1p ps=5.88u w=2.5u l=1u
X312 X a_73254_43142# a_73166_43186# VSS nfet_06v0 ad=0.6448p pd=3u as=1.0912p ps=5.84u w=2.48u l=1u
X313 a_55770_58419# a_48510_63573# a_56438_63319# VSS nfet_06v0 ad=1.1p pd=5.88u as=0.65p ps=3.02u w=2.5u l=1u
X314 a_53542_58349# a_48850_58305# a_53210_58349# VDD pfet_06v0 ad=2.5p pd=10.5u as=3.3p ps=10.66u w=10u l=1u
X315 a_58002_41059# a_61902_45913# a_57550_45959# VSS nfet_06v0 ad=1.1p pd=5.88u as=1.1p ps=5.88u w=2.5u l=1u
X316 a_52850_45529# a_48510_46213# a_52550_45529# VSS nfet_06v0 ad=1.65p pd=5.66u as=1.25p ps=5.5u w=5u l=1u
X317 a_2594_40945# a_2594_40945# a_5250_46329# VSS nfet_06v0 ad=0.44p pd=2.88u as=0.25p ps=1.5u w=1u l=1u
X318 VSS a_10182_67083# a_8398_70483# VSS nfet_06v0 ad=1.1p pd=5.88u as=0.65p ps=3.02u w=2.5u l=1u
X319 a_55326_67083# a_56886_71483# VDD VDD pfet_06v0 ad=1.3p pd=5.52u as=1.3p ps=5.52u w=5u l=1u
X320 a_48510_63573# a_48510_63573# VSS VSS nfet_06v0 ad=0.44p pd=2.88u as=0.44p ps=2.88u w=1u l=1u
X321 a_76478_36780# a_76478_36780# a_78114_35580# VDD pfet_06v0 ad=4.4p pd=20.88u as=3.3p ps=10.66u w=10u l=1u
X322 a_50474_63689# a_48850_58305# VSS VSS nfet_06v0 ad=0.25p pd=1.5u as=0.44p ps=2.88u w=1u l=1u
X323 a_35870_28838# a_24654_28794# VSS VSS nfet_06v0 ad=1.25p pd=5.5u as=2.2p ps=10.88u w=5u l=1u
X324 a_3168_33750# a_18586_33300# VSS ppolyf_u_1k r_width=1u r_length=76.45u
X325 a_54078_36780# a_54078_36780# a_55714_35580# VDD pfet_06v0 ad=4.4p pd=20.88u as=3.3p ps=10.66u w=10u l=1u
X326 a_13470_28838# a_2254_28794# VSS VSS nfet_06v0 ad=1.25p pd=5.5u as=2.2p ps=10.88u w=5u l=1u
X327 a_3168_33300# a_7934_28794# a_7402_28838# VSS nfet_06v0 ad=0.88p pd=4.88u as=0.88p ps=4.88u w=2u l=1u
X328 a_7958_45459# a_7758_45415# a_6594_45529# VSS nfet_06v0 ad=1.3p pd=5.52u as=2.2p ps=10.88u w=5u l=1u
X329 a_18354_62889# a_18154_62773# VSS VSS nfet_06v0 ad=1.25p pd=5.5u as=2.2p ps=10.88u w=5u l=1u
X330 a_70574_28838# a_69342_28794# VSS VSS nfet_06v0 ad=1.25p pd=5.5u as=2.2p ps=10.88u w=5u l=1u
X331 a_57550_45959# a_48510_46213# a_54654_41059# VSS nfet_06v0 ad=0.65p pd=3.02u as=1.1p ps=5.88u w=2.5u l=1u
X332 a_72104_49876# a_72104_49876# a_74368_49992# VSS nfet_06v0 ad=0.308p pd=2.28u as=0.175p ps=1.2u w=0.7u l=1u
X333 a_63566_49653# a_49242_49609# VSS VSS nfet_06v0 ad=1.25p pd=5.5u as=2.2p ps=10.88u w=5u l=1u
X334 a_85566_42758# a_83814_42758# a_84634_42642# VSS nfet_06v0 ad=0.25p pd=1.5u as=0.44p ps=2.88u w=1u l=1u
X335 a_74068_44750# a_72104_44598# a_73768_44750# VSS nfet_06v0 ad=0.175p pd=1.2u as=0.175p ps=1.2u w=0.7u l=1u
X336 a_5530_58349# a_2294_58305# VDD VDD pfet_06v0 ad=2.5p pd=10.5u as=4.4p ps=20.88u w=10u l=1u
X337 a_3186_49653# a_2986_49609# VSS VSS nfet_06v0 ad=1.25p pd=5.5u as=2.2p ps=10.88u w=5u l=1u
X338 a_65974_67083# a_57550_67083# VSS VSS nfet_06v0 ad=2.2p pd=10.88u as=1.3p ps=5.52u w=5u l=1u
X339 a_64610_62889# a_64410_62773# VSS VSS nfet_06v0 ad=1.25p pd=5.5u as=2.2p ps=10.88u w=5u l=1u
X340 a_52850_49653# a_12006_25588# a_54214_49723# VSS nfet_06v0 ad=2.2p pd=10.88u as=1.3p ps=5.52u w=5u l=1u
X341 VDD a_10630_71483# a_9070_67083# VDD pfet_06v0 ad=1.3p pd=5.52u as=1.3p ps=5.52u w=5u l=1u
X342 VDD a_10630_54123# a_9070_49723# VDD pfet_06v0 ad=2.2p pd=10.88u as=1.3p ps=5.52u w=5u l=1u
X343 VDD VSS VDD VDD pfet_06v0 ad=7.92p pd=36.88u as=0 ps=0 w=18u l=2u
X344 a_2594_53077# a_2594_53077# a_5250_49653# VSS nfet_06v0 ad=0.44p pd=2.88u as=0.25p ps=1.5u w=1u l=1u
X345 a_52910_40989# a_48550_40945# VDD VDD pfet_06v0 ad=2.5p pd=10.5u as=4.4p ps=20.88u w=10u l=1u
X346 a_55770_53123# a_7758_49607# a_53210_53193# VDD pfet_06v0 ad=2.6p pd=10.52u as=4.4p ps=20.88u w=10u l=1u
X347 VSS a_49242_45413# a_53182_45529# VSS nfet_06v0 ad=2.2p pd=10.88u as=1.25p ps=5.5u w=5u l=1u
X348 VDD VSS VDD VDD pfet_06v0 ad=4.29p pd=20.38u as=0 ps=0 w=9.75u l=2u
X349 a_72054_51200# a_72104_49876# VSS VSS nfet_06v0 ad=0.5456p pd=3.36u as=0.5456p ps=3.36u w=1.24u l=1u
X350 a_70256_33750# a_85674_33300# VSS ppolyf_u_1k r_width=1u r_length=76.45u
X351 a_70256_33300# a_75022_28794# a_74490_28838# VSS nfet_06v0 ad=0.88p pd=4.88u as=0.88p ps=4.88u w=2u l=1u
X352 a_47856_34650# a_30830_66967# VSS ppolyf_u_1k r_width=1u r_length=76.45u
X353 VSS VDD VSS VSS nfet_06v0 ad=7.92p pd=36.88u as=0 ps=0 w=18u l=2u
X354 VDD VSS VDD VDD pfet_06v0 ad=0.44p pd=2.88u as=0 ps=0 w=1u l=2u
X355 a_35870_4870# a_24654_4826# VSS VSS nfet_06v0 ad=1.25p pd=5.5u as=2.2p ps=10.88u w=5u l=1u
X356 Y VDD a_75112_49992# VSS nfet_06v0 ad=0.6448p pd=3u as=1.0912p ps=5.84u w=2.48u l=1u
X357 a_47856_33300# a_52622_28794# a_52090_28838# VSS nfet_06v0 ad=0.88p pd=4.88u as=0.88p ps=4.88u w=2u l=1u
X358 VDD a_71494_67000# a_72314_66956# VDD pfet_06v0 ad=1.32p pd=6.88u as=0.99p ps=3.66u w=3u l=1u
X359 a_76086_67000# a_42790_67083# a_75154_66956# VSS nfet_06v0 ad=0.25p pd=1.5u as=0.44p ps=2.88u w=1u l=1u
X360 a_33042_28838# a_32842_28794# VSS VSS nfet_06v0 ad=1.25p pd=5.5u as=2.2p ps=10.88u w=5u l=1u
X361 a_9514_70483# a_2254_66969# a_10182_67083# VSS nfet_06v0 ad=1.1p pd=5.88u as=0.65p ps=3.02u w=2.5u l=1u
X362 a_41018_70553# a_40818_70437# VDD VDD pfet_06v0 ad=2.5p pd=10.5u as=4.4p ps=20.88u w=10u l=1u
X363 a_15646_66969# a_2594_70437# a_19390_70553# VDD pfet_06v0 ad=4.4p pd=20.88u as=2.5p ps=10.5u w=10u l=1u
X364 a_10642_28838# a_10442_28794# VSS VSS nfet_06v0 ad=1.25p pd=5.5u as=2.2p ps=10.88u w=5u l=1u
X365 a_32586_53123# a_33254_49723# VSS VSS nfet_06v0 ad=0.65p pd=3.02u as=0.65p ps=3.02u w=2.5u l=1u
X366 a_61902_63273# a_61902_63273# a_64410_62773# VSS nfet_06v0 ad=2.2p pd=10.88u as=1.65p ps=5.66u w=5u l=1u
X367 a_48850_40945# a_48850_40945# a_51506_46329# VSS nfet_06v0 ad=0.44p pd=2.88u as=0.25p ps=1.5u w=1u l=1u
X368 a_7958_67083# a_10630_71483# VDD VDD pfet_06v0 ad=1.3p pd=5.52u as=2.2p ps=10.88u w=5u l=1u
X369 VDD a_11746_71483# a_19718_67083# VDD pfet_06v0 ad=2.6p pd=10.52u as=2.6p ps=10.52u w=10u l=1u
X370 VDD X X VDD pfet_06v0 ad=0.88p pd=4.88u as=0.52p ps=2.52u w=2u l=1u
X371 a_53542_40989# a_48850_40945# a_53210_40989# VDD pfet_06v0 ad=2.5p pd=10.5u as=3.3p ps=10.66u w=10u l=1u
X372 VSS a_33254_45959# a_31470_41059# VSS nfet_06v0 ad=1.1p pd=5.88u as=0.65p ps=3.02u w=2.5u l=1u
X373 a_30358_53193# a_25666_53077# a_30026_53193# VDD pfet_06v0 ad=2.5p pd=10.5u as=3.3p ps=10.66u w=10u l=1u
X374 a_50482_25172# a_47242_24672# a_50218_16930# VSS nfet_06v0 ad=1.1p pd=5.88u as=0.825p ps=3.16u w=2.5u l=1u
X375 a_19718_49723# a_11294_49723# VSS VSS nfet_06v0 ad=2.2p pd=10.88u as=1.3p ps=5.52u w=5u l=1u
X376 a_72618_16930# S3N a_69882_16930# VDD pfet_06v0 ad=0.22p pd=1.88u as=0.22p ps=1.88u w=0.5u l=1u
X377 a_51030_11728# a_47282_11612# a_49938_4870# VDD pfet_06v0 ad=4.4p pd=20.88u as=4.4p ps=20.88u w=10u l=1u
X378 VDD VSS VDD VDD pfet_06v0 ad=4.29p pd=20.38u as=0 ps=0 w=9.75u l=2u
X379 a_15646_49609# a_15646_49609# a_18154_49609# VSS nfet_06v0 ad=2.2p pd=10.88u as=1.65p ps=5.66u w=5u l=1u
X380 a_8398_53123# a_10182_49723# VSS VSS nfet_06v0 ad=0.65p pd=3.02u as=1.1p ps=5.88u w=2.5u l=1u
X381 a_54214_67083# a_56886_71483# VDD VDD pfet_06v0 ad=1.3p pd=5.52u as=2.2p ps=10.88u w=5u l=1u
X382 a_27118_13618# a_30830_45415# cap_mim_2f0_m4m5_noshield c_width=25u c_length=8u
X383 a_54214_49723# a_56886_54123# VDD VDD pfet_06v0 ad=1.3p pd=5.52u as=1.3p ps=5.52u w=5u l=1u
X384 a_50218_16930# S4N a_47482_16930# VDD pfet_06v0 ad=0.22p pd=1.88u as=0.22p ps=1.88u w=0.5u l=1u
X385 a_30830_62775# a_70256_21126# VDD VDD pfet_06v0 ad=0.44p pd=2.88u as=0.44p ps=2.88u w=1u l=1u
X386 a_49206_24288# S4P a_47442_24788# VSS nfet_06v0 ad=3.3p pd=15.88u as=3.3p ps=15.88u w=7.5u l=1u
X387 a_24854_24788# a_24654_24672# VSS VSS nfet_06v0 ad=1.25p pd=5.5u as=2.2p ps=10.88u w=5u l=1u
X388 a_3168_33300# a_2594_35580# a_4518_28838# VDD pfet_06v0 ad=4.4p pd=20.88u as=4.4p ps=20.88u w=10u l=1u
X389 a_7758_49607# a_70256_9332# VDD VDD pfet_06v0 ad=0.44p pd=2.88u as=0.44p ps=2.88u w=1u l=1u
X390 VSS a_19718_62819# a_83814_60230# VSS nfet_06v0 ad=0.44p pd=2.88u as=0.44p ps=2.88u w=1u l=1u
X391 a_4718_13618# a_7758_45415# cap_mim_2f0_m4m5_noshield c_width=25u c_length=8u
X392 a_54654_41059# a_56438_45959# VSS VSS nfet_06v0 ad=0.65p pd=3.02u as=0.65p ps=3.02u w=2.5u l=1u
X393 a_2986_45413# a_2254_46213# a_3186_45529# VSS nfet_06v0 ad=2.2p pd=10.88u as=1.25p ps=5.5u w=5u l=1u
X394 a_6594_49653# a_8870_49607# a_9070_49723# VSS nfet_06v0 ad=2.2p pd=10.88u as=1.3p ps=5.52u w=5u l=1u
X395 a_77154_60546# a_72104_61958# VSS VSS nfet_06v0 ad=0.5456p pd=3.36u as=0.5456p ps=3.36u w=1.24u l=1u
X396 a_48850_53077# a_48850_53077# a_51506_49653# VSS nfet_06v0 ad=0.44p pd=2.88u as=0.25p ps=1.5u w=1u l=1u
X397 a_10630_71483# a_2594_70437# a_9070_67083# VDD pfet_06v0 ad=1.3p pd=5.52u as=2.2p ps=10.88u w=5u l=1u
X398 a_30334_28794# a_30334_28794# a_32842_28794# VSS nfet_06v0 ad=2.2p pd=10.88u as=1.65p ps=5.66u w=5u l=1u
X399 a_25194_16930# a_24994_16886# a_26006_16930# VDD pfet_06v0 ad=4.4p pd=20.88u as=2.5p ps=10.5u w=10u l=1u
X400 a_48550_40945# a_48850_40945# a_50474_46329# VSS nfet_06v0 ad=0.44p pd=2.88u as=0.25p ps=1.5u w=1u l=1u
X401 a_7934_28794# a_7934_28794# a_10442_28794# VSS nfet_06v0 ad=2.2p pd=10.88u as=1.65p ps=5.66u w=5u l=1u
X402 a_24894_16930# a_24694_16886# VDD VDD pfet_06v0 ad=2.5p pd=10.5u as=4.4p ps=20.88u w=10u l=1u
X403 a_5530_40989# a_2294_40945# VDD VDD pfet_06v0 ad=2.5p pd=10.5u as=4.4p ps=20.88u w=10u l=1u
X404 a_18154_45413# a_2254_46213# a_18354_45529# VSS nfet_06v0 ad=1.65p pd=5.66u as=1.25p ps=5.5u w=5u l=1u
X405 a_27118_16930# a_8870_49607# cap_mim_2f0_m4m5_noshield c_width=25u c_length=8u
X406 a_58002_58419# a_48850_58305# a_54214_62819# VDD pfet_06v0 ad=1.3p pd=5.52u as=2.2p ps=10.88u w=5u l=1u
X407 VDD a_33702_41059# a_31030_45459# VDD pfet_06v0 ad=2.2p pd=10.88u as=1.3p ps=5.52u w=5u l=1u
X408 a_19718_62819# a_11746_58419# VDD VDD pfet_06v0 ad=2.6p pd=10.52u as=4.4p ps=20.88u w=10u l=1u
X409 a_64410_45413# a_48510_46213# a_64610_45529# VSS nfet_06v0 ad=1.65p pd=5.66u as=1.25p ps=5.5u w=5u l=1u
X410 a_31998_24788# a_24654_24672# VSS VSS nfet_06v0 ad=1.25p pd=5.5u as=2.2p ps=10.88u w=5u l=1u
X411 a_69382_35580# a_69682_35580# a_87154_35696# VDD pfet_06v0 ad=4.4p pd=20.88u as=2.5p ps=10.5u w=10u l=1u
X412 a_29726_70553# a_25366_70437# VDD VDD pfet_06v0 ad=2.5p pd=10.5u as=4.4p ps=20.88u w=10u l=1u
X413 a_47856_33300# a_47282_35580# a_49206_28838# VDD pfet_06v0 ad=4.4p pd=20.88u as=4.4p ps=20.88u w=10u l=1u
X414 VSS a_10182_45959# a_9514_41059# VSS nfet_06v0 ad=1.1p pd=5.88u as=0.65p ps=3.02u w=2.5u l=1u
X415 a_54654_58419# a_48510_63573# a_57550_63319# VSS nfet_06v0 ad=1.1p pd=5.88u as=0.65p ps=3.02u w=2.5u l=1u
X416 a_47142_28838# a_46942_28794# VSS VSS nfet_06v0 ad=1.25p pd=5.5u as=2.2p ps=10.88u w=5u l=1u
X417 a_26258_49653# a_26058_49609# VSS VSS nfet_06v0 ad=1.25p pd=5.5u as=2.2p ps=10.88u w=5u l=1u
X418 a_33702_71483# a_38718_66969# a_33254_67083# VSS nfet_06v0 ad=1.1p pd=5.88u as=1.1p ps=5.88u w=2.5u l=1u
X419 a_25568_34650# a_40986_34200# VSS ppolyf_u_1k r_width=1u r_length=76.45u
X420 a_76410_43352# X VSS VSS nfet_06v0 ad=0.5p pd=2.5u as=0.88p ps=4.88u w=2u l=1u
X421 VSS VDD VSS VSS nfet_06v0 ad=4.29p pd=20.38u as=0 ps=0 w=9.75u l=2u
X422 a_48550_53077# a_48850_53077# a_50474_49653# VSS nfet_06v0 ad=0.44p pd=2.88u as=0.25p ps=1.5u w=1u l=1u
X423 a_30830_62775# a_71606_24288# cap_mim_2f0_m4m5_noshield c_width=25u c_length=8u
X424 a_3168_33750# a_18586_34200# VSS ppolyf_u_1k r_width=1u r_length=76.45u
X425 VSS VDD VSS VSS nfet_06v0 ad=4.29p pd=20.38u as=0 ps=0 w=9.75u l=2u
X426 a_7402_28838# a_2554_28794# a_4718_37586# VSS nfet_06v0 ad=1.1p pd=5.88u as=0.825p ps=3.16u w=2.5u l=1u
X427 a_57550_49723# a_62366_54077# a_58002_54123# VDD pfet_06v0 ad=2.2p pd=10.88u as=2.2p ps=10.88u w=5u l=1u
X428 a_65974_49723# a_54214_49723# cap_mim_2f0_m4m5_noshield c_width=20u c_length=10u
X429 XP XN VSS VSS nfet_05v0 ad=0.5808p pd=3.52u as=0.5808p ps=3.52u w=1.32u l=0.6u
X430 VSS VDD VSS VSS nfet_06v0 ad=0.44p pd=2.88u as=0 ps=0 w=1u l=2u
X431 a_75022_28794# a_69682_35580# a_79758_35696# VDD pfet_06v0 ad=4.4p pd=20.88u as=2.5p ps=10.5u w=10u l=1u
X432 a_52622_28794# a_47282_35580# a_57358_35696# VDD pfet_06v0 ad=4.4p pd=20.88u as=2.5p ps=10.5u w=10u l=1u
X433 a_55770_41059# a_56438_45959# VSS VSS nfet_06v0 ad=0.65p pd=3.02u as=1.1p ps=5.88u w=2.5u l=1u
X434 a_69882_16930# a_69682_16886# a_70694_16930# VDD pfet_06v0 ad=4.4p pd=20.88u as=2.5p ps=10.5u w=10u l=1u
X435 VDD a_56886_58419# a_55326_62819# VDD pfet_06v0 ad=1.3p pd=5.52u as=1.3p ps=5.52u w=5u l=1u
X436 a_8870_62775# a_4518_28838# cap_mim_2f0_m4m5_noshield c_width=25u c_length=8u
X437 a_70256_33750# a_85674_34200# VSS ppolyf_u_1k r_width=1u r_length=76.45u
X438 a_32586_58419# a_8870_62775# a_30026_58349# VDD pfet_06v0 ad=2.6p pd=10.52u as=4.4p ps=20.88u w=10u l=1u
X439 a_11294_63319# a_16110_58305# a_11746_58419# VDD pfet_06v0 ad=2.2p pd=10.88u as=2.2p ps=10.88u w=5u l=1u
X440 VSS VDD VSS VSS nfet_06v0 ad=7.92p pd=36.88u as=0 ps=0 w=18u l=2u
X441 a_9070_62819# a_10630_58419# VDD VDD pfet_06v0 ad=1.3p pd=5.52u as=2.2p ps=10.88u w=5u l=1u
X442 a_48174_4870# a_46942_4826# VSS VSS nfet_06v0 ad=1.25p pd=5.5u as=2.2p ps=10.88u w=5u l=1u
X443 a_33626_35696# a_33426_35580# VDD VDD pfet_06v0 ad=2.5p pd=10.5u as=4.4p ps=20.88u w=10u l=1u
X444 VSS a_42790_67083# a_72142_60502# VSS nfet_06v0 ad=0.44p pd=2.88u as=0.33p ps=1.66u w=1u l=1u
X445 VSS VDD VSS VSS nfet_06v0 ad=4.29p pd=20.38u as=0 ps=0 w=9.75u l=2u
X446 VSS VDD VSS VSS nfet_06v0 ad=4.29p pd=20.38u as=0 ps=0 w=9.75u l=2u
X447 a_4718_13618# S2P a_2794_11728# VDD pfet_06v0 ad=0.242p pd=1.98u as=0.242p ps=1.98u w=0.55u l=1u
X448 a_31030_45459# a_33702_41059# VDD VDD pfet_06v0 ad=1.3p pd=5.52u as=2.2p ps=10.88u w=5u l=1u
X449 VSS VDD VSS VSS nfet_06v0 ad=0.44p pd=2.88u as=0 ps=0 w=1u l=2u
X450 a_11226_35696# a_11026_35580# VDD VDD pfet_06v0 ad=2.5p pd=10.5u as=4.4p ps=20.88u w=10u l=1u
X451 a_75112_49992# a_72104_49876# VSS VSS nfet_06v0 ad=0.5456p pd=3.36u as=0.5456p ps=3.36u w=1.24u l=1u
X452 a_62830_35696# a_46982_35580# VDD VDD pfet_06v0 ad=2.5p pd=10.5u as=4.4p ps=20.88u w=10u l=1u
X453 a_6926_67013# a_2254_66969# a_6594_67013# VSS nfet_06v0 ad=1.25p pd=5.5u as=1.65p ps=5.66u w=5u l=1u
X454 VDD a_34818_71483# a_42790_67083# VDD pfet_06v0 ad=2.6p pd=10.52u as=2.6p ps=10.52u w=10u l=1u
X455 a_8398_70483# a_2254_66969# a_11294_67083# VSS nfet_06v0 ad=1.1p pd=5.88u as=0.65p ps=3.02u w=2.5u l=1u
X456 VDD VSS VDD VDD pfet_06v0 ad=0.44p pd=2.88u as=0 ps=0 w=1u l=2u
X457 a_40382_67013# a_26058_66969# VSS VSS nfet_06v0 ad=1.25p pd=5.5u as=2.2p ps=10.88u w=5u l=1u
X458 a_42790_49723# a_34366_49723# VSS VSS nfet_06v0 ad=2.2p pd=10.88u as=1.3p ps=5.52u w=5u l=1u
X459 a_25326_66969# a_25666_70437# a_25566_70553# VDD pfet_06v0 ad=4.4p pd=20.88u as=2.5p ps=10.5u w=10u l=1u
X460 a_31470_53123# a_33254_49723# VSS VSS nfet_06v0 ad=0.65p pd=3.02u as=1.1p ps=5.88u w=2.5u l=1u
X461 a_29802_25288# a_31790_16886# a_25568_21126# VDD pfet_06v0 ad=1.76p pd=8.88u as=1.76p ps=8.88u w=4u l=1u
X462 a_33702_41059# a_25666_40945# a_32142_45459# VDD pfet_06v0 ad=1.3p pd=5.52u as=2.2p ps=10.88u w=5u l=1u
X463 a_7402_25288# a_9390_16886# a_3168_21126# VDD pfet_06v0 ad=1.76p pd=8.88u as=1.76p ps=8.88u w=4u l=1u
X464 a_71806_13618# S4P a_69882_11728# VDD pfet_06v0 ad=0.242p pd=1.98u as=0.242p ps=1.98u w=0.55u l=1u
X465 a_49242_62773# a_48510_63573# a_49442_62889# VSS nfet_06v0 ad=2.2p pd=10.88u as=1.25p ps=5.5u w=5u l=1u
X466 a_2754_28838# a_2554_28794# a_2454_28838# VSS nfet_06v0 ad=2.2p pd=10.88u as=1.25p ps=5.5u w=5u l=1u
X467 a_29666_62889# a_25326_63573# a_29366_62889# VSS nfet_06v0 ad=1.65p pd=5.66u as=1.25p ps=5.5u w=5u l=1u
X468 a_10630_41059# a_15646_45913# a_10182_45959# VSS nfet_06v0 ad=1.1p pd=5.88u as=1.1p ps=5.88u w=2.5u l=1u
X469 a_27118_37586# a_28194_28794# VSS VSS nfet_06v0 ad=0.825p pd=3.16u as=1.1p ps=5.88u w=2.5u l=1u
X470 a_31790_36780# a_31790_36780# a_33426_35580# VDD pfet_06v0 ad=4.4p pd=20.88u as=3.3p ps=10.66u w=10u l=1u
X471 Y a_79086_51084# a_72304_49992# VSS nfet_06v0 ad=0.6448p pd=3u as=1.0912p ps=5.84u w=2.48u l=1u
X472 a_71494_67000# a_19718_67083# VDD VDD pfet_06v0 ad=1.32p pd=6.88u as=1.32p ps=6.88u w=3u l=1u
X473 a_56886_41059# a_61902_45913# a_56438_45959# VSS nfet_06v0 ad=1.1p pd=5.88u as=1.1p ps=5.88u w=2.5u l=1u
X474 a_17030_11728# a_2294_11612# VDD VDD pfet_06v0 ad=2.5p pd=10.5u as=4.4p ps=20.88u w=10u l=1u
X475 a_8870_49607# a_25568_21126# VDD VDD pfet_06v0 ad=0.44p pd=2.88u as=0.44p ps=2.88u w=1u l=1u
X476 a_42790_62819# a_34818_58419# VDD VDD pfet_06v0 ad=2.6p pd=10.52u as=4.4p ps=20.88u w=10u l=1u
X477 VSS VDD VSS VSS nfet_06v0 ad=7.92p pd=36.88u as=0 ps=0 w=18u l=2u
X478 a_48750_53193# a_48550_53077# VDD VDD pfet_06v0 ad=2.5p pd=10.5u as=4.4p ps=20.88u w=10u l=1u
X479 a_5794_28794# a_9390_36780# a_6342_35696# VDD pfet_06v0 ad=1.76p pd=8.88u as=1.76p ps=8.88u w=4u l=1u
X480 a_12006_25588# a_3168_21126# VDD VDD pfet_06v0 ad=0.44p pd=2.88u as=0.44p ps=2.88u w=1u l=1u
X481 a_11746_54123# a_15646_49609# a_11294_49723# VSS nfet_06v0 ad=1.1p pd=5.88u as=1.1p ps=5.88u w=2.5u l=1u
X482 a_65974_67083# a_54214_67083# cap_mim_2f0_m4m5_noshield c_width=20u c_length=10u
X483 a_72618_13628# S4N a_69882_11728# VDD pfet_06v0 ad=0.22p pd=1.88u as=0.22p ps=1.88u w=0.5u l=1u
X484 a_6342_35696# a_7934_28794# a_5794_28794# VSS nfet_06v0 ad=0.88p pd=4.88u as=0.88p ps=4.88u w=2u l=1u
X485 VDD VSS VDD VDD pfet_06v0 ad=4.29p pd=20.38u as=0 ps=0 w=9.75u l=2u
X486 a_59190_25588# a_47282_16886# VSS VSS nfet_06v0 ad=0.25p pd=1.5u as=0.44p ps=2.88u w=1u l=1u
X487 a_6342_16930# a_2594_16886# a_5250_24088# VDD pfet_06v0 ad=4.4p pd=20.88u as=4.4p ps=20.88u w=10u l=1u
X488 a_58002_54123# a_61902_49609# a_57550_49723# VSS nfet_06v0 ad=1.1p pd=5.88u as=1.1p ps=5.88u w=2.5u l=1u
X489 a_50218_13628# S1N a_47482_11728# VDD pfet_06v0 ad=0.22p pd=1.88u as=0.22p ps=1.88u w=0.5u l=1u
X490 VSS a_84634_42642# a_77242_51084# VSS nfet_06v0 ad=0.44p pd=2.88u as=0.44p ps=2.88u w=1u l=1u
X491 a_11294_45959# a_16110_40945# a_11746_41059# VDD pfet_06v0 ad=2.2p pd=10.88u as=2.2p ps=10.88u w=5u l=1u
X492 VSS a_19718_62819# a_88406_60230# VSS nfet_06v0 ad=0.44p pd=2.88u as=0.25p ps=1.5u w=1u l=1u
X493 VSS VDD VSS VSS nfet_06v0 ad=0.44p pd=2.88u as=0 ps=0 w=1u l=2u
X494 a_54654_58419# a_65974_62819# cap_mim_2f0_m4m5_noshield c_width=20u c_length=10u
X495 a_25568_34650# a_7758_66967# VSS ppolyf_u_1k r_width=1u r_length=76.45u
X496 a_19718_45459# a_11294_45959# VSS VSS nfet_06v0 ad=1.3p pd=5.52u as=2.2p ps=10.88u w=5u l=1u
X497 VDD a_33702_71483# a_32142_67083# VDD pfet_06v0 ad=2.2p pd=10.88u as=1.3p ps=5.52u w=5u l=1u
X498 a_25568_33300# a_30334_28794# a_29802_28838# VSS nfet_06v0 ad=0.88p pd=4.88u as=0.88p ps=4.88u w=2u l=1u
X499 a_30026_58349# a_25666_58305# a_29726_58349# VDD pfet_06v0 ad=3.3p pd=10.66u as=2.5p ps=10.5u w=10u l=1u
X500 a_2494_11728# a_2294_11612# VDD VDD pfet_06v0 ad=2.5p pd=10.5u as=4.4p ps=20.88u w=10u l=1u
X501 VSS a_56438_63319# a_55770_58419# VSS nfet_06v0 ad=0.65p pd=3.02u as=0.65p ps=3.02u w=2.5u l=1u
X502 a_70574_4870# a_69342_4826# VSS VSS nfet_06v0 ad=1.25p pd=5.5u as=2.2p ps=10.88u w=5u l=1u
X503 a_4718_37586# a_8870_62775# cap_mim_2f0_m4m5_noshield c_width=25u c_length=8u
X504 a_31470_41059# a_25326_46213# a_34366_45959# VSS nfet_06v0 ad=1.1p pd=5.88u as=0.65p ps=3.02u w=2.5u l=1u
X505 a_78114_16886# a_69682_16886# a_78314_16930# VDD pfet_06v0 ad=3.3p pd=10.66u as=2.5p ps=10.5u w=10u l=1u
X506 a_8870_66967# a_70256_33300# VDD VDD pfet_06v0 ad=0.44p pd=2.88u as=0.44p ps=2.88u w=1u l=1u
X507 a_55714_16886# a_47282_16886# a_55914_16930# VDD pfet_06v0 ad=3.3p pd=10.66u as=2.5p ps=10.5u w=10u l=1u
X508 a_33426_11612# a_24994_11612# a_33626_11728# VDD pfet_06v0 ad=3.3p pd=10.66u as=2.5p ps=10.5u w=10u l=1u
X509 a_17310_49653# a_2986_49609# VSS VSS nfet_06v0 ad=1.25p pd=5.5u as=2.2p ps=10.88u w=5u l=1u
X510 a_65646_53193# a_48550_53077# VDD VDD pfet_06v0 ad=2.5p pd=10.5u as=4.4p ps=20.88u w=10u l=1u
X511 a_11026_11612# a_2594_11612# a_11226_11728# VDD pfet_06v0 ad=3.3p pd=10.66u as=2.5p ps=10.5u w=10u l=1u
X512 a_6294_49653# a_2986_49609# VSS VSS nfet_06v0 ad=1.25p pd=5.5u as=2.2p ps=10.88u w=5u l=1u
X513 a_69882_35696# a_69682_35580# a_69582_35696# VDD pfet_06v0 ad=4.4p pd=20.88u as=2.5p ps=10.5u w=10u l=1u
X514 a_84634_42642# a_65974_45459# VDD VDD pfet_06v0 ad=0.99p pd=3.66u as=1.32p ps=6.88u w=3u l=1u
X515 VSS a_10182_45959# a_9514_41059# VSS nfet_06v0 ad=0.65p pd=3.02u as=0.65p ps=3.02u w=2.5u l=1u
X516 a_73430_16930# a_69682_16886# a_72338_24088# VDD pfet_06v0 ad=4.4p pd=20.88u as=4.4p ps=20.88u w=10u l=1u
X517 a_46942_4826# a_47282_11612# a_62830_11728# VDD pfet_06v0 ad=4.4p pd=20.88u as=2.5p ps=10.5u w=10u l=1u
X518 a_25568_9332# a_40986_9332# VSS ppolyf_u_1k r_width=1u r_length=76.45u
X519 a_51030_35696# a_52622_28794# a_50482_28794# VSS nfet_06v0 ad=0.88p pd=4.88u as=0.88p ps=4.88u w=2u l=1u
X520 a_47482_35696# a_47282_35580# a_47182_35696# VDD pfet_06v0 ad=4.4p pd=20.88u as=2.5p ps=10.5u w=10u l=1u
X521 a_30026_53193# a_8870_49607# a_32586_53123# VDD pfet_06v0 ad=4.4p pd=20.88u as=2.6p ps=10.52u w=10u l=1u
X522 VSS a_87474_60114# a_79086_43142# VSS nfet_06v0 ad=0.44p pd=2.88u as=0.44p ps=2.88u w=1u l=1u
X523 a_73430_16930# a_75022_25272# a_72882_25172# VSS nfet_06v0 ad=0.88p pd=4.88u as=0.88p ps=4.88u w=2u l=1u
X524 a_53182_62889# a_48510_63573# a_52850_62889# VSS nfet_06v0 ad=1.25p pd=5.5u as=1.65p ps=5.66u w=5u l=1u
X525 a_34366_63319# a_39182_58305# a_34818_58419# VDD pfet_06v0 ad=2.2p pd=10.88u as=2.2p ps=10.88u w=5u l=1u
X526 a_52850_67013# a_48510_66969# a_52550_67013# VSS nfet_06v0 ad=1.65p pd=5.66u as=1.25p ps=5.5u w=5u l=1u
X527 a_48550_70437# a_48850_70437# a_51786_70553# VDD pfet_06v0 ad=4.4p pd=20.88u as=2.5p ps=10.5u w=10u l=1u
X528 a_56886_58419# a_48850_58305# a_55326_62819# VDD pfet_06v0 ad=1.3p pd=5.52u as=2.2p ps=10.88u w=5u l=1u
X529 a_31030_67083# a_33702_71483# VDD VDD pfet_06v0 ad=1.3p pd=5.52u as=1.3p ps=5.52u w=5u l=1u
X530 a_54654_53123# a_65974_49723# cap_mim_2f0_m4m5_noshield c_width=20u c_length=10u
X531 a_42462_70553# a_25366_70437# VDD VDD pfet_06v0 ad=2.5p pd=10.5u as=4.4p ps=20.88u w=10u l=1u
X532 a_50218_13628# a_50482_4826# VSS VSS nfet_06v0 ad=0.825p pd=3.16u as=1.1p ps=5.88u w=2.5u l=1u
X533 a_58158_24788# a_46942_24672# VSS VSS nfet_06v0 ad=1.25p pd=5.5u as=2.2p ps=10.88u w=5u l=1u
X534 VSS VDD VSS VSS nfet_06v0 ad=0.44p pd=2.88u as=0 ps=0 w=1u l=2u
X535 a_31790_12812# a_24954_4826# a_31998_4870# VSS nfet_06v0 ad=2.2p pd=10.88u as=1.25p ps=5.5u w=5u l=1u
X536 a_8870_49607# a_25568_21126# VDD VDD pfet_06v0 ad=0.44p pd=2.88u as=0.44p ps=2.88u w=1u l=1u
X537 a_39182_58305# a_39182_58305# a_40818_58305# VDD pfet_06v0 ad=4.4p pd=20.88u as=3.3p ps=10.66u w=10u l=1u
X538 a_64202_70553# a_64002_70437# VDD VDD pfet_06v0 ad=2.5p pd=10.5u as=4.4p ps=20.88u w=10u l=1u
X539 a_31470_53123# a_33254_49723# VSS VSS nfet_06v0 ad=0.65p pd=3.02u as=0.65p ps=3.02u w=2.5u l=1u
X540 a_55326_49723# a_48850_53077# a_56886_54123# VDD pfet_06v0 ad=2.2p pd=10.88u as=1.3p ps=5.52u w=5u l=1u
X541 a_12006_25588# a_3168_21126# VDD VDD pfet_06v0 ad=0.44p pd=2.88u as=0.44p ps=2.88u w=1u l=1u
X542 a_24694_16886# a_24994_16886# a_36902_25588# VSS nfet_06v0 ad=0.44p pd=2.88u as=0.25p ps=1.5u w=1u l=1u
X543 a_71806_16930# a_72882_25172# VSS VSS nfet_06v0 ad=0.825p pd=3.16u as=1.1p ps=5.88u w=2.5u l=1u
X544 a_55770_53123# a_56438_49723# VSS VSS nfet_06v0 ad=0.65p pd=3.02u as=0.65p ps=3.02u w=2.5u l=1u
X545 a_25366_53077# a_25666_53077# a_28602_53193# VDD pfet_06v0 ad=4.4p pd=20.88u as=2.5p ps=10.5u w=10u l=1u
X546 Y a_77242_51084# a_77154_51200# VSS nfet_06v0 ad=0.6448p pd=3u as=1.0912p ps=5.84u w=2.48u l=1u
X547 a_49406_16930# a_50482_25172# VSS VSS nfet_06v0 ad=0.825p pd=3.16u as=1.1p ps=5.88u w=2.5u l=1u
X548 VSS a_56438_49723# a_54654_53123# VSS nfet_06v0 ad=0.65p pd=3.02u as=0.65p ps=3.02u w=2.5u l=1u
X549 a_25326_46213# a_25326_46213# VSS VSS nfet_06v0 ad=0.44p pd=2.88u as=0.44p ps=2.88u w=1u l=1u
X550 a_6954_53193# a_8870_49607# a_9514_53123# VDD pfet_06v0 ad=4.4p pd=20.88u as=2.6p ps=10.52u w=10u l=1u
X551 a_57550_67083# a_48510_66969# a_54654_70483# VSS nfet_06v0 ad=0.65p pd=3.02u as=1.1p ps=5.88u w=2.5u l=1u
X552 a_54654_70483# a_30830_66967# a_53210_70553# VDD pfet_06v0 ad=2.6p pd=10.52u as=4.4p ps=20.88u w=10u l=1u
X553 a_26058_66969# a_25666_70437# a_26678_70553# VDD pfet_06v0 ad=4.4p pd=20.88u as=2.5p ps=10.5u w=10u l=1u
X554 VSS a_49242_66969# a_53182_67013# VSS nfet_06v0 ad=2.2p pd=10.88u as=1.25p ps=5.5u w=5u l=1u
X555 a_24854_28838# a_24654_28794# VSS VSS nfet_06v0 ad=1.25p pd=5.5u as=2.2p ps=10.88u w=5u l=1u
X556 a_63566_62889# a_49242_62773# VSS VSS nfet_06v0 ad=1.25p pd=5.5u as=2.2p ps=10.88u w=5u l=1u
X557 a_69682_16886# a_69682_16886# a_82622_25588# VSS nfet_06v0 ad=0.44p pd=2.88u as=0.25p ps=1.5u w=1u l=1u
X558 a_3186_62889# a_2986_62773# VSS VSS nfet_06v0 ad=1.25p pd=5.5u as=2.2p ps=10.88u w=5u l=1u
X559 a_31470_58419# a_42790_62819# cap_mim_2f0_m4m5_noshield c_width=20u c_length=10u
X560 a_47282_16886# a_47282_16886# a_60222_25588# VSS nfet_06v0 ad=0.44p pd=2.88u as=0.25p ps=1.5u w=1u l=1u
X561 a_30026_40989# a_25666_40945# a_29726_40989# VDD pfet_06v0 ad=3.3p pd=10.66u as=2.5p ps=10.5u w=10u l=1u
X562 a_58002_41059# a_48850_40945# a_54214_45459# VDD pfet_06v0 ad=1.3p pd=5.52u as=2.2p ps=10.88u w=5u l=1u
X563 VSS VDD VSS VSS nfet_06v0 ad=7.92p pd=36.88u as=0 ps=0 w=18u l=2u
X564 a_19718_45459# a_11746_41059# VDD VDD pfet_06v0 ad=2.6p pd=10.52u as=4.4p ps=20.88u w=10u l=1u
X565 a_41426_45529# a_41226_45413# VSS VSS nfet_06v0 ad=1.25p pd=5.5u as=2.2p ps=10.88u w=5u l=1u
X566 a_47282_11612# a_47282_11612# a_60222_4870# VSS nfet_06v0 ad=0.44p pd=2.88u as=0.25p ps=1.5u w=1u l=1u
X567 a_2294_70437# a_2594_70437# a_4218_67013# VSS nfet_06v0 ad=0.44p pd=2.88u as=0.25p ps=1.5u w=1u l=1u
X568 a_28322_63689# a_25666_58305# VSS VSS nfet_06v0 ad=0.25p pd=1.5u as=0.44p ps=2.88u w=1u l=1u
X569 VDD VSS VDD VDD pfet_06v0 ad=7.92p pd=36.88u as=0 ps=0 w=18u l=2u
X570 a_42790_49723# a_34366_49723# VSS VSS nfet_06v0 ad=1.3p pd=5.52u as=2.2p ps=10.88u w=5u l=1u
X571 a_25326_49609# a_25326_49609# VSS VSS nfet_06v0 ad=0.44p pd=2.88u as=0.44p ps=2.88u w=1u l=1u
X572 a_3606_53193# a_2294_53077# VDD VDD pfet_06v0 ad=2.5p pd=10.5u as=4.4p ps=20.88u w=10u l=1u
X573 a_31030_62819# a_25666_58305# a_34818_58419# VDD pfet_06v0 ad=2.2p pd=10.88u as=1.3p ps=5.52u w=5u l=1u
X574 a_54214_62819# a_30830_62775# a_52850_62889# VSS nfet_06v0 ad=1.3p pd=5.52u as=2.2p ps=10.88u w=5u l=1u
X575 a_3168_21126# a_7934_25272# a_7402_25288# VSS nfet_06v0 ad=0.88p pd=4.88u as=0.88p ps=4.88u w=2u l=1u
X576 a_33254_49723# a_25326_49609# a_32586_53123# VSS nfet_06v0 ad=0.65p pd=3.02u as=1.1p ps=5.88u w=2.5u l=1u
X577 a_72304_62002# a_72104_61958# VSS VSS nfet_06v0 ad=0.5456p pd=3.36u as=0.5456p ps=3.36u w=1.24u l=1u
X578 a_69382_16886# a_69682_16886# a_81590_25588# VSS nfet_06v0 ad=0.44p pd=2.88u as=0.25p ps=1.5u w=1u l=1u
X579 a_31998_28838# a_24654_28794# VSS VSS nfet_06v0 ad=1.25p pd=5.5u as=2.2p ps=10.88u w=5u l=1u
X580 a_18142_11728# a_2294_11612# VDD VDD pfet_06v0 ad=2.5p pd=10.5u as=4.4p ps=20.88u w=10u l=1u
X581 a_49862_53193# a_48550_53077# VDD VDD pfet_06v0 ad=2.5p pd=10.5u as=4.4p ps=20.88u w=10u l=1u
X582 a_30830_45415# a_25568_9332# VDD VDD pfet_06v0 ad=0.44p pd=2.88u as=0.44p ps=2.88u w=1u l=1u
X583 a_34366_45959# a_39182_40945# a_34818_41059# VDD pfet_06v0 ad=2.2p pd=10.88u as=2.2p ps=10.88u w=5u l=1u
X584 a_34818_41059# a_38718_45913# a_34366_45959# VSS nfet_06v0 ad=1.1p pd=5.88u as=1.1p ps=5.88u w=2.5u l=1u
X585 a_7758_45415# a_3168_9332# VDD VDD pfet_06v0 ad=0.44p pd=2.88u as=0.44p ps=2.88u w=1u l=1u
X586 a_26918_4870# a_28742_11728# VDD VDD pfet_06v0 ad=2.2p pd=10.88u as=2.2p ps=10.88u w=5u l=1u
X587 VSS VDD VSS VSS nfet_06v0 ad=4.29p pd=20.38u as=0 ps=0 w=9.75u l=2u
X588 a_74368_62110# a_72104_61958# a_74068_62110# VSS nfet_06v0 ad=0.175p pd=1.2u as=0.175p ps=1.2u w=0.7u l=1u
X589 a_2986_66969# a_2254_66969# a_3186_67013# VSS nfet_06v0 ad=2.2p pd=10.88u as=1.25p ps=5.5u w=5u l=1u
X590 a_27290_63689# a_25666_58305# VSS VSS nfet_06v0 ad=0.25p pd=1.5u as=0.44p ps=2.88u w=1u l=1u
X591 VDD a_56886_41059# a_55326_45459# VDD pfet_06v0 ad=1.3p pd=5.52u as=1.3p ps=5.52u w=5u l=1u
X592 a_84634_60114# a_65974_62819# VDD VDD pfet_06v0 ad=0.99p pd=3.66u as=1.32p ps=6.88u w=3u l=1u
X593 VSS a_33254_67083# a_31470_70483# VSS nfet_06v0 ad=1.1p pd=5.88u as=0.65p ps=3.02u w=2.5u l=1u
X594 VSS VDD VSS VSS nfet_06v0 ad=4.29p pd=20.38u as=0 ps=0 w=9.75u l=2u
X595 a_47856_20226# a_63274_19776# VSS ppolyf_u_1k r_width=1u r_length=76.45u
X596 a_31470_53123# a_42790_49723# cap_mim_2f0_m4m5_noshield c_width=20u c_length=10u
X597 a_49406_13618# a_50482_4826# VSS VSS nfet_06v0 ad=0.825p pd=3.16u as=1.1p ps=5.88u w=2.5u l=1u
X598 a_9514_58419# a_10182_63319# VSS VSS nfet_06v0 ad=0.65p pd=3.02u as=0.65p ps=3.02u w=2.5u l=1u
X599 VSS VDD VSS VSS nfet_06v0 ad=7.92p pd=36.88u as=0 ps=0 w=18u l=2u
X600 a_39182_40945# a_39182_40945# a_40818_40945# VDD pfet_06v0 ad=4.4p pd=20.88u as=3.3p ps=10.66u w=10u l=1u
X601 a_70256_21126# a_75022_25272# a_74490_25288# VSS nfet_06v0 ad=0.88p pd=4.88u as=0.88p ps=4.88u w=2u l=1u
X602 a_15646_63273# a_15646_63273# a_18154_62773# VSS nfet_06v0 ad=2.2p pd=10.88u as=1.65p ps=5.66u w=5u l=1u
X603 a_47856_21126# a_52622_25272# a_52090_25288# VSS nfet_06v0 ad=0.88p pd=4.88u as=0.88p ps=4.88u w=2u l=1u
X604 a_40542_35696# a_24694_35580# VDD VDD pfet_06v0 ad=2.5p pd=10.5u as=4.4p ps=20.88u w=10u l=1u
X605 a_75388_53540# Y VDD VDD pfet_05v0 ad=0.8052p pd=4.54u as=0.8052p ps=4.54u w=1.83u l=0.5u
X606 a_32586_41059# a_8870_45415# a_30026_40989# VDD pfet_06v0 ad=2.6p pd=10.52u as=4.4p ps=20.88u w=10u l=1u
X607 a_18154_66969# a_2254_66969# a_18354_67013# VSS nfet_06v0 ad=1.65p pd=5.66u as=1.25p ps=5.5u w=5u l=1u
X608 VSS a_33254_45959# a_32586_41059# VSS nfet_06v0 ad=0.65p pd=3.02u as=0.65p ps=3.02u w=2.5u l=1u
X609 a_72104_49876# a_72104_49876# VDD VDD pfet_06v0 ad=0.88p pd=4.88u as=0.88p ps=4.88u w=2u l=1u
X610 a_54654_70483# a_56438_67083# VSS VSS nfet_06v0 ad=0.65p pd=3.02u as=0.65p ps=3.02u w=2.5u l=1u
X611 a_32142_62819# a_33702_58419# VDD VDD pfet_06v0 ad=1.3p pd=5.52u as=1.3p ps=5.52u w=5u l=1u
X612 a_54654_70483# a_65974_67083# cap_mim_2f0_m4m5_noshield c_width=20u c_length=10u
X613 a_9070_45459# a_10630_41059# VDD VDD pfet_06v0 ad=1.3p pd=5.52u as=2.2p ps=10.88u w=5u l=1u
X614 a_64410_66969# a_48510_66969# a_64610_67013# VSS nfet_06v0 ad=1.65p pd=5.66u as=1.25p ps=5.5u w=5u l=1u
X615 a_7958_49723# a_10630_54123# VDD VDD pfet_06v0 ad=1.3p pd=5.52u as=1.3p ps=5.52u w=5u l=1u
X616 VDD Z Z VDD pfet_06v0 ad=0.52p pd=2.52u as=0.52p ps=2.52u w=2u l=1u
X617 VDD a_56886_58419# a_54214_62819# VDD pfet_06v0 ad=1.3p pd=5.52u as=1.3p ps=5.52u w=5u l=1u
X618 a_7758_66967# a_25568_33300# VDD VDD pfet_06v0 ad=0.44p pd=2.88u as=0.44p ps=2.88u w=1u l=1u
X619 a_88406_49640# a_42790_49723# a_87474_49596# VSS nfet_06v0 ad=0.25p pd=1.5u as=0.44p ps=2.88u w=1u l=1u
X620 a_47482_35696# a_47282_35580# a_48294_35696# VDD pfet_06v0 ad=4.4p pd=20.88u as=2.5p ps=10.5u w=10u l=1u
X621 a_8870_62775# a_3168_33300# VDD VDD pfet_06v0 ad=0.44p pd=2.88u as=0.44p ps=2.88u w=1u l=1u
X622 VDD VSS VDD VDD pfet_06v0 ad=4.29p pd=20.38u as=0 ps=0 w=9.75u l=2u
X623 a_37934_25588# a_24994_16886# VSS VSS nfet_06v0 ad=0.25p pd=1.5u as=0.44p ps=2.88u w=1u l=1u
X624 a_74490_25288# a_69642_24672# a_71806_16930# VSS nfet_06v0 ad=1.1p pd=5.88u as=0.825p ps=3.16u w=2.5u l=1u
X625 a_69342_24672# a_69642_24672# a_80558_24788# VSS nfet_06v0 ad=2.2p pd=10.88u as=1.25p ps=5.5u w=5u l=1u
X626 a_62366_40945# a_48510_46213# a_63566_45529# VSS nfet_06v0 ad=2.2p pd=10.88u as=1.25p ps=5.5u w=5u l=1u
X627 a_70694_11728# a_69382_11612# VDD VDD pfet_06v0 ad=2.5p pd=10.5u as=4.4p ps=20.88u w=10u l=1u
X628 a_15534_25588# a_2594_16886# VSS VSS nfet_06v0 ad=0.25p pd=1.5u as=0.44p ps=2.88u w=1u l=1u
X629 a_9070_62819# a_2594_58305# a_10630_58419# VDD pfet_06v0 ad=2.2p pd=10.88u as=1.3p ps=5.52u w=5u l=1u
X630 a_31030_49723# a_12006_25588# a_29666_49653# VSS nfet_06v0 ad=1.3p pd=5.52u as=2.2p ps=10.88u w=5u l=1u
X631 a_39430_16930# a_24694_16886# VDD VDD pfet_06v0 ad=2.5p pd=10.5u as=4.4p ps=20.88u w=10u l=1u
X632 VSS a_10182_67083# a_9514_70483# VSS nfet_06v0 ad=1.1p pd=5.88u as=0.65p ps=3.02u w=2.5u l=1u
X633 a_17746_58305# a_2594_58305# a_17946_58349# VDD pfet_06v0 ad=3.3p pd=10.66u as=2.5p ps=10.5u w=10u l=1u
X634 a_69642_28794# a_69642_28794# VSS VSS nfet_06v0 ad=0.44p pd=2.88u as=0.44p ps=2.88u w=1u l=1u
X635 a_26258_62889# a_26058_62773# VSS VSS nfet_06v0 ad=1.25p pd=5.5u as=2.2p ps=10.88u w=5u l=1u
X636 a_25666_40945# a_25666_40945# a_28322_46329# VSS nfet_06v0 ad=0.44p pd=2.88u as=0.25p ps=1.5u w=1u l=1u
X637 a_38718_63273# a_25666_58305# a_42462_58349# VDD pfet_06v0 ad=4.4p pd=20.88u as=2.5p ps=10.5u w=10u l=1u
X638 a_33702_58419# a_38718_63273# a_33254_63319# VSS nfet_06v0 ad=1.1p pd=5.88u as=1.1p ps=5.88u w=2.5u l=1u
X639 a_30830_45415# a_25568_9332# VDD VDD pfet_06v0 ad=0.44p pd=2.88u as=0.44p ps=2.88u w=1u l=1u
X640 a_47242_28794# a_47242_28794# VSS VSS nfet_06v0 ad=0.44p pd=2.88u as=0.44p ps=2.88u w=1u l=1u
X641 a_64002_58305# a_48850_58305# a_64202_58349# VDD pfet_06v0 ad=3.3p pd=10.66u as=2.5p ps=10.5u w=10u l=1u
X642 a_7758_45415# a_3168_9332# VDD VDD pfet_06v0 ad=0.44p pd=2.88u as=0.44p ps=2.88u w=1u l=1u
X643 a_4518_24288# a_6342_16930# VDD VDD pfet_06v0 ad=2.2p pd=10.88u as=2.2p ps=10.88u w=5u l=1u
X644 a_9390_12812# a_2554_4826# a_9598_4870# VSS nfet_06v0 ad=2.2p pd=10.88u as=1.25p ps=5.5u w=5u l=1u
X645 YP YN VDD VDD pfet_05v0 ad=0.8052p pd=4.54u as=0.8052p ps=4.54u w=1.83u l=0.5u
X646 a_46982_35580# a_47282_35580# a_64754_35696# VDD pfet_06v0 ad=4.4p pd=20.88u as=2.5p ps=10.5u w=10u l=1u
X647 a_86922_51052# a_65974_49723# a_73254_60502# VDD pfet_06v0 ad=0.75p pd=3.5u as=1.32p ps=6.88u w=3u l=1u
X648 a_55770_70483# a_56438_67083# VSS VSS nfet_06v0 ad=0.65p pd=3.02u as=1.1p ps=5.88u w=2.5u l=1u
X649 a_28602_58349# a_25366_58305# VDD VDD pfet_06v0 ad=2.5p pd=10.5u as=4.4p ps=20.88u w=10u l=1u
X650 a_42790_45459# a_34818_41059# VDD VDD pfet_06v0 ad=2.6p pd=10.52u as=4.4p ps=20.88u w=10u l=1u
X651 a_69682_35580# a_69682_35580# VDD VDD pfet_06v0 ad=0.88p pd=4.88u as=0.88p ps=4.88u w=2u l=1u
X652 a_10630_54123# a_15646_49609# a_10182_49723# VSS nfet_06v0 ad=1.1p pd=5.88u as=1.1p ps=5.88u w=2.5u l=1u
X653 a_25666_53077# a_25666_53077# a_28322_49653# VSS nfet_06v0 ad=0.44p pd=2.88u as=0.25p ps=1.5u w=1u l=1u
X654 a_72054_60546# a_72104_61958# VSS VSS nfet_06v0 ad=0.5456p pd=3.36u as=0.5456p ps=3.36u w=1.24u l=1u
X655 VDD VSS VDD VDD pfet_06v0 ad=0.44p pd=2.88u as=0 ps=0 w=1u l=2u
X656 a_25366_40945# a_25666_40945# a_27290_46329# VSS nfet_06v0 ad=0.44p pd=2.88u as=0.25p ps=1.5u w=1u l=1u
X657 a_56886_54123# a_61902_49609# a_56438_49723# VSS nfet_06v0 ad=1.1p pd=5.88u as=1.1p ps=5.88u w=2.5u l=1u
X658 a_71606_24288# a_73430_16930# VDD VDD pfet_06v0 ad=2.2p pd=10.88u as=2.2p ps=10.88u w=5u l=1u
X659 VSS a_19718_45459# a_83814_42758# VSS nfet_06v0 ad=0.44p pd=2.88u as=0.44p ps=2.88u w=1u l=1u
X660 a_7958_67083# a_2594_70437# a_11746_71483# VDD pfet_06v0 ad=2.2p pd=10.88u as=1.3p ps=5.52u w=5u l=1u
X661 a_69342_24672# a_69682_16886# a_85230_16930# VDD pfet_06v0 ad=4.4p pd=20.88u as=2.5p ps=10.5u w=10u l=1u
X662 a_32142_49723# a_33702_54123# VDD VDD pfet_06v0 ad=1.3p pd=5.52u as=2.2p ps=10.88u w=5u l=1u
X663 VDD VSS VDD VDD pfet_06v0 ad=4.29p pd=20.38u as=0 ps=0 w=9.75u l=2u
X664 a_49206_24288# a_51030_16930# VDD VDD pfet_06v0 ad=2.2p pd=10.88u as=2.2p ps=10.88u w=5u l=1u
X665 a_6954_53193# a_2594_53077# a_6654_53193# VDD pfet_06v0 ad=3.3p pd=10.66u as=2.5p ps=10.5u w=10u l=1u
X666 a_24654_4826# a_24994_11612# a_40542_11728# VDD pfet_06v0 ad=4.4p pd=20.88u as=2.5p ps=10.5u w=10u l=1u
X667 a_7758_66967# a_25568_33300# VDD VDD pfet_06v0 ad=0.44p pd=2.88u as=0.44p ps=2.88u w=1u l=1u
X668 a_28742_35696# a_30334_28794# a_28194_28794# VSS nfet_06v0 ad=0.88p pd=4.88u as=0.88p ps=4.88u w=2u l=1u
X669 a_31470_70483# a_42790_67083# cap_mim_2f0_m4m5_noshield c_width=20u c_length=10u
X670 a_8870_62775# a_3168_33300# VDD VDD pfet_06v0 ad=0.44p pd=2.88u as=0.44p ps=2.88u w=1u l=1u
X671 a_55326_62819# a_7758_62775# a_52850_62889# VSS nfet_06v0 ad=1.3p pd=5.52u as=2.2p ps=10.88u w=5u l=1u
X672 a_3606_35696# a_2294_35580# VDD VDD pfet_06v0 ad=2.5p pd=10.5u as=4.4p ps=20.88u w=10u l=1u
X673 VSS a_57550_45959# a_65974_45459# VSS nfet_06v0 ad=1.3p pd=5.52u as=1.3p ps=5.52u w=5u l=1u
X674 a_34366_49723# a_25326_49609# a_31470_53123# VSS nfet_06v0 ad=0.65p pd=3.02u as=1.1p ps=5.88u w=2.5u l=1u
X675 Y Y VDD VDD pfet_06v0 ad=0.52p pd=2.52u as=0.88p ps=4.88u w=2u l=1u
X676 a_25568_21126# a_24994_16886# a_26918_24288# VDD pfet_06v0 ad=4.4p pd=20.88u as=4.4p ps=20.88u w=10u l=1u
X677 a_25366_53077# a_25666_53077# a_27290_49653# VSS nfet_06v0 ad=0.44p pd=2.88u as=0.25p ps=1.5u w=1u l=1u
X678 a_47442_4870# a_47242_4826# a_47142_4870# VSS nfet_06v0 ad=2.2p pd=10.88u as=1.25p ps=5.5u w=5u l=1u
X679 VDD VSS VDD VDD pfet_06v0 ad=4.29p pd=20.38u as=0 ps=0 w=9.75u l=2u
X680 a_32586_58419# a_33254_63319# VSS VSS nfet_06v0 ad=0.65p pd=3.02u as=0.65p ps=3.02u w=2.5u l=1u
X681 a_6594_45529# a_7758_45415# a_7958_45459# VSS nfet_06v0 ad=2.2p pd=10.88u as=1.3p ps=5.52u w=5u l=1u
X682 VSS a_42790_62819# a_79086_60502# VSS nfet_06v0 ad=0.44p pd=2.88u as=0.33p ps=1.66u w=1u l=1u
X683 a_30334_4826# a_24994_11612# a_35070_11728# VDD pfet_06v0 ad=4.4p pd=20.88u as=2.5p ps=10.5u w=10u l=1u
X684 a_9514_53123# a_10182_49723# VSS VSS nfet_06v0 ad=0.65p pd=3.02u as=1.1p ps=5.88u w=2.5u l=1u
X685 VSS a_2986_49609# a_6926_49653# VSS nfet_06v0 ad=2.2p pd=10.88u as=1.25p ps=5.5u w=5u l=1u
X686 Z a_79086_60502# a_72304_62002# VSS nfet_06v0 ad=0.6448p pd=3u as=1.0912p ps=5.84u w=2.48u l=1u
X687 a_17746_40945# a_2594_40945# a_17946_40989# VDD pfet_06v0 ad=3.3p pd=10.66u as=2.5p ps=10.5u w=10u l=1u
X688 a_8398_58419# a_10182_63319# VSS VSS nfet_06v0 ad=0.65p pd=3.02u as=1.1p ps=5.88u w=2.5u l=1u
X689 a_38718_45913# a_25666_40945# a_42462_40989# VDD pfet_06v0 ad=4.4p pd=20.88u as=2.5p ps=10.5u w=10u l=1u
X690 a_9070_67083# a_10630_71483# VDD VDD pfet_06v0 ad=1.3p pd=5.52u as=1.3p ps=5.52u w=5u l=1u
X691 VDD a_2294_53077# a_7286_53193# VDD pfet_06v0 ad=4.4p pd=20.88u as=2.5p ps=10.5u w=10u l=1u
X692 a_19718_49723# a_7958_49723# cap_mim_2f0_m4m5_noshield c_width=20u c_length=10u
X693 a_64002_40945# a_48850_40945# a_64202_40989# VDD pfet_06v0 ad=3.3p pd=10.66u as=2.5p ps=10.5u w=10u l=1u
X694 a_56886_41059# a_48850_40945# a_55326_45459# VDD pfet_06v0 ad=1.3p pd=5.52u as=2.2p ps=10.88u w=5u l=1u
X695 a_54214_49723# a_48850_53077# a_58002_54123# VDD pfet_06v0 ad=2.2p pd=10.88u as=1.3p ps=5.52u w=5u l=1u
X696 a_40818_53077# a_25666_53077# a_41018_53193# VDD pfet_06v0 ad=3.3p pd=10.66u as=2.5p ps=10.5u w=10u l=1u
X697 a_26058_45413# a_25326_46213# a_26258_45529# VSS nfet_06v0 ad=2.2p pd=10.88u as=1.25p ps=5.5u w=5u l=1u
X698 VDD VSS VDD VDD pfet_06v0 ad=0.44p pd=2.88u as=0 ps=0 w=1u l=2u
X699 a_78314_11728# a_78114_11612# VDD VDD pfet_06v0 ad=2.5p pd=10.5u as=4.4p ps=20.88u w=10u l=1u
X700 XN a_75388_40976# VSS VSS nfet_05v0 ad=0.5808p pd=3.52u as=0.5808p ps=3.52u w=1.32u l=0.6u
X701 a_47856_9782# a_63274_9332# VSS ppolyf_u_1k r_width=1u r_length=76.45u
X702 VSS a_11294_49723# a_19718_49723# VSS nfet_06v0 ad=1.3p pd=5.52u as=1.3p ps=5.52u w=5u l=1u
X703 Z VDD a_75112_61754# VSS nfet_06v0 ad=0.6448p pd=3u as=1.0912p ps=5.84u w=2.48u l=1u
X704 a_20066_35696# a_2294_35580# VDD VDD pfet_06v0 ad=2.5p pd=10.5u as=4.4p ps=20.88u w=10u l=1u
X705 a_28602_40989# a_25366_40945# VDD VDD pfet_06v0 ad=2.5p pd=10.5u as=4.4p ps=20.88u w=10u l=1u
X706 a_77730_4870# a_77530_4826# VSS VSS nfet_06v0 ad=1.25p pd=5.5u as=2.2p ps=10.88u w=5u l=1u
X707 a_53210_58349# a_30830_62775# a_54654_58419# VDD pfet_06v0 ad=4.4p pd=20.88u as=2.6p ps=10.52u w=10u l=1u
X708 a_56438_67083# a_62366_71437# a_56886_71483# VDD pfet_06v0 ad=2.2p pd=10.88u as=2.2p ps=10.88u w=5u l=1u
X709 a_69642_4826# a_69682_11612# a_84118_11728# VDD pfet_06v0 ad=4.4p pd=20.88u as=2.5p ps=10.5u w=10u l=1u
X710 a_58158_28838# a_46942_28794# VSS VSS nfet_06v0 ad=1.25p pd=5.5u as=2.2p ps=10.88u w=5u l=1u
X711 a_11746_54123# a_2594_53077# a_7958_49723# VDD pfet_06v0 ad=1.3p pd=5.52u as=2.2p ps=10.88u w=5u l=1u
X712 a_9390_36780# a_9390_36780# a_11026_35580# VDD pfet_06v0 ad=4.4p pd=20.88u as=3.3p ps=10.66u w=10u l=1u
X713 VDD VSS VDD VDD pfet_06v0 ad=0.44p pd=2.88u as=0 ps=0 w=1u l=2u
X714 VSS a_33254_49723# a_32586_53123# VSS nfet_06v0 ad=1.1p pd=5.88u as=0.65p ps=3.02u w=2.5u l=1u
X715 a_33042_4870# a_32842_4826# VSS VSS nfet_06v0 ad=1.25p pd=5.5u as=2.2p ps=10.88u w=5u l=1u
X716 a_32142_49723# a_8870_49607# a_29666_49653# VSS nfet_06v0 ad=1.3p pd=5.52u as=2.2p ps=10.88u w=5u l=1u
X717 a_2494_70553# a_2294_70437# VDD VDD pfet_06v0 ad=2.5p pd=10.5u as=4.4p ps=20.88u w=10u l=1u
X718 VSS VDD VSS VSS nfet_06v0 ad=7.92p pd=36.88u as=0 ps=0 w=18u l=2u
X719 a_31470_70483# a_25326_66969# a_34366_67083# VSS nfet_06v0 ad=1.1p pd=5.88u as=0.65p ps=3.02u w=2.5u l=1u
X720 a_52850_45529# a_30830_45415# a_54214_45459# VSS nfet_06v0 ad=2.2p pd=10.88u as=1.3p ps=5.52u w=5u l=1u
X721 VSS a_10182_49723# a_8398_53123# VSS nfet_06v0 ad=0.65p pd=3.02u as=0.65p ps=3.02u w=2.5u l=1u
X722 a_30026_70553# a_30830_66967# a_31470_70483# VDD pfet_06v0 ad=4.4p pd=20.88u as=2.6p ps=10.52u w=10u l=1u
X723 VSS VDD VSS VSS nfet_06v0 ad=7.92p pd=36.88u as=0 ps=0 w=18u l=2u
X724 VSS VDD VSS VSS nfet_06v0 ad=4.29p pd=20.38u as=0 ps=0 w=9.75u l=2u
X725 a_17310_62889# a_2986_62773# VSS VSS nfet_06v0 ad=1.25p pd=5.5u as=2.2p ps=10.88u w=5u l=1u
X726 VSS VDD VSS VSS nfet_06v0 ad=7.92p pd=36.88u as=0 ps=0 w=18u l=2u
X727 a_6342_16930# a_7934_25272# a_5794_25172# VSS nfet_06v0 ad=0.88p pd=4.88u as=0.88p ps=4.88u w=2u l=1u
X728 a_31030_45459# a_25666_40945# a_34818_41059# VDD pfet_06v0 ad=2.2p pd=10.88u as=1.3p ps=5.52u w=5u l=1u
X729 a_6294_62889# a_2986_62773# VSS VSS nfet_06v0 ad=1.25p pd=5.5u as=2.2p ps=10.88u w=5u l=1u
X730 VSS VDD VSS VSS nfet_06v0 ad=7.92p pd=36.88u as=0 ps=0 w=18u l=2u
X731 VSS a_10182_67083# a_9514_70483# VSS nfet_06v0 ad=0.65p pd=3.02u as=0.65p ps=3.02u w=2.5u l=1u
X732 a_75154_66956# a_19718_67083# VDD VDD pfet_06v0 ad=0.99p pd=3.66u as=1.32p ps=6.88u w=3u l=1u
X733 a_2794_11728# a_2594_11612# a_3606_11728# VDD pfet_06v0 ad=4.4p pd=20.88u as=2.5p ps=10.5u w=10u l=1u
X734 a_46982_35580# a_47282_35580# a_59190_28838# VSS nfet_06v0 ad=0.44p pd=2.88u as=0.25p ps=1.5u w=1u l=1u
X735 a_73254_43142# a_87474_49596# VDD VDD pfet_06v0 ad=1.32p pd=6.88u as=1.32p ps=6.88u w=3u l=1u
X736 a_25568_20226# a_40986_19776# VSS ppolyf_u_1k r_width=1u r_length=76.45u
X737 a_25568_21126# a_30334_25272# a_29802_25288# VSS nfet_06v0 ad=0.88p pd=4.88u as=0.88p ps=4.88u w=2u l=1u
X738 a_29666_62889# a_30830_62775# a_31030_62819# VSS nfet_06v0 ad=2.2p pd=10.88u as=1.3p ps=5.52u w=5u l=1u
X739 VDD Y Y VDD pfet_06v0 ad=0.88p pd=4.88u as=0.52p ps=2.52u w=2u l=1u
X740 a_25886_4870# a_24654_4826# VSS VSS nfet_06v0 ad=1.25p pd=5.5u as=2.2p ps=10.88u w=5u l=1u
X741 Z a_77242_60502# a_77154_60546# VSS nfet_06v0 ad=0.6448p pd=3u as=1.0912p ps=5.84u w=2.48u l=1u
X742 a_75112_61754# a_72104_61958# VSS VSS nfet_06v0 ad=0.5456p pd=3.36u as=0.5456p ps=3.36u w=1.24u l=1u
X743 a_65974_62819# a_57550_63319# VSS VSS nfet_06v0 ad=1.3p pd=5.52u as=2.2p ps=10.88u w=5u l=1u
X744 a_52910_53193# a_48550_53077# VDD VDD pfet_06v0 ad=2.5p pd=10.5u as=4.4p ps=20.88u w=10u l=1u
X745 a_31470_58419# a_30830_62775# a_30026_58349# VDD pfet_06v0 ad=2.6p pd=10.52u as=4.4p ps=20.88u w=10u l=1u
X746 a_51030_16930# a_47282_16886# a_49938_24088# VDD pfet_06v0 ad=4.4p pd=20.88u as=4.4p ps=20.88u w=10u l=1u
X747 a_70256_9782# a_85674_9332# VSS ppolyf_u_1k r_width=1u r_length=76.45u
X748 VDD VSS VDD VDD pfet_06v0 ad=0.44p pd=2.88u as=0 ps=0 w=1u l=2u
X749 VDD a_25366_70437# a_30358_70553# VDD pfet_06v0 ad=4.4p pd=20.88u as=2.5p ps=10.5u w=10u l=1u
X750 a_34818_54123# a_38718_49609# a_34366_49723# VSS nfet_06v0 ad=1.1p pd=5.88u as=1.1p ps=5.88u w=2.5u l=1u
X751 a_8870_45415# a_49206_4870# cap_mim_2f0_m4m5_noshield c_width=25u c_length=8u
X752 a_51030_16930# a_52622_25272# a_50482_25172# VSS nfet_06v0 ad=0.88p pd=4.88u as=0.88p ps=4.88u w=2u l=1u
X753 a_19718_45459# a_11294_45959# VSS VSS nfet_06v0 ad=2.2p pd=10.88u as=1.3p ps=5.52u w=5u l=1u
X754 a_26918_24288# S1P a_25154_24788# VSS nfet_06v0 ad=3.3p pd=15.88u as=3.3p ps=15.88u w=7.5u l=1u
X755 a_56438_45959# a_48510_46213# a_55770_41059# VSS nfet_06v0 ad=0.65p pd=3.02u as=1.1p ps=5.88u w=2.5u l=1u
X756 a_19718_67083# a_7958_67083# cap_mim_2f0_m4m5_noshield c_width=20u c_length=10u
X757 a_6654_58349# a_2294_58305# VDD VDD pfet_06v0 ad=2.5p pd=10.5u as=4.4p ps=20.88u w=10u l=1u
X758 a_32142_45459# a_33702_41059# VDD VDD pfet_06v0 ad=1.3p pd=5.52u as=1.3p ps=5.52u w=5u l=1u
X759 a_32586_53123# a_33254_49723# VSS VSS nfet_06v0 ad=0.65p pd=3.02u as=1.1p ps=5.88u w=2.5u l=1u
X760 a_17946_70553# a_17746_70437# VDD VDD pfet_06v0 ad=2.5p pd=10.5u as=4.4p ps=20.88u w=10u l=1u
X761 a_41426_67013# a_41226_66969# VSS VSS nfet_06v0 ad=1.25p pd=5.5u as=2.2p ps=10.88u w=5u l=1u
X762 VDD X X VDD pfet_06v0 ad=0.52p pd=2.52u as=0.52p ps=2.52u w=2u l=1u
X763 VDD a_56886_41059# a_54214_45459# VDD pfet_06v0 ad=1.3p pd=5.52u as=1.3p ps=5.52u w=5u l=1u
X764 VSS a_33254_45959# a_31470_41059# VSS nfet_06v0 ad=0.65p pd=3.02u as=0.65p ps=3.02u w=2.5u l=1u
X765 a_13470_4870# a_2254_4826# VSS VSS nfet_06v0 ad=1.25p pd=5.5u as=2.2p ps=10.88u w=5u l=1u
X766 VSS a_19718_45459# a_88406_42758# VSS nfet_06v0 ad=0.44p pd=2.88u as=0.25p ps=1.5u w=1u l=1u
X767 a_31470_58419# a_33254_63319# VSS VSS nfet_06v0 ad=0.65p pd=3.02u as=1.1p ps=5.88u w=2.5u l=1u
X768 a_48850_70437# a_48850_70437# VDD VDD pfet_06v0 ad=0.88p pd=4.88u as=0.88p ps=4.88u w=2u l=1u
X769 a_5250_4870# S2N a_2754_4870# VSS nfet_06v0 ad=3.74p pd=17.88u as=3.74p ps=17.88u w=8.5u l=1u
X770 a_6594_45529# a_8870_45415# a_9070_45459# VSS nfet_06v0 ad=2.2p pd=10.88u as=1.3p ps=5.52u w=5u l=1u
X771 a_5794_25172# a_9390_16886# a_6342_16930# VDD pfet_06v0 ad=1.76p pd=8.88u as=1.76p ps=8.88u w=4u l=1u
X772 a_2594_11612# a_2594_11612# VDD VDD pfet_06v0 ad=0.88p pd=4.88u as=0.88p ps=4.88u w=2u l=1u
X773 a_2294_16886# a_2594_16886# a_14502_25588# VSS nfet_06v0 ad=0.44p pd=2.88u as=0.25p ps=1.5u w=1u l=1u
X774 a_54654_41059# a_56438_45959# VSS VSS nfet_06v0 ad=0.65p pd=3.02u as=1.1p ps=5.88u w=2.5u l=1u
X775 a_9070_45459# a_2594_40945# a_10630_41059# VDD pfet_06v0 ad=2.2p pd=10.88u as=1.3p ps=5.52u w=5u l=1u
X776 a_53542_53193# a_48850_53077# a_53210_53193# VDD pfet_06v0 ad=2.5p pd=10.5u as=3.3p ps=10.66u w=10u l=1u
X777 a_65974_62819# a_58002_58419# VDD VDD pfet_06v0 ad=4.4p pd=20.88u as=2.6p ps=10.52u w=10u l=1u
X778 a_46942_4826# a_47242_4826# a_58158_4870# VSS nfet_06v0 ad=2.2p pd=10.88u as=1.25p ps=5.5u w=5u l=1u
X779 a_24694_35580# a_24994_35580# a_42466_35696# VDD pfet_06v0 ad=4.4p pd=20.88u as=2.5p ps=10.5u w=10u l=1u
X780 VDD VSS VDD VDD pfet_06v0 ad=4.29p pd=20.38u as=0 ps=0 w=9.75u l=2u
X781 a_47442_24788# a_47242_24672# a_48174_24788# VSS nfet_06v0 ad=2.2p pd=10.88u as=1.25p ps=5.5u w=5u l=1u
X782 a_2294_35580# a_2594_35580# a_20066_35696# VDD pfet_06v0 ad=4.4p pd=20.88u as=2.5p ps=10.5u w=10u l=1u
X783 a_69342_28794# a_69642_28794# a_80558_28838# VSS nfet_06v0 ad=2.2p pd=10.88u as=1.25p ps=5.5u w=5u l=1u
X784 a_54214_67083# a_30830_66967# a_52850_67013# VSS nfet_06v0 ad=1.3p pd=5.52u as=2.2p ps=10.88u w=5u l=1u
X785 a_7286_58349# a_2594_58305# a_6954_58349# VDD pfet_06v0 ad=2.5p pd=10.5u as=3.3p ps=10.66u w=10u l=1u
X786 VSS a_87474_42642# a_77242_43142# VSS nfet_06v0 ad=0.44p pd=2.88u as=0.44p ps=2.88u w=1u l=1u
X787 a_16110_71437# a_16110_71437# a_17746_70437# VDD pfet_06v0 ad=4.4p pd=20.88u as=3.3p ps=10.66u w=10u l=1u
X788 a_16110_40945# a_2254_46213# a_17310_45529# VSS nfet_06v0 ad=2.2p pd=10.88u as=1.25p ps=5.5u w=5u l=1u
X789 a_75010_60642# Z a_76410_60712# VSS nfet_06v0 ad=0.88p pd=4.88u as=0.5p ps=2.5u w=2u l=1u
X790 a_6594_45529# a_2254_46213# a_6294_45529# VSS nfet_06v0 ad=1.65p pd=5.66u as=1.25p ps=5.5u w=5u l=1u
X791 a_51030_11728# a_52622_4826# a_50482_4826# VSS nfet_06v0 ad=0.88p pd=4.88u as=0.88p ps=4.88u w=2u l=1u
X792 a_62366_71437# a_62366_71437# a_64002_70437# VDD pfet_06v0 ad=4.4p pd=20.88u as=3.3p ps=10.66u w=10u l=1u
X793 a_70256_9332# a_69682_11612# a_71606_4870# VDD pfet_06v0 ad=4.4p pd=20.88u as=4.4p ps=20.88u w=10u l=1u
X794 a_5530_53193# a_2294_53077# VDD VDD pfet_06v0 ad=2.5p pd=10.5u as=4.4p ps=20.88u w=10u l=1u
X795 a_29802_4870# a_31790_12812# a_25568_9332# VDD pfet_06v0 ad=1.76p pd=8.88u as=1.76p ps=8.88u w=4u l=1u
X796 a_2594_11612# a_2594_11612# a_15534_4870# VSS nfet_06v0 ad=0.44p pd=2.88u as=0.25p ps=1.5u w=1u l=1u
X797 a_75388_58336# Z VSS VSS nfet_05v0 ad=0.5808p pd=3.52u as=0.5808p ps=3.52u w=1.32u l=0.6u
X798 a_7402_4870# a_9390_12812# a_3168_9332# VDD pfet_06v0 ad=1.76p pd=8.88u as=1.76p ps=8.88u w=4u l=1u
X799 a_29802_25288# a_24954_24672# a_27118_16930# VSS nfet_06v0 ad=1.1p pd=5.88u as=0.825p ps=3.16u w=2.5u l=1u
X800 a_26006_11728# a_24694_11612# VDD VDD pfet_06v0 ad=2.5p pd=10.5u as=4.4p ps=20.88u w=10u l=1u
X801 a_2594_16886# a_2594_16886# VDD VDD pfet_06v0 ad=0.88p pd=4.88u as=0.88p ps=4.88u w=2u l=1u
X802 a_53210_70553# a_7758_66967# a_55770_70483# VDD pfet_06v0 ad=4.4p pd=20.88u as=2.6p ps=10.52u w=10u l=1u
X803 a_2254_63573# a_2594_58305# a_2494_58349# VDD pfet_06v0 ad=4.4p pd=20.88u as=2.5p ps=10.5u w=10u l=1u
X804 a_49442_49653# a_49242_49609# VSS VSS nfet_06v0 ad=1.25p pd=5.5u as=2.2p ps=10.88u w=5u l=1u
X805 VSS a_33254_67083# a_32586_70483# VSS nfet_06v0 ad=0.65p pd=3.02u as=0.65p ps=3.02u w=2.5u l=1u
X806 a_6654_40989# a_2294_40945# VDD VDD pfet_06v0 ad=2.5p pd=10.5u as=4.4p ps=20.88u w=10u l=1u
X807 a_29366_49653# a_26058_49609# VSS VSS nfet_06v0 ad=1.25p pd=5.5u as=2.2p ps=10.88u w=5u l=1u
X808 a_62366_71437# a_48510_66969# a_63566_67013# VSS nfet_06v0 ad=2.2p pd=10.88u as=1.25p ps=5.5u w=5u l=1u
X809 a_38718_45913# a_38718_45913# a_41226_45413# VSS nfet_06v0 ad=2.2p pd=10.88u as=1.65p ps=5.66u w=5u l=1u
X810 a_28194_28794# a_24954_28794# a_27930_37596# VSS nfet_06v0 ad=1.1p pd=5.88u as=0.825p ps=3.16u w=2.5u l=1u
X811 a_11294_49723# a_16110_54077# a_11746_54123# VDD pfet_06v0 ad=2.2p pd=10.88u as=2.2p ps=10.88u w=5u l=1u
X812 a_5794_4826# a_2554_4826# a_5530_13628# VSS nfet_06v0 ad=1.1p pd=5.88u as=0.825p ps=3.16u w=2.5u l=1u
X813 a_32142_49723# a_25666_53077# a_33702_54123# VDD pfet_06v0 ad=2.2p pd=10.88u as=1.3p ps=5.52u w=5u l=1u
X814 VDD VSS VDD VDD pfet_06v0 ad=7.92p pd=36.88u as=0 ps=0 w=18u l=2u
X815 a_29666_62889# a_8870_62775# a_32142_62819# VSS nfet_06v0 ad=2.2p pd=10.88u as=1.3p ps=5.52u w=5u l=1u
X816 a_42790_45459# a_34366_45959# VSS VSS nfet_06v0 ad=2.2p pd=10.88u as=1.3p ps=5.52u w=5u l=1u
X817 a_2754_4870# a_2554_4826# a_2454_4870# VSS nfet_06v0 ad=2.2p pd=10.88u as=1.25p ps=5.5u w=5u l=1u
X818 a_52090_4870# a_47242_4826# a_49406_13618# VSS nfet_06v0 ad=1.1p pd=5.88u as=0.825p ps=3.16u w=2.5u l=1u
X819 VDD a_10630_71483# a_7958_67083# VDD pfet_06v0 ad=2.2p pd=10.88u as=1.3p ps=5.52u w=5u l=1u
X820 a_55770_58419# a_7758_62775# a_53210_58349# VDD pfet_06v0 ad=2.6p pd=10.52u as=4.4p ps=20.88u w=10u l=1u
X821 a_31470_58419# a_33254_63319# VSS VSS nfet_06v0 ad=0.65p pd=3.02u as=0.65p ps=3.02u w=2.5u l=1u
X822 a_85230_11728# a_69382_11612# VDD VDD pfet_06v0 ad=2.5p pd=10.5u as=4.4p ps=20.88u w=10u l=1u
X823 a_35070_35696# a_24694_35580# VDD VDD pfet_06v0 ad=2.5p pd=10.5u as=4.4p ps=20.88u w=10u l=1u
X824 a_7286_40989# a_2594_40945# a_6954_40989# VDD pfet_06v0 ad=2.5p pd=10.5u as=3.3p ps=10.66u w=10u l=1u
X825 a_55770_58419# a_56438_63319# VSS VSS nfet_06v0 ad=0.65p pd=3.02u as=0.65p ps=3.02u w=2.5u l=1u
X826 VSS a_10182_49723# a_8398_53123# VSS nfet_06v0 ad=1.1p pd=5.88u as=0.65p ps=3.02u w=2.5u l=1u
X827 VDD a_56886_71483# a_54214_67083# VDD pfet_06v0 ad=2.2p pd=10.88u as=1.3p ps=5.52u w=5u l=1u
X828 a_12670_35696# a_2294_35580# VDD VDD pfet_06v0 ad=2.5p pd=10.5u as=4.4p ps=20.88u w=10u l=1u
X829 a_75112_44394# VDD X VSS nfet_06v0 ad=1.0912p pd=5.84u as=0.6448p ps=3u w=2.48u l=1u
X830 a_9070_62819# a_8870_62775# a_6594_62889# VSS nfet_06v0 ad=1.3p pd=5.52u as=2.2p ps=10.88u w=5u l=1u
X831 a_52090_25288# a_47242_24672# a_49406_16930# VSS nfet_06v0 ad=1.1p pd=5.88u as=0.825p ps=3.16u w=2.5u l=1u
X832 a_24994_35580# a_24994_35580# a_37934_28838# VSS nfet_06v0 ad=0.44p pd=2.88u as=0.25p ps=1.5u w=1u l=1u
X833 VSS a_56438_63319# a_54654_58419# VSS nfet_06v0 ad=0.65p pd=3.02u as=0.65p ps=3.02u w=2.5u l=1u
X834 a_29802_4870# a_24954_4826# a_27118_13618# VSS nfet_06v0 ad=1.1p pd=5.88u as=0.825p ps=3.16u w=2.5u l=1u
X835 a_70256_9332# a_75022_4826# a_74490_4870# VSS nfet_06v0 ad=0.88p pd=4.88u as=0.88p ps=4.88u w=2u l=1u
X836 a_17030_16930# a_2294_16886# VDD VDD pfet_06v0 ad=2.5p pd=10.5u as=4.4p ps=20.88u w=10u l=1u
X837 VDD a_58002_71483# a_65974_67083# VDD pfet_06v0 ad=2.6p pd=10.52u as=2.6p ps=10.52u w=10u l=1u
X838 a_6954_53193# a_7758_49607# a_8398_53123# VDD pfet_06v0 ad=4.4p pd=20.88u as=2.6p ps=10.52u w=10u l=1u
X839 a_34818_71483# a_25666_70437# a_31030_67083# VDD pfet_06v0 ad=1.3p pd=5.52u as=2.2p ps=10.88u w=5u l=1u
X840 a_2454_24788# a_2254_24672# VSS VSS nfet_06v0 ad=1.25p pd=5.5u as=2.2p ps=10.88u w=5u l=1u
X841 a_65974_49723# a_57550_49723# VSS VSS nfet_06v0 ad=2.2p pd=10.88u as=1.3p ps=5.52u w=5u l=1u
X842 a_48510_66969# a_48850_70437# a_48750_70553# VDD pfet_06v0 ad=4.4p pd=20.88u as=2.5p ps=10.5u w=10u l=1u
X843 a_53210_40989# a_30830_45415# a_54654_41059# VDD pfet_06v0 ad=4.4p pd=20.88u as=2.6p ps=10.52u w=10u l=1u
X844 VDD a_33702_58419# a_31030_62819# VDD pfet_06v0 ad=1.3p pd=5.52u as=1.3p ps=5.52u w=5u l=1u
X845 a_36902_4870# a_24994_11612# VSS VSS nfet_06v0 ad=0.25p pd=1.5u as=0.44p ps=2.88u w=1u l=1u
X846 a_2254_46213# a_2594_40945# a_2494_40989# VDD pfet_06v0 ad=4.4p pd=20.88u as=2.5p ps=10.5u w=10u l=1u
X847 a_84118_35696# a_69382_35580# VDD VDD pfet_06v0 ad=2.5p pd=10.5u as=4.4p ps=20.88u w=10u l=1u
X848 a_2494_16930# a_2294_16886# VDD VDD pfet_06v0 ad=2.5p pd=10.5u as=4.4p ps=20.88u w=10u l=1u
X849 a_61718_35696# a_46982_35580# VDD VDD pfet_06v0 ad=2.5p pd=10.5u as=4.4p ps=20.88u w=10u l=1u
X850 a_10182_67083# a_16110_71437# a_10630_71483# VDD pfet_06v0 ad=2.2p pd=10.88u as=2.2p ps=10.88u w=5u l=1u
X851 a_55326_67083# a_7758_66967# a_52850_67013# VSS nfet_06v0 ad=1.3p pd=5.52u as=2.2p ps=10.88u w=5u l=1u
X852 a_33254_63319# a_25326_63573# a_32586_58419# VSS nfet_06v0 ad=0.65p pd=3.02u as=1.1p ps=5.88u w=2.5u l=1u
X853 a_47282_35580# a_47282_35580# VDD VDD pfet_06v0 ad=0.88p pd=4.88u as=0.88p ps=4.88u w=2u l=1u
X854 a_71806_13618# a_7758_49607# cap_mim_2f0_m4m5_noshield c_width=25u c_length=8u
X855 a_52550_45529# a_49242_45413# VSS VSS nfet_06v0 ad=1.25p pd=5.5u as=2.2p ps=10.88u w=5u l=1u
X856 VDD VSS VDD VDD pfet_06v0 ad=0.44p pd=2.88u as=0 ps=0 w=1u l=2u
X857 a_33426_16886# a_24994_16886# a_33626_16930# VDD pfet_06v0 ad=3.3p pd=10.66u as=2.5p ps=10.5u w=10u l=1u
X858 a_28194_28794# a_31790_36780# a_28742_35696# VDD pfet_06v0 ad=1.76p pd=8.88u as=1.76p ps=8.88u w=4u l=1u
X859 a_9514_53123# a_2254_49609# a_10182_49723# VSS nfet_06v0 ad=1.1p pd=5.88u as=0.65p ps=3.02u w=2.5u l=1u
X860 a_5250_46329# a_2594_40945# VSS VSS nfet_06v0 ad=0.25p pd=1.5u as=0.44p ps=2.88u w=1u l=1u
X861 a_11026_16886# a_2594_16886# a_11226_16930# VDD pfet_06v0 ad=3.3p pd=10.66u as=2.5p ps=10.5u w=10u l=1u
X862 a_5530_16930# a_5794_25172# VSS VSS nfet_06v0 ad=0.825p pd=3.16u as=1.1p ps=5.88u w=2.5u l=1u
X863 a_61902_66969# a_48850_70437# a_65646_70553# VDD pfet_06v0 ad=4.4p pd=20.88u as=2.5p ps=10.5u w=10u l=1u
X864 VDD VSS VDD VDD pfet_06v0 ad=4.29p pd=20.38u as=0 ps=0 w=9.75u l=2u
X865 a_9514_70483# a_8870_66967# a_6954_70553# VDD pfet_06v0 ad=2.6p pd=10.52u as=4.4p ps=20.88u w=10u l=1u
X866 a_46942_24672# a_47282_16886# a_62830_16930# VDD pfet_06v0 ad=4.4p pd=20.88u as=2.5p ps=10.5u w=10u l=1u
X867 VDD a_33702_71483# a_32142_67083# VDD pfet_06v0 ad=1.3p pd=5.52u as=1.3p ps=5.52u w=5u l=1u
X868 a_26058_66969# a_25326_66969# a_26258_67013# VSS nfet_06v0 ad=2.2p pd=10.88u as=1.25p ps=5.5u w=5u l=1u
X869 a_25194_35696# a_24994_35580# a_24894_35696# VDD pfet_06v0 ad=4.4p pd=20.88u as=2.5p ps=10.5u w=10u l=1u
X870 a_3168_34650# a_18586_34200# VSS ppolyf_u_1k r_width=1u r_length=76.45u
X871 a_53210_70553# a_48850_70437# a_52910_70553# VDD pfet_06v0 ad=3.3p pd=10.66u as=2.5p ps=10.5u w=10u l=1u
X872 VSS a_56438_45959# a_55770_41059# VSS nfet_06v0 ad=1.1p pd=5.88u as=0.65p ps=3.02u w=2.5u l=1u
X873 a_2594_53077# a_2594_53077# VDD VDD pfet_06v0 ad=0.88p pd=4.88u as=0.88p ps=4.88u w=2u l=1u
X874 VSS a_2986_62773# a_6926_62889# VSS nfet_06v0 ad=2.2p pd=10.88u as=1.25p ps=5.5u w=5u l=1u
X875 a_30830_45415# a_26918_4870# cap_mim_2f0_m4m5_noshield c_width=25u c_length=8u
X876 a_77154_43186# a_77242_43142# X VSS nfet_06v0 ad=1.0912p pd=5.84u as=0.6448p ps=3u w=2.48u l=1u
X877 a_74368_49992# a_72104_49876# a_74068_49992# VSS nfet_06v0 ad=0.175p pd=1.2u as=0.175p ps=1.2u w=0.7u l=1u
X878 a_28742_16930# a_30334_25272# a_28194_25172# VSS nfet_06v0 ad=0.88p pd=4.88u as=0.88p ps=4.88u w=2u l=1u
X879 a_73166_60546# a_72104_61958# VSS VSS nfet_06v0 ad=0.5456p pd=3.36u as=0.5456p ps=3.36u w=1.24u l=1u
X880 a_73768_44750# a_72104_44598# VSS VSS nfet_06v0 ad=0.175p pd=1.2u as=0.308p ps=2.28u w=0.7u l=1u
X881 VDD a_56886_71483# a_55326_67083# VDD pfet_06v0 ad=2.2p pd=10.88u as=1.3p ps=5.52u w=5u l=1u
X882 a_49406_16930# S4P a_47482_16930# VDD pfet_06v0 ad=0.242p pd=1.98u as=0.242p ps=1.98u w=0.55u l=1u
X883 a_27930_37596# S4N a_25194_35696# VDD pfet_06v0 ad=0.22p pd=1.88u as=0.22p ps=1.88u w=0.5u l=1u
X884 a_5250_49653# a_2594_53077# VSS VSS nfet_06v0 ad=0.25p pd=1.5u as=0.44p ps=2.88u w=1u l=1u
X885 a_34366_49723# a_39182_54077# a_34818_54123# VDD pfet_06v0 ad=2.2p pd=10.88u as=2.2p ps=10.88u w=5u l=1u
X886 a_8870_45415# a_47856_9332# VDD VDD pfet_06v0 ad=0.44p pd=2.88u as=0.44p ps=2.88u w=1u l=1u
X887 a_31470_41059# a_30830_45415# a_30026_40989# VDD pfet_06v0 ad=2.6p pd=10.52u as=4.4p ps=20.88u w=10u l=1u
X888 a_65974_49723# a_58002_54123# VDD VDD pfet_06v0 ad=2.6p pd=10.52u as=4.4p ps=20.88u w=10u l=1u
X889 a_72618_16930# a_72882_25172# VSS VSS nfet_06v0 ad=0.825p pd=3.16u as=1.1p ps=5.88u w=2.5u l=1u
X890 VDD a_10630_58419# a_9070_62819# VDD pfet_06v0 ad=2.2p pd=10.88u as=1.3p ps=5.52u w=5u l=1u
X891 a_39182_54077# a_25326_49609# a_40382_49653# VSS nfet_06v0 ad=2.2p pd=10.88u as=1.25p ps=5.5u w=5u l=1u
X892 a_7934_4826# a_2594_11612# a_12670_11728# VDD pfet_06v0 ad=4.4p pd=20.88u as=2.5p ps=10.5u w=10u l=1u
X893 a_47856_9782# a_63274_10232# VSS ppolyf_u_1k r_width=1u r_length=76.45u
X894 a_50218_16930# a_50482_25172# VSS VSS nfet_06v0 ad=0.825p pd=3.16u as=1.1p ps=5.88u w=2.5u l=1u
X895 a_70256_34650# a_85674_34200# VSS ppolyf_u_1k r_width=1u r_length=76.45u
X896 a_24654_4826# a_24954_4826# a_35870_4870# VSS nfet_06v0 ad=2.2p pd=10.88u as=1.25p ps=5.5u w=5u l=1u
X897 VSS VDD VSS VSS nfet_06v0 ad=0.44p pd=2.88u as=0 ps=0 w=1u l=2u
X898 VSS a_34366_63319# a_42790_62819# VSS nfet_06v0 ad=1.3p pd=5.52u as=1.3p ps=5.52u w=5u l=1u
X899 VSS VDD VSS VSS nfet_06v0 ad=0.44p pd=2.88u as=0 ps=0 w=1u l=2u
X900 a_19390_70553# a_2294_70437# VDD VDD pfet_06v0 ad=2.5p pd=10.5u as=4.4p ps=20.88u w=10u l=1u
X901 a_55914_11728# a_55714_11612# VDD VDD pfet_06v0 ad=2.5p pd=10.5u as=4.4p ps=20.88u w=10u l=1u
X902 a_32586_41059# a_25326_46213# a_33254_45959# VSS nfet_06v0 ad=1.1p pd=5.88u as=0.65p ps=3.02u w=2.5u l=1u
X903 a_5530_13628# a_5794_4826# VSS VSS nfet_06v0 ad=0.825p pd=3.16u as=1.1p ps=5.88u w=2.5u l=1u
X904 a_7758_66967# a_29802_28838# VSS VSS nfet_06v0 ad=0.44p pd=2.88u as=0.44p ps=2.88u w=1u l=1u
X905 a_51506_46329# a_48850_40945# VSS VSS nfet_06v0 ad=0.25p pd=1.5u as=0.44p ps=2.88u w=1u l=1u
X906 a_83814_42758# a_19718_45459# VDD VDD pfet_06v0 ad=1.32p pd=6.88u as=1.32p ps=6.88u w=3u l=1u
X907 a_2294_58305# a_2594_58305# a_4218_63689# VSS nfet_06v0 ad=0.44p pd=2.88u as=0.25p ps=1.5u w=1u l=1u
X908 X X a_75010_43282# VSS nfet_06v0 ad=0.52p pd=2.52u as=0.88p ps=4.88u w=2u l=1u
X909 a_65974_45459# a_58002_41059# VDD VDD pfet_06v0 ad=4.4p pd=20.88u as=2.6p ps=10.52u w=10u l=1u
X910 a_47242_4826# a_47282_11612# a_61718_11728# VDD pfet_06v0 ad=4.4p pd=20.88u as=2.5p ps=10.5u w=10u l=1u
X911 a_10182_45959# a_2254_46213# a_9514_41059# VSS nfet_06v0 ad=0.65p pd=3.02u as=1.1p ps=5.88u w=2.5u l=1u
X912 a_2986_66969# a_2594_70437# a_3606_70553# VDD pfet_06v0 ad=4.4p pd=20.88u as=2.5p ps=10.5u w=10u l=1u
X913 a_42790_45459# a_34366_45959# VSS VSS nfet_06v0 ad=1.3p pd=5.52u as=2.2p ps=10.88u w=5u l=1u
X914 VSS a_42790_45459# a_77242_60502# VSS nfet_06v0 ad=0.44p pd=2.88u as=0.33p ps=1.66u w=1u l=1u
X915 VDD a_10630_71483# a_7958_67083# VDD pfet_06v0 ad=1.3p pd=5.52u as=1.3p ps=5.52u w=5u l=1u
X916 a_19718_67083# a_11746_71483# VDD VDD pfet_06v0 ad=4.4p pd=20.88u as=2.6p ps=10.52u w=10u l=1u
X917 a_54214_62819# a_56886_58419# VDD VDD pfet_06v0 ad=1.3p pd=5.52u as=1.3p ps=5.52u w=5u l=1u
X918 VSS VDD VSS VSS nfet_06v0 ad=4.29p pd=20.38u as=0 ps=0 w=9.75u l=2u
X919 a_18142_16930# a_2294_16886# VDD VDD pfet_06v0 ad=2.5p pd=10.5u as=4.4p ps=20.88u w=10u l=1u
X920 a_55326_67083# a_56886_71483# VDD VDD pfet_06v0 ad=1.3p pd=5.52u as=2.2p ps=10.88u w=5u l=1u
X921 a_48510_46213# a_48510_46213# VSS VSS nfet_06v0 ad=0.44p pd=2.88u as=0.44p ps=2.88u w=1u l=1u
X922 a_51506_49653# a_48850_53077# VSS VSS nfet_06v0 ad=0.25p pd=1.5u as=0.44p ps=2.88u w=1u l=1u
X923 a_55326_49723# a_56886_54123# VDD VDD pfet_06v0 ad=1.3p pd=5.52u as=1.3p ps=5.52u w=5u l=1u
X924 a_76478_12812# a_76478_12812# a_78114_11612# VDD pfet_06v0 ad=4.4p pd=20.88u as=3.3p ps=10.66u w=10u l=1u
X925 a_47442_28838# a_47242_28794# a_48174_28838# VSS nfet_06v0 ad=2.2p pd=10.88u as=1.25p ps=5.5u w=5u l=1u
X926 VSS VDD VSS VSS nfet_06v0 ad=0.44p pd=2.88u as=0 ps=0 w=1u l=2u
X927 a_50474_46329# a_48850_40945# VSS VSS nfet_06v0 ad=0.25p pd=1.5u as=0.44p ps=2.88u w=1u l=1u
X928 a_49242_66969# a_48850_70437# a_49862_70553# VDD pfet_06v0 ad=4.4p pd=20.88u as=2.5p ps=10.5u w=10u l=1u
X929 a_29666_67013# a_30830_66967# a_31030_67083# VSS nfet_06v0 ad=2.2p pd=10.88u as=1.3p ps=5.52u w=5u l=1u
X930 a_54078_12812# a_54078_12812# a_55714_11612# VDD pfet_06v0 ad=4.4p pd=20.88u as=3.3p ps=10.66u w=10u l=1u
X931 a_18354_45529# a_18154_45413# VSS VSS nfet_06v0 ad=1.25p pd=5.5u as=2.2p ps=10.88u w=5u l=1u
X932 Y a_72142_51084# a_72054_51200# VSS nfet_06v0 ad=0.6448p pd=3u as=1.0912p ps=5.84u w=2.48u l=1u
X933 a_33254_67083# a_39182_71437# a_33702_71483# VDD pfet_06v0 ad=2.2p pd=10.88u as=2.2p ps=10.88u w=5u l=1u
X934 a_30026_53193# a_25666_53077# a_29726_53193# VDD pfet_06v0 ad=3.3p pd=10.66u as=2.5p ps=10.5u w=10u l=1u
X935 a_5250_28838# a_6342_35696# VDD VDD pfet_06v0 ad=2.2p pd=10.88u as=2.2p ps=10.88u w=5u l=1u
X936 a_65974_67083# a_57550_67083# VSS VSS nfet_06v0 ad=1.3p pd=5.52u as=2.2p ps=10.88u w=5u l=1u
X937 a_64610_45529# a_64410_45413# VSS VSS nfet_06v0 ad=1.25p pd=5.5u as=2.2p ps=10.88u w=5u l=1u
X938 VDD a_10630_54123# a_9070_49723# VDD pfet_06v0 ad=1.3p pd=5.52u as=1.3p ps=5.52u w=5u l=1u
X939 a_48510_49609# a_48510_49609# VSS VSS nfet_06v0 ad=0.44p pd=2.88u as=0.44p ps=2.88u w=1u l=1u
X940 a_56438_67083# a_48510_66969# a_55770_70483# VSS nfet_06v0 ad=0.65p pd=3.02u as=1.1p ps=5.88u w=2.5u l=1u
X941 a_34366_63319# a_25326_63573# a_31470_58419# VSS nfet_06v0 ad=0.65p pd=3.02u as=1.1p ps=5.88u w=2.5u l=1u
X942 VDD VSS VDD VDD pfet_06v0 ad=7.92p pd=36.88u as=0 ps=0 w=18u l=2u
X943 a_50474_49653# a_48850_53077# VSS VSS nfet_06v0 ad=0.25p pd=1.5u as=0.44p ps=2.88u w=1u l=1u
X944 a_8398_53123# a_2254_49609# a_11294_49723# VSS nfet_06v0 ad=1.1p pd=5.88u as=0.65p ps=3.02u w=2.5u l=1u
X945 a_3168_34650# a_8870_62775# VSS ppolyf_u_1k r_width=1u r_length=76.45u
X946 VSS a_33254_67083# a_31470_70483# VSS nfet_06v0 ad=0.65p pd=3.02u as=0.65p ps=3.02u w=2.5u l=1u
X947 a_9514_58419# a_10182_63319# VSS VSS nfet_06v0 ad=0.65p pd=3.02u as=1.1p ps=5.88u w=2.5u l=1u
X948 a_79758_35696# a_69382_35580# VDD VDD pfet_06v0 ad=2.5p pd=10.5u as=4.4p ps=20.88u w=10u l=1u
X949 a_72142_60502# a_65974_67083# VSS VSS nfet_06v0 ad=0.33p pd=1.66u as=0.44p ps=2.88u w=1u l=1u
X950 a_72338_28838# a_73430_35696# VDD VDD pfet_06v0 ad=2.2p pd=10.88u as=2.2p ps=10.88u w=5u l=1u
X951 VDD VSS VDD VDD pfet_06v0 ad=0.44p pd=2.88u as=0 ps=0 w=1u l=2u
X952 a_30830_62775# a_70256_21126# VDD VDD pfet_06v0 ad=0.44p pd=2.88u as=0.44p ps=2.88u w=1u l=1u
X953 a_47856_19326# a_7758_62775# VSS ppolyf_u_1k r_width=1u r_length=76.45u
X954 a_7758_66967# a_26918_28838# cap_mim_2f0_m4m5_noshield c_width=25u c_length=8u
X955 a_57358_35696# a_46982_35580# VDD VDD pfet_06v0 ad=2.5p pd=10.5u as=4.4p ps=20.88u w=10u l=1u
X956 a_49938_28838# a_51030_35696# VDD VDD pfet_06v0 ad=2.2p pd=10.88u as=2.2p ps=10.88u w=5u l=1u
X957 Y Y a_75010_51200# VSS nfet_06v0 ad=0.52p pd=2.52u as=0.88p ps=4.88u w=2u l=1u
X958 a_70694_16930# a_69382_16886# VDD VDD pfet_06v0 ad=2.5p pd=10.5u as=4.4p ps=20.88u w=10u l=1u
X959 a_16110_71437# a_2254_66969# a_17310_67013# VSS nfet_06v0 ad=2.2p pd=10.88u as=1.25p ps=5.5u w=5u l=1u
X960 VDD VSS VDD VDD pfet_06v0 ad=4.29p pd=20.38u as=0 ps=0 w=9.75u l=2u
X961 a_54654_70483# a_56438_67083# VSS VSS nfet_06v0 ad=0.65p pd=3.02u as=1.1p ps=5.88u w=2.5u l=1u
X962 a_25568_9782# a_40986_9332# VSS ppolyf_u_1k r_width=1u r_length=76.45u
X963 a_6594_67013# a_2254_66969# a_6294_67013# VSS nfet_06v0 ad=1.65p pd=5.66u as=1.25p ps=5.5u w=5u l=1u
X964 a_61902_45913# a_61902_45913# a_64410_45413# VSS nfet_06v0 ad=2.2p pd=10.88u as=1.65p ps=5.66u w=5u l=1u
X965 a_39182_54077# a_39182_54077# a_40818_53077# VDD pfet_06v0 ad=4.4p pd=20.88u as=3.3p ps=10.66u w=10u l=1u
X966 VDD a_11746_54123# a_19718_49723# VDD pfet_06v0 ad=2.6p pd=10.52u as=2.6p ps=10.52u w=10u l=1u
X967 a_7958_49723# a_10630_54123# VDD VDD pfet_06v0 ad=1.3p pd=5.52u as=2.2p ps=10.88u w=5u l=1u
X968 a_70256_34650# a_8870_66967# VSS ppolyf_u_1k r_width=1u r_length=76.45u
X969 a_55770_41059# a_7758_45415# a_53210_40989# VDD pfet_06v0 ad=2.6p pd=10.52u as=4.4p ps=20.88u w=10u l=1u
X970 a_31030_45459# a_30830_45415# a_29666_45529# VSS nfet_06v0 ad=1.3p pd=5.52u as=2.2p ps=10.88u w=5u l=1u
X971 a_54214_49723# a_56886_54123# VDD VDD pfet_06v0 ad=1.3p pd=5.52u as=2.2p ps=10.88u w=5u l=1u
X972 a_24954_28794# a_24954_28794# VSS VSS nfet_06v0 ad=0.44p pd=2.88u as=0.44p ps=2.88u w=1u l=1u
X973 VDD VSS VDD VDD pfet_06v0 ad=4.29p pd=20.38u as=0 ps=0 w=9.75u l=2u
X974 a_3168_9332# a_2594_11612# a_4518_4870# VDD pfet_06v0 ad=4.4p pd=20.88u as=4.4p ps=20.88u w=10u l=1u
X975 a_2554_28794# a_2554_28794# VSS VSS nfet_06v0 ad=0.44p pd=2.88u as=0.44p ps=2.88u w=1u l=1u
X976 a_83814_60230# a_19718_62819# VDD VDD pfet_06v0 ad=1.32p pd=6.88u as=1.32p ps=6.88u w=3u l=1u
X977 a_77154_43186# a_72104_44598# VSS VSS nfet_06v0 ad=0.5456p pd=3.36u as=0.5456p ps=3.36u w=1.24u l=1u
X978 a_30026_58349# a_8870_62775# a_32586_58419# VDD pfet_06v0 ad=4.4p pd=20.88u as=2.6p ps=10.52u w=10u l=1u
X979 a_71606_4870# S4P a_69842_4870# VSS nfet_06v0 ad=3.3p pd=15.88u as=3.3p ps=15.88u w=7.5u l=1u
X980 VDD VSS VDD VDD pfet_06v0 ad=4.29p pd=20.38u as=0 ps=0 w=9.75u l=2u
X981 a_10630_54123# a_2594_53077# a_9070_49723# VDD pfet_06v0 ad=1.3p pd=5.52u as=2.2p ps=10.88u w=5u l=1u
X982 VSS a_33254_63319# a_32586_58419# VSS nfet_06v0 ad=1.1p pd=5.88u as=0.65p ps=3.02u w=2.5u l=1u
X983 a_8398_70483# a_7758_66967# a_6954_70553# VDD pfet_06v0 ad=2.6p pd=10.52u as=4.4p ps=20.88u w=10u l=1u
X984 a_25566_70553# a_25366_70437# VDD VDD pfet_06v0 ad=2.5p pd=10.5u as=4.4p ps=20.88u w=10u l=1u
X985 VSS VDD VSS VSS nfet_06v0 ad=4.29p pd=20.38u as=0 ps=0 w=9.75u l=2u
X986 VDD a_33702_41059# a_31030_45459# VDD pfet_06v0 ad=1.3p pd=5.52u as=1.3p ps=5.52u w=5u l=1u
X987 a_41018_58349# a_40818_58305# VDD VDD pfet_06v0 ad=2.5p pd=10.5u as=4.4p ps=20.88u w=10u l=1u
X988 a_38718_66969# a_38718_66969# a_41226_66969# VSS nfet_06v0 ad=2.2p pd=10.88u as=1.65p ps=5.66u w=5u l=1u
X989 a_72882_28794# a_76478_36780# a_73430_35696# VDD pfet_06v0 ad=1.76p pd=8.88u as=1.76p ps=8.88u w=4u l=1u
X990 a_24994_35580# a_24994_35580# VDD VDD pfet_06v0 ad=0.88p pd=4.88u as=0.88p ps=4.88u w=2u l=1u
X991 a_49406_37586# S3P a_47482_35696# VDD pfet_06v0 ad=0.242p pd=1.98u as=0.242p ps=1.98u w=0.55u l=1u
X992 a_15646_63273# a_2594_58305# a_19390_58349# VDD pfet_06v0 ad=4.4p pd=20.88u as=2.5p ps=10.5u w=10u l=1u
X993 a_25666_70437# a_25666_70437# VDD VDD pfet_06v0 ad=0.88p pd=4.88u as=0.88p ps=4.88u w=2u l=1u
X994 VSS a_10182_63319# a_8398_58419# VSS nfet_06v0 ad=0.65p pd=3.02u as=0.65p ps=3.02u w=2.5u l=1u
X995 a_50482_28794# a_54078_36780# a_51030_35696# VDD pfet_06v0 ad=1.76p pd=8.88u as=1.76p ps=8.88u w=4u l=1u
X996 a_69382_11612# a_69682_11612# a_87154_11728# VDD pfet_06v0 ad=4.4p pd=20.88u as=2.5p ps=10.5u w=10u l=1u
X997 a_42790_67083# a_34818_71483# VDD VDD pfet_06v0 ad=4.4p pd=20.88u as=2.6p ps=10.52u w=10u l=1u
X998 a_49442_62889# a_49242_62773# VSS VSS nfet_06v0 ad=1.25p pd=5.5u as=2.2p ps=10.88u w=5u l=1u
X999 a_47856_9332# a_47282_11612# a_49206_4870# VDD pfet_06v0 ad=4.4p pd=20.88u as=4.4p ps=20.88u w=10u l=1u
X1000 a_26918_24288# a_28742_16930# VDD VDD pfet_06v0 ad=2.2p pd=10.88u as=2.2p ps=10.88u w=5u l=1u
X1001 a_2454_28838# a_2254_28794# VSS VSS nfet_06v0 ad=1.25p pd=5.5u as=2.2p ps=10.88u w=5u l=1u
X1002 a_29366_62889# a_26058_62773# VSS VSS nfet_06v0 ad=1.25p pd=5.5u as=2.2p ps=10.88u w=5u l=1u
X1003 a_24654_24672# a_24994_16886# a_40542_16930# VDD pfet_06v0 ad=4.4p pd=20.88u as=2.5p ps=10.5u w=10u l=1u
X1004 VDD VSS VDD VDD pfet_06v0 ad=7.92p pd=36.88u as=0 ps=0 w=18u l=2u
X1005 VDD a_42790_67083# a_75154_66956# VDD pfet_06v0 ad=1.32p pd=6.88u as=0.99p ps=3.66u w=3u l=1u
X1006 a_30830_62775# a_70256_21126# VDD VDD pfet_06v0 ad=0.44p pd=2.88u as=0.44p ps=2.88u w=1u l=1u
X1007 a_84634_49596# a_65974_49723# VDD VDD pfet_06v0 ad=0.99p pd=3.66u as=1.32p ps=6.88u w=3u l=1u
X1008 a_72104_44598# a_72104_44598# a_74368_44750# VSS nfet_06v0 ad=0.308p pd=2.28u as=0.175p ps=1.2u w=0.7u l=1u
X1009 a_6954_58349# a_8870_62775# a_9514_58419# VDD pfet_06v0 ad=4.4p pd=20.88u as=2.6p ps=10.52u w=10u l=1u
X1010 a_7758_62775# a_47856_21126# VDD VDD pfet_06v0 ad=0.44p pd=2.88u as=0.44p ps=2.88u w=1u l=1u
X1011 a_75022_4826# a_69682_11612# a_79758_11728# VDD pfet_06v0 ad=4.4p pd=20.88u as=2.5p ps=10.5u w=10u l=1u
X1012 a_30334_25272# a_24994_16886# a_35070_16930# VDD pfet_06v0 ad=4.4p pd=20.88u as=2.5p ps=10.5u w=10u l=1u
X1013 a_52622_4826# a_47282_11612# a_57358_11728# VDD pfet_06v0 ad=4.4p pd=20.88u as=2.5p ps=10.5u w=10u l=1u
X1014 a_29666_67013# a_8870_66967# a_32142_67083# VSS nfet_06v0 ad=2.2p pd=10.88u as=1.3p ps=5.52u w=5u l=1u
X1015 a_72304_49992# a_79086_51084# Y VSS nfet_06v0 ad=1.0912p pd=5.84u as=0.6448p ps=3u w=2.48u l=1u
X1016 Y a_73254_51084# a_73166_51200# VSS nfet_06v0 ad=0.6448p pd=3u as=1.0912p ps=5.84u w=2.48u l=1u
X1017 a_25568_9782# a_40986_10232# VSS ppolyf_u_1k r_width=1u r_length=76.45u
X1018 a_88406_60230# a_42790_62819# a_87474_60114# VSS nfet_06v0 ad=0.25p pd=1.5u as=0.44p ps=2.88u w=1u l=1u
X1019 a_69842_4870# a_69642_4826# a_70574_4870# VSS nfet_06v0 ad=2.2p pd=10.88u as=1.25p ps=5.5u w=5u l=1u
X1020 a_27930_13628# a_28194_4826# VSS VSS nfet_06v0 ad=0.825p pd=3.16u as=1.1p ps=5.88u w=2.5u l=1u
X1021 a_29726_58349# a_25366_58305# VDD VDD pfet_06v0 ad=2.5p pd=10.5u as=4.4p ps=20.88u w=10u l=1u
X1022 a_32586_58419# a_33254_63319# VSS VSS nfet_06v0 ad=0.65p pd=3.02u as=1.1p ps=5.88u w=2.5u l=1u
X1023 a_9070_67083# a_8870_66967# a_6594_67013# VSS nfet_06v0 ad=1.3p pd=5.52u as=2.2p ps=10.88u w=5u l=1u
X1024 a_47856_20226# a_63274_20676# VSS ppolyf_u_1k r_width=1u r_length=76.45u
X1025 a_78314_16930# a_78114_16886# VDD VDD pfet_06v0 ad=2.5p pd=10.5u as=4.4p ps=20.88u w=10u l=1u
X1026 VDD a_10630_41059# a_9070_45459# VDD pfet_06v0 ad=2.2p pd=10.88u as=1.3p ps=5.52u w=5u l=1u
X1027 a_57550_49723# a_48510_49609# a_54654_53123# VSS nfet_06v0 ad=0.65p pd=3.02u as=1.1p ps=5.88u w=2.5u l=1u
X1028 a_33626_11728# a_33426_11612# VDD VDD pfet_06v0 ad=2.5p pd=10.5u as=4.4p ps=20.88u w=10u l=1u
X1029 a_28742_35696# a_24994_35580# a_27650_28838# VDD pfet_06v0 ad=4.4p pd=20.88u as=4.4p ps=20.88u w=10u l=1u
X1030 VSS a_11294_45959# a_19718_45459# VSS nfet_06v0 ad=1.3p pd=5.52u as=1.3p ps=5.52u w=5u l=1u
X1031 a_11226_11728# a_11026_11612# VDD VDD pfet_06v0 ad=2.5p pd=10.5u as=4.4p ps=20.88u w=10u l=1u
X1032 a_8398_58419# a_19718_62819# cap_mim_2f0_m4m5_noshield c_width=20u c_length=10u
X1033 VSS VDD VSS VSS nfet_06v0 ad=7.92p pd=36.88u as=0 ps=0 w=18u l=2u
X1034 a_69582_35696# a_69382_35580# VDD VDD pfet_06v0 ad=2.5p pd=10.5u as=4.4p ps=20.88u w=10u l=1u
X1035 a_8398_41059# a_10182_45959# VSS VSS nfet_06v0 ad=0.65p pd=3.02u as=0.65p ps=3.02u w=2.5u l=1u
X1036 a_29998_49653# a_25326_49609# a_29666_49653# VSS nfet_06v0 ad=1.25p pd=5.5u as=1.65p ps=5.66u w=5u l=1u
X1037 a_62830_11728# a_46982_11612# VDD VDD pfet_06v0 ad=2.5p pd=10.5u as=4.4p ps=20.88u w=10u l=1u
X1038 a_69642_24672# a_69682_16886# a_84118_16930# VDD pfet_06v0 ad=4.4p pd=20.88u as=2.5p ps=10.5u w=10u l=1u
X1039 VSS VDD VSS VSS nfet_06v0 ad=7.92p pd=36.88u as=0 ps=0 w=18u l=2u
X1040 a_41018_40989# a_40818_40945# VDD VDD pfet_06v0 ad=2.5p pd=10.5u as=4.4p ps=20.88u w=10u l=1u
X1041 VDD a_34818_54123# a_42790_49723# VDD pfet_06v0 ad=2.6p pd=10.52u as=2.6p ps=10.52u w=10u l=1u
X1042 a_3168_9332# a_18586_9332# VSS ppolyf_u_1k r_width=1u r_length=76.45u
X1043 a_15646_45913# a_2594_40945# a_19390_40989# VDD pfet_06v0 ad=4.4p pd=20.88u as=2.5p ps=10.5u w=10u l=1u
X1044 a_73430_11728# a_75022_4826# a_72882_4826# VSS nfet_06v0 ad=0.88p pd=4.88u as=0.88p ps=4.88u w=2u l=1u
X1045 a_52550_67013# a_49242_66969# VSS VSS nfet_06v0 ad=1.25p pd=5.5u as=2.2p ps=10.88u w=5u l=1u
X1046 a_17746_53077# a_2594_53077# a_17946_53193# VDD pfet_06v0 ad=3.3p pd=10.66u as=2.5p ps=10.5u w=10u l=1u
X1047 a_51786_70553# a_48550_70437# VDD VDD pfet_06v0 ad=2.5p pd=10.5u as=4.4p ps=20.88u w=10u l=1u
X1048 a_59190_4870# a_47282_11612# VSS VSS nfet_06v0 ad=0.25p pd=1.5u as=0.44p ps=2.88u w=1u l=1u
X1049 a_2594_35580# a_2594_35580# a_15534_28838# VSS nfet_06v0 ad=0.44p pd=2.88u as=0.25p ps=1.5u w=1u l=1u
X1050 a_38718_49609# a_25666_53077# a_42462_53193# VDD pfet_06v0 ad=4.4p pd=20.88u as=2.5p ps=10.5u w=10u l=1u
X1051 a_75010_60642# Z Z VSS nfet_06v0 ad=0.88p pd=4.88u as=0.52p ps=2.52u w=2u l=1u
X1052 a_48850_58305# a_48850_58305# VDD VDD pfet_06v0 ad=0.88p pd=4.88u as=0.88p ps=4.88u w=2u l=1u
X1053 a_28742_11728# a_30334_4826# a_28194_4826# VSS nfet_06v0 ad=0.88p pd=4.88u as=0.88p ps=4.88u w=2u l=1u
X1054 a_64002_53077# a_48850_53077# a_64202_53193# VDD pfet_06v0 ad=3.3p pd=10.66u as=2.5p ps=10.5u w=10u l=1u
X1055 a_49242_45413# a_48510_46213# a_49442_45529# VSS nfet_06v0 ad=2.2p pd=10.88u as=1.25p ps=5.5u w=5u l=1u
X1056 a_32142_45459# a_8870_45415# a_29666_45529# VSS nfet_06v0 ad=1.3p pd=5.52u as=2.2p ps=10.88u w=5u l=1u
X1057 a_24994_11612# a_24994_11612# a_37934_4870# VSS nfet_06v0 ad=0.44p pd=2.88u as=0.25p ps=1.5u w=1u l=1u
X1058 a_29666_45529# a_25326_46213# a_29366_45529# VSS nfet_06v0 ad=1.65p pd=5.66u as=1.25p ps=5.5u w=5u l=1u
X1059 a_31790_12812# a_31790_12812# a_33426_11612# VDD pfet_06v0 ad=4.4p pd=20.88u as=3.3p ps=10.66u w=10u l=1u
X1060 a_28602_53193# a_25366_53077# VDD VDD pfet_06v0 ad=2.5p pd=10.5u as=4.4p ps=20.88u w=10u l=1u
X1061 a_55326_62819# a_48850_58305# a_56886_58419# VDD pfet_06v0 ad=2.2p pd=10.88u as=1.3p ps=5.52u w=5u l=1u
X1062 VDD a_33702_71483# a_31030_67083# VDD pfet_06v0 ad=2.2p pd=10.88u as=1.3p ps=5.52u w=5u l=1u
X1063 a_2794_16930# a_2594_16886# a_3606_16930# VDD pfet_06v0 ad=4.4p pd=20.88u as=2.5p ps=10.5u w=10u l=1u
X1064 a_8398_53123# a_19718_49723# cap_mim_2f0_m4m5_noshield c_width=20u c_length=10u
X1065 a_54214_45459# a_56886_41059# VDD VDD pfet_06v0 ad=1.3p pd=5.52u as=1.3p ps=5.52u w=5u l=1u
X1066 a_8870_66967# a_70256_33300# VDD VDD pfet_06v0 ad=0.44p pd=2.88u as=0.44p ps=2.88u w=1u l=1u
X1067 VSS a_56438_67083# a_55770_70483# VSS nfet_06v0 ad=1.1p pd=5.88u as=0.65p ps=3.02u w=2.5u l=1u
X1068 VSS a_33254_49723# a_31470_53123# VSS nfet_06v0 ad=1.1p pd=5.88u as=0.65p ps=3.02u w=2.5u l=1u
X1069 a_5794_4826# a_9390_12812# a_6342_11728# VDD pfet_06v0 ad=1.76p pd=8.88u as=1.76p ps=8.88u w=4u l=1u
X1070 a_55330_4870# a_55130_4826# VSS VSS nfet_06v0 ad=1.25p pd=5.5u as=2.2p ps=10.88u w=5u l=1u
X1071 a_30830_62775# a_74490_25288# VSS VSS nfet_06v0 ad=0.44p pd=2.88u as=0.44p ps=2.88u w=1u l=1u
X1072 VSS a_65974_49723# a_85566_49640# VSS nfet_06v0 ad=0.44p pd=2.88u as=0.25p ps=1.5u w=1u l=1u
X1073 a_26678_70553# a_25366_70437# VDD VDD pfet_06v0 ad=2.5p pd=10.5u as=4.4p ps=20.88u w=10u l=1u
X1074 a_82622_25588# a_69682_16886# VSS VSS nfet_06v0 ad=0.25p pd=1.5u as=0.44p ps=2.88u w=1u l=1u
X1075 a_7758_62775# a_52090_25288# VSS VSS nfet_06v0 ad=0.44p pd=2.88u as=0.44p ps=2.88u w=1u l=1u
X1076 VDD VSS VDD VDD pfet_06v0 ad=0.44p pd=2.88u as=0 ps=0 w=1u l=2u
X1077 VSS VDD VSS VSS nfet_06v0 ad=0.44p pd=2.88u as=0 ps=0 w=1u l=2u
X1078 a_25326_63573# a_25666_58305# a_25566_58349# VDD pfet_06v0 ad=4.4p pd=20.88u as=2.5p ps=10.5u w=10u l=1u
X1079 a_49406_13618# a_8870_45415# cap_mim_2f0_m4m5_noshield c_width=25u c_length=8u
X1080 a_60222_25588# a_47282_16886# VSS VSS nfet_06v0 ad=0.25p pd=1.5u as=0.44p ps=2.88u w=1u l=1u
X1081 a_24954_28794# a_24994_35580# a_39430_35696# VDD pfet_06v0 ad=4.4p pd=20.88u as=2.5p ps=10.5u w=10u l=1u
X1082 VDD VSS VDD VDD pfet_06v0 ad=7.92p pd=36.88u as=0 ps=0 w=18u l=2u
X1083 a_29726_40989# a_25366_40945# VDD VDD pfet_06v0 ad=2.5p pd=10.5u as=4.4p ps=20.88u w=10u l=1u
X1084 a_54654_53123# a_56438_49723# VSS VSS nfet_06v0 ad=0.65p pd=3.02u as=0.65p ps=3.02u w=2.5u l=1u
X1085 a_10642_4870# a_10442_4826# VSS VSS nfet_06v0 ad=1.25p pd=5.5u as=2.2p ps=10.88u w=5u l=1u
X1086 a_2554_28794# a_2594_35580# a_17030_35696# VDD pfet_06v0 ad=4.4p pd=20.88u as=2.5p ps=10.5u w=10u l=1u
X1087 VDD a_33702_54123# a_32142_49723# VDD pfet_06v0 ad=2.2p pd=10.88u as=1.3p ps=5.52u w=5u l=1u
X1088 a_4218_67013# a_2594_70437# VSS VSS nfet_06v0 ad=0.25p pd=1.5u as=0.44p ps=2.88u w=1u l=1u
X1089 a_74490_4870# a_69642_4826# a_71806_13618# VSS nfet_06v0 ad=1.1p pd=5.88u as=0.825p ps=3.16u w=2.5u l=1u
X1090 a_39182_58305# a_25326_63573# a_40382_62889# VSS nfet_06v0 ad=2.2p pd=10.88u as=1.25p ps=5.5u w=5u l=1u
X1091 a_25568_19326# a_8870_49607# VSS ppolyf_u_1k r_width=1u r_length=76.45u
X1092 a_27650_28838# a_28742_35696# VDD VDD pfet_06v0 ad=2.2p pd=10.88u as=2.2p ps=10.88u w=5u l=1u
X1093 a_7758_49607# a_70256_9332# VDD VDD pfet_06v0 ad=0.44p pd=2.88u as=0.44p ps=2.88u w=1u l=1u
X1094 a_72142_51084# a_72314_66956# VDD VDD pfet_06v0 ad=1.32p pd=6.88u as=1.32p ps=6.88u w=3u l=1u
X1095 VDD VSS VDD VDD pfet_06v0 ad=4.29p pd=20.38u as=0 ps=0 w=9.75u l=2u
X1096 VDD Y Y VDD pfet_06v0 ad=0.52p pd=2.52u as=0.52p ps=2.52u w=2u l=1u
X1097 VSS a_34366_67083# a_42790_67083# VSS nfet_06v0 ad=1.3p pd=5.52u as=1.3p ps=5.52u w=5u l=1u
X1098 a_81590_25588# a_69682_16886# VSS VSS nfet_06v0 ad=0.25p pd=1.5u as=0.44p ps=2.88u w=1u l=1u
X1099 a_69882_11728# a_69682_11612# a_69582_11728# VDD pfet_06v0 ad=4.4p pd=20.88u as=2.5p ps=10.5u w=10u l=1u
X1100 a_47482_11728# a_47282_11612# a_47182_11728# VDD pfet_06v0 ad=4.4p pd=20.88u as=2.5p ps=10.5u w=10u l=1u
X1101 a_32586_70483# a_25326_66969# a_33254_67083# VSS nfet_06v0 ad=1.1p pd=5.88u as=0.65p ps=3.02u w=2.5u l=1u
X1102 a_81590_4870# a_69682_11612# VSS VSS nfet_06v0 ad=0.25p pd=1.5u as=0.44p ps=2.88u w=1u l=1u
X1103 a_53182_45529# a_48510_46213# a_52850_45529# VSS nfet_06v0 ad=1.25p pd=5.5u as=1.65p ps=5.66u w=5u l=1u
X1104 VSS a_10182_49723# a_9514_53123# VSS nfet_06v0 ad=1.1p pd=5.88u as=0.65p ps=3.02u w=2.5u l=1u
X1105 a_48850_40945# a_48850_40945# VDD VDD pfet_06v0 ad=0.88p pd=4.88u as=0.88p ps=4.88u w=2u l=1u
X1106 VDD VSS VDD VDD pfet_06v0 ad=4.29p pd=20.38u as=0 ps=0 w=9.75u l=2u
X1107 VSS a_10182_63319# a_8398_58419# VSS nfet_06v0 ad=1.1p pd=5.88u as=0.65p ps=3.02u w=2.5u l=1u
X1108 a_47856_21126# a_63274_20676# VSS ppolyf_u_1k r_width=1u r_length=76.45u
X1109 VDD a_42790_67083# a_74602_68412# VDD pfet_06v0 ad=1.32p pd=6.88u as=0.75p ps=3.5u w=3u l=1u
X1110 a_31030_67083# a_33702_71483# VDD VDD pfet_06v0 ad=1.3p pd=5.52u as=2.2p ps=10.88u w=5u l=1u
X1111 a_31030_49723# a_33702_54123# VDD VDD pfet_06v0 ad=1.3p pd=5.52u as=1.3p ps=5.52u w=5u l=1u
X1112 VDD a_48550_70437# a_53542_70553# VDD pfet_06v0 ad=4.4p pd=20.88u as=2.5p ps=10.5u w=10u l=1u
X1113 VSS VDD VSS VSS nfet_06v0 ad=7.92p pd=36.88u as=0 ps=0 w=18u l=2u
X1114 a_25154_24788# a_24954_24672# a_25886_24788# VSS nfet_06v0 ad=2.2p pd=10.88u as=1.25p ps=5.5u w=5u l=1u
X1115 a_10182_67083# a_2254_66969# a_9514_70483# VSS nfet_06v0 ad=0.65p pd=3.02u as=1.1p ps=5.88u w=2.5u l=1u
X1116 a_18354_67013# a_18154_66969# VSS VSS nfet_06v0 ad=1.25p pd=5.5u as=2.2p ps=10.88u w=5u l=1u
X1117 a_8870_66967# a_70256_33300# VDD VDD pfet_06v0 ad=0.44p pd=2.88u as=0.44p ps=2.88u w=1u l=1u
X1118 VSS VDD VSS VSS nfet_06v0 ad=0.44p pd=2.88u as=0 ps=0 w=1u l=2u
X1119 a_74490_28838# a_76478_36780# a_70256_33300# VDD pfet_06v0 ad=1.76p pd=8.88u as=1.76p ps=8.88u w=4u l=1u
X1120 a_55770_53123# a_56438_49723# VSS VSS nfet_06v0 ad=0.65p pd=3.02u as=1.1p ps=5.88u w=2.5u l=1u
X1121 Z a_72142_60502# a_72054_60546# VSS nfet_06v0 ad=0.6448p pd=3u as=1.0912p ps=5.84u w=2.48u l=1u
X1122 VSS a_26058_49609# a_29998_49653# VSS nfet_06v0 ad=2.2p pd=10.88u as=1.25p ps=5.5u w=5u l=1u
X1123 a_64610_67013# a_64410_66969# VSS VSS nfet_06v0 ad=1.25p pd=5.5u as=2.2p ps=10.88u w=5u l=1u
X1124 a_8870_62775# a_7402_28838# VSS VSS nfet_06v0 ad=0.44p pd=2.88u as=0.44p ps=2.88u w=1u l=1u
X1125 VSS VDD VSS VSS nfet_06v0 ad=7.92p pd=36.88u as=0 ps=0 w=18u l=2u
X1126 a_70256_21126# a_69682_16886# a_71606_24288# VDD pfet_06v0 ad=4.4p pd=20.88u as=4.4p ps=20.88u w=10u l=1u
X1127 a_28194_25172# a_31790_16886# a_28742_16930# VDD pfet_06v0 ad=1.76p pd=8.88u as=1.76p ps=8.88u w=4u l=1u
X1128 a_30830_66967# a_47856_33300# VDD VDD pfet_06v0 ad=0.44p pd=2.88u as=0.44p ps=2.88u w=1u l=1u
X1129 a_33702_71483# a_25666_70437# a_32142_67083# VDD pfet_06v0 ad=1.3p pd=5.52u as=2.2p ps=10.88u w=5u l=1u
X1130 a_48294_35696# a_46982_35580# VDD VDD pfet_06v0 ad=2.5p pd=10.5u as=4.4p ps=20.88u w=10u l=1u
X1131 a_30026_40989# a_8870_45415# a_32586_41059# VDD pfet_06v0 ad=4.4p pd=20.88u as=2.6p ps=10.52u w=10u l=1u
X1132 ZN a_75388_58336# VDD VDD pfet_05v0 ad=0.8052p pd=4.54u as=0.8052p ps=4.54u w=1.83u l=0.5u
X1133 a_25326_46213# a_25666_40945# a_25566_40989# VDD pfet_06v0 ad=4.4p pd=20.88u as=2.5p ps=10.5u w=10u l=1u
X1134 a_54654_53123# a_12006_25588# a_53210_53193# VDD pfet_06v0 ad=2.6p pd=10.52u as=4.4p ps=20.88u w=10u l=1u
X1135 a_7958_62819# a_10630_58419# VDD VDD pfet_06v0 ad=1.3p pd=5.52u as=1.3p ps=5.52u w=5u l=1u
X1136 a_42790_49723# a_31030_49723# cap_mim_2f0_m4m5_noshield c_width=20u c_length=10u
X1137 a_2294_70437# a_2594_70437# a_5530_70553# VDD pfet_06v0 ad=4.4p pd=20.88u as=2.5p ps=10.5u w=10u l=1u
X1138 a_80558_24788# a_69342_24672# VSS VSS nfet_06v0 ad=1.25p pd=5.5u as=2.2p ps=10.88u w=5u l=1u
X1139 a_63566_45529# a_49242_45413# VSS VSS nfet_06v0 ad=1.25p pd=5.5u as=2.2p ps=10.88u w=5u l=1u
X1140 a_8398_70483# a_19718_67083# cap_mim_2f0_m4m5_noshield c_width=20u c_length=10u
X1141 VSS VDD VSS VSS nfet_06v0 ad=4.29p pd=20.38u as=0 ps=0 w=9.75u l=2u
X1142 a_3186_45529# a_2986_45413# VSS VSS nfet_06v0 ad=1.25p pd=5.5u as=2.2p ps=10.88u w=5u l=1u
X1143 Z Z VDD VDD pfet_06v0 ad=0.52p pd=2.52u as=0.52p ps=2.52u w=2u l=1u
X1144 a_48550_58305# a_48850_58305# a_51786_58349# VDD pfet_06v0 ad=4.4p pd=20.88u as=2.5p ps=10.5u w=10u l=1u
X1145 a_26006_16930# a_24694_16886# VDD VDD pfet_06v0 ad=2.5p pd=10.5u as=4.4p ps=20.88u w=10u l=1u
X1146 a_4718_37586# a_5794_28794# VSS VSS nfet_06v0 ad=0.825p pd=3.16u as=1.1p ps=5.88u w=2.5u l=1u
X1147 a_87474_42642# a_19718_45459# VDD VDD pfet_06v0 ad=0.99p pd=3.66u as=1.32p ps=6.88u w=3u l=1u
X1148 a_28322_46329# a_25666_40945# VSS VSS nfet_06v0 ad=0.25p pd=1.5u as=0.44p ps=2.88u w=1u l=1u
X1149 a_42462_58349# a_25366_58305# VDD VDD pfet_06v0 ad=2.5p pd=10.5u as=4.4p ps=20.88u w=10u l=1u
X1150 a_9514_58419# a_2254_63573# a_10182_63319# VSS nfet_06v0 ad=1.1p pd=5.88u as=0.65p ps=3.02u w=2.5u l=1u
X1151 a_6342_11728# a_7934_4826# a_5794_4826# VSS nfet_06v0 ad=0.88p pd=4.88u as=0.88p ps=4.88u w=2u l=1u
X1152 a_27650_28838# S4N a_25154_28838# VSS nfet_06v0 ad=3.74p pd=17.88u as=3.74p ps=17.88u w=8.5u l=1u
X1153 a_64202_58349# a_64002_58305# VDD VDD pfet_06v0 ad=2.5p pd=10.5u as=4.4p ps=20.88u w=10u l=1u
X1154 a_61902_66969# a_61902_66969# a_64410_66969# VSS nfet_06v0 ad=2.2p pd=10.88u as=1.65p ps=5.66u w=5u l=1u
X1155 a_12006_25588# a_4518_24288# cap_mim_2f0_m4m5_noshield c_width=25u c_length=8u
X1156 a_87154_35696# a_69382_35580# VDD VDD pfet_06v0 ad=2.5p pd=10.5u as=4.4p ps=20.88u w=10u l=1u
X1157 VSS VDD VSS VSS nfet_06v0 ad=4.29p pd=20.38u as=0 ps=0 w=9.75u l=2u
X1158 a_64754_35696# a_46982_35580# VDD VDD pfet_06v0 ad=2.5p pd=10.5u as=4.4p ps=20.88u w=10u l=1u
X1159 a_6954_40989# a_8870_45415# a_9514_41059# VDD pfet_06v0 ad=4.4p pd=20.88u as=2.6p ps=10.52u w=10u l=1u
X1160 a_11294_45959# a_2254_46213# a_8398_41059# VSS nfet_06v0 ad=0.65p pd=3.02u as=1.1p ps=5.88u w=2.5u l=1u
X1161 a_28322_49653# a_25666_53077# VSS VSS nfet_06v0 ad=0.25p pd=1.5u as=0.44p ps=2.88u w=1u l=1u
X1162 a_25568_20226# a_40986_20676# VSS ppolyf_u_1k r_width=1u r_length=76.45u
X1163 a_26058_62773# a_25666_58305# a_26678_58349# VDD pfet_06v0 ad=4.4p pd=20.88u as=2.5p ps=10.5u w=10u l=1u
X1164 a_27290_46329# a_25666_40945# VSS VSS nfet_06v0 ad=0.25p pd=1.5u as=0.44p ps=2.88u w=1u l=1u
X1165 a_3168_20226# a_18586_19776# VSS ppolyf_u_1k r_width=1u r_length=76.45u
X1166 a_2254_28794# a_2594_35580# a_18142_35696# VDD pfet_06v0 ad=4.4p pd=20.88u as=2.5p ps=10.5u w=10u l=1u
X1167 a_85230_16930# a_69382_16886# VDD VDD pfet_06v0 ad=2.5p pd=10.5u as=4.4p ps=20.88u w=10u l=1u
X1168 a_41226_49609# a_25326_49609# a_41426_49653# VSS nfet_06v0 ad=1.65p pd=5.66u as=1.25p ps=5.5u w=5u l=1u
X1169 a_6654_53193# a_2294_53077# VDD VDD pfet_06v0 ad=2.5p pd=10.5u as=4.4p ps=20.88u w=10u l=1u
X1170 a_15646_45913# a_15646_45913# a_18154_45413# VSS nfet_06v0 ad=2.2p pd=10.88u as=1.65p ps=5.66u w=5u l=1u
X1171 a_7758_62775# a_47856_21126# VDD VDD pfet_06v0 ad=0.44p pd=2.88u as=0.44p ps=2.88u w=1u l=1u
X1172 a_40542_11728# a_24694_11612# VDD VDD pfet_06v0 ad=2.5p pd=10.5u as=4.4p ps=20.88u w=10u l=1u
X1173 YP YN VSS VSS nfet_05v0 ad=0.5808p pd=3.52u as=0.5808p ps=3.52u w=1.32u l=0.6u
X1174 a_32142_62819# a_33702_58419# VDD VDD pfet_06v0 ad=1.3p pd=5.52u as=2.2p ps=10.88u w=5u l=1u
X1175 VDD VSS VDD VDD pfet_06v0 ad=4.29p pd=20.38u as=0 ps=0 w=9.75u l=2u
X1176 a_49406_37586# a_30830_66967# cap_mim_2f0_m4m5_noshield c_width=25u c_length=8u
X1177 VSS VDD VSS VSS nfet_06v0 ad=4.29p pd=20.38u as=0 ps=0 w=9.75u l=2u
X1178 XN a_75388_40976# VDD VDD pfet_05v0 ad=0.8052p pd=4.54u as=0.8052p ps=4.54u w=1.83u l=0.5u
X1179 VDD Z Z VDD pfet_06v0 ad=0.52p pd=2.52u as=0.52p ps=2.52u w=2u l=1u
X1180 a_27290_49653# a_25666_53077# VSS VSS nfet_06v0 ad=0.25p pd=1.5u as=0.44p ps=2.88u w=1u l=1u
X1181 a_30830_45415# a_25568_9332# VDD VDD pfet_06v0 ad=0.44p pd=2.88u as=0.44p ps=2.88u w=1u l=1u
X1182 a_70256_20226# a_85674_19776# VSS ppolyf_u_1k r_width=1u r_length=76.45u
X1183 a_47482_11728# a_47282_11612# a_48294_11728# VDD pfet_06v0 ad=4.4p pd=20.88u as=2.5p ps=10.5u w=10u l=1u
X1184 a_7758_45415# a_3168_9332# VDD VDD pfet_06v0 ad=0.44p pd=2.88u as=0.44p ps=2.88u w=1u l=1u
X1185 a_4518_24288# S2P a_2754_24788# VSS nfet_06v0 ad=3.3p pd=15.88u as=3.3p ps=15.88u w=7.5u l=1u
X1186 VSS VDD VSS VSS nfet_06v0 ad=0.44p pd=2.88u as=0 ps=0 w=1u l=2u
X1187 a_52850_62889# a_7758_62775# a_55326_62819# VSS nfet_06v0 ad=2.2p pd=10.88u as=1.3p ps=5.52u w=5u l=1u
X1188 a_71806_37586# a_8870_66967# cap_mim_2f0_m4m5_noshield c_width=25u c_length=8u
X1189 a_48550_40945# a_48850_40945# a_51786_40989# VDD pfet_06v0 ad=4.4p pd=20.88u as=2.5p ps=10.5u w=10u l=1u
X1190 a_65974_45459# a_57550_45959# VSS VSS nfet_06v0 ad=2.2p pd=10.88u as=1.3p ps=5.52u w=5u l=1u
X1191 a_31470_53123# a_25326_49609# a_34366_49723# VSS nfet_06v0 ad=1.1p pd=5.88u as=0.65p ps=3.02u w=2.5u l=1u
X1192 VSS a_56438_45959# a_54654_41059# VSS nfet_06v0 ad=1.1p pd=5.88u as=0.65p ps=3.02u w=2.5u l=1u
X1193 a_42462_40989# a_25366_40945# VDD VDD pfet_06v0 ad=2.5p pd=10.5u as=4.4p ps=20.88u w=10u l=1u
X1194 a_42790_67083# a_31030_67083# cap_mim_2f0_m4m5_noshield c_width=20u c_length=10u
X1195 a_7286_53193# a_2594_53077# a_6954_53193# VDD pfet_06v0 ad=2.5p pd=10.5u as=3.3p ps=10.66u w=10u l=1u
X1196 a_64202_40989# a_64002_40945# VDD VDD pfet_06v0 ad=2.5p pd=10.5u as=4.4p ps=20.88u w=10u l=1u
X1197 a_26258_45529# a_26058_45413# VSS VSS nfet_06v0 ad=1.25p pd=5.5u as=2.2p ps=10.88u w=5u l=1u
X1198 VSS a_10182_49723# a_9514_53123# VSS nfet_06v0 ad=0.65p pd=3.02u as=0.65p ps=3.02u w=2.5u l=1u
X1199 a_33702_41059# a_38718_45913# a_33254_45959# VSS nfet_06v0 ad=1.1p pd=5.88u as=1.1p ps=5.88u w=2.5u l=1u
X1200 VDD VSS VDD VDD pfet_06v0 ad=7.92p pd=36.88u as=0 ps=0 w=18u l=2u
X1201 a_72304_62002# a_79086_60502# Z VSS nfet_06v0 ad=1.0912p pd=5.84u as=0.6448p ps=3u w=2.48u l=1u
X1202 Z a_73254_60502# a_73166_60546# VSS nfet_06v0 ad=0.6448p pd=3u as=1.0912p ps=5.84u w=2.48u l=1u
X1203 a_26918_4870# S3P a_25154_4870# VSS nfet_06v0 ad=3.3p pd=15.88u as=3.3p ps=15.88u w=7.5u l=1u
X1204 a_71606_24288# S3P a_69842_24788# VSS nfet_06v0 ad=3.3p pd=15.88u as=3.3p ps=15.88u w=7.5u l=1u
X1205 a_54214_62819# a_48850_58305# a_58002_58419# VDD pfet_06v0 ad=2.2p pd=10.88u as=1.3p ps=5.52u w=5u l=1u
X1206 a_77530_4826# a_69642_4826# a_77730_4870# VSS nfet_06v0 ad=1.65p pd=5.66u as=1.25p ps=5.5u w=5u l=1u
X1207 a_87474_60114# a_19718_62819# VDD VDD pfet_06v0 ad=0.99p pd=3.66u as=1.32p ps=6.88u w=3u l=1u
X1208 a_58002_71483# a_48850_70437# a_54214_67083# VDD pfet_06v0 ad=1.3p pd=5.52u as=2.2p ps=10.88u w=5u l=1u
X1209 a_55326_45459# a_48850_40945# a_56886_41059# VDD pfet_06v0 ad=2.2p pd=10.88u as=1.3p ps=5.52u w=5u l=1u
X1210 a_46982_11612# a_47282_11612# a_64754_11728# VDD pfet_06v0 ad=4.4p pd=20.88u as=2.5p ps=10.5u w=10u l=1u
X1211 a_47856_9332# a_52622_4826# a_52090_4870# VSS nfet_06v0 ad=0.88p pd=4.88u as=0.88p ps=4.88u w=2u l=1u
X1212 VDD VSS VDD VDD pfet_06v0 ad=7.92p pd=36.88u as=0 ps=0 w=18u l=2u
X1213 a_4718_16930# a_12006_25588# cap_mim_2f0_m4m5_noshield c_width=25u c_length=8u
X1214 a_26058_45413# a_25666_40945# a_26678_40989# VDD pfet_06v0 ad=4.4p pd=20.88u as=2.5p ps=10.5u w=10u l=1u
X1215 VDD VSS VDD VDD pfet_06v0 ad=7.92p pd=36.88u as=0 ps=0 w=18u l=2u
X1216 a_69682_11612# a_69682_11612# VDD VDD pfet_06v0 ad=0.88p pd=4.88u as=0.88p ps=4.88u w=2u l=1u
X1217 a_11746_58419# a_2594_58305# a_7958_62819# VDD pfet_06v0 ad=1.3p pd=5.52u as=2.2p ps=10.88u w=5u l=1u
X1218 a_7958_62819# a_7758_62775# a_6594_62889# VSS nfet_06v0 ad=1.3p pd=5.52u as=2.2p ps=10.88u w=5u l=1u
X1219 a_2254_49609# a_2594_53077# a_2494_53193# VDD pfet_06v0 ad=4.4p pd=20.88u as=2.5p ps=10.5u w=10u l=1u
X1220 a_14502_4870# a_2594_11612# VSS VSS nfet_06v0 ad=0.25p pd=1.5u as=0.44p ps=2.88u w=1u l=1u
X1221 a_27118_16930# S1P a_25194_16930# VDD pfet_06v0 ad=0.242p pd=1.98u as=0.242p ps=1.98u w=0.55u l=1u
X1222 a_7958_49723# a_2594_53077# a_11746_54123# VDD pfet_06v0 ad=2.2p pd=10.88u as=1.3p ps=5.52u w=5u l=1u
X1223 a_8398_58419# a_2254_63573# a_11294_63319# VSS nfet_06v0 ad=1.1p pd=5.88u as=0.65p ps=3.02u w=2.5u l=1u
X1224 a_30830_45415# a_25568_9332# VDD VDD pfet_06v0 ad=0.44p pd=2.88u as=0.44p ps=2.88u w=1u l=1u
X1225 a_7934_25272# a_2594_16886# a_12670_16930# VDD pfet_06v0 ad=4.4p pd=20.88u as=2.5p ps=10.5u w=10u l=1u
X1226 VSS VDD VSS VSS nfet_06v0 ad=4.29p pd=20.38u as=0 ps=0 w=9.75u l=2u
X1227 a_7758_45415# a_3168_9332# VDD VDD pfet_06v0 ad=0.44p pd=2.88u as=0.44p ps=2.88u w=1u l=1u
X1228 a_47856_33300# a_63274_33300# VSS ppolyf_u_1k r_width=1u r_length=76.45u
X1229 a_7402_25288# a_2554_24672# a_4718_16930# VSS nfet_06v0 ad=1.1p pd=5.88u as=0.825p ps=3.16u w=2.5u l=1u
X1230 a_8398_70483# a_10182_67083# VSS VSS nfet_06v0 ad=0.65p pd=3.02u as=0.65p ps=3.02u w=2.5u l=1u
X1231 a_3606_11728# a_2294_11612# VDD VDD pfet_06v0 ad=2.5p pd=10.5u as=4.4p ps=20.88u w=10u l=1u
X1232 VDD a_56886_71483# a_55326_67083# VDD pfet_06v0 ad=1.3p pd=5.52u as=1.3p ps=5.52u w=5u l=1u
X1233 a_49242_66969# a_48510_66969# a_49442_67013# VSS nfet_06v0 ad=2.2p pd=10.88u as=1.25p ps=5.5u w=5u l=1u
X1234 a_29998_62889# a_25326_63573# a_29666_62889# VSS nfet_06v0 ad=1.25p pd=5.5u as=1.65p ps=5.66u w=5u l=1u
X1235 a_25568_21126# a_40986_20676# VSS ppolyf_u_1k r_width=1u r_length=76.45u
X1236 VDD VSS VDD VDD pfet_06v0 ad=0.44p pd=2.88u as=0 ps=0 w=1u l=2u
X1237 a_29666_67013# a_25326_66969# a_29366_67013# VSS nfet_06v0 ad=1.65p pd=5.66u as=1.25p ps=5.5u w=5u l=1u
X1238 VDD VSS VDD VDD pfet_06v0 ad=0.44p pd=2.88u as=0 ps=0 w=1u l=2u
X1239 a_25154_4870# a_24954_4826# a_25886_4870# VSS nfet_06v0 ad=2.2p pd=10.88u as=1.25p ps=5.5u w=5u l=1u
X1240 a_55914_16930# a_55714_16886# VDD VDD pfet_06v0 ad=2.5p pd=10.5u as=4.4p ps=20.88u w=10u l=1u
X1241 a_5794_28794# a_2554_28794# a_5530_37596# VSS nfet_06v0 ad=1.1p pd=5.88u as=0.825p ps=3.16u w=2.5u l=1u
X1242 a_2254_66969# a_2254_66969# VSS VSS nfet_06v0 ad=0.44p pd=2.88u as=0.44p ps=2.88u w=1u l=1u
X1243 a_54214_49723# a_12006_25588# a_52850_49653# VSS nfet_06v0 ad=1.3p pd=5.52u as=2.2p ps=10.88u w=5u l=1u
X1244 a_72882_25172# a_76478_16886# a_73430_16930# VDD pfet_06v0 ad=1.76p pd=8.88u as=1.76p ps=8.88u w=4u l=1u
X1245 a_77530_24672# a_69642_24672# a_77730_24788# VSS nfet_06v0 ad=1.65p pd=5.66u as=1.25p ps=5.5u w=5u l=1u
X1246 a_9070_67083# a_10630_71483# VDD VDD pfet_06v0 ad=1.3p pd=5.52u as=2.2p ps=10.88u w=5u l=1u
X1247 a_69682_16886# a_69682_16886# VDD VDD pfet_06v0 ad=0.88p pd=4.88u as=0.88p ps=4.88u w=2u l=1u
X1248 a_3486_4870# a_2254_4826# VSS VSS nfet_06v0 ad=1.25p pd=5.5u as=2.2p ps=10.88u w=5u l=1u
X1249 a_9070_49723# a_10630_54123# VDD VDD pfet_06v0 ad=1.3p pd=5.52u as=1.3p ps=5.52u w=5u l=1u
X1250 a_47182_35696# a_46982_35580# VDD VDD pfet_06v0 ad=2.5p pd=10.5u as=4.4p ps=20.88u w=10u l=1u
X1251 a_50482_25172# a_54078_16886# a_51030_16930# VDD pfet_06v0 ad=1.76p pd=8.88u as=1.76p ps=8.88u w=4u l=1u
X1252 a_55130_24672# a_47242_24672# a_55330_24788# VSS nfet_06v0 ad=1.65p pd=5.66u as=1.25p ps=5.5u w=5u l=1u
X1253 a_30358_70553# a_25666_70437# a_30026_70553# VDD pfet_06v0 ad=2.5p pd=10.5u as=3.3p ps=10.66u w=10u l=1u
X1254 a_47242_24672# a_47282_16886# a_61718_16930# VDD pfet_06v0 ad=4.4p pd=20.88u as=2.5p ps=10.5u w=10u l=1u
X1255 a_72054_43186# a_72142_43142# X VSS nfet_06v0 ad=1.0912p pd=5.84u as=0.6448p ps=3u w=2.48u l=1u
X1256 a_20066_11728# a_2294_11612# VDD VDD pfet_06v0 ad=2.5p pd=10.5u as=4.4p ps=20.88u w=10u l=1u
X1257 a_2254_4826# a_2554_4826# a_13470_4870# VSS nfet_06v0 ad=2.2p pd=10.88u as=1.25p ps=5.5u w=5u l=1u
X1258 a_76686_4870# a_69342_4826# VSS VSS nfet_06v0 ad=1.25p pd=5.5u as=2.2p ps=10.88u w=5u l=1u
X1259 a_72882_28794# a_69642_28794# a_72618_37596# VSS nfet_06v0 ad=1.1p pd=5.88u as=0.825p ps=3.16u w=2.5u l=1u
X1260 a_76478_16886# a_76478_16886# a_78114_16886# VDD pfet_06v0 ad=4.4p pd=20.88u as=3.3p ps=10.66u w=10u l=1u
X1261 a_88406_42758# a_42790_45459# a_87474_42642# VSS nfet_06v0 ad=0.25p pd=1.5u as=0.44p ps=2.88u w=1u l=1u
X1262 a_25154_28838# a_24954_28794# a_25886_28838# VSS nfet_06v0 ad=2.2p pd=10.88u as=1.25p ps=5.5u w=5u l=1u
X1263 a_54078_16886# a_54078_16886# a_55714_16886# VDD pfet_06v0 ad=4.4p pd=20.88u as=3.3p ps=10.66u w=10u l=1u
X1264 a_55770_41059# a_48510_46213# a_56438_45959# VSS nfet_06v0 ad=1.1p pd=5.88u as=0.65p ps=3.02u w=2.5u l=1u
X1265 VSS a_65974_67083# a_73246_67000# VSS nfet_06v0 ad=0.44p pd=2.88u as=0.25p ps=1.5u w=1u l=1u
X1266 a_36902_25588# a_24994_16886# VSS VSS nfet_06v0 ad=0.25p pd=1.5u as=0.44p ps=2.88u w=1u l=1u
X1267 a_7958_45459# a_10630_41059# VDD VDD pfet_06v0 ad=1.3p pd=5.52u as=1.3p ps=5.52u w=5u l=1u
X1268 VSS a_33254_49723# a_32586_53123# VSS nfet_06v0 ad=0.65p pd=3.02u as=0.65p ps=3.02u w=2.5u l=1u
X1269 VDD VSS VDD VDD pfet_06v0 ad=0.44p pd=2.88u as=0 ps=0 w=1u l=2u
X1270 a_9390_12812# a_9390_12812# a_11026_11612# VDD pfet_06v0 ad=4.4p pd=20.88u as=3.3p ps=10.66u w=10u l=1u
X1271 a_31998_4870# a_24654_4826# VSS VSS nfet_06v0 ad=1.25p pd=5.5u as=2.2p ps=10.88u w=5u l=1u
X1272 a_14502_25588# a_2594_16886# VSS VSS nfet_06v0 ad=0.25p pd=1.5u as=0.44p ps=2.88u w=1u l=1u
X1273 a_19718_67083# a_11746_71483# VDD VDD pfet_06v0 ad=2.6p pd=10.52u as=4.4p ps=20.88u w=10u l=1u
X1274 X X VDD VDD pfet_06v0 ad=0.52p pd=2.52u as=0.52p ps=2.52u w=2u l=1u
X1275 a_42466_35696# a_24694_35580# VDD VDD pfet_06v0 ad=2.5p pd=10.5u as=4.4p ps=20.88u w=10u l=1u
X1276 a_30830_66967# a_47856_33300# VDD VDD pfet_06v0 ad=0.44p pd=2.88u as=0.44p ps=2.88u w=1u l=1u
X1277 a_53182_67013# a_48510_66969# a_52850_67013# VSS nfet_06v0 ad=1.25p pd=5.5u as=1.65p ps=5.66u w=5u l=1u
X1278 a_30026_53193# a_12006_25588# a_31470_53123# VDD pfet_06v0 ad=4.4p pd=20.88u as=2.6p ps=10.52u w=10u l=1u
X1279 a_27118_16930# a_28194_25172# VSS VSS nfet_06v0 ad=0.825p pd=3.16u as=1.1p ps=5.88u w=2.5u l=1u
X1280 a_80558_28838# a_69342_28794# VSS VSS nfet_06v0 ad=1.25p pd=5.5u as=2.2p ps=10.88u w=5u l=1u
X1281 a_7758_45415# a_7402_4870# VSS VSS nfet_06v0 ad=0.44p pd=2.88u as=0.44p ps=2.88u w=1u l=1u
X1282 a_25666_58305# a_25666_58305# VDD VDD pfet_06v0 ad=0.88p pd=4.88u as=0.88p ps=4.88u w=2u l=1u
X1283 VDD VSS VDD VDD pfet_06v0 ad=0.44p pd=2.88u as=0 ps=0 w=1u l=2u
X1284 a_27650_24088# S1N a_25154_24788# VSS nfet_06v0 ad=3.74p pd=17.88u as=3.74p ps=17.88u w=8.5u l=1u
X1285 a_17310_45529# a_2986_45413# VSS VSS nfet_06v0 ad=1.25p pd=5.5u as=2.2p ps=10.88u w=5u l=1u
X1286 a_76410_60712# Z VSS VSS nfet_06v0 ad=0.5p pd=2.5u as=0.88p ps=4.88u w=2u l=1u
X1287 VSS VDD VSS VSS nfet_06v0 ad=4.29p pd=20.38u as=0 ps=0 w=9.75u l=2u
X1288 a_30830_66967# a_49206_28838# cap_mim_2f0_m4m5_noshield c_width=25u c_length=8u
X1289 a_6954_58349# a_7758_62775# a_8398_58419# VDD pfet_06v0 ad=4.4p pd=20.88u as=2.6p ps=10.52u w=10u l=1u
X1290 a_6294_45529# a_2986_45413# VSS VSS nfet_06v0 ad=1.25p pd=5.5u as=2.2p ps=10.88u w=5u l=1u
X1291 a_57550_67083# a_62366_71437# a_58002_71483# VDD pfet_06v0 ad=2.2p pd=10.88u as=2.2p ps=10.88u w=5u l=1u
X1292 a_27930_37596# a_28194_28794# VSS VSS nfet_06v0 ad=0.825p pd=3.16u as=1.1p ps=5.88u w=2.5u l=1u
X1293 a_54654_41059# a_65974_45459# cap_mim_2f0_m4m5_noshield c_width=20u c_length=10u
X1294 VDD VSS VDD VDD pfet_06v0 ad=4.29p pd=20.38u as=0 ps=0 w=9.75u l=2u
X1295 a_2794_35696# a_2594_35580# a_2494_35696# VDD pfet_06v0 ad=4.4p pd=20.88u as=2.5p ps=10.5u w=10u l=1u
X1296 a_2494_58349# a_2294_58305# VDD VDD pfet_06v0 ad=2.5p pd=10.5u as=4.4p ps=20.88u w=10u l=1u
X1297 a_57550_63319# a_48510_63573# a_54654_58419# VSS nfet_06v0 ad=0.65p pd=3.02u as=1.1p ps=5.88u w=2.5u l=1u
X1298 a_32586_70483# a_8870_66967# a_30026_70553# VDD pfet_06v0 ad=2.6p pd=10.52u as=4.4p ps=20.88u w=10u l=1u
X1299 a_63566_67013# a_49242_66969# VSS VSS nfet_06v0 ad=1.25p pd=5.5u as=2.2p ps=10.88u w=5u l=1u
X1300 VDD a_42790_45459# a_86922_40946# VDD pfet_06v0 ad=1.32p pd=6.88u as=0.75p ps=3.5u w=3u l=1u
X1301 a_3186_67013# a_2986_66969# VSS VSS nfet_06v0 ad=1.25p pd=5.5u as=2.2p ps=10.88u w=5u l=1u
X1302 VSS a_26058_62773# a_29998_62889# VSS nfet_06v0 ad=2.2p pd=10.88u as=1.25p ps=5.5u w=5u l=1u
X1303 a_74068_62110# a_72104_61958# a_73768_62110# VSS nfet_06v0 ad=0.175p pd=1.2u as=0.175p ps=1.2u w=0.7u l=1u
X1304 a_3168_21126# a_2594_16886# a_4518_24288# VDD pfet_06v0 ad=4.4p pd=20.88u as=4.4p ps=20.88u w=10u l=1u
X1305 a_32142_45459# a_33702_41059# VDD VDD pfet_06v0 ad=1.3p pd=5.52u as=2.2p ps=10.88u w=5u l=1u
X1306 a_52622_4826# a_52622_4826# a_55130_4826# VSS nfet_06v0 ad=2.2p pd=10.88u as=1.65p ps=5.66u w=5u l=1u
X1307 a_5530_37596# S1N a_2794_35696# VDD pfet_06v0 ad=0.22p pd=1.88u as=0.22p ps=1.88u w=0.5u l=1u
X1308 a_2594_70437# a_2594_70437# a_5250_67013# VSS nfet_06v0 ad=0.44p pd=2.88u as=0.25p ps=1.5u w=1u l=1u
X1309 a_47856_10682# a_63274_10232# VSS ppolyf_u_1k r_width=1u r_length=76.45u
X1310 VDD X X VDD pfet_06v0 ad=0.52p pd=2.52u as=0.52p ps=2.52u w=2u l=1u
X1311 a_56886_71483# a_48850_70437# a_55326_67083# VDD pfet_06v0 ad=1.3p pd=5.52u as=2.2p ps=10.88u w=5u l=1u
X1312 a_52090_28838# a_54078_36780# a_47856_33300# VDD pfet_06v0 ad=1.76p pd=8.88u as=1.76p ps=8.88u w=4u l=1u
X1313 a_32142_62819# a_25666_58305# a_33702_58419# VDD pfet_06v0 ad=2.2p pd=10.88u as=1.3p ps=5.52u w=5u l=1u
X1314 a_27118_37586# S4P a_25194_35696# VDD pfet_06v0 ad=0.242p pd=1.98u as=0.242p ps=1.98u w=0.55u l=1u
X1315 a_69642_4826# a_69642_4826# VSS VSS nfet_06v0 ad=0.44p pd=2.88u as=0.44p ps=2.88u w=1u l=1u
X1316 a_55326_49723# a_7758_49607# a_52850_49653# VSS nfet_06v0 ad=1.3p pd=5.52u as=2.2p ps=10.88u w=5u l=1u
X1317 a_69382_16886# a_69682_16886# a_87154_16930# VDD pfet_06v0 ad=4.4p pd=20.88u as=2.5p ps=10.5u w=10u l=1u
X1318 VSS VDD VSS VSS nfet_06v0 ad=7.92p pd=36.88u as=0 ps=0 w=18u l=2u
X1319 a_65974_62819# a_58002_58419# VDD VDD pfet_06v0 ad=2.6p pd=10.52u as=4.4p ps=20.88u w=10u l=1u
X1320 a_25666_40945# a_25666_40945# VDD VDD pfet_06v0 ad=0.88p pd=4.88u as=0.88p ps=4.88u w=2u l=1u
X1321 a_47856_21126# a_47282_16886# a_49206_24288# VDD pfet_06v0 ad=4.4p pd=20.88u as=4.4p ps=20.88u w=10u l=1u
X1322 VDD VSS VDD VDD pfet_06v0 ad=7.92p pd=36.88u as=0 ps=0 w=18u l=2u
X1323 a_24694_11612# a_24994_11612# a_42466_11728# VDD pfet_06v0 ad=4.4p pd=20.88u as=2.5p ps=10.5u w=10u l=1u
X1324 a_73166_43186# a_73254_43142# X VSS nfet_06v0 ad=1.0912p pd=5.84u as=0.6448p ps=3u w=2.48u l=1u
X1325 a_2294_11612# a_2594_11612# a_20066_11728# VDD pfet_06v0 ad=4.4p pd=20.88u as=2.5p ps=10.5u w=10u l=1u
X1326 a_24954_4826# a_24954_4826# VSS VSS nfet_06v0 ad=0.44p pd=2.88u as=0.44p ps=2.88u w=1u l=1u
X1327 VDD a_25366_58305# a_30358_58349# VDD pfet_06v0 ad=4.4p pd=20.88u as=2.5p ps=10.5u w=10u l=1u
X1328 VSS a_33254_63319# a_31470_58419# VSS nfet_06v0 ad=1.1p pd=5.88u as=0.65p ps=3.02u w=2.5u l=1u
X1329 a_27930_16930# S1N a_25194_16930# VDD pfet_06v0 ad=0.22p pd=1.88u as=0.22p ps=1.88u w=0.5u l=1u
X1330 a_54214_45459# a_48850_40945# a_58002_41059# VDD pfet_06v0 ad=2.2p pd=10.88u as=1.3p ps=5.52u w=5u l=1u
X1331 a_7402_4870# a_2554_4826# a_4718_13618# VSS nfet_06v0 ad=1.1p pd=5.88u as=0.825p ps=3.16u w=2.5u l=1u
X1332 a_17946_58349# a_17746_58305# VDD VDD pfet_06v0 ad=2.5p pd=10.5u as=4.4p ps=20.88u w=10u l=1u
X1333 a_15646_66969# a_15646_66969# a_18154_66969# VSS nfet_06v0 ad=2.2p pd=10.88u as=1.65p ps=5.66u w=5u l=1u
X1334 a_75022_25272# a_69682_16886# a_79758_16930# VDD pfet_06v0 ad=4.4p pd=20.88u as=2.5p ps=10.5u w=10u l=1u
X1335 VSS VDD VSS VSS nfet_06v0 ad=7.92p pd=36.88u as=0 ps=0 w=18u l=2u
X1336 a_42790_67083# a_34818_71483# VDD VDD pfet_06v0 ad=2.6p pd=10.52u as=4.4p ps=20.88u w=10u l=1u
X1337 a_11294_67083# a_2254_66969# a_8398_70483# VSS nfet_06v0 ad=0.65p pd=3.02u as=1.1p ps=5.88u w=2.5u l=1u
X1338 a_31470_41059# a_42790_45459# cap_mim_2f0_m4m5_noshield c_width=20u c_length=10u
X1339 a_48750_70553# a_48550_70437# VDD VDD pfet_06v0 ad=2.5p pd=10.5u as=4.4p ps=20.88u w=10u l=1u
X1340 a_52622_25272# a_47282_16886# a_57358_16930# VDD pfet_06v0 ad=4.4p pd=20.88u as=2.5p ps=10.5u w=10u l=1u
X1341 VSS VDD VSS VSS nfet_06v0 ad=4.29p pd=20.38u as=0 ps=0 w=9.75u l=2u
X1342 a_54654_41059# a_48510_46213# a_57550_45959# VSS nfet_06v0 ad=1.1p pd=5.88u as=0.65p ps=3.02u w=2.5u l=1u
X1343 a_33702_54123# a_38718_49609# a_33254_49723# VSS nfet_06v0 ad=1.1p pd=5.88u as=1.1p ps=5.88u w=2.5u l=1u
X1344 a_54654_58419# a_56438_63319# VSS VSS nfet_06v0 ad=0.65p pd=3.02u as=0.65p ps=3.02u w=2.5u l=1u
X1345 a_49938_4870# S1N a_47442_4870# VSS nfet_06v0 ad=3.74p pd=17.88u as=3.74p ps=17.88u w=8.5u l=1u
X1346 a_11746_41059# a_2594_40945# a_7958_45459# VDD pfet_06v0 ad=1.3p pd=5.52u as=2.2p ps=10.88u w=5u l=1u
X1347 a_48850_70437# a_48850_70437# a_51506_67013# VSS nfet_06v0 ad=0.44p pd=2.88u as=0.25p ps=1.5u w=1u l=1u
X1348 a_25568_33300# a_40986_33300# VSS ppolyf_u_1k r_width=1u r_length=76.45u
X1349 a_2494_40989# a_2294_40945# VDD VDD pfet_06v0 ad=2.5p pd=10.5u as=4.4p ps=20.88u w=10u l=1u
X1350 a_75388_40976# X VSS VSS nfet_05v0 ad=0.5808p pd=3.52u as=0.5808p ps=3.52u w=1.32u l=0.6u
X1351 a_41226_62773# a_25326_63573# a_41426_62889# VSS nfet_06v0 ad=1.65p pd=5.66u as=1.25p ps=5.5u w=5u l=1u
X1352 a_77154_51200# a_72104_49876# VSS VSS nfet_06v0 ad=0.5456p pd=3.36u as=0.5456p ps=3.36u w=1.24u l=1u
X1353 a_56438_63319# a_62366_58305# a_56886_58419# VDD pfet_06v0 ad=2.2p pd=10.88u as=2.2p ps=10.88u w=5u l=1u
X1354 a_31030_67083# a_25666_70437# a_34818_71483# VDD pfet_06v0 ad=2.2p pd=10.88u as=1.3p ps=5.52u w=5u l=1u
X1355 VDD VSS VDD VDD pfet_06v0 ad=4.29p pd=20.38u as=0 ps=0 w=9.75u l=2u
X1356 a_53210_53193# a_7758_49607# a_55770_53123# VDD pfet_06v0 ad=4.4p pd=20.88u as=2.6p ps=10.52u w=10u l=1u
X1357 a_19718_62819# a_11294_63319# VSS VSS nfet_06v0 ad=1.3p pd=5.52u as=2.2p ps=10.88u w=5u l=1u
X1358 a_65974_45459# a_54214_45459# cap_mim_2f0_m4m5_noshield c_width=20u c_length=10u
X1359 a_33626_16930# a_33426_16886# VDD VDD pfet_06v0 ad=2.5p pd=10.5u as=4.4p ps=20.88u w=10u l=1u
X1360 a_74490_25288# a_76478_16886# a_70256_21126# VDD pfet_06v0 ad=1.76p pd=8.88u as=1.76p ps=8.88u w=4u l=1u
X1361 a_7758_49607# a_74490_4870# VSS VSS nfet_06v0 ad=0.44p pd=2.88u as=0.44p ps=2.88u w=1u l=1u
X1362 a_11226_16930# a_11026_16886# VDD VDD pfet_06v0 ad=2.5p pd=10.5u as=4.4p ps=20.88u w=10u l=1u
X1363 a_75112_49992# VDD Y VSS nfet_06v0 ad=1.0912p pd=5.84u as=0.6448p ps=3u w=2.48u l=1u
X1364 a_16110_58305# a_16110_58305# a_17746_58305# VDD pfet_06v0 ad=4.4p pd=20.88u as=3.3p ps=10.66u w=10u l=1u
X1365 VSS a_10182_63319# a_9514_58419# VSS nfet_06v0 ad=1.1p pd=5.88u as=0.65p ps=3.02u w=2.5u l=1u
X1366 a_25194_35696# a_24994_35580# a_26006_35696# VDD pfet_06v0 ad=4.4p pd=20.88u as=2.5p ps=10.5u w=10u l=1u
X1367 a_65646_70553# a_48550_70437# VDD VDD pfet_06v0 ad=2.5p pd=10.5u as=4.4p ps=20.88u w=10u l=1u
X1368 a_62830_16930# a_46982_16886# VDD VDD pfet_06v0 ad=2.5p pd=10.5u as=4.4p ps=20.88u w=10u l=1u
X1369 a_26258_67013# a_26058_66969# VSS VSS nfet_06v0 ad=1.25p pd=5.5u as=2.2p ps=10.88u w=5u l=1u
X1370 VDD VSS VDD VDD pfet_06v0 ad=7.92p pd=36.88u as=0 ps=0 w=18u l=2u
X1371 a_24894_35696# a_24694_35580# VDD VDD pfet_06v0 ad=2.5p pd=10.5u as=4.4p ps=20.88u w=10u l=1u
X1372 VDD a_42790_62819# a_86922_58418# VDD pfet_06v0 ad=1.32p pd=6.88u as=0.75p ps=3.5u w=3u l=1u
X1373 a_52850_67013# a_7758_66967# a_55326_67083# VSS nfet_06v0 ad=2.2p pd=10.88u as=1.3p ps=5.52u w=5u l=1u
X1374 a_62366_58305# a_62366_58305# a_64002_58305# VDD pfet_06v0 ad=4.4p pd=20.88u as=3.3p ps=10.66u w=10u l=1u
X1375 a_48550_70437# a_48850_70437# a_50474_67013# VSS nfet_06v0 ad=0.44p pd=2.88u as=0.25p ps=1.5u w=1u l=1u
X1376 a_32842_24672# a_24954_24672# a_33042_24788# VSS nfet_06v0 ad=1.65p pd=5.66u as=1.25p ps=5.5u w=5u l=1u
X1377 VSS VDD VSS VSS nfet_06v0 ad=4.29p pd=20.38u as=0 ps=0 w=9.75u l=2u
X1378 VSS a_56438_67083# a_54654_70483# VSS nfet_06v0 ad=1.1p pd=5.88u as=0.65p ps=3.02u w=2.5u l=1u
X1379 a_83814_49640# a_19718_49723# VDD VDD pfet_06v0 ad=1.32p pd=6.88u as=1.32p ps=6.88u w=3u l=1u
X1380 a_73254_60502# a_65974_49723# VSS VSS nfet_06v0 ad=0.33p pd=1.66u as=0.44p ps=2.88u w=1u l=1u
X1381 VSS VDD VSS VSS nfet_06v0 ad=4.29p pd=20.38u as=0 ps=0 w=9.75u l=2u
X1382 a_47856_19326# a_63274_19776# VSS ppolyf_u_1k r_width=1u r_length=76.45u
X1383 VDD a_10630_54123# a_7958_49723# VDD pfet_06v0 ad=2.2p pd=10.88u as=1.3p ps=5.52u w=5u l=1u
X1384 a_32142_67083# a_33702_71483# VDD VDD pfet_06v0 ad=1.3p pd=5.52u as=1.3p ps=5.52u w=5u l=1u
X1385 VDD a_25366_40945# a_30358_40989# VDD pfet_06v0 ad=4.4p pd=20.88u as=2.5p ps=10.5u w=10u l=1u
X1386 a_55770_58419# a_56438_63319# VSS VSS nfet_06v0 ad=0.65p pd=3.02u as=1.1p ps=5.88u w=2.5u l=1u
X1387 a_35070_11728# a_24694_11612# VDD VDD pfet_06v0 ad=2.5p pd=10.5u as=4.4p ps=20.88u w=10u l=1u
X1388 VDD a_56886_71483# a_54214_67083# VDD pfet_06v0 ad=1.3p pd=5.52u as=1.3p ps=5.52u w=5u l=1u
X1389 a_6926_49653# a_2254_49609# a_6594_49653# VSS nfet_06v0 ad=1.25p pd=5.5u as=1.65p ps=5.66u w=5u l=1u
X1390 VDD a_56886_54123# a_54214_49723# VDD pfet_06v0 ad=2.2p pd=10.88u as=1.3p ps=5.52u w=5u l=1u
X1391 a_12670_11728# a_2294_11612# VDD VDD pfet_06v0 ad=2.5p pd=10.5u as=4.4p ps=20.88u w=10u l=1u
X1392 a_40382_49653# a_26058_49609# VSS VSS nfet_06v0 ad=1.25p pd=5.5u as=2.2p ps=10.88u w=5u l=1u
X1393 a_31790_16886# a_31790_16886# a_33426_16886# VDD pfet_06v0 ad=4.4p pd=20.88u as=3.3p ps=10.66u w=10u l=1u
X1394 a_47856_10682# a_8870_45415# VSS ppolyf_u_1k r_width=1u r_length=76.45u
X1395 a_47142_4870# a_46942_4826# VSS VSS nfet_06v0 ad=1.25p pd=5.5u as=2.2p ps=10.88u w=5u l=1u
X1396 a_17946_40989# a_17746_40945# VDD VDD pfet_06v0 ad=2.5p pd=10.5u as=4.4p ps=20.88u w=10u l=1u
X1397 a_29666_49653# a_12006_25588# a_31030_49723# VSS nfet_06v0 ad=2.2p pd=10.88u as=1.3p ps=5.52u w=5u l=1u
X1398 a_77530_28794# a_69642_28794# a_77730_28838# VSS nfet_06v0 ad=1.65p pd=5.66u as=1.25p ps=5.5u w=5u l=1u
X1399 a_25366_70437# a_25666_70437# a_28602_70553# VDD pfet_06v0 ad=4.4p pd=20.88u as=2.5p ps=10.5u w=10u l=1u
X1400 a_41018_53193# a_40818_53077# VDD VDD pfet_06v0 ad=2.5p pd=10.5u as=4.4p ps=20.88u w=10u l=1u
X1401 a_9070_67083# a_2594_70437# a_10630_71483# VDD pfet_06v0 ad=2.2p pd=10.88u as=1.3p ps=5.52u w=5u l=1u
X1402 a_55130_28794# a_47242_28794# a_55330_28838# VSS nfet_06v0 ad=1.65p pd=5.66u as=1.25p ps=5.5u w=5u l=1u
X1403 VDD a_58002_54123# a_65974_49723# VDD pfet_06v0 ad=2.6p pd=10.52u as=2.6p ps=10.52u w=10u l=1u
X1404 a_72338_4870# S4N a_69842_4870# VSS nfet_06v0 ad=3.74p pd=17.88u as=3.74p ps=17.88u w=8.5u l=1u
X1405 a_34818_54123# a_25666_53077# a_31030_49723# VDD pfet_06v0 ad=1.3p pd=5.52u as=2.2p ps=10.88u w=5u l=1u
X1406 a_15646_49609# a_2594_53077# a_19390_53193# VDD pfet_06v0 ad=4.4p pd=20.88u as=2.5p ps=10.5u w=10u l=1u
X1407 a_65974_49723# a_57550_49723# VSS VSS nfet_06v0 ad=1.3p pd=5.52u as=2.2p ps=10.88u w=5u l=1u
X1408 a_69882_35696# a_69682_35580# a_70694_35696# VDD pfet_06v0 ad=4.4p pd=20.88u as=2.5p ps=10.5u w=10u l=1u
X1409 VDD VSS VDD VDD pfet_06v0 ad=7.92p pd=36.88u as=0 ps=0 w=18u l=2u
X1410 a_7958_67083# a_7758_66967# a_6594_67013# VSS nfet_06v0 ad=1.3p pd=5.52u as=2.2p ps=10.88u w=5u l=1u
X1411 VDD VSS VDD VDD pfet_06v0 ad=7.92p pd=36.88u as=0 ps=0 w=18u l=2u
X1412 VDD VSS VDD VDD pfet_06v0 ad=7.92p pd=36.88u as=0 ps=0 w=18u l=2u
X1413 a_56438_45959# a_62366_40945# a_56886_41059# VDD pfet_06v0 ad=2.2p pd=10.88u as=2.2p ps=10.88u w=5u l=1u
X1414 VDD a_11746_58419# a_19718_62819# VDD pfet_06v0 ad=2.6p pd=10.52u as=2.6p ps=10.52u w=10u l=1u
X1415 a_49206_28838# S3P a_47442_28838# VSS nfet_06v0 ad=3.3p pd=15.88u as=3.3p ps=15.88u w=7.5u l=1u
X1416 a_56438_49723# a_48510_49609# a_55770_53123# VSS nfet_06v0 ad=0.65p pd=3.02u as=1.1p ps=5.88u w=2.5u l=1u
X1417 VDD a_42790_45459# a_87474_42642# VDD pfet_06v0 ad=1.32p pd=6.88u as=0.99p ps=3.66u w=3u l=1u
X1418 VSS VDD VSS VSS nfet_06v0 ad=7.92p pd=36.88u as=0 ps=0 w=18u l=2u
X1419 YN a_75388_53540# VSS VSS nfet_05v0 ad=0.5808p pd=3.52u as=0.5808p ps=3.52u w=1.32u l=0.6u
X1420 a_84118_11728# a_69382_11612# VDD VDD pfet_06v0 ad=2.5p pd=10.5u as=4.4p ps=20.88u w=10u l=1u
X1421 a_4218_63689# a_2594_58305# VSS VSS nfet_06v0 ad=0.25p pd=1.5u as=0.44p ps=2.88u w=1u l=1u
X1422 a_69842_24788# a_69642_24672# a_69542_24788# VSS nfet_06v0 ad=2.2p pd=10.88u as=1.25p ps=5.5u w=5u l=1u
X1423 a_75010_51200# Y a_76410_51130# VSS nfet_06v0 ad=0.88p pd=4.88u as=0.5p ps=2.5u w=2u l=1u
X1424 a_9390_16886# a_2554_24672# a_9598_24788# VSS nfet_06v0 ad=2.2p pd=10.88u as=1.25p ps=5.5u w=5u l=1u
X1425 a_61718_11728# a_46982_11612# VDD VDD pfet_06v0 ad=2.5p pd=10.5u as=4.4p ps=20.88u w=10u l=1u
X1426 VSS a_33254_49723# a_31470_53123# VSS nfet_06v0 ad=0.65p pd=3.02u as=0.65p ps=3.02u w=2.5u l=1u
X1427 VDD VSS VDD VDD pfet_06v0 ad=7.92p pd=36.88u as=0 ps=0 w=18u l=2u
X1428 a_47442_24788# a_47242_24672# a_47142_24788# VSS nfet_06v0 ad=2.2p pd=10.88u as=1.25p ps=5.5u w=5u l=1u
X1429 a_16110_40945# a_16110_40945# a_17746_40945# VDD pfet_06v0 ad=4.4p pd=20.88u as=3.3p ps=10.66u w=10u l=1u
X1430 a_47282_11612# a_47282_11612# VDD VDD pfet_06v0 ad=0.88p pd=4.88u as=0.88p ps=4.88u w=2u l=1u
X1431 a_3606_70553# a_2294_70437# VDD VDD pfet_06v0 ad=2.5p pd=10.5u as=4.4p ps=20.88u w=10u l=1u
X1432 VSS VDD VSS VSS nfet_06v0 ad=0.44p pd=2.88u as=0 ps=0 w=1u l=2u
X1433 a_28194_4826# a_31790_12812# a_28742_11728# VDD pfet_06v0 ad=1.76p pd=8.88u as=1.76p ps=8.88u w=4u l=1u
X1434 a_62366_40945# a_62366_40945# a_64002_40945# VDD pfet_06v0 ad=4.4p pd=20.88u as=3.3p ps=10.66u w=10u l=1u
X1435 VSS a_19718_67083# a_71494_67000# VSS nfet_06v0 ad=0.44p pd=2.88u as=0.44p ps=2.88u w=1u l=1u
X1436 a_69882_16930# a_69682_16886# a_69582_16930# VDD pfet_06v0 ad=4.4p pd=20.88u as=2.5p ps=10.5u w=10u l=1u
X1437 a_54654_53123# a_56438_49723# VSS VSS nfet_06v0 ad=0.65p pd=3.02u as=1.1p ps=5.88u w=2.5u l=1u
X1438 a_6954_40989# a_7758_45415# a_8398_41059# VDD pfet_06v0 ad=4.4p pd=20.88u as=2.6p ps=10.52u w=10u l=1u
X1439 a_9514_53123# a_8870_49607# a_6954_53193# VDD pfet_06v0 ad=2.6p pd=10.52u as=4.4p ps=20.88u w=10u l=1u
X1440 VDD a_33702_54123# a_32142_49723# VDD pfet_06v0 ad=1.3p pd=5.52u as=1.3p ps=5.52u w=5u l=1u
X1441 a_47482_16930# a_47282_16886# a_47182_16930# VDD pfet_06v0 ad=4.4p pd=20.88u as=2.5p ps=10.5u w=10u l=1u
X1442 a_49862_70553# a_48550_70437# VDD VDD pfet_06v0 ad=2.5p pd=10.5u as=4.4p ps=20.88u w=10u l=1u
X1443 VDD VSS VDD VDD pfet_06v0 ad=7.92p pd=36.88u as=0 ps=0 w=18u l=2u
X1444 a_25194_11728# a_24994_11612# a_24894_11728# VDD pfet_06v0 ad=4.4p pd=20.88u as=2.5p ps=10.5u w=10u l=1u
X1445 VDD a_83814_42758# a_84634_42642# VDD pfet_06v0 ad=1.32p pd=6.88u as=0.99p ps=3.66u w=3u l=1u
X1446 VSS a_56438_45959# a_55770_41059# VSS nfet_06v0 ad=0.65p pd=3.02u as=0.65p ps=3.02u w=2.5u l=1u
X1447 VSS a_2986_45413# a_6926_45529# VSS nfet_06v0 ad=2.2p pd=10.88u as=1.25p ps=5.5u w=5u l=1u
X1448 a_55326_62819# a_56886_58419# VDD VDD pfet_06v0 ad=1.3p pd=5.52u as=1.3p ps=5.52u w=5u l=1u
X1449 a_48510_63573# a_48850_58305# a_48750_58349# VDD pfet_06v0 ad=4.4p pd=20.88u as=2.5p ps=10.5u w=10u l=1u
X1450 a_76478_16886# a_69642_24672# a_76686_24788# VSS nfet_06v0 ad=2.2p pd=10.88u as=1.25p ps=5.5u w=5u l=1u
X1451 a_4718_13618# a_5794_4826# VSS VSS nfet_06v0 ad=0.825p pd=3.16u as=1.1p ps=5.88u w=2.5u l=1u
X1452 a_73166_43186# a_72104_44598# VSS VSS nfet_06v0 ad=0.5456p pd=3.36u as=0.5456p ps=3.36u w=1.24u l=1u
X1453 a_29726_53193# a_25366_53077# VDD VDD pfet_06v0 ad=2.5p pd=10.5u as=4.4p ps=20.88u w=10u l=1u
X1454 a_54078_16886# a_47242_24672# a_54286_24788# VSS nfet_06v0 ad=2.2p pd=10.88u as=1.25p ps=5.5u w=5u l=1u
X1455 a_59190_28838# a_47282_35580# VSS VSS nfet_06v0 ad=0.25p pd=1.5u as=0.44p ps=2.88u w=1u l=1u
X1456 VDD a_56886_54123# a_55326_49723# VDD pfet_06v0 ad=2.2p pd=10.88u as=1.3p ps=5.52u w=5u l=1u
X1457 a_11746_71483# a_15646_66969# a_11294_67083# VSS nfet_06v0 ad=1.1p pd=5.88u as=1.1p ps=5.88u w=2.5u l=1u
X1458 a_27930_13628# S3N a_25194_11728# VDD pfet_06v0 ad=0.22p pd=1.88u as=0.22p ps=1.88u w=0.5u l=1u
X1459 a_25568_10682# a_40986_10232# VSS ppolyf_u_1k r_width=1u r_length=76.45u
X1460 VDD a_10630_58419# a_9070_62819# VDD pfet_06v0 ad=1.3p pd=5.52u as=1.3p ps=5.52u w=5u l=1u
X1461 a_3168_9782# a_18586_10232# VSS ppolyf_u_1k r_width=1u r_length=76.45u
X1462 a_58002_71483# a_61902_66969# a_57550_67083# VSS nfet_06v0 ad=1.1p pd=5.88u as=1.1p ps=5.88u w=2.5u l=1u
X1463 a_52850_49653# a_48510_49609# a_52550_49653# VSS nfet_06v0 ad=1.65p pd=5.66u as=1.25p ps=5.5u w=5u l=1u
X1464 VSS VDD VSS VSS nfet_06v0 ad=0.44p pd=2.88u as=0 ps=0 w=1u l=2u
X1465 a_47282_16886# a_47282_16886# VDD VDD pfet_06v0 ad=0.88p pd=4.88u as=0.88p ps=4.88u w=2u l=1u
X1466 VSS VDD VSS VSS nfet_06v0 ad=7.92p pd=36.88u as=0 ps=0 w=18u l=2u
X1467 a_55770_70483# a_48510_66969# a_56438_67083# VSS nfet_06v0 ad=1.1p pd=5.88u as=0.65p ps=3.02u w=2.5u l=1u
X1468 a_31470_58419# a_25326_63573# a_34366_63319# VSS nfet_06v0 ad=1.1p pd=5.88u as=0.65p ps=3.02u w=2.5u l=1u
X1469 a_61902_63273# a_48850_58305# a_65646_58349# VDD pfet_06v0 ad=4.4p pd=20.88u as=2.5p ps=10.5u w=10u l=1u
X1470 a_53210_58349# a_48850_58305# a_52910_58349# VDD pfet_06v0 ad=3.3p pd=10.66u as=2.5p ps=10.5u w=10u l=1u
X1471 a_17310_67013# a_2986_66969# VSS VSS nfet_06v0 ad=1.25p pd=5.5u as=2.2p ps=10.88u w=5u l=1u
X1472 a_6342_35696# a_2594_35580# a_5250_28838# VDD pfet_06v0 ad=4.4p pd=20.88u as=4.4p ps=20.88u w=10u l=1u
X1473 a_6294_67013# a_2986_66969# VSS VSS nfet_06v0 ad=1.25p pd=5.5u as=2.2p ps=10.88u w=5u l=1u
X1474 VSS a_10182_63319# a_9514_58419# VSS nfet_06v0 ad=0.65p pd=3.02u as=0.65p ps=3.02u w=2.5u l=1u
X1475 a_3168_9782# a_18586_9332# VSS ppolyf_u_1k r_width=1u r_length=76.45u
X1476 a_70256_9782# a_85674_10232# VSS ppolyf_u_1k r_width=1u r_length=76.45u
X1477 a_32142_45459# a_25666_40945# a_33702_41059# VDD pfet_06v0 ad=2.2p pd=10.88u as=1.3p ps=5.52u w=5u l=1u
X1478 a_50482_28794# a_47242_28794# a_50218_37596# VSS nfet_06v0 ad=1.1p pd=5.88u as=0.825p ps=3.16u w=2.5u l=1u
X1479 a_2294_40945# a_2594_40945# a_4218_46329# VSS nfet_06v0 ad=0.44p pd=2.88u as=0.25p ps=1.5u w=1u l=1u
X1480 VSS a_65974_62819# a_85566_60230# VSS nfet_06v0 ad=0.44p pd=2.88u as=0.25p ps=1.5u w=1u l=1u
X1481 a_7758_62775# a_47856_21126# VDD VDD pfet_06v0 ad=0.44p pd=2.88u as=0.44p ps=2.88u w=1u l=1u
X1482 a_25568_9332# a_30334_4826# a_29802_4870# VSS nfet_06v0 ad=0.88p pd=4.88u as=0.88p ps=4.88u w=2u l=1u
X1483 a_65974_45459# a_58002_41059# VDD VDD pfet_06v0 ad=2.6p pd=10.52u as=4.4p ps=20.88u w=10u l=1u
X1484 a_78114_35580# a_69682_35580# a_78314_35696# VDD pfet_06v0 ad=3.3p pd=10.66u as=2.5p ps=10.5u w=10u l=1u
X1485 a_7958_62819# a_10630_58419# VDD VDD pfet_06v0 ad=1.3p pd=5.52u as=2.2p ps=10.88u w=5u l=1u
X1486 VSS VDD VSS VSS nfet_06v0 ad=4.29p pd=20.38u as=0 ps=0 w=9.75u l=2u
X1487 a_49938_28838# S3N a_47442_28838# VSS nfet_06v0 ad=3.74p pd=17.88u as=3.74p ps=17.88u w=8.5u l=1u
X1488 a_55714_35580# a_47282_35580# a_55914_35696# VDD pfet_06v0 ad=3.3p pd=10.66u as=2.5p ps=10.5u w=10u l=1u
X1489 VSS a_49242_49609# a_53182_49653# VSS nfet_06v0 ad=2.2p pd=10.88u as=1.25p ps=5.5u w=5u l=1u
X1490 VDD VSS VDD VDD pfet_06v0 ad=0.44p pd=2.88u as=0 ps=0 w=1u l=2u
X1491 VDD a_42790_62819# a_87474_60114# VDD pfet_06v0 ad=1.32p pd=6.88u as=0.99p ps=3.66u w=3u l=1u
X1492 a_24694_35580# a_24994_35580# a_36902_28838# VSS nfet_06v0 ad=0.44p pd=2.88u as=0.25p ps=1.5u w=1u l=1u
X1493 a_29666_49653# a_8870_49607# a_32142_49723# VSS nfet_06v0 ad=2.2p pd=10.88u as=1.3p ps=5.52u w=5u l=1u
X1494 a_19718_49723# a_11746_54123# VDD VDD pfet_06v0 ad=4.4p pd=20.88u as=2.6p ps=10.52u w=10u l=1u
X1495 VDD a_10630_54123# a_7958_49723# VDD pfet_06v0 ad=1.3p pd=5.52u as=1.3p ps=5.52u w=5u l=1u
X1496 a_54214_62819# a_56886_58419# VDD VDD pfet_06v0 ad=1.3p pd=5.52u as=2.2p ps=10.88u w=5u l=1u
X1497 a_73430_35696# a_69682_35580# a_72338_28838# VDD pfet_06v0 ad=4.4p pd=20.88u as=4.4p ps=20.88u w=10u l=1u
X1498 VDD a_34818_58419# a_42790_62819# VDD pfet_06v0 ad=2.6p pd=10.52u as=2.6p ps=10.52u w=10u l=1u
X1499 a_48174_24788# a_46942_24672# VSS VSS nfet_06v0 ad=1.25p pd=5.5u as=2.2p ps=10.88u w=5u l=1u
X1500 a_55326_49723# a_56886_54123# VDD VDD pfet_06v0 ad=1.3p pd=5.52u as=2.2p ps=10.88u w=5u l=1u
X1501 a_48510_46213# a_48850_40945# a_48750_40989# VDD pfet_06v0 ad=4.4p pd=20.88u as=2.5p ps=10.5u w=10u l=1u
X1502 a_25326_49609# a_25666_53077# a_25566_53193# VDD pfet_06v0 ad=4.4p pd=20.88u as=2.5p ps=10.5u w=10u l=1u
X1503 VSS VDD VSS VSS nfet_06v0 ad=0.44p pd=2.88u as=0 ps=0 w=1u l=2u
X1504 a_2294_53077# a_2594_53077# a_4218_49653# VSS nfet_06v0 ad=0.44p pd=2.88u as=0.25p ps=1.5u w=1u l=1u
X1505 a_58158_4870# a_46942_4826# VSS VSS nfet_06v0 ad=1.25p pd=5.5u as=2.2p ps=10.88u w=5u l=1u
X1506 a_10630_58419# a_2594_58305# a_9070_62819# VDD pfet_06v0 ad=1.3p pd=5.52u as=2.2p ps=10.88u w=5u l=1u
X1507 a_69682_35580# a_69682_35580# a_82622_28838# VSS nfet_06v0 ad=0.44p pd=2.88u as=0.25p ps=1.5u w=1u l=1u
X1508 a_19390_58349# a_2294_58305# VDD VDD pfet_06v0 ad=2.5p pd=10.5u as=4.4p ps=20.88u w=10u l=1u
X1509 a_9070_49723# a_8870_49607# a_6594_49653# VSS nfet_06v0 ad=1.3p pd=5.52u as=2.2p ps=10.88u w=5u l=1u
X1510 a_5250_4870# a_6342_11728# VDD VDD pfet_06v0 ad=2.2p pd=10.88u as=2.2p ps=10.88u w=5u l=1u
X1511 a_47282_35580# a_47282_35580# a_60222_28838# VSS nfet_06v0 ad=0.44p pd=2.88u as=0.25p ps=1.5u w=1u l=1u
X1512 a_72304_44642# a_72104_44598# VSS VSS nfet_06v0 ad=0.5456p pd=3.36u as=0.5456p ps=3.36u w=1.24u l=1u
X1513 a_77242_51084# a_84634_42642# VDD VDD pfet_06v0 ad=1.32p pd=6.88u as=1.32p ps=6.88u w=3u l=1u
X1514 VDD a_83814_60230# a_84634_60114# VDD pfet_06v0 ad=1.32p pd=6.88u as=0.99p ps=3.66u w=3u l=1u
X1515 a_40542_16930# a_24694_16886# VDD VDD pfet_06v0 ad=2.5p pd=10.5u as=4.4p ps=20.88u w=10u l=1u
X1516 a_6954_70553# a_2594_70437# a_6654_70553# VDD pfet_06v0 ad=3.3p pd=10.66u as=2.5p ps=10.5u w=10u l=1u
X1517 VSS VDD VSS VSS nfet_06v0 ad=4.29p pd=20.38u as=0 ps=0 w=9.75u l=2u
X1518 a_74368_44750# a_72104_44598# a_74068_44750# VSS nfet_06v0 ad=0.175p pd=1.2u as=0.175p ps=1.2u w=0.7u l=1u
X1519 a_2986_49609# a_2254_49609# a_3186_49653# VSS nfet_06v0 ad=2.2p pd=10.88u as=1.25p ps=5.5u w=5u l=1u
X1520 a_2986_62773# a_2594_58305# a_3606_58349# VDD pfet_06v0 ad=4.4p pd=20.88u as=2.5p ps=10.5u w=10u l=1u
X1521 a_61902_45913# a_48850_40945# a_65646_40989# VDD pfet_06v0 ad=4.4p pd=20.88u as=2.5p ps=10.5u w=10u l=1u
X1522 a_25568_19326# a_40986_19776# VSS ppolyf_u_1k r_width=1u r_length=76.45u
X1523 a_9514_41059# a_10182_45959# VSS VSS nfet_06v0 ad=0.65p pd=3.02u as=0.65p ps=3.02u w=2.5u l=1u
X1524 VSS a_57550_63319# a_65974_62819# VSS nfet_06v0 ad=1.3p pd=5.52u as=1.3p ps=5.52u w=5u l=1u
X1525 a_7758_45415# a_4518_4870# cap_mim_2f0_m4m5_noshield c_width=25u c_length=8u
X1526 a_69382_35580# a_69682_35580# a_81590_28838# VSS nfet_06v0 ad=0.44p pd=2.88u as=0.25p ps=1.5u w=1u l=1u
X1527 a_47482_16930# a_47282_16886# a_48294_16930# VDD pfet_06v0 ad=4.4p pd=20.88u as=2.5p ps=10.5u w=10u l=1u
X1528 a_72338_4870# a_73430_11728# VDD VDD pfet_06v0 ad=2.2p pd=10.88u as=2.2p ps=10.88u w=5u l=1u
X1529 a_79758_11728# a_69382_11612# VDD VDD pfet_06v0 ad=2.5p pd=10.5u as=4.4p ps=20.88u w=10u l=1u
X1530 a_53210_40989# a_48850_40945# a_52910_40989# VDD pfet_06v0 ad=3.3p pd=10.66u as=2.5p ps=10.5u w=10u l=1u
X1531 a_10182_63319# a_16110_58305# a_10630_58419# VDD pfet_06v0 ad=2.2p pd=10.88u as=2.2p ps=10.88u w=5u l=1u
X1532 a_3168_19326# a_12006_25588# VSS ppolyf_u_1k r_width=1u r_length=76.45u
X1533 a_25326_66969# a_25326_66969# VSS VSS nfet_06v0 ad=0.44p pd=2.88u as=0.44p ps=2.88u w=1u l=1u
X1534 a_57358_11728# a_46982_11612# VDD VDD pfet_06v0 ad=2.5p pd=10.5u as=4.4p ps=20.88u w=10u l=1u
X1535 a_49938_4870# a_51030_11728# VDD VDD pfet_06v0 ad=2.2p pd=10.88u as=2.2p ps=10.88u w=5u l=1u
X1536 a_18154_49609# a_2254_49609# a_18354_49653# VSS nfet_06v0 ad=1.65p pd=5.66u as=1.25p ps=5.5u w=5u l=1u
X1537 a_49242_62773# a_48850_58305# a_49862_58349# VDD pfet_06v0 ad=4.4p pd=20.88u as=2.5p ps=10.5u w=10u l=1u
X1538 a_65974_62819# a_54214_62819# cap_mim_2f0_m4m5_noshield c_width=20u c_length=10u
X1539 a_6594_62889# a_7758_62775# a_7958_62819# VSS nfet_06v0 ad=2.2p pd=10.88u as=1.3p ps=5.52u w=5u l=1u
X1540 a_25568_10682# a_30830_45415# VSS ppolyf_u_1k r_width=1u r_length=76.45u
X1541 a_4518_28838# a_6342_35696# VDD VDD pfet_06v0 ad=2.2p pd=10.88u as=2.2p ps=10.88u w=5u l=1u
X1542 YN a_75388_53540# VDD VDD pfet_05v0 ad=0.8052p pd=4.54u as=0.8052p ps=4.54u w=1.83u l=0.5u
X1543 a_64410_49609# a_48510_49609# a_64610_49653# VSS nfet_06v0 ad=1.65p pd=5.66u as=1.25p ps=5.5u w=5u l=1u
X1544 VDD a_2294_70437# a_7286_70553# VDD pfet_06v0 ad=4.4p pd=20.88u as=2.5p ps=10.5u w=10u l=1u
X1545 VSS a_19718_67083# a_76086_67000# VSS nfet_06v0 ad=0.44p pd=2.88u as=0.25p ps=1.5u w=1u l=1u
X1546 a_32842_28794# a_24954_28794# a_33042_28838# VSS nfet_06v0 ad=1.65p pd=5.66u as=1.25p ps=5.5u w=5u l=1u
X1547 a_40818_70437# a_25666_70437# a_41018_70553# VDD pfet_06v0 ad=3.3p pd=10.66u as=2.5p ps=10.5u w=10u l=1u
X1548 VDD VSS VDD VDD pfet_06v0 ad=7.92p pd=36.88u as=0 ps=0 w=18u l=2u
X1549 a_7758_49607# a_71606_4870# cap_mim_2f0_m4m5_noshield c_width=25u c_length=8u
X1550 VSS VDD VSS VSS nfet_06v0 ad=4.29p pd=20.38u as=0 ps=0 w=9.75u l=2u
X1551 VSS a_56438_49723# a_55770_53123# VSS nfet_06v0 ad=1.1p pd=5.88u as=0.65p ps=3.02u w=2.5u l=1u
X1552 a_70256_19326# a_30830_62775# VSS ppolyf_u_1k r_width=1u r_length=76.45u
X1553 a_77154_51200# a_77242_51084# Y VSS nfet_06v0 ad=1.0912p pd=5.84u as=0.6448p ps=3u w=2.48u l=1u
X1554 VDD VSS VDD VDD pfet_06v0 ad=7.92p pd=36.88u as=0 ps=0 w=18u l=2u
X1555 a_30830_45415# a_29802_4870# VSS VSS nfet_06v0 ad=0.44p pd=2.88u as=0.44p ps=2.88u w=1u l=1u
X1556 VSS VDD VSS VSS nfet_06v0 ad=7.92p pd=36.88u as=0 ps=0 w=18u l=2u
X1557 a_2754_24788# a_2554_24672# a_3486_24788# VSS nfet_06v0 ad=2.2p pd=10.88u as=1.25p ps=5.5u w=5u l=1u
X1558 a_46982_16886# a_47282_16886# a_64754_16930# VDD pfet_06v0 ad=4.4p pd=20.88u as=2.5p ps=10.5u w=10u l=1u
X1559 a_71606_28838# a_73430_35696# VDD VDD pfet_06v0 ad=2.2p pd=10.88u as=2.2p ps=10.88u w=5u l=1u
X1560 a_80558_4870# a_69342_4826# VSS VSS nfet_06v0 ad=1.25p pd=5.5u as=2.2p ps=10.88u w=5u l=1u
X1561 a_54654_70483# a_48510_66969# a_57550_67083# VSS nfet_06v0 ad=1.1p pd=5.88u as=0.65p ps=3.02u w=2.5u l=1u
X1562 VDD VSS VDD VDD pfet_06v0 ad=7.92p pd=36.88u as=0 ps=0 w=18u l=2u
X1563 VSS a_33254_63319# a_32586_58419# VSS nfet_06v0 ad=0.65p pd=3.02u as=0.65p ps=3.02u w=2.5u l=1u
X1564 a_53210_70553# a_30830_66967# a_54654_70483# VDD pfet_06v0 ad=4.4p pd=20.88u as=2.6p ps=10.52u w=10u l=1u
X1565 a_49206_28838# a_51030_35696# VDD VDD pfet_06v0 ad=2.2p pd=10.88u as=2.2p ps=10.88u w=5u l=1u
X1566 a_19390_40989# a_2294_40945# VDD VDD pfet_06v0 ad=2.5p pd=10.5u as=4.4p ps=20.88u w=10u l=1u
X1567 a_48550_53077# a_48850_53077# a_51786_53193# VDD pfet_06v0 ad=4.4p pd=20.88u as=2.5p ps=10.5u w=10u l=1u
X1568 a_37934_28838# a_24994_35580# VSS VSS nfet_06v0 ad=0.25p pd=1.5u as=0.44p ps=2.88u w=1u l=1u
X1569 a_8398_53123# a_7758_49607# a_6954_53193# VDD pfet_06v0 ad=2.6p pd=10.52u as=4.4p ps=20.88u w=10u l=1u
X1570 a_24994_11612# a_24994_11612# VDD VDD pfet_06v0 ad=0.88p pd=4.88u as=0.88p ps=4.88u w=2u l=1u
X1571 a_49406_13618# S1P a_47482_11728# VDD pfet_06v0 ad=0.242p pd=1.98u as=0.242p ps=1.98u w=0.55u l=1u
X1572 a_72882_4826# a_76478_12812# a_73430_11728# VDD pfet_06v0 ad=1.76p pd=8.88u as=1.76p ps=8.88u w=4u l=1u
X1573 a_15534_28838# a_2594_35580# VSS VSS nfet_06v0 ad=0.25p pd=1.5u as=0.44p ps=2.88u w=1u l=1u
X1574 a_42462_53193# a_25366_53077# VDD VDD pfet_06v0 ad=2.5p pd=10.5u as=4.4p ps=20.88u w=10u l=1u
X1575 a_69642_24672# a_69642_24672# VSS VSS nfet_06v0 ad=0.44p pd=2.88u as=0.44p ps=2.88u w=1u l=1u
X1576 VDD a_11746_41059# a_19718_45459# VDD pfet_06v0 ad=2.6p pd=10.52u as=2.6p ps=10.52u w=10u l=1u
X1577 a_50482_4826# a_54078_12812# a_51030_11728# VDD pfet_06v0 ad=1.76p pd=8.88u as=1.76p ps=8.88u w=4u l=1u
X1578 a_64202_53193# a_64002_53077# VDD VDD pfet_06v0 ad=2.5p pd=10.5u as=4.4p ps=20.88u w=10u l=1u
X1579 a_27118_13618# a_28194_4826# VSS VSS nfet_06v0 ad=0.825p pd=3.16u as=1.1p ps=5.88u w=2.5u l=1u
X1580 a_24654_24672# a_24954_24672# a_35870_24788# VSS nfet_06v0 ad=2.2p pd=10.88u as=1.25p ps=5.5u w=5u l=1u
X1581 a_49442_45529# a_49242_45413# VSS VSS nfet_06v0 ad=1.25p pd=5.5u as=2.2p ps=10.88u w=5u l=1u
X1582 VDD VSS VDD VDD pfet_06v0 ad=4.29p pd=20.38u as=0 ps=0 w=9.75u l=2u
X1583 a_19718_67083# a_11294_67083# VSS VSS nfet_06v0 ad=1.3p pd=5.52u as=2.2p ps=10.88u w=5u l=1u
X1584 a_49206_4870# S1P a_47442_4870# VSS nfet_06v0 ad=3.3p pd=15.88u as=3.3p ps=15.88u w=7.5u l=1u
X1585 a_82622_4870# a_69682_11612# VSS VSS nfet_06v0 ad=0.25p pd=1.5u as=0.44p ps=2.88u w=1u l=1u
X1586 a_47242_24672# a_47242_24672# VSS VSS nfet_06v0 ad=0.44p pd=2.88u as=0.44p ps=2.88u w=1u l=1u
X1587 a_42790_49723# a_34818_54123# VDD VDD pfet_06v0 ad=4.4p pd=20.88u as=2.6p ps=10.52u w=10u l=1u
X1588 a_29366_45529# a_26058_45413# VSS VSS nfet_06v0 ad=1.25p pd=5.5u as=2.2p ps=10.88u w=5u l=1u
X1589 VSS a_34366_49723# a_42790_49723# VSS nfet_06v0 ad=1.3p pd=5.52u as=1.3p ps=5.52u w=5u l=1u
X1590 a_2254_24672# a_2554_24672# a_13470_24788# VSS nfet_06v0 ad=2.2p pd=10.88u as=1.25p ps=5.5u w=5u l=1u
X1591 a_69842_24788# a_69642_24672# a_70574_24788# VSS nfet_06v0 ad=2.2p pd=10.88u as=1.25p ps=5.5u w=5u l=1u
X1592 a_52850_62889# a_30830_62775# a_54214_62819# VSS nfet_06v0 ad=2.2p pd=10.88u as=1.3p ps=5.52u w=5u l=1u
X1593 a_2986_45413# a_2594_40945# a_3606_40989# VDD pfet_06v0 ad=4.4p pd=20.88u as=2.5p ps=10.5u w=10u l=1u
X1594 a_3168_9332# a_7934_4826# a_7402_4870# VSS nfet_06v0 ad=0.88p pd=4.88u as=0.88p ps=4.88u w=2u l=1u
X1595 a_72054_43186# a_72104_44598# VSS VSS nfet_06v0 ad=0.5456p pd=3.36u as=0.5456p ps=3.36u w=1.24u l=1u
X1596 a_32586_53123# a_25326_49609# a_33254_49723# VSS nfet_06v0 ad=1.1p pd=5.88u as=0.65p ps=3.02u w=2.5u l=1u
X1597 a_79086_51084# a_84634_60114# VDD VDD pfet_06v0 ad=1.32p pd=6.88u as=1.32p ps=6.88u w=3u l=1u
X1598 a_3606_16930# a_2294_16886# VDD VDD pfet_06v0 ad=2.5p pd=10.5u as=4.4p ps=20.88u w=10u l=1u
X1599 a_10182_45959# a_16110_40945# a_10630_41059# VDD pfet_06v0 ad=2.2p pd=10.88u as=2.2p ps=10.88u w=5u l=1u
X1600 a_72104_61958# a_72104_61958# VDD VDD pfet_06v0 ad=0.88p pd=4.88u as=0.88p ps=4.88u w=2u l=1u
X1601 a_31790_16886# a_24954_24672# a_31998_24788# VSS nfet_06v0 ad=2.2p pd=10.88u as=1.25p ps=5.5u w=5u l=1u
X1602 a_55130_4826# a_47242_4826# a_55330_4870# VSS nfet_06v0 ad=1.65p pd=5.66u as=1.25p ps=5.5u w=5u l=1u
X1603 a_54654_58419# a_30830_62775# a_53210_58349# VDD pfet_06v0 ad=2.6p pd=10.52u as=4.4p ps=20.88u w=10u l=1u
X1604 a_69842_28838# a_69642_28794# a_69542_28838# VSS nfet_06v0 ad=2.2p pd=10.88u as=1.25p ps=5.5u w=5u l=1u
X1605 a_49242_45413# a_48850_40945# a_49862_40989# VDD pfet_06v0 ad=4.4p pd=20.88u as=2.5p ps=10.5u w=10u l=1u
X1606 VDD VSS VDD VDD pfet_06v0 ad=4.29p pd=20.38u as=0 ps=0 w=9.75u l=2u
X1607 a_26058_49609# a_25666_53077# a_26678_53193# VDD pfet_06v0 ad=4.4p pd=20.88u as=2.5p ps=10.5u w=10u l=1u
X1608 VDD VSS VDD VDD pfet_06v0 ad=4.29p pd=20.38u as=0 ps=0 w=9.75u l=2u
X1609 a_9390_36780# a_2554_28794# a_9598_28838# VSS nfet_06v0 ad=2.2p pd=10.88u as=1.25p ps=5.5u w=5u l=1u
X1610 a_75022_4826# a_75022_4826# a_77530_4826# VSS nfet_06v0 ad=2.2p pd=10.88u as=1.65p ps=5.66u w=5u l=1u
X1611 a_47442_28838# a_47242_28794# a_47142_28838# VSS nfet_06v0 ad=2.2p pd=10.88u as=1.25p ps=5.5u w=5u l=1u
X1612 a_5250_28838# S1N a_2754_28838# VSS nfet_06v0 ad=3.74p pd=17.88u as=3.74p ps=17.88u w=8.5u l=1u
X1613 VDD VSS VDD VDD pfet_06v0 ad=7.92p pd=36.88u as=0 ps=0 w=18u l=2u
X1614 a_85566_49640# a_83814_49640# a_84634_49596# VSS nfet_06v0 ad=0.25p pd=1.5u as=0.44p ps=2.88u w=1u l=1u
X1615 a_2254_63573# a_2254_63573# VSS VSS nfet_06v0 ad=0.44p pd=2.88u as=0.44p ps=2.88u w=1u l=1u
X1616 a_25566_58349# a_25366_58305# VDD VDD pfet_06v0 ad=2.5p pd=10.5u as=4.4p ps=20.88u w=10u l=1u
X1617 a_10442_4826# a_2554_4826# a_10642_4870# VSS nfet_06v0 ad=1.65p pd=5.66u as=1.25p ps=5.5u w=5u l=1u
X1618 a_39430_35696# a_24694_35580# VDD VDD pfet_06v0 ad=2.5p pd=10.5u as=4.4p ps=20.88u w=10u l=1u
X1619 a_55326_45459# a_56886_41059# VDD VDD pfet_06v0 ad=1.3p pd=5.52u as=1.3p ps=5.52u w=5u l=1u
X1620 a_10182_49723# a_2254_49609# a_9514_53123# VSS nfet_06v0 ad=0.65p pd=3.02u as=1.1p ps=5.88u w=2.5u l=1u
X1621 a_52090_25288# a_54078_16886# a_47856_21126# VDD pfet_06v0 ad=1.76p pd=8.88u as=1.76p ps=8.88u w=4u l=1u
X1622 a_30334_4826# a_30334_4826# a_32842_4826# VSS nfet_06v0 ad=2.2p pd=10.88u as=1.65p ps=5.66u w=5u l=1u
X1623 a_30830_66967# a_47856_33300# VDD VDD pfet_06v0 ad=0.44p pd=2.88u as=0.44p ps=2.88u w=1u l=1u
X1624 a_52910_70553# a_48550_70437# VDD VDD pfet_06v0 ad=2.5p pd=10.5u as=4.4p ps=20.88u w=10u l=1u
X1625 a_24994_16886# a_24994_16886# VDD VDD pfet_06v0 ad=0.88p pd=4.88u as=0.88p ps=4.88u w=2u l=1u
X1626 a_54214_45459# a_30830_45415# a_52850_45529# VSS nfet_06v0 ad=1.3p pd=5.52u as=2.2p ps=10.88u w=5u l=1u
X1627 a_31470_70483# a_30830_66967# a_30026_70553# VDD pfet_06v0 ad=2.6p pd=10.52u as=4.4p ps=20.88u w=10u l=1u
X1628 a_10630_71483# a_15646_66969# a_10182_67083# VSS nfet_06v0 ad=1.1p pd=5.88u as=1.1p ps=5.88u w=2.5u l=1u
X1629 a_6926_62889# a_2254_63573# a_6594_62889# VSS nfet_06v0 ad=1.25p pd=5.5u as=1.65p ps=5.66u w=5u l=1u
X1630 a_32586_41059# a_33254_45959# VSS VSS nfet_06v0 ad=0.65p pd=3.02u as=0.65p ps=3.02u w=2.5u l=1u
X1631 a_74068_49992# a_72104_49876# a_73768_49992# VSS nfet_06v0 ad=0.175p pd=1.2u as=0.175p ps=1.2u w=0.7u l=1u
X1632 a_25666_70437# a_25666_70437# a_28322_67013# VSS nfet_06v0 ad=0.44p pd=2.88u as=0.25p ps=1.5u w=1u l=1u
X1633 a_40382_62889# a_26058_62773# VSS VSS nfet_06v0 ad=1.25p pd=5.5u as=2.2p ps=10.88u w=5u l=1u
X1634 a_30830_62775# a_70256_21126# VDD VDD pfet_06v0 ad=0.44p pd=2.88u as=0.44p ps=2.88u w=1u l=1u
X1635 a_3168_20226# a_18586_20676# VSS ppolyf_u_1k r_width=1u r_length=76.45u
X1636 a_10442_24672# a_2554_24672# a_10642_24788# VSS nfet_06v0 ad=1.65p pd=5.66u as=1.25p ps=5.5u w=5u l=1u
X1637 VDD a_33702_58419# a_32142_62819# VDD pfet_06v0 ad=2.2p pd=10.88u as=1.3p ps=5.52u w=5u l=1u
X1638 a_76478_36780# a_69642_28794# a_76686_28838# VSS nfet_06v0 ad=2.2p pd=10.88u as=1.25p ps=5.5u w=5u l=1u
X1639 a_33254_63319# a_39182_58305# a_33702_58419# VDD pfet_06v0 ad=2.2p pd=10.88u as=2.2p ps=10.88u w=5u l=1u
X1640 a_56886_71483# a_61902_66969# a_56438_67083# VSS nfet_06v0 ad=1.1p pd=5.88u as=1.1p ps=5.88u w=2.5u l=1u
X1641 a_27118_37586# a_7758_66967# cap_mim_2f0_m4m5_noshield c_width=25u c_length=8u
X1642 VDD a_10630_41059# a_9070_45459# VDD pfet_06v0 ad=1.3p pd=5.52u as=1.3p ps=5.52u w=5u l=1u
X1643 a_19718_62819# a_11294_63319# VSS VSS nfet_06v0 ad=2.2p pd=10.88u as=1.3p ps=5.52u w=5u l=1u
X1644 a_28194_25172# a_24954_24672# a_27930_16930# VSS nfet_06v0 ad=1.1p pd=5.88u as=0.825p ps=3.16u w=2.5u l=1u
X1645 a_54078_36780# a_47242_28794# a_54286_28838# VSS nfet_06v0 ad=2.2p pd=10.88u as=1.25p ps=5.5u w=5u l=1u
X1646 a_28742_11728# a_24994_11612# a_27650_4870# VDD pfet_06v0 ad=4.4p pd=20.88u as=4.4p ps=20.88u w=10u l=1u
X1647 a_20066_16930# a_2294_16886# VDD VDD pfet_06v0 ad=2.5p pd=10.5u as=4.4p ps=20.88u w=10u l=1u
X1648 a_8398_41059# a_10182_45959# VSS VSS nfet_06v0 ad=0.65p pd=3.02u as=1.1p ps=5.88u w=2.5u l=1u
X1649 a_69582_11728# a_69382_11612# VDD VDD pfet_06v0 ad=2.5p pd=10.5u as=4.4p ps=20.88u w=10u l=1u
X1650 VSS VDD VSS VSS nfet_06v0 ad=7.92p pd=36.88u as=0 ps=0 w=18u l=2u
X1651 a_47442_4870# a_47242_4826# a_48174_4870# VSS nfet_06v0 ad=2.2p pd=10.88u as=1.25p ps=5.5u w=5u l=1u
X1652 a_69382_11612# a_69682_11612# a_81590_4870# VSS nfet_06v0 ad=0.44p pd=2.88u as=0.25p ps=1.5u w=1u l=1u
X1653 a_19718_45459# a_7958_45459# cap_mim_2f0_m4m5_noshield c_width=20u c_length=10u
X1654 a_6594_62889# a_8870_62775# a_9070_62819# VSS nfet_06v0 ad=2.2p pd=10.88u as=1.3p ps=5.52u w=5u l=1u
X1655 a_9390_16886# a_9390_16886# a_11026_16886# VDD pfet_06v0 ad=4.4p pd=20.88u as=3.3p ps=10.66u w=10u l=1u
X1656 Y Y VDD VDD pfet_06v0 ad=0.52p pd=2.52u as=0.52p ps=2.52u w=2u l=1u
X1657 a_8870_66967# a_71606_28838# cap_mim_2f0_m4m5_noshield c_width=25u c_length=8u
X1658 a_70256_20226# a_85674_20676# VSS ppolyf_u_1k r_width=1u r_length=76.45u
X1659 a_25366_70437# a_25666_70437# a_27290_67013# VSS nfet_06v0 ad=0.44p pd=2.88u as=0.25p ps=1.5u w=1u l=1u
X1660 a_69342_28794# a_69682_35580# a_85230_35696# VDD pfet_06v0 ad=4.4p pd=20.88u as=2.5p ps=10.5u w=10u l=1u
X1661 a_87474_49596# a_19718_49723# VDD VDD pfet_06v0 ad=0.99p pd=3.66u as=1.32p ps=6.88u w=3u l=1u
X1662 a_74602_68412# a_65974_67083# a_72142_60502# VDD pfet_06v0 ad=0.75p pd=3.5u as=1.32p ps=6.88u w=3u l=1u
X1663 a_53542_70553# a_48850_70437# a_53210_70553# VDD pfet_06v0 ad=2.5p pd=10.5u as=3.3p ps=10.66u w=10u l=1u
X1664 a_65974_67083# a_58002_71483# VDD VDD pfet_06v0 ad=4.4p pd=20.88u as=2.6p ps=10.52u w=10u l=1u
X1665 a_25886_24788# a_24654_24672# VSS VSS nfet_06v0 ad=1.25p pd=5.5u as=2.2p ps=10.88u w=5u l=1u
X1666 VSS a_2986_66969# a_6926_67013# VSS nfet_06v0 ad=2.2p pd=10.88u as=1.25p ps=5.5u w=5u l=1u
X1667 a_31030_62819# a_33702_58419# VDD VDD pfet_06v0 ad=1.3p pd=5.52u as=1.3p ps=5.52u w=5u l=1u
X1668 VDD VSS VDD VDD pfet_06v0 ad=7.92p pd=36.88u as=0 ps=0 w=18u l=2u
X1669 a_72104_44598# a_72104_44598# VDD VDD pfet_06v0 ad=0.88p pd=4.88u as=0.88p ps=4.88u w=2u l=1u
X1670 a_49938_24088# S4N a_47442_24788# VSS nfet_06v0 ad=3.74p pd=17.88u as=3.74p ps=17.88u w=8.5u l=1u
X1671 a_7958_45459# a_10630_41059# VDD VDD pfet_06v0 ad=1.3p pd=5.52u as=2.2p ps=10.88u w=5u l=1u
X1672 a_71806_37586# a_72882_28794# VSS VSS nfet_06v0 ad=0.825p pd=3.16u as=1.1p ps=5.88u w=2.5u l=1u
X1673 a_25568_33300# a_24994_35580# a_26918_28838# VDD pfet_06v0 ad=4.4p pd=20.88u as=4.4p ps=20.88u w=10u l=1u
X1674 VDD a_33702_71483# a_31030_67083# VDD pfet_06v0 ad=1.3p pd=5.52u as=1.3p ps=5.52u w=5u l=1u
X1675 a_49406_37586# a_50482_28794# VSS VSS nfet_06v0 ad=0.825p pd=3.16u as=1.1p ps=5.88u w=2.5u l=1u
X1676 VDD a_33702_54123# a_31030_49723# VDD pfet_06v0 ad=2.2p pd=10.88u as=1.3p ps=5.52u w=5u l=1u
X1677 VSS VDD VSS VSS nfet_06v0 ad=7.92p pd=36.88u as=0 ps=0 w=18u l=2u
X1678 a_54214_45459# a_56886_41059# VDD VDD pfet_06v0 ad=1.3p pd=5.52u as=2.2p ps=10.88u w=5u l=1u
X1679 VSS a_56438_67083# a_55770_70483# VSS nfet_06v0 ad=0.65p pd=3.02u as=0.65p ps=3.02u w=2.5u l=1u
X1680 a_7758_49607# a_70256_9332# VDD VDD pfet_06v0 ad=0.44p pd=2.88u as=0.44p ps=2.88u w=1u l=1u
X1681 VDD a_34818_41059# a_42790_45459# VDD pfet_06v0 ad=2.6p pd=10.52u as=2.6p ps=10.52u w=10u l=1u
X1682 a_54286_4870# a_46942_4826# VSS VSS nfet_06v0 ad=1.25p pd=5.5u as=2.2p ps=10.88u w=5u l=1u
X1683 a_25566_40989# a_25366_40945# VDD VDD pfet_06v0 ad=2.5p pd=10.5u as=4.4p ps=20.88u w=10u l=1u
X1684 a_5530_70553# a_2294_70437# VDD VDD pfet_06v0 ad=2.5p pd=10.5u as=4.4p ps=20.88u w=10u l=1u
X1685 VSS VDD VSS VSS nfet_06v0 ad=4.29p pd=20.38u as=0 ps=0 w=9.75u l=2u
X1686 a_24954_4826# a_24994_11612# a_39430_11728# VDD pfet_06v0 ad=4.4p pd=20.88u as=2.5p ps=10.5u w=10u l=1u
X1687 a_10630_41059# a_2594_40945# a_9070_45459# VDD pfet_06v0 ad=1.3p pd=5.52u as=2.2p ps=10.88u w=5u l=1u
X1688 a_51786_58349# a_48550_58305# VDD VDD pfet_06v0 ad=2.5p pd=10.5u as=4.4p ps=20.88u w=10u l=1u
X1689 a_2554_4826# a_2594_11612# a_17030_11728# VDD pfet_06v0 ad=4.4p pd=20.88u as=2.5p ps=10.5u w=10u l=1u
X1690 a_48174_28838# a_46942_28794# VSS VSS nfet_06v0 ad=1.25p pd=5.5u as=2.2p ps=10.88u w=5u l=1u
X1691 a_11746_58419# a_15646_63273# a_11294_63319# VSS nfet_06v0 ad=1.1p pd=5.88u as=1.1p ps=5.88u w=2.5u l=1u
X1692 a_33254_45959# a_39182_40945# a_33702_41059# VDD pfet_06v0 ad=2.2p pd=10.88u as=2.2p ps=10.88u w=5u l=1u
X1693 a_8870_49607# a_26918_24288# cap_mim_2f0_m4m5_noshield c_width=25u c_length=8u
X1694 a_39182_40945# a_25326_46213# a_40382_45529# VSS nfet_06v0 ad=2.2p pd=10.88u as=1.25p ps=5.5u w=5u l=1u
X1695 a_52850_62889# a_48510_63573# a_52550_62889# VSS nfet_06v0 ad=1.65p pd=5.66u as=1.25p ps=5.5u w=5u l=1u
X1696 a_58002_58419# a_61902_63273# a_57550_63319# VSS nfet_06v0 ad=1.1p pd=5.88u as=1.1p ps=5.88u w=2.5u l=1u
X1697 a_27650_4870# a_28742_11728# VDD VDD pfet_06v0 ad=2.2p pd=10.88u as=2.2p ps=10.88u w=5u l=1u
X1698 a_46982_16886# a_47282_16886# a_59190_25588# VSS nfet_06v0 ad=0.44p pd=2.88u as=0.25p ps=1.5u w=1u l=1u
X1699 a_2594_58305# a_2594_58305# a_5250_63689# VSS nfet_06v0 ad=0.44p pd=2.88u as=0.25p ps=1.5u w=1u l=1u
X1700 a_4718_16930# S2P a_2794_16930# VDD pfet_06v0 ad=0.242p pd=1.98u as=0.242p ps=1.98u w=0.55u l=1u
X1701 VDD Y Y VDD pfet_06v0 ad=0.52p pd=2.52u as=0.52p ps=2.52u w=2u l=1u
X1702 a_75112_44394# a_72104_44598# VSS VSS nfet_06v0 ad=0.5456p pd=3.36u as=0.5456p ps=3.36u w=1.24u l=1u
X1703 a_69542_4870# a_69342_4826# VSS VSS nfet_06v0 ad=1.25p pd=5.5u as=2.2p ps=10.88u w=5u l=1u
X1704 a_11294_67083# a_16110_71437# a_11746_71483# VDD pfet_06v0 ad=2.2p pd=10.88u as=2.2p ps=10.88u w=5u l=1u
X1705 a_47856_33750# a_63274_33300# VSS ppolyf_u_1k r_width=1u r_length=76.45u
X1706 VDD VSS VDD VDD pfet_06v0 ad=4.29p pd=20.38u as=0 ps=0 w=9.75u l=2u
X1707 a_26678_58349# a_25366_58305# VDD VDD pfet_06v0 ad=2.5p pd=10.5u as=4.4p ps=20.88u w=10u l=1u
X1708 a_24854_4870# a_24654_4826# VSS VSS nfet_06v0 ad=1.25p pd=5.5u as=2.2p ps=10.88u w=5u l=1u
X1709 a_3168_21126# a_18586_20676# VSS ppolyf_u_1k r_width=1u r_length=76.45u
X1710 VDD a_10630_71483# a_9070_67083# VDD pfet_06v0 ad=2.2p pd=10.88u as=1.3p ps=5.52u w=5u l=1u
X1711 VSS VDD VSS VSS nfet_06v0 ad=0.44p pd=2.88u as=0 ps=0 w=1u l=2u
X1712 a_42790_62819# a_34366_63319# VSS VSS nfet_06v0 ad=2.2p pd=10.88u as=1.3p ps=5.52u w=5u l=1u
X1713 a_41426_49653# a_41226_49609# VSS VSS nfet_06v0 ad=1.25p pd=5.5u as=2.2p ps=10.88u w=5u l=1u
X1714 a_31030_49723# a_33702_54123# VDD VDD pfet_06v0 ad=1.3p pd=5.52u as=2.2p ps=10.88u w=5u l=1u
X1715 a_55770_70483# a_7758_66967# a_53210_70553# VDD pfet_06v0 ad=2.6p pd=10.52u as=4.4p ps=20.88u w=10u l=1u
X1716 a_24694_16886# a_24994_16886# a_42466_16930# VDD pfet_06v0 ad=4.4p pd=20.88u as=2.5p ps=10.5u w=10u l=1u
X1717 a_71806_16930# S3P a_69882_16930# VDD pfet_06v0 ad=0.242p pd=1.98u as=0.242p ps=1.98u w=0.55u l=1u
X1718 a_55326_45459# a_7758_45415# a_52850_45529# VSS nfet_06v0 ad=1.3p pd=5.52u as=2.2p ps=10.88u w=5u l=1u
X1719 a_31470_41059# a_33254_45959# VSS VSS nfet_06v0 ad=0.65p pd=3.02u as=1.1p ps=5.88u w=2.5u l=1u
X1720 a_48850_53077# a_48850_53077# VDD VDD pfet_06v0 ad=0.88p pd=4.88u as=0.88p ps=4.88u w=2u l=1u
X1721 VSS a_49242_62773# a_53182_62889# VSS nfet_06v0 ad=2.2p pd=10.88u as=1.25p ps=5.5u w=5u l=1u
X1722 a_2294_16886# a_2594_16886# a_20066_16930# VDD pfet_06v0 ad=4.4p pd=20.88u as=2.5p ps=10.5u w=10u l=1u
X1723 a_7758_49607# a_70256_9332# VDD VDD pfet_06v0 ad=0.44p pd=2.88u as=0.44p ps=2.88u w=1u l=1u
X1724 a_74490_4870# a_76478_12812# a_70256_9332# VDD pfet_06v0 ad=1.76p pd=8.88u as=1.76p ps=8.88u w=4u l=1u
X1725 a_75112_61754# VDD Z VSS nfet_06v0 ad=1.0912p pd=5.84u as=0.6448p ps=3u w=2.48u l=1u
X1726 a_50482_4826# a_47242_4826# a_50218_13628# VSS nfet_06v0 ad=1.1p pd=5.88u as=0.825p ps=3.16u w=2.5u l=1u
X1727 a_34818_71483# a_38718_66969# a_34366_67083# VSS nfet_06v0 ad=1.1p pd=5.88u as=1.1p ps=5.88u w=2.5u l=1u
X1728 a_8870_45415# a_47856_9332# VDD VDD pfet_06v0 ad=0.44p pd=2.88u as=0.44p ps=2.88u w=1u l=1u
X1729 a_46942_24672# a_47242_24672# a_58158_24788# VSS nfet_06v0 ad=2.2p pd=10.88u as=1.25p ps=5.5u w=5u l=1u
X1730 a_33702_54123# a_25666_53077# a_32142_49723# VDD pfet_06v0 ad=1.3p pd=5.52u as=2.2p ps=10.88u w=5u l=1u
X1731 a_48294_11728# a_46982_11612# VDD VDD pfet_06v0 ad=2.5p pd=10.5u as=4.4p ps=20.88u w=10u l=1u
X1732 a_70256_21126# a_85674_20676# VSS ppolyf_u_1k r_width=1u r_length=76.45u
X1733 X a_79086_43142# a_72304_44642# VSS nfet_06v0 ad=0.6448p pd=3u as=1.0912p ps=5.84u w=2.48u l=1u
X1734 a_56438_63319# a_48510_63573# a_55770_58419# VSS nfet_06v0 ad=0.65p pd=3.02u as=1.1p ps=5.88u w=2.5u l=1u
X1735 a_74490_28838# a_69642_28794# a_71806_37586# VSS nfet_06v0 ad=1.1p pd=5.88u as=0.825p ps=3.16u w=2.5u l=1u
X1736 a_51786_40989# a_48550_40945# VDD VDD pfet_06v0 ad=2.5p pd=10.5u as=4.4p ps=20.88u w=10u l=1u
X1737 a_48850_58305# a_48850_58305# a_51506_63689# VSS nfet_06v0 ad=0.44p pd=2.88u as=0.25p ps=1.5u w=1u l=1u
X1738 Z Z VDD VDD pfet_06v0 ad=0.52p pd=2.52u as=0.52p ps=2.52u w=2u l=1u
X1739 VDD VSS VDD VDD pfet_06v0 ad=7.92p pd=36.88u as=0 ps=0 w=18u l=2u
X1740 a_72142_43142# a_75154_66956# VDD VDD pfet_06v0 ad=1.32p pd=6.88u as=1.32p ps=6.88u w=3u l=1u
X1741 VSS a_33254_63319# a_31470_58419# VSS nfet_06v0 ad=0.65p pd=3.02u as=0.65p ps=3.02u w=2.5u l=1u
X1742 a_2294_35580# a_2594_35580# a_14502_28838# VSS nfet_06v0 ad=0.44p pd=2.88u as=0.25p ps=1.5u w=1u l=1u
X1743 a_2754_28838# a_2554_28794# a_3486_28838# VSS nfet_06v0 ad=2.2p pd=10.88u as=1.25p ps=5.5u w=5u l=1u
X1744 a_51030_35696# a_47282_35580# a_49938_28838# VDD pfet_06v0 ad=4.4p pd=20.88u as=4.4p ps=20.88u w=10u l=1u
X1745 a_47242_4826# a_47242_4826# VSS VSS nfet_06v0 ad=0.44p pd=2.88u as=0.44p ps=2.88u w=1u l=1u
X1746 a_8398_53123# a_10182_49723# VSS VSS nfet_06v0 ad=0.65p pd=3.02u as=0.65p ps=3.02u w=2.5u l=1u
X1747 VDD a_48550_58305# a_53542_58349# VDD pfet_06v0 ad=4.4p pd=20.88u as=2.5p ps=10.5u w=10u l=1u
X1748 a_54214_67083# a_56886_71483# VDD VDD pfet_06v0 ad=1.3p pd=5.52u as=1.3p ps=5.52u w=5u l=1u
X1749 X VDD a_75112_44394# VSS nfet_06v0 ad=0.6448p pd=3u as=1.0912p ps=5.84u w=2.48u l=1u
X1750 VDD VSS VDD VDD pfet_06v0 ad=0.44p pd=2.88u as=0 ps=0 w=1u l=2u
X1751 a_8870_66967# a_70256_33300# VDD VDD pfet_06v0 ad=0.44p pd=2.88u as=0.44p ps=2.88u w=1u l=1u
X1752 a_54654_58419# a_56438_63319# VSS VSS nfet_06v0 ad=0.65p pd=3.02u as=1.1p ps=5.88u w=2.5u l=1u
X1753 a_2554_4826# a_2554_4826# VSS VSS nfet_06v0 ad=0.44p pd=2.88u as=0.44p ps=2.88u w=1u l=1u
X1754 a_2986_62773# a_2254_63573# a_3186_62889# VSS nfet_06v0 ad=2.2p pd=10.88u as=1.25p ps=5.5u w=5u l=1u
X1755 a_56438_49723# a_62366_54077# a_56886_54123# VDD pfet_06v0 ad=2.2p pd=10.88u as=2.2p ps=10.88u w=5u l=1u
X1756 a_9514_70483# a_10182_67083# VSS VSS nfet_06v0 ad=0.65p pd=3.02u as=0.65p ps=3.02u w=2.5u l=1u
X1757 a_87154_11728# a_69382_11612# VDD VDD pfet_06v0 ad=2.5p pd=10.5u as=4.4p ps=20.88u w=10u l=1u
X1758 a_4518_4870# S2P a_2754_4870# VSS nfet_06v0 ad=3.3p pd=15.88u as=3.3p ps=15.88u w=7.5u l=1u
X1759 VSS a_57550_67083# a_65974_67083# VSS nfet_06v0 ad=1.3p pd=5.52u as=1.3p ps=5.52u w=5u l=1u
X1760 a_64754_11728# a_46982_11612# VDD VDD pfet_06v0 ad=2.5p pd=10.5u as=4.4p ps=20.88u w=10u l=1u
X1761 a_48550_58305# a_48850_58305# a_50474_63689# VSS nfet_06v0 ad=0.44p pd=2.88u as=0.25p ps=1.5u w=1u l=1u
X1762 a_24654_28794# a_24954_28794# a_35870_28838# VSS nfet_06v0 ad=2.2p pd=10.88u as=1.25p ps=5.5u w=5u l=1u
X1763 a_2254_28794# a_2554_28794# a_13470_28838# VSS nfet_06v0 ad=2.2p pd=10.88u as=1.25p ps=5.5u w=5u l=1u
X1764 a_54654_41059# a_30830_45415# a_53210_40989# VDD pfet_06v0 ad=2.6p pd=10.52u as=4.4p ps=20.88u w=10u l=1u
X1765 a_26678_40989# a_25366_40945# VDD VDD pfet_06v0 ad=2.5p pd=10.5u as=4.4p ps=20.88u w=10u l=1u
X1766 a_18154_62773# a_2254_63573# a_18354_62889# VSS nfet_06v0 ad=1.65p pd=5.66u as=1.25p ps=5.5u w=5u l=1u
X1767 a_69842_28838# a_69642_28794# a_70574_28838# VSS nfet_06v0 ad=2.2p pd=10.88u as=1.25p ps=5.5u w=5u l=1u
X1768 VSS VDD VSS VSS nfet_06v0 ad=7.92p pd=36.88u as=0 ps=0 w=18u l=2u
X1769 a_5250_24088# S2N a_2754_24788# VSS nfet_06v0 ad=3.74p pd=17.88u as=3.74p ps=17.88u w=8.5u l=1u
X1770 a_6594_67013# a_7758_66967# a_7958_67083# VSS nfet_06v0 ad=2.2p pd=10.88u as=1.3p ps=5.52u w=5u l=1u
X1771 VSS a_84634_49596# a_73254_51084# VSS nfet_06v0 ad=0.44p pd=2.88u as=0.44p ps=2.88u w=1u l=1u
X1772 a_62366_54077# a_48510_49609# a_63566_49653# VSS nfet_06v0 ad=2.2p pd=10.88u as=1.25p ps=5.5u w=5u l=1u
X1773 VSS a_65974_45459# a_85566_42758# VSS nfet_06v0 ad=0.44p pd=2.88u as=0.25p ps=1.5u w=1u l=1u
X1774 a_2294_58305# a_2594_58305# a_5530_58349# VDD pfet_06v0 ad=4.4p pd=20.88u as=2.5p ps=10.5u w=10u l=1u
X1775 a_2294_11612# a_2594_11612# a_14502_4870# VSS nfet_06v0 ad=0.44p pd=2.88u as=0.25p ps=1.5u w=1u l=1u
X1776 a_2494_53193# a_2294_53077# VDD VDD pfet_06v0 ad=2.5p pd=10.5u as=4.4p ps=20.88u w=10u l=1u
X1777 a_77154_60546# a_77242_60502# Z VSS nfet_06v0 ad=1.0912p pd=5.84u as=0.6448p ps=3u w=2.48u l=1u
X1778 a_64410_62773# a_48510_63573# a_64610_62889# VSS nfet_06v0 ad=1.65p pd=5.66u as=1.25p ps=5.5u w=5u l=1u
X1779 a_31790_36780# a_24954_28794# a_31998_28838# VSS nfet_06v0 ad=2.2p pd=10.88u as=1.25p ps=5.5u w=5u l=1u
X1780 a_2254_4826# a_2594_11612# a_18142_11728# VDD pfet_06v0 ad=4.4p pd=20.88u as=2.5p ps=10.5u w=10u l=1u
X1781 VDD VSS VDD VDD pfet_06v0 ad=4.29p pd=20.38u as=0 ps=0 w=9.75u l=2u
X1782 a_30026_58349# a_30830_62775# a_31470_58419# VDD pfet_06v0 ad=4.4p pd=20.88u as=2.6p ps=10.52u w=10u l=1u
X1783 a_35070_16930# a_24694_16886# VDD VDD pfet_06v0 ad=2.5p pd=10.5u as=4.4p ps=20.88u w=10u l=1u
X1784 a_7958_62819# a_2594_58305# a_11746_58419# VDD pfet_06v0 ad=2.2p pd=10.88u as=1.3p ps=5.52u w=5u l=1u
X1785 a_34366_67083# a_39182_71437# a_34818_71483# VDD pfet_06v0 ad=2.2p pd=10.88u as=2.2p ps=10.88u w=5u l=1u
X1786 a_12670_16930# a_2294_16886# VDD VDD pfet_06v0 ad=2.5p pd=10.5u as=4.4p ps=20.88u w=10u l=1u
X1787 a_47856_33750# a_63274_34200# VSS ppolyf_u_1k r_width=1u r_length=76.45u
X1788 VDD a_33702_41059# a_32142_45459# VDD pfet_06v0 ad=2.2p pd=10.88u as=1.3p ps=5.52u w=5u l=1u
X1789 ZP ZN VSS VSS nfet_05v0 ad=0.5808p pd=3.52u as=0.5808p ps=3.52u w=1.32u l=0.6u
X1790 a_49442_67013# a_49242_66969# VSS VSS nfet_06v0 ad=1.25p pd=5.5u as=2.2p ps=10.88u w=5u l=1u
X1791 a_8870_45415# a_52090_4870# VSS VSS nfet_06v0 ad=0.44p pd=2.88u as=0.44p ps=2.88u w=1u l=1u
X1792 a_31470_41059# a_33254_45959# VSS VSS nfet_06v0 ad=0.65p pd=3.02u as=0.65p ps=3.02u w=2.5u l=1u
X1793 VSS VDD VSS VSS nfet_06v0 ad=7.92p pd=36.88u as=0 ps=0 w=18u l=2u
X1794 a_29366_67013# a_26058_66969# VSS VSS nfet_06v0 ad=1.25p pd=5.5u as=2.2p ps=10.88u w=5u l=1u
X1795 VDD VSS VDD VDD pfet_06v0 ad=7.92p pd=36.88u as=0 ps=0 w=18u l=2u
X1796 a_29666_45529# a_30830_45415# a_31030_45459# VSS nfet_06v0 ad=2.2p pd=10.88u as=1.3p ps=5.52u w=5u l=1u
X1797 a_55770_41059# a_56438_45959# VSS VSS nfet_06v0 ad=0.65p pd=3.02u as=0.65p ps=3.02u w=2.5u l=1u
X1798 a_10442_28794# a_2554_28794# a_10642_28838# VSS nfet_06v0 ad=1.65p pd=5.66u as=1.25p ps=5.5u w=5u l=1u
X1799 VDD VSS VDD VDD pfet_06v0 ad=7.92p pd=36.88u as=0 ps=0 w=18u l=2u
X1800 X a_77242_43142# a_77154_43186# VSS nfet_06v0 ad=0.6448p pd=3u as=1.0912p ps=5.84u w=2.48u l=1u
X1801 a_65974_45459# a_57550_45959# VSS VSS nfet_06v0 ad=1.3p pd=5.52u as=2.2p ps=10.88u w=5u l=1u
X1802 VSS VDD VSS VSS nfet_06v0 ad=7.92p pd=36.88u as=0 ps=0 w=18u l=2u
X1803 a_2754_4870# a_2554_4826# a_3486_4870# VSS nfet_06v0 ad=2.2p pd=10.88u as=1.25p ps=5.5u w=5u l=1u
X1804 a_26918_28838# S4P a_25154_28838# VSS nfet_06v0 ad=3.3p pd=15.88u as=3.3p ps=15.88u w=7.5u l=1u
X1805 VSS a_56438_45959# a_54654_41059# VSS nfet_06v0 ad=0.65p pd=3.02u as=0.65p ps=3.02u w=2.5u l=1u
X1806 VDD a_25366_53077# a_30358_53193# VDD pfet_06v0 ad=4.4p pd=20.88u as=2.5p ps=10.5u w=10u l=1u
X1807 a_77730_24788# a_77530_24672# VSS VSS nfet_06v0 ad=1.25p pd=5.5u as=2.2p ps=10.88u w=5u l=1u
X1808 VSS VDD VSS VSS nfet_06v0 ad=7.92p pd=36.88u as=0 ps=0 w=18u l=2u
X1809 VDD a_48550_40945# a_53542_40989# VDD pfet_06v0 ad=4.4p pd=20.88u as=2.5p ps=10.5u w=10u l=1u
X1810 a_84118_16930# a_69382_16886# VDD VDD pfet_06v0 ad=2.5p pd=10.5u as=4.4p ps=20.88u w=10u l=1u
X1811 a_55330_24788# a_55130_24672# VSS VSS nfet_06v0 ad=1.25p pd=5.5u as=2.2p ps=10.88u w=5u l=1u
X1812 a_61718_16930# a_46982_16886# VDD VDD pfet_06v0 ad=2.5p pd=10.5u as=4.4p ps=20.88u w=10u l=1u
X1813 Z Z a_75010_60642# VSS nfet_06v0 ad=0.52p pd=2.52u as=0.88p ps=4.88u w=2u l=1u
X1814 a_9070_62819# a_10630_58419# VDD VDD pfet_06v0 ad=1.3p pd=5.52u as=1.3p ps=5.52u w=5u l=1u
X1815 a_24994_16886# a_24994_16886# a_37934_25588# VSS nfet_06v0 ad=0.44p pd=2.88u as=0.25p ps=1.5u w=1u l=1u
X1816 a_25154_24788# a_24954_24672# a_24854_24788# VSS nfet_06v0 ad=2.2p pd=10.88u as=1.25p ps=5.5u w=5u l=1u
X1817 a_52850_67013# a_30830_66967# a_54214_67083# VSS nfet_06v0 ad=2.2p pd=10.88u as=1.3p ps=5.52u w=5u l=1u
X1818 a_4718_37586# S1P a_2794_35696# VDD pfet_06v0 ad=0.242p pd=1.98u as=0.242p ps=1.98u w=0.55u l=1u
X1819 a_17946_53193# a_17746_53077# VDD VDD pfet_06v0 ad=2.5p pd=10.5u as=4.4p ps=20.88u w=10u l=1u
X1820 a_19718_62819# a_7958_62819# cap_mim_2f0_m4m5_noshield c_width=20u c_length=10u
X1821 a_31030_45459# a_33702_41059# VDD VDD pfet_06v0 ad=1.3p pd=5.52u as=1.3p ps=5.52u w=5u l=1u
X1822 a_76478_12812# a_69642_4826# a_76686_4870# VSS nfet_06v0 ad=2.2p pd=10.88u as=1.25p ps=5.5u w=5u l=1u
X1823 a_42790_62819# a_34366_63319# VSS VSS nfet_06v0 ad=1.3p pd=5.52u as=2.2p ps=10.88u w=5u l=1u
X1824 a_8870_49607# a_25568_21126# VDD VDD pfet_06v0 ad=0.44p pd=2.88u as=0.44p ps=2.88u w=1u l=1u
X1825 a_58002_54123# a_48850_53077# a_54214_49723# VDD pfet_06v0 ad=1.3p pd=5.52u as=2.2p ps=10.88u w=5u l=1u
X1826 VDD VSS VDD VDD pfet_06v0 ad=4.29p pd=20.38u as=0 ps=0 w=9.75u l=2u
X1827 a_12006_25588# a_3168_21126# VDD VDD pfet_06v0 ad=0.44p pd=2.88u as=0.44p ps=2.88u w=1u l=1u
X1828 a_25886_28838# a_24654_28794# VSS VSS nfet_06v0 ad=1.25p pd=5.5u as=2.2p ps=10.88u w=5u l=1u
X1829 a_25194_16930# a_24994_16886# a_24894_16930# VDD pfet_06v0 ad=4.4p pd=20.88u as=2.5p ps=10.5u w=10u l=1u
X1830 a_2294_40945# a_2594_40945# a_5530_40989# VDD pfet_06v0 ad=4.4p pd=20.88u as=2.5p ps=10.5u w=10u l=1u
X1831 a_73246_67000# a_71494_67000# a_72314_66956# VSS nfet_06v0 ad=0.25p pd=1.5u as=0.44p ps=2.88u w=1u l=1u
X1832 a_33254_45959# a_25326_46213# a_32586_41059# VSS nfet_06v0 ad=0.65p pd=3.02u as=1.1p ps=5.88u w=2.5u l=1u
X1833 a_37934_4870# a_24994_11612# VSS VSS nfet_06v0 ad=0.25p pd=1.5u as=0.44p ps=2.88u w=1u l=1u
X1834 a_5530_16930# S2N a_2794_16930# VDD pfet_06v0 ad=0.22p pd=1.88u as=0.22p ps=1.88u w=0.5u l=1u
X1835 a_75022_25272# a_75022_25272# a_77530_24672# VSS nfet_06v0 ad=2.2p pd=10.88u as=1.65p ps=5.66u w=5u l=1u
X1836 a_30026_70553# a_25666_70437# a_29726_70553# VDD pfet_06v0 ad=3.3p pd=10.66u as=2.5p ps=10.5u w=10u l=1u
X1837 a_71806_37586# S2P a_69882_35696# VDD pfet_06v0 ad=0.242p pd=1.98u as=0.242p ps=1.98u w=0.55u l=1u
X1838 VDD a_42790_49723# a_86922_51052# VDD pfet_06v0 ad=1.32p pd=6.88u as=0.75p ps=3.5u w=3u l=1u
X1839 a_32586_70483# a_33254_67083# VSS VSS nfet_06v0 ad=0.65p pd=3.02u as=0.65p ps=3.02u w=2.5u l=1u
X1840 a_10630_58419# a_15646_63273# a_10182_63319# VSS nfet_06v0 ad=1.1p pd=5.88u as=1.1p ps=5.88u w=2.5u l=1u
X1841 a_26058_49609# a_25326_49609# a_26258_49653# VSS nfet_06v0 ad=2.2p pd=10.88u as=1.25p ps=5.5u w=5u l=1u
X1842 a_25568_33750# a_40986_33300# VSS ppolyf_u_1k r_width=1u r_length=76.45u
X1843 a_75010_43282# X a_76410_43352# VSS nfet_06v0 ad=0.88p pd=4.88u as=0.5p ps=2.5u w=2u l=1u
X1844 a_16110_54077# a_16110_54077# a_17746_53077# VDD pfet_06v0 ad=4.4p pd=20.88u as=3.3p ps=10.66u w=10u l=1u
X1845 a_79086_60502# a_65974_62819# VSS VSS nfet_06v0 ad=0.33p pd=1.66u as=0.44p ps=2.88u w=1u l=1u
X1846 a_19718_67083# a_11294_67083# VSS VSS nfet_06v0 ad=2.2p pd=10.88u as=1.3p ps=5.52u w=5u l=1u
X1847 a_3168_33300# a_18586_33300# VSS ppolyf_u_1k r_width=1u r_length=76.45u
X1848 a_56886_58419# a_61902_63273# a_56438_63319# VSS nfet_06v0 ad=1.1p pd=5.88u as=1.1p ps=5.88u w=2.5u l=1u
X1849 VDD VSS VDD VDD pfet_06v0 ad=4.29p pd=20.38u as=0 ps=0 w=9.75u l=2u
X1850 a_62366_54077# a_62366_54077# a_64002_53077# VDD pfet_06v0 ad=4.4p pd=20.88u as=3.3p ps=10.66u w=10u l=1u
X1851 a_8398_70483# a_10182_67083# VSS VSS nfet_06v0 ad=0.65p pd=3.02u as=1.1p ps=5.88u w=2.5u l=1u
X1852 a_17030_35696# a_2294_35580# VDD VDD pfet_06v0 ad=2.5p pd=10.5u as=4.4p ps=20.88u w=10u l=1u
X1853 a_29998_45529# a_25326_46213# a_29666_45529# VSS nfet_06v0 ad=1.25p pd=5.5u as=1.65p ps=5.66u w=5u l=1u
X1854 VDD a_56886_54123# a_55326_49723# VDD pfet_06v0 ad=1.3p pd=5.52u as=1.3p ps=5.52u w=5u l=1u
X1855 a_72618_37596# S2N a_69882_35696# VDD pfet_06v0 ad=0.22p pd=1.88u as=0.22p ps=1.88u w=0.5u l=1u
X1856 a_6594_67013# a_8870_66967# a_9070_67083# VSS nfet_06v0 ad=2.2p pd=10.88u as=1.3p ps=5.52u w=5u l=1u
X1857 VSS VDD VSS VSS nfet_06v0 ad=0.44p pd=2.88u as=0 ps=0 w=1u l=2u
X1858 a_50218_37596# S3N a_47482_35696# VDD pfet_06v0 ad=0.22p pd=1.88u as=0.22p ps=1.88u w=0.5u l=1u
X1859 a_53210_58349# a_7758_62775# a_55770_58419# VDD pfet_06v0 ad=4.4p pd=20.88u as=2.6p ps=10.52u w=10u l=1u
X1860 a_9070_49723# a_10630_54123# VDD VDD pfet_06v0 ad=1.3p pd=5.52u as=2.2p ps=10.88u w=5u l=1u
X1861 a_70256_33300# a_85674_33300# VSS ppolyf_u_1k r_width=1u r_length=76.45u
X1862 a_2494_35696# a_2294_35580# VDD VDD pfet_06v0 ad=2.5p pd=10.5u as=4.4p ps=20.88u w=10u l=1u
X1863 a_39182_71437# a_39182_71437# a_40818_70437# VDD pfet_06v0 ad=4.4p pd=20.88u as=3.3p ps=10.66u w=10u l=1u
X1864 a_47182_11728# a_46982_11612# VDD VDD pfet_06v0 ad=2.5p pd=10.5u as=4.4p ps=20.88u w=10u l=1u
X1865 a_2594_70437# a_2594_70437# VDD VDD pfet_06v0 ad=0.88p pd=4.88u as=0.88p ps=4.88u w=2u l=1u
X1866 VSS a_56438_63319# a_55770_58419# VSS nfet_06v0 ad=1.1p pd=5.88u as=0.65p ps=3.02u w=2.5u l=1u
X1867 VSS VDD VSS VSS nfet_06v0 ad=0.44p pd=2.88u as=0 ps=0 w=1u l=2u
X1868 a_8870_49607# a_25568_21126# VDD VDD pfet_06v0 ad=0.44p pd=2.88u as=0.44p ps=2.88u w=1u l=1u
X1869 a_31030_62819# a_30830_62775# a_29666_62889# VSS nfet_06v0 ad=1.3p pd=5.52u as=2.2p ps=10.88u w=5u l=1u
X1870 a_8398_41059# a_19718_45459# cap_mim_2f0_m4m5_noshield c_width=20u c_length=10u
X1871 a_12006_25588# a_3168_21126# VDD VDD pfet_06v0 ad=0.44p pd=2.88u as=0.44p ps=2.88u w=1u l=1u
X1872 a_73768_62110# a_72104_61958# VSS VSS nfet_06v0 ad=0.175p pd=1.2u as=0.308p ps=2.28u w=0.7u l=1u
X1873 a_33426_35580# a_24994_35580# a_33626_35696# VDD pfet_06v0 ad=3.3p pd=10.66u as=2.5p ps=10.5u w=10u l=1u
X1874 a_11294_49723# a_2254_49609# a_8398_53123# VSS nfet_06v0 ad=0.65p pd=3.02u as=1.1p ps=5.88u w=2.5u l=1u
X1875 a_73166_51200# a_72104_49876# VSS VSS nfet_06v0 ad=0.5456p pd=3.36u as=0.5456p ps=3.36u w=1.24u l=1u
X1876 a_11026_35580# a_2594_35580# a_11226_35696# VDD pfet_06v0 ad=3.3p pd=10.66u as=2.5p ps=10.5u w=10u l=1u
X1877 a_5250_67013# a_2594_70437# VSS VSS nfet_06v0 ad=0.25p pd=1.5u as=0.44p ps=2.88u w=1u l=1u
X1878 a_46942_28794# a_47282_35580# a_62830_35696# VDD pfet_06v0 ad=4.4p pd=20.88u as=2.5p ps=10.5u w=10u l=1u
X1879 a_30026_70553# a_8870_66967# a_32586_70483# VDD pfet_06v0 ad=4.4p pd=20.88u as=2.6p ps=10.52u w=10u l=1u
X1880 VSS VDD VSS VSS nfet_06v0 ad=7.92p pd=36.88u as=0 ps=0 w=18u l=2u
X1881 a_29666_45529# a_8870_45415# a_32142_45459# VSS nfet_06v0 ad=2.2p pd=10.88u as=1.3p ps=5.52u w=5u l=1u
X1882 VSS VDD VSS VSS nfet_06v0 ad=7.92p pd=36.88u as=0 ps=0 w=18u l=2u
X1883 a_39182_71437# a_25326_66969# a_40382_67013# VSS nfet_06v0 ad=2.2p pd=10.88u as=1.25p ps=5.5u w=5u l=1u
X1884 a_8870_49607# a_29802_25288# VSS VSS nfet_06v0 ad=0.44p pd=2.88u as=0.44p ps=2.88u w=1u l=1u
X1885 VSS VDD VSS VSS nfet_06v0 ad=4.29p pd=20.38u as=0 ps=0 w=9.75u l=2u
X1886 VSS VDD VSS VSS nfet_06v0 ad=0.44p pd=2.88u as=0 ps=0 w=1u l=2u
X1887 X X VDD VDD pfet_06v0 ad=0.52p pd=2.52u as=0.52p ps=2.52u w=2u l=1u
X1888 a_19718_49723# a_11746_54123# VDD VDD pfet_06v0 ad=2.6p pd=10.52u as=4.4p ps=20.88u w=10u l=1u
X1889 VSS VDD VSS VSS nfet_06v0 ad=0.44p pd=2.88u as=0 ps=0 w=1u l=2u
X1890 a_9070_45459# a_8870_45415# a_6594_45529# VSS nfet_06v0 ad=1.3p pd=5.52u as=2.2p ps=10.88u w=5u l=1u
X1891 a_42466_11728# a_24694_11612# VDD VDD pfet_06v0 ad=2.5p pd=10.5u as=4.4p ps=20.88u w=10u l=1u
X1892 a_32842_4826# a_24954_4826# a_33042_4870# VSS nfet_06v0 ad=1.65p pd=5.66u as=1.25p ps=5.5u w=5u l=1u
X1893 a_46942_28794# a_47242_28794# a_58158_28838# VSS nfet_06v0 ad=2.2p pd=10.88u as=1.25p ps=5.5u w=5u l=1u
X1894 a_55326_67083# a_48850_70437# a_56886_71483# VDD pfet_06v0 ad=2.2p pd=10.88u as=1.3p ps=5.52u w=5u l=1u
X1895 a_8870_45415# a_47856_9332# VDD VDD pfet_06v0 ad=0.44p pd=2.88u as=0.44p ps=2.88u w=1u l=1u
X1896 a_32586_58419# a_25326_63573# a_33254_63319# VSS nfet_06v0 ad=1.1p pd=5.88u as=0.65p ps=3.02u w=2.5u l=1u
X1897 a_30358_58349# a_25666_58305# a_30026_58349# VDD pfet_06v0 ad=2.5p pd=10.5u as=3.3p ps=10.66u w=10u l=1u
X1898 a_52850_49653# a_7758_49607# a_55326_49723# VSS nfet_06v0 ad=2.2p pd=10.88u as=1.3p ps=5.52u w=5u l=1u
X1899 VDD a_58002_58419# a_65974_62819# VDD pfet_06v0 ad=2.6p pd=10.52u as=2.6p ps=10.52u w=10u l=1u
X1900 VSS a_56438_49723# a_54654_53123# VSS nfet_06v0 ad=1.1p pd=5.88u as=0.65p ps=3.02u w=2.5u l=1u
X1901 a_48510_49609# a_48850_53077# a_48750_53193# VDD pfet_06v0 ad=4.4p pd=20.88u as=2.5p ps=10.5u w=10u l=1u
X1902 a_6954_70553# a_8870_66967# a_9514_70483# VDD pfet_06v0 ad=4.4p pd=20.88u as=2.6p ps=10.52u w=10u l=1u
X1903 a_25326_63573# a_25326_63573# VSS VSS nfet_06v0 ad=0.44p pd=2.88u as=0.44p ps=2.88u w=1u l=1u
X1904 a_79758_16930# a_69382_16886# VDD VDD pfet_06v0 ad=2.5p pd=10.5u as=4.4p ps=20.88u w=10u l=1u
X1905 a_10182_63319# a_2254_63573# a_9514_58419# VSS nfet_06v0 ad=0.65p pd=3.02u as=1.1p ps=5.88u w=2.5u l=1u
X1906 a_57358_16930# a_46982_16886# VDD VDD pfet_06v0 ad=2.5p pd=10.5u as=4.4p ps=20.88u w=10u l=1u
X1907 a_34366_45959# a_25326_46213# a_31470_41059# VSS nfet_06v0 ad=0.65p pd=3.02u as=1.1p ps=5.88u w=2.5u l=1u
X1908 a_49406_16930# a_7758_62775# cap_mim_2f0_m4m5_noshield c_width=25u c_length=8u
X1909 VSS a_19718_49723# a_83814_49640# VSS nfet_06v0 ad=0.44p pd=2.88u as=0.44p ps=2.88u w=1u l=1u
X1910 a_51506_67013# a_48850_70437# VSS VSS nfet_06v0 ad=0.25p pd=1.5u as=0.44p ps=2.88u w=1u l=1u
X1911 a_25568_33750# a_40986_34200# VSS ppolyf_u_1k r_width=1u r_length=76.45u
X1912 a_42790_67083# a_34366_67083# VSS VSS nfet_06v0 ad=2.2p pd=10.88u as=1.3p ps=5.52u w=5u l=1u
X1913 a_41426_62889# a_41226_62773# VSS VSS nfet_06v0 ad=1.25p pd=5.5u as=2.2p ps=10.88u w=5u l=1u
X1914 a_29802_28838# a_24954_28794# a_27118_37586# VSS nfet_06v0 ad=1.1p pd=5.88u as=0.825p ps=3.16u w=2.5u l=1u
X1915 a_10182_49723# a_16110_54077# a_10630_54123# VDD pfet_06v0 ad=2.2p pd=10.88u as=2.2p ps=10.88u w=5u l=1u
X1916 a_31470_70483# a_33254_67083# VSS VSS nfet_06v0 ad=0.65p pd=3.02u as=1.1p ps=5.88u w=2.5u l=1u
X1917 a_2794_11728# a_2594_11612# a_2494_11728# VDD pfet_06v0 ad=4.4p pd=20.88u as=2.5p ps=10.5u w=10u l=1u
X1918 a_9514_41059# a_10182_45959# VSS VSS nfet_06v0 ad=0.65p pd=3.02u as=1.1p ps=5.88u w=2.5u l=1u
X1919 a_30026_40989# a_30830_45415# a_31470_41059# VDD pfet_06v0 ad=4.4p pd=20.88u as=2.6p ps=10.52u w=10u l=1u
X1920 a_32586_53123# a_8870_49607# a_30026_53193# VDD pfet_06v0 ad=2.6p pd=10.52u as=4.4p ps=20.88u w=10u l=1u
X1921 a_71806_16930# a_30830_62775# cap_mim_2f0_m4m5_noshield c_width=25u c_length=8u
X1922 VSS a_26058_45413# a_29998_45529# VSS nfet_06v0 ad=2.2p pd=10.88u as=1.25p ps=5.5u w=5u l=1u
X1923 VDD VSS VDD VDD pfet_06v0 ad=4.29p pd=20.38u as=0 ps=0 w=9.75u l=2u
X1924 a_7958_45459# a_2594_40945# a_11746_41059# VDD pfet_06v0 ad=2.2p pd=10.88u as=1.3p ps=5.52u w=5u l=1u
X1925 VSS VDD VSS VSS nfet_06v0 ad=0.44p pd=2.88u as=0 ps=0 w=1u l=2u
X1926 a_16110_54077# a_2254_49609# a_17310_49653# VSS nfet_06v0 ad=2.2p pd=10.88u as=1.25p ps=5.5u w=5u l=1u
X1927 a_18142_35696# a_2294_35580# VDD VDD pfet_06v0 ad=2.5p pd=10.5u as=4.4p ps=20.88u w=10u l=1u
X1928 a_61902_49609# a_48850_53077# a_65646_53193# VDD pfet_06v0 ad=4.4p pd=20.88u as=2.5p ps=10.5u w=10u l=1u
X1929 a_9514_58419# a_8870_62775# a_6954_58349# VDD pfet_06v0 ad=2.6p pd=10.52u as=4.4p ps=20.88u w=10u l=1u
X1930 a_6594_49653# a_2254_49609# a_6294_49653# VSS nfet_06v0 ad=1.65p pd=5.66u as=1.25p ps=5.5u w=5u l=1u
X1931 a_7758_66967# a_25568_33300# VDD VDD pfet_06v0 ad=0.44p pd=2.88u as=0.44p ps=2.88u w=1u l=1u
X1932 a_7958_49723# a_7758_49607# a_6594_49653# VSS nfet_06v0 ad=1.3p pd=5.52u as=2.2p ps=10.88u w=5u l=1u
X1933 a_5530_13628# S2N a_2794_11728# VDD pfet_06v0 ad=0.22p pd=1.88u as=0.22p ps=1.88u w=0.5u l=1u
X1934 a_53210_53193# a_48850_53077# a_52910_53193# VDD pfet_06v0 ad=3.3p pd=10.66u as=2.5p ps=10.5u w=10u l=1u
X1935 a_34818_58419# a_38718_63273# a_34366_63319# VSS nfet_06v0 ad=1.1p pd=5.88u as=1.1p ps=5.88u w=2.5u l=1u
X1936 a_3168_10682# a_18586_10232# VSS ppolyf_u_1k r_width=1u r_length=76.45u
X1937 a_48510_66969# a_48510_66969# VSS VSS nfet_06v0 ad=0.44p pd=2.88u as=0.44p ps=2.88u w=1u l=1u
X1938 VSS a_11294_63319# a_19718_62819# VSS nfet_06v0 ad=1.3p pd=5.52u as=1.3p ps=5.52u w=5u l=1u
X1939 a_8870_62775# a_3168_33300# VDD VDD pfet_06v0 ad=0.44p pd=2.88u as=0.44p ps=2.88u w=1u l=1u
X1940 a_50474_67013# a_48850_70437# VSS VSS nfet_06v0 ad=0.25p pd=1.5u as=0.44p ps=2.88u w=1u l=1u
X1941 a_26918_28838# a_28742_35696# VDD VDD pfet_06v0 ad=2.2p pd=10.88u as=2.2p ps=10.88u w=5u l=1u
X1942 a_56886_54123# a_48850_53077# a_55326_49723# VDD pfet_06v0 ad=1.3p pd=5.52u as=2.2p ps=10.88u w=5u l=1u
X1943 VDD a_42790_49723# a_87474_49596# VDD pfet_06v0 ad=1.32p pd=6.88u as=0.99p ps=3.66u w=3u l=1u
X1944 a_52090_4870# a_54078_12812# a_47856_9332# VDD pfet_06v0 ad=1.76p pd=8.88u as=1.76p ps=8.88u w=4u l=1u
X1945 a_27118_13618# S3P a_25194_11728# VDD pfet_06v0 ad=0.242p pd=1.98u as=0.242p ps=1.98u w=0.55u l=1u
X1946 a_17746_70437# a_2594_70437# a_17946_70553# VDD pfet_06v0 ad=3.3p pd=10.66u as=2.5p ps=10.5u w=10u l=1u
X1947 a_38718_66969# a_25666_70437# a_42462_70553# VDD pfet_06v0 ad=4.4p pd=20.88u as=2.5p ps=10.5u w=10u l=1u
X1948 a_30358_40989# a_25666_40945# a_30026_40989# VDD pfet_06v0 ad=2.5p pd=10.5u as=3.3p ps=10.66u w=10u l=1u
X1949 a_24954_24672# a_24954_24672# VSS VSS nfet_06v0 ad=0.44p pd=2.88u as=0.44p ps=2.88u w=1u l=1u
X1950 a_64002_70437# a_48850_70437# a_64202_70553# VDD pfet_06v0 ad=3.3p pd=10.66u as=2.5p ps=10.5u w=10u l=1u
X1951 VSS a_33254_45959# a_32586_41059# VSS nfet_06v0 ad=1.1p pd=5.88u as=0.65p ps=3.02u w=2.5u l=1u
X1952 a_32142_62819# a_8870_62775# a_29666_62889# VSS nfet_06v0 ad=1.3p pd=5.52u as=2.2p ps=10.88u w=5u l=1u
X1953 a_2554_24672# a_2554_24672# VSS VSS nfet_06v0 ad=0.44p pd=2.88u as=0.44p ps=2.88u w=1u l=1u
X1954 VDD a_10630_58419# a_7958_62819# VDD pfet_06v0 ad=2.2p pd=10.88u as=1.3p ps=5.52u w=5u l=1u
X1955 a_70256_10682# a_85674_10232# VSS ppolyf_u_1k r_width=1u r_length=76.45u
X1956 a_5250_24088# a_6342_16930# VDD VDD pfet_06v0 ad=2.2p pd=10.88u as=2.2p ps=10.88u w=5u l=1u
X1957 a_52090_28838# a_47242_28794# a_49406_37586# VSS nfet_06v0 ad=1.1p pd=5.88u as=0.825p ps=3.16u w=2.5u l=1u
X1958 a_9070_45459# a_10630_41059# VDD VDD pfet_06v0 ad=1.3p pd=5.52u as=1.3p ps=5.52u w=5u l=1u
X1959 VSS a_34366_45959# a_42790_45459# VSS nfet_06v0 ad=1.3p pd=5.52u as=1.3p ps=5.52u w=5u l=1u
X1960 a_7958_67083# a_10630_71483# VDD VDD pfet_06v0 ad=1.3p pd=5.52u as=1.3p ps=5.52u w=5u l=1u
X1961 a_38718_49609# a_38718_49609# a_41226_49609# VSS nfet_06v0 ad=2.2p pd=10.88u as=1.65p ps=5.66u w=5u l=1u
X1962 VDD a_56886_58419# a_54214_62819# VDD pfet_06v0 ad=2.2p pd=10.88u as=1.3p ps=5.52u w=5u l=1u
X1963 a_25666_53077# a_25666_53077# VDD VDD pfet_06v0 ad=0.88p pd=4.88u as=0.88p ps=4.88u w=2u l=1u
X1964 a_77730_28838# a_77530_28794# VSS VSS nfet_06v0 ad=1.25p pd=5.5u as=2.2p ps=10.88u w=5u l=1u
X1965 VSS a_10182_45959# a_8398_41059# VSS nfet_06v0 ad=0.65p pd=3.02u as=0.65p ps=3.02u w=2.5u l=1u
X1966 VDD a_83814_49640# a_84634_49596# VDD pfet_06v0 ad=1.32p pd=6.88u as=0.99p ps=3.66u w=3u l=1u
X1967 a_28602_70553# a_25366_70437# VDD VDD pfet_06v0 ad=2.5p pd=10.5u as=4.4p ps=20.88u w=10u l=1u
.ends
