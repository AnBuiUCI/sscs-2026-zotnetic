* fuente: /foss/designs/a_zonetic2026/XSCHEM/WEIGTH/simulation/WEIGHT_COMP.sch/WEIGHT_COMP.spice
* leida via enlace: /foss/designs/a_zonetic2026/spice_blocks/WEIGHT_COMP.spice
* fecha de la fuente: 2026-08-08 05:13   sha1: 6c0d95a613
* generado por flatten_spice.py — NO editar a mano
* netlist plana generada por flatten_spice.py (top: WEIGHT_COMP)
* 23 MOSFETs; nets fusionadas por V=0: x1_net11->VSS, x1_net12->VSS, x1_net10->VSS, x1_net13->VSS
* nombres: los del esquematico; solo llevan la ruta de instancias (Mx1_M4) los 8 que chocaban
* m -> fingers: XM2: m=6 nf=1 -> nf=6; Mx1_XM3: m=2 nf=1 -> nf=2; XM5: m=2 nf=1 -> nf=2; XM1: m=2 nf=1 -> nf=2; XM9: m=2 nf=1 -> nf=2; XM11: m=2 nf=1 -> nf=2
* para LVS: cada dedo, un transistor en paralelo
.subckt WEIGHT_COMP VDD VSS VA VB VC VD WE OUT OUT_N
XM2_f1 WE WE VDD VDD pfet_06v0 L=1u W=2u
XM2_f2 WE WE VDD VDD pfet_06v0 L=1u W=2u
XM2_f3 WE WE VDD VDD pfet_06v0 L=1u W=2u
XM2_f4 WE WE VDD VDD pfet_06v0 L=1u W=2u
XM2_f5 WE WE VDD VDD pfet_06v0 L=1u W=2u
XM2_f6 WE WE VDD VDD pfet_06v0 L=1u W=2u
XMx1_XM3_f1 WE VD x1_net1 VSS nfet_06v0 L=1u W=2.48u
XMx1_XM3_f2 WE VD x1_net1 VSS nfet_06v0 L=1u W=2.48u
XM5_f1 WE VB x1_net2 VSS nfet_06v0 L=1u W=2.48u
XM5_f2 WE VB x1_net2 VSS nfet_06v0 L=1u W=2.48u
XM6 x1_net2 x1_IN VSS VSS nfet_06v0 L=1u W=1.24u
XM1_f1 WE WE x1_net3 VSS nfet_06v0 L=1u W=2u
XM1_f2 WE WE x1_net3 VSS nfet_06v0 L=1u W=2u
XM7 x1_net3 WE x1_net4 VSS nfet_06v0 L=1u W=2u
XM8 x1_net4 WE VSS VSS nfet_06v0 L=1u W=2u
XM9_f1 WE VA x1_net5 VSS nfet_06v0 L=1u W=2.48u
XM9_f2 WE VA x1_net5 VSS nfet_06v0 L=1u W=2.48u
XM10 x1_net5 x1_IN VSS VSS nfet_06v0 L=1u W=1.24u
XM11_f1 WE VC x1_net6 VSS nfet_06v0 L=1u W=2.48u
XM11_f2 WE VC x1_net6 VSS nfet_06v0 L=1u W=2.48u
XM12 x1_net6 x1_IN VSS VSS nfet_06v0 L=1u W=1.24u
XMx1_XM4 x1_net1 x1_IN VSS VSS nfet_06v0 L=1u W=1.24u
XM13 x1_IN x1_IN VDD VDD pfet_06v0 L=1u W=2u
XM14 x1_net8 x1_IN x1_net9 VSS nfet_06v0 L=1u W=0.7u
XM15 x1_net7 x1_IN x1_net8 VSS nfet_06v0 L=1u W=0.7u
XM16 x1_IN x1_IN x1_net7 VSS nfet_06v0 L=1u W=0.7u
XM17 x1_net9 x1_IN VSS VSS nfet_06v0 L=1u W=0.7u
XMx2_x1_XM3 x2_net1 WE VDD VDD pfet_05v0 L=0.5u W=1.83u
XMx2_x1_XM4 x2_net1 WE VSS VSS nfet_05v0 L=0.6u W=1.32u
XMx2_x2_XM3 OUT x2_net1 VDD VDD pfet_05v0 L=0.5u W=1.83u
XMx2_x2_XM4 OUT x2_net1 VSS VSS nfet_05v0 L=0.6u W=1.32u
XMx2_x3_XM3 OUT_N OUT VDD VDD pfet_05v0 L=0.5u W=1.83u
XMx2_x3_XM4 OUT_N OUT VSS VSS nfet_05v0 L=0.6u W=1.32u
.ends
