* NGSPICE file created from GRADIENT_NAV2.ext - technology: gf180mcuD

.subckt GRADIENT_NAV2 S2N S2P S3N S3P S4N S4P X Z S1N S1P XN XP Y YN YP ZN ZP VDD
+ VSS
X0 a_70674_16764# a_64106_16720# VSS VSS nfet_06v0 ad=1.25p pd=5.5u as=2.2p ps=10.88u w=5u l=1u
X1 a_47050_16720# a_48196_24466# a_47532_24466# VDD pfet_06v0 ad=2.2p pd=10.88u as=1.65p ps=5.66u w=5u l=1u
X2 a_32182_49608# a_8798_49492# a_29706_49538# VSS nfet_06v0 ad=1.3p pd=5.52u as=2.2p ps=10.88u w=5u l=1u
X3 a_6204_36450# a_6386_28704# a_5722_28704# VSS nfet_06v0 ad=1.1p pd=5.88u as=0.825p ps=3.16u w=2.5u l=1u
X4 a_31510_70368# a_42842_66968# cap_mim_2f0_m4m5_noshield c_width=20u c_length=10u
X5 VDD a_2210_44226# a_7214_44342# VDD pfet_06v0 ad=4.4p pd=20.88u as=2.5p ps=10.5u w=10u l=1u
X6 a_2210_35450# a_2510_35450# a_13654_28748# VSS nfet_06v0 ad=0.44p pd=2.88u as=0.25p ps=1.5u w=1u l=1u
X7 a_6882_53078# a_7686_49492# a_8326_53008# VDD pfet_06v0 ad=4.4p pd=20.88u as=2.6p ps=10.52u w=10u l=1u
X8 S3P a_4234_28704# VSS ppolyf_u_1k r_width=1u r_length=2u
X9 VDD VSS VDD VDD pfet_06v0 ad=0.88p pd=4.88u as=1.88377n ps=9.04086m w=2u l=2u
X10 a_23852_9652# a_39270_9202# VSS ppolyf_u_1k r_width=1u r_length=76.45u
X11 a_45962_37346# a_30870_66852# cap_mim_2f0_m4m5_noshield c_width=25u c_length=4u
X12 a_55698_53008# a_7686_49492# a_53138_53078# VDD pfet_06v0 ad=2.6p pd=10.52u as=4.4p ps=20.88u w=10u l=1u
X13 a_54142_40872# a_56814_45272# VDD VDD pfet_06v0 ad=1.3p pd=5.52u as=1.3p ps=5.52u w=5u l=1u
X14 a_25354_40758# a_25694_44226# a_25594_44342# VDD pfet_06v0 ad=4.4p pd=20.88u as=2.5p ps=10.5u w=10u l=1u
X15 a_30038_58162# a_25354_58118# a_29706_58162# VSS nfet_06v0 ad=1.25p pd=5.5u as=1.65p ps=5.66u w=5u l=1u
X16 a_49002_28748# a_48196_36450# a_44572_33170# VDD pfet_06v0 ad=2.2p pd=10.88u as=1.65p ps=5.66u w=5u l=1u
X17 a_70674_4780# a_64106_4736# VSS VSS nfet_06v0 ad=1.25p pd=5.5u as=2.2p ps=10.88u w=5u l=1u
X18 a_2710_23582# a_2510_23466# a_3522_23582# VDD pfet_06v0 ad=4.4p pd=20.88u as=2.5p ps=10.5u w=10u l=1u
X19 a_56366_66968# a_48426_66854# a_55698_70368# VSS nfet_06v0 ad=0.65p pd=3.02u as=1.1p ps=5.88u w=2.5u l=1u
X20 VSS VDD VSS VSS nfet_06v0 ad=0.88p pd=4.88u as=1.21602n ps=6.02716m w=2u l=2u
X21 VDD a_57930_54008# a_30954_81052# VDD pfet_06v0 ad=2.6p pd=10.52u as=2.6p ps=10.52u w=10u l=1u
X22 a_15574_49494# a_2510_52962# a_19336_53078# VDD pfet_06v0 ad=4.4p pd=20.88u as=2.5p ps=10.5u w=10u l=1u
X23 a_2170_16720# a_2510_23466# a_16344_23582# VDD pfet_06v0 ad=4.4p pd=20.88u as=2.5p ps=10.5u w=10u l=1u
D0 VSS S1P diode_nd2ps_06v0 pj=30u area=50p
X24 a_31510_44272# a_21542_81052# cap_mim_2f0_m4m5_noshield c_width=20u c_length=10u
X25 VDD a_41030_81052# a_44258_81052# VDD pfet_06v0 ad=1.32p pd=6.88u as=0.99p ps=3.66u w=3u l=1u
X26 a_34406_66968# a_25354_66854# a_31510_70368# VSS nfet_06v0 ad=0.65p pd=3.02u as=1.1p ps=5.88u w=2.5u l=1u
X27 VSS VDD VSS VSS nfet_06v0 ad=0.88p pd=4.88u as=0 ps=0 w=2u l=2u
X28 a_53950_28748# a_43498_28704# VSS VSS nfet_06v0 ad=1.25p pd=5.5u as=2.2p ps=10.88u w=5u l=1u
X29 VSS VDD VSS VSS nfet_06v0 ad=4.29p pd=20.38u as=0 ps=0 w=9.75u l=2u
X30 a_31480_35566# a_22818_35450# VDD VDD pfet_06v0 ad=2.5p pd=10.5u as=4.4p ps=20.88u w=10u l=1u
X31 a_64106_16720# a_64406_16720# a_74558_16764# VSS nfet_06v0 ad=2.2p pd=10.88u as=1.25p ps=5.5u w=5u l=1u
X32 a_35294_4780# a_23118_11482# VSS VSS nfet_06v0 ad=0.25p pd=1.5u as=0.44p ps=2.88u w=1u l=1u
X33 a_33230_4780# a_22778_4736# VSS VSS nfet_06v0 ad=1.25p pd=5.5u as=2.2p ps=10.88u w=5u l=1u
X34 a_9442_70368# a_8798_66852# a_6882_70438# VDD pfet_06v0 ad=2.6p pd=10.52u as=4.4p ps=20.88u w=10u l=1u
X35 ZP a_74894_62048# VSS VSS nfet_05v0 ad=0.5808p pd=3.52u as=0.5808p ps=3.52u w=1.32u l=0.6u
X36 VDD a_25394_70322# a_30398_70438# VDD pfet_06v0 ad=4.4p pd=20.88u as=2.5p ps=10.5u w=10u l=1u
X37 a_34858_54008# a_38758_49494# a_34406_49608# VSS nfet_06v0 ad=1.1p pd=5.88u as=1.1p ps=5.88u w=2.5u l=1u
X38 a_18094_58118# a_2170_58118# a_18294_58162# VSS nfet_06v0 ad=1.65p pd=5.66u as=1.25p ps=5.5u w=5u l=1u
X39 VDD a_56814_62632# a_55254_58232# VDD pfet_06v0 ad=2.2p pd=10.88u as=1.3p ps=5.52u w=5u l=1u
X40 a_21210_81052# a_57478_40872# VSS VSS nfet_06v0 ad=2.2p pd=10.88u as=1.3p ps=5.52u w=5u l=1u
X41 VDD VSS VDD VDD pfet_06v0 ad=7.92p pd=36.88u as=0 ps=0 w=18u l=2u
X42 a_54142_49608# a_56814_54008# VDD VDD pfet_06v0 ad=1.3p pd=5.52u as=1.3p ps=5.52u w=5u l=1u
X43 a_48466_70322# a_48766_70322# a_51702_70438# VDD pfet_06v0 ad=4.4p pd=20.88u as=2.5p ps=10.5u w=10u l=1u
X44 a_43498_4736# a_43838_11482# a_57672_11598# VDD pfet_06v0 ad=4.4p pd=20.88u as=2.5p ps=10.5u w=10u l=1u
X45 a_64350_58118# a_48426_58118# a_64550_58162# VSS nfet_06v0 ad=1.65p pd=5.66u as=1.25p ps=5.5u w=5u l=1u
X46 VDD VSS VDD VDD pfet_06v0 ad=0.66p pd=3.88u as=0 ps=0 w=1.5u l=2u
X47 a_8798_66852# a_65180_33170# VDD VDD pfet_06v0 ad=0.22p pd=1.88u as=0.22p ps=1.88u w=0.5u l=1u
X48 VSS VDD VSS VSS nfet_06v0 ad=4.29p pd=20.38u as=0 ps=0 w=9.75u l=2u
X49 a_52262_81096# a_52350_81052# VDD VDD pfet_06v0 ad=1.32p pd=6.88u as=1.32p ps=6.88u w=3u l=1u
X50 a_19336_44342# a_2210_44226# VDD VDD pfet_06v0 ad=2.5p pd=10.5u as=4.4p ps=20.88u w=10u l=1u
X51 a_50756_23582# a_50556_23466# VDD VDD pfet_06v0 ad=2.5p pd=10.5u as=4.4p ps=20.88u w=10u l=1u
X52 a_63494_40802# a_49158_40758# VSS VSS nfet_06v0 ad=1.25p pd=5.5u as=2.2p ps=10.88u w=5u l=1u
X53 a_10558_71368# a_2510_70322# a_8998_66968# VDD pfet_06v0 ad=1.3p pd=5.52u as=2.2p ps=10.88u w=5u l=1u
X54 a_45762_16764# a_4234_16720# a_43998_16764# VSS nfet_06v0 ad=0.44p pd=2.88u as=0.44p ps=2.88u w=1u l=1u
X55 a_2670_28748# a_2470_28704# a_3402_28748# VSS nfet_06v0 ad=2.2p pd=10.88u as=1.25p ps=5.5u w=5u l=1u
X56 VSS a_2902_49494# a_6854_49538# VSS nfet_06v0 ad=2.2p pd=10.88u as=1.25p ps=5.5u w=5u l=1u
X57 a_22818_23466# a_23118_23466# a_34262_16764# VSS nfet_06v0 ad=0.44p pd=2.88u as=0.25p ps=1.5u w=1u l=1u
X58 a_9794_16764# a_9594_16720# VSS VSS nfet_06v0 ad=1.25p pd=5.5u as=2.2p ps=10.88u w=5u l=1u
X59 a_46494_28748# a_4966_4736# a_43998_28748# VSS nfet_06v0 ad=0.44p pd=2.88u as=0.44p ps=2.88u w=1u l=1u
X60 a_51122_28748# a_50922_28704# VSS VSS nfet_06v0 ad=1.25p pd=5.5u as=2.2p ps=10.88u w=5u l=1u
X61 a_74516_59840# a_17396_80992# a_75916_59770# VSS nfet_06v0 ad=0.88p pd=4.88u as=0.5p ps=2.5u w=2u l=1u
X62 VDD VSS VDD VDD pfet_06v0 ad=0.88p pd=4.88u as=0 ps=0 w=2u l=2u
X63 a_69610_4780# a_64406_4736# a_66570_13378# VSS nfet_06v0 ad=0.825p pd=3.16u as=0.825p ps=3.16u w=2.5u l=1u
X64 a_35294_28748# a_23118_35450# VSS VSS nfet_06v0 ad=0.25p pd=1.5u as=0.44p ps=2.88u w=1u l=1u
X65 a_28630_53078# a_25394_52962# VDD VDD pfet_06v0 ad=2.5p pd=10.5u as=4.4p ps=20.88u w=10u l=1u
X66 a_54142_66968# a_30870_66852# a_52778_66898# VSS nfet_06v0 ad=1.3p pd=5.52u as=2.2p ps=10.88u w=5u l=1u
X67 a_43838_11482# a_43838_11482# a_56014_4780# VSS nfet_06v0 ad=0.44p pd=2.88u as=0.25p ps=1.5u w=1u l=1u
X68 a_30870_40756# a_25042_4780# cap_mim_2f0_m4m5_noshield c_width=25u c_length=4u
X69 a_55254_40872# a_56814_45272# VDD VDD pfet_06v0 ad=1.3p pd=5.52u as=1.3p ps=5.52u w=5u l=1u
X70 a_46774_13398# a_47050_4736# VSS VSS nfet_06v0 ad=0.825p pd=3.16u as=1.1p ps=5.88u w=2.5u l=1u
X71 a_3244_21186# a_2510_23466# a_4434_16764# VDD pfet_06v0 ad=1.65p pd=5.66u as=1.65p ps=5.66u w=5u l=1u
X72 VSS VDD VSS VSS nfet_06v0 ad=7.92p pd=36.88u as=0 ps=0 w=18u l=2u
X73 a_59596_23582# a_43538_23466# VDD VDD pfet_06v0 ad=2.5p pd=10.5u as=4.4p ps=20.88u w=10u l=1u
X74 VDD VSS VDD VDD pfet_06v0 ad=4.29p pd=20.38u as=0 ps=0 w=9.75u l=2u
X75 VSS a_33294_66968# a_32626_70368# VSS nfet_06v0 ad=1.1p pd=5.88u as=0.65p ps=3.02u w=2.5u l=1u
D1 VSS S1N diode_nd2ps_06v0 pj=30u area=50p
X76 a_30398_61702# a_25694_61586# a_30066_61702# VDD pfet_06v0 ad=2.5p pd=10.5u as=3.3p ps=10.66u w=10u l=1u
X77 a_5722_28704# a_6868_36450# a_6204_36450# VDD pfet_06v0 ad=2.2p pd=10.88u as=1.65p ps=5.66u w=5u l=1u
X78 a_2902_58118# a_2170_58118# a_3102_58162# VSS nfet_06v0 ad=2.2p pd=10.88u as=1.25p ps=5.5u w=5u l=1u
X79 a_48766_44226# a_48766_44226# VDD VDD pfet_06v0 ad=0.88p pd=4.88u as=0.88p ps=4.88u w=2u l=1u
X80 ZP a_74894_62048# VDD VDD pfet_05v0 ad=0.8052p pd=4.54u as=0.8052p ps=4.54u w=1.83u l=0.5u
X81 a_26054_13398# a_26330_4736# VSS VSS nfet_06v0 ad=0.825p pd=3.16u as=1.1p ps=5.88u w=2.5u l=1u
X82 a_2670_28748# a_2470_28704# a_2370_28748# VSS nfet_06v0 ad=2.2p pd=10.88u as=1.25p ps=5.5u w=5u l=1u
X83 a_51702_61702# a_48466_61586# VDD VDD pfet_06v0 ad=2.5p pd=10.5u as=4.4p ps=20.88u w=10u l=1u
X84 a_6868_24466# a_2470_16720# a_8738_16764# VSS nfet_06v0 ad=2.2p pd=10.88u as=1.25p ps=5.5u w=5u l=1u
X85 VDD a_71650_44468# a_71650_44468# VDD pfet_06v0 ad=0.88p pd=4.88u as=0.52p ps=2.52u w=2u l=1u
X86 VDD a_10558_45272# a_8998_40872# VDD pfet_06v0 ad=1.3p pd=5.52u as=1.3p ps=5.52u w=5u l=1u
X87 a_39228_62586# a_39228_62586# a_40876_61586# VDD pfet_06v0 ad=4.4p pd=20.88u as=3.3p ps=10.66u w=10u l=1u
X88 VSS VDD VSS VSS nfet_06v0 ad=4.29p pd=20.38u as=0 ps=0 w=9.75u l=2u
X89 a_67102_4780# a_68140_12482# VDD VDD pfet_06v0 ad=1.65p pd=5.66u as=2.2p ps=10.88u w=5u l=1u
X90 a_48196_24466# a_48196_24466# a_50556_23466# VDD pfet_06v0 ad=4.4p pd=20.88u as=3.3p ps=10.66u w=10u l=1u
X91 a_45762_16764# a_47532_24466# VDD VDD pfet_06v0 ad=1.65p pd=5.66u as=2.2p ps=10.88u w=5u l=1u
X92 a_32182_40872# a_25694_44226# a_33742_45272# VDD pfet_06v0 ad=2.2p pd=10.88u as=1.3p ps=5.52u w=5u l=1u
X93 a_2710_35566# a_2510_35450# a_2410_35566# VDD pfet_06v0 ad=4.4p pd=20.88u as=2.5p ps=10.5u w=10u l=1u
X94 a_33742_71368# a_38758_66854# a_33294_66968# VSS nfet_06v0 ad=1.1p pd=5.88u as=1.1p ps=5.88u w=2.5u l=1u
X95 VSS VDD VSS VSS nfet_06v0 ad=4.29p pd=20.38u as=0 ps=0 w=9.75u l=2u
X96 a_47714_28704# a_47714_28704# a_50922_28704# VSS nfet_06v0 ad=2.2p pd=10.88u as=1.65p ps=5.66u w=5u l=1u
X97 a_2470_28704# a_2510_35450# a_15232_35566# VDD pfet_06v0 ad=4.4p pd=20.88u as=2.5p ps=10.5u w=10u l=1u
X98 VDD a_56814_62632# a_54142_58232# VDD pfet_06v0 ad=1.3p pd=5.52u as=1.3p ps=5.52u w=5u l=1u
X99 VSS VDD VSS VSS nfet_06v0 ad=4.29p pd=20.38u as=0 ps=0 w=9.75u l=2u
X100 a_2170_58118# a_2170_58118# VSS VSS nfet_06v0 ad=0.44p pd=2.88u as=0.44p ps=2.88u w=1u l=1u
X101 a_55254_49608# a_56814_54008# VDD VDD pfet_06v0 ad=1.3p pd=5.52u as=1.3p ps=5.52u w=5u l=1u
X102 VSS a_26086_58118# a_30038_58162# VSS nfet_06v0 ad=2.2p pd=10.88u as=1.25p ps=5.5u w=5u l=1u
X103 a_55254_66968# a_56814_71368# VDD VDD pfet_06v0 ad=1.3p pd=5.52u as=2.2p ps=10.88u w=5u l=1u
X104 a_25354_40758# a_25354_40758# VSS VSS nfet_06v0 ad=0.44p pd=2.88u as=0.44p ps=2.88u w=1u l=1u
X105 S1P a_7876_75392# VSS ppolyf_u_1k r_width=1u r_length=2u
X106 a_8998_58232# a_2510_61586# a_10558_62632# VDD pfet_06v0 ad=2.2p pd=10.88u as=1.3p ps=5.52u w=5u l=1u
X107 a_30036_11598# a_29836_11482# VDD VDD pfet_06v0 ad=2.5p pd=10.5u as=4.4p ps=20.88u w=10u l=1u
X108 a_9442_70368# a_2170_66854# a_10110_66968# VSS nfet_06v0 ad=1.1p pd=5.88u as=0.65p ps=3.02u w=2.5u l=1u
X109 a_26812_12482# a_23118_11482# a_25774_4780# VDD pfet_06v0 ad=1.65p pd=5.66u as=1.65p ps=5.66u w=5u l=1u
X110 a_7686_66852# a_25042_28748# cap_mim_2f0_m4m5_noshield c_width=25u c_length=4u
X111 a_7886_58232# a_7686_58116# a_6522_58162# VSS nfet_06v0 ad=1.3p pd=5.52u as=2.2p ps=10.88u w=5u l=1u
X112 VDD VSS VDD VDD pfet_06v0 ad=0.88p pd=4.88u as=0 ps=0 w=2u l=2u
X113 a_57478_66968# a_48426_66854# a_54582_70368# VSS nfet_06v0 ad=0.65p pd=3.02u as=1.1p ps=5.88u w=2.5u l=1u
X114 a_71730_16764# a_71530_16720# VSS VSS nfet_06v0 ad=1.25p pd=5.5u as=2.2p ps=10.88u w=5u l=1u
X115 VSS VDD VSS VSS nfet_06v0 ad=4.29p pd=20.38u as=0 ps=0 w=9.75u l=2u
X116 VDD a_10558_54008# a_8998_49608# VDD pfet_06v0 ad=1.3p pd=5.52u as=1.3p ps=5.52u w=5u l=1u
X117 a_7674_4780# a_6868_12482# a_3244_9202# VDD pfet_06v0 ad=2.2p pd=10.88u as=1.65p ps=5.66u w=5u l=1u
X118 a_7686_40756# a_3244_9202# VDD VDD pfet_06v0 ad=0.22p pd=1.88u as=0.22p ps=1.88u w=0.5u l=1u
X119 a_32182_49608# a_25694_52962# a_33742_54008# VDD pfet_06v0 ad=2.2p pd=10.88u as=1.3p ps=5.52u w=5u l=1u
X120 a_54142_40872# a_56814_45272# VDD VDD pfet_06v0 ad=1.3p pd=5.52u as=2.2p ps=10.88u w=5u l=1u
X121 VDD VSS VDD VDD pfet_06v0 ad=0.88p pd=4.88u as=0 ps=0 w=2u l=2u
X122 a_32626_70368# a_33294_66968# VSS VSS nfet_06v0 ad=0.65p pd=3.02u as=1.1p ps=5.88u w=2.5u l=1u
X123 VDD a_21542_81052# a_24770_81052# VDD pfet_06v0 ad=1.32p pd=6.88u as=0.99p ps=3.66u w=3u l=1u
X124 a_71650_44468# a_71650_44468# a_74516_42480# VSS nfet_06v0 ad=0.52p pd=2.52u as=0.88p ps=4.88u w=2u l=1u
X125 a_44850_11598# a_43538_11482# VDD VDD pfet_06v0 ad=2.5p pd=10.5u as=4.4p ps=20.88u w=10u l=1u
X126 a_3402_4780# a_2170_4736# VSS VSS nfet_06v0 ad=1.25p pd=5.5u as=2.2p ps=10.88u w=5u l=1u
X127 a_64446_35450# a_64446_35450# VDD VDD pfet_06v0 ad=0.88p pd=4.88u as=0.88p ps=4.88u w=2u l=1u
X128 VSS VDD VSS VSS nfet_06v0 ad=0.88p pd=4.88u as=0 ps=0 w=2u l=2u
X129 a_44572_9202# a_43838_11482# a_45762_4780# VDD pfet_06v0 ad=1.65p pd=5.66u as=1.65p ps=5.66u w=5u l=1u
X130 a_71650_44468# a_71650_44468# VDD VDD pfet_06v0 ad=0.52p pd=2.52u as=0.52p ps=2.52u w=2u l=1u
X131 a_53138_61702# a_7686_58116# a_55698_61632# VDD pfet_06v0 ad=4.4p pd=20.88u as=2.6p ps=10.52u w=10u l=1u
D2 VSS S2N diode_nd2ps_06v0 pj=30u area=50p
X132 a_5446_13398# a_5722_4736# VSS VSS nfet_06v0 ad=0.825p pd=3.16u as=1.1p ps=5.88u w=2.5u l=1u
X133 a_9428_11598# a_9228_11482# VDD VDD pfet_06v0 ad=2.5p pd=10.5u as=4.4p ps=20.88u w=10u l=1u
X134 a_64148_61702# a_63948_61586# VDD VDD pfet_06v0 ad=2.5p pd=10.5u as=4.4p ps=20.88u w=10u l=1u
X135 a_5446_53078# a_2210_52962# VDD VDD pfet_06v0 ad=2.5p pd=10.5u as=4.4p ps=20.88u w=10u l=1u
X136 a_17892_70438# a_17692_70322# VDD VDD pfet_06v0 ad=2.5p pd=10.5u as=4.4p ps=20.88u w=10u l=1u
X137 a_44572_9652# a_59990_10102# VSS ppolyf_u_1k r_width=1u r_length=76.45u
X138 a_29706_66898# a_30870_66852# a_31070_66968# VSS nfet_06v0 ad=2.2p pd=10.88u as=1.3p ps=5.52u w=5u l=1u
X139 a_68322_16720# a_68322_16720# a_71530_16720# VSS nfet_06v0 ad=2.2p pd=10.88u as=1.65p ps=5.66u w=5u l=1u
X140 a_52200_11598# a_43538_11482# VDD VDD pfet_06v0 ad=2.5p pd=10.5u as=4.4p ps=20.88u w=10u l=1u
X141 VDD a_34858_62632# a_41030_81052# VDD pfet_06v0 ad=2.6p pd=10.52u as=2.6p ps=10.52u w=10u l=1u
X142 a_34858_71368# a_25694_70322# a_31070_66968# VDD pfet_06v0 ad=1.3p pd=5.52u as=2.2p ps=10.88u w=5u l=1u
X143 a_4134_58162# a_2510_61586# VSS VSS nfet_06v0 ad=0.25p pd=1.5u as=0.44p ps=2.88u w=1u l=1u
X144 VDD VSS VDD VDD pfet_06v0 ad=0.88p pd=4.88u as=0 ps=0 w=2u l=2u
X145 a_53110_49538# a_48426_49494# a_52778_49538# VSS nfet_06v0 ad=1.25p pd=5.5u as=1.65p ps=5.66u w=5u l=1u
X146 a_50066_4780# a_43498_4736# VSS VSS nfet_06v0 ad=1.25p pd=5.5u as=2.2p ps=10.88u w=5u l=1u
X147 a_49358_49538# a_49158_49494# VSS VSS nfet_06v0 ad=1.25p pd=5.5u as=2.2p ps=10.88u w=5u l=1u
X148 a_54142_49608# a_56814_54008# VDD VDD pfet_06v0 ad=1.3p pd=5.52u as=2.2p ps=10.88u w=5u l=1u
X149 a_67382_13398# a_4966_4736# a_64646_11598# VDD pfet_06v0 ad=0.44p pd=2.88u as=0.44p ps=2.88u w=1u l=1u
X150 a_52778_58162# a_48426_58118# a_52478_58162# VSS nfet_06v0 ad=1.65p pd=5.66u as=1.25p ps=5.5u w=5u l=1u
X151 VDD a_10558_45272# a_8998_40872# VDD pfet_06v0 ad=2.2p pd=10.88u as=1.3p ps=5.52u w=5u l=1u
X152 VDD VSS VDD VDD pfet_06v0 ad=4.29p pd=20.38u as=0 ps=0 w=9.75u l=2u
X153 a_4434_28748# a_6204_36450# VDD VDD pfet_06v0 ad=1.65p pd=5.66u as=2.2p ps=10.88u w=5u l=1u
X154 VSS VDD VSS VSS nfet_06v0 ad=4.29p pd=20.38u as=0 ps=0 w=9.75u l=2u
X155 a_7876_80992# a_7876_80992# a_74516_51216# VSS nfet_06v0 ad=0.52p pd=2.52u as=0.88p ps=4.88u w=2u l=1u
X156 VDD a_10558_62632# a_7886_58232# VDD pfet_06v0 ad=2.2p pd=10.88u as=1.3p ps=5.52u w=5u l=1u
X157 a_25694_52962# a_25694_52962# VDD VDD pfet_06v0 ad=0.88p pd=4.88u as=0.88p ps=4.88u w=2u l=1u
X158 a_35840_11598# a_22818_11482# VDD VDD pfet_06v0 ad=2.5p pd=10.5u as=4.4p ps=20.88u w=10u l=1u
X159 a_70674_28748# a_64106_28704# VSS VSS nfet_06v0 ad=1.25p pd=5.5u as=2.2p ps=10.88u w=5u l=1u
X160 a_49158_40758# a_48426_40758# a_49358_40802# VSS nfet_06v0 ad=2.2p pd=10.88u as=1.25p ps=5.5u w=5u l=1u
X161 a_47050_28704# a_48196_36450# a_47532_36450# VDD pfet_06v0 ad=2.2p pd=10.88u as=1.65p ps=5.66u w=5u l=1u
X162 a_18294_40802# a_18094_40758# VSS VSS nfet_06v0 ad=1.25p pd=5.5u as=2.2p ps=10.88u w=5u l=1u
X163 a_34514_81052# a_19658_49608# VDD VDD pfet_06v0 ad=0.99p pd=3.66u as=1.32p ps=6.88u w=3u l=1u
X164 VSS a_33294_66968# a_31510_70368# VSS nfet_06v0 ad=0.65p pd=3.02u as=0.65p ps=3.02u w=2.5u l=1u
X165 a_7886_40872# a_7686_40756# a_6522_40802# VSS nfet_06v0 ad=1.3p pd=5.52u as=2.2p ps=10.88u w=5u l=1u
X166 VSS a_11222_49608# a_19658_49608# VSS nfet_06v0 ad=1.3p pd=5.52u as=1.3p ps=5.52u w=5u l=1u
X167 VDD VSS VDD VDD pfet_06v0 ad=4.29p pd=20.38u as=0 ps=0 w=9.75u l=2u
X168 a_55698_61632# a_48426_58118# a_56366_58232# VSS nfet_06v0 ad=1.1p pd=5.88u as=0.65p ps=3.02u w=2.5u l=1u
X169 a_23278_16764# a_23078_16720# a_22978_16764# VSS nfet_06v0 ad=2.2p pd=10.88u as=1.25p ps=5.5u w=5u l=1u
X170 a_64306_16764# a_64106_16720# VSS VSS nfet_06v0 ad=1.25p pd=5.5u as=2.2p ps=10.88u w=5u l=1u
X171 a_57478_49608# a_62300_53962# a_57930_54008# VDD pfet_06v0 ad=2.2p pd=10.88u as=2.2p ps=10.88u w=5u l=1u
X172 a_64550_40802# a_64350_40758# VSS VSS nfet_06v0 ad=1.25p pd=5.5u as=2.2p ps=10.88u w=5u l=1u
X173 a_73010_41156# a_73010_41156# VDD VDD pfet_06v0 ad=0.88p pd=4.88u as=0.88p ps=4.88u w=2u l=1u
X174 a_17692_44226# a_2510_44226# a_17892_44342# VDD pfet_06v0 ad=3.3p pd=10.66u as=2.5p ps=10.5u w=10u l=1u
X175 a_28350_49538# a_25694_52962# VSS VSS nfet_06v0 ad=0.25p pd=1.5u as=0.44p ps=2.88u w=1u l=1u
X176 a_2670_4780# a_2470_4736# a_2370_4780# VSS nfet_06v0 ad=2.2p pd=10.88u as=1.25p ps=5.5u w=5u l=1u
X177 a_21542_81052# a_34858_45272# VDD VDD pfet_06v0 ad=2.6p pd=10.52u as=4.4p ps=20.88u w=10u l=1u
X178 VDD VSS VDD VDD pfet_06v0 ad=0.66p pd=3.88u as=0 ps=0 w=1.5u l=2u
X179 a_17238_49538# a_2902_49494# VSS VSS nfet_06v0 ad=1.25p pd=5.5u as=2.2p ps=10.88u w=5u l=1u
X180 a_62300_71322# a_62300_71322# a_63948_70322# VDD pfet_06v0 ad=4.4p pd=20.88u as=3.3p ps=10.66u w=10u l=1u
X181 a_29406_66898# a_26086_66854# VSS VSS nfet_06v0 ad=1.25p pd=5.5u as=2.2p ps=10.88u w=5u l=1u
X182 a_23318_23582# a_23118_23466# a_23018_23582# VDD pfet_06v0 ad=4.4p pd=20.88u as=2.5p ps=10.5u w=10u l=1u
X183 a_31510_61632# a_25354_58118# a_34406_58232# VSS nfet_06v0 ad=1.1p pd=5.88u as=0.65p ps=3.02u w=2.5u l=1u
X184 VDD a_33742_71368# a_32182_66968# VDD pfet_06v0 ad=1.3p pd=5.52u as=1.3p ps=5.52u w=5u l=1u
X185 a_30066_61702# a_30870_58116# a_31510_61632# VDD pfet_06v0 ad=4.4p pd=20.88u as=2.6p ps=10.52u w=10u l=1u
X186 a_2710_35566# a_2510_35450# a_3522_35566# VDD pfet_06v0 ad=4.4p pd=20.88u as=2.5p ps=10.5u w=10u l=1u
X187 a_25694_44226# a_25694_44226# a_28350_40802# VSS nfet_06v0 ad=0.44p pd=2.88u as=0.25p ps=1.5u w=1u l=1u
X188 VSS VDD VSS VSS nfet_06v0 ad=0.66p pd=3.88u as=0 ps=0 w=1.5u l=2u
X189 a_2170_28704# a_2510_35450# a_16344_35566# VDD pfet_06v0 ad=4.4p pd=20.88u as=2.5p ps=10.5u w=10u l=1u
D3 VSS S3N diode_nd2ps_06v0 pj=30u area=50p
X190 a_16044_45226# a_2170_40758# a_17238_40802# VSS nfet_06v0 ad=2.2p pd=10.88u as=1.25p ps=5.5u w=5u l=1u
X191 a_38758_66854# a_25694_70322# a_42520_70438# VDD pfet_06v0 ad=4.4p pd=20.88u as=2.5p ps=10.5u w=10u l=1u
X192 a_11158_16764# a_3244_21186# VDD VDD pfet_06v0 ad=0.22p pd=1.88u as=0.22p ps=1.88u w=0.5u l=1u
X193 VDD VSS VDD VDD pfet_06v0 ad=0.66p pd=3.88u as=0 ps=0 w=1.5u l=2u
X194 VDD a_10558_54008# a_8998_49608# VDD pfet_06v0 ad=2.2p pd=10.88u as=1.3p ps=5.52u w=5u l=1u
X195 a_29836_11482# a_23118_11482# a_30036_11598# VDD pfet_06v0 ad=3.3p pd=10.66u as=2.5p ps=10.5u w=10u l=1u
X196 a_72672_59840# a_30906_82772# a_17396_80992# VSS nfet_06v0 ad=1.0912p pd=5.84u as=0.6448p ps=3u w=2.48u l=1u
X197 a_30870_58116# a_66370_16764# cap_mim_2f0_m4m5_noshield c_width=25u c_length=4u
X198 a_77168_23582# a_64146_23466# VDD VDD pfet_06v0 ad=2.5p pd=10.5u as=4.4p ps=20.88u w=10u l=1u
X199 S3N a_4966_28704# VSS ppolyf_u_1k r_width=1u r_length=2u
X200 a_31070_58232# a_25694_61586# a_34858_62632# VDD pfet_06v0 ad=2.2p pd=10.88u as=1.3p ps=5.52u w=5u l=1u
X201 a_23018_11598# a_22818_11482# VDD VDD pfet_06v0 ad=2.5p pd=10.5u as=4.4p ps=20.88u w=10u l=1u
X202 a_31510_61632# a_41030_81052# cap_mim_2f0_m4m5_noshield c_width=20u c_length=10u
X203 a_64106_28704# a_64406_28704# a_74558_28748# VSS nfet_06v0 ad=2.2p pd=10.88u as=1.25p ps=5.5u w=5u l=1u
X204 XP a_74894_44688# VSS VSS nfet_05v0 ad=0.5808p pd=3.52u as=0.5808p ps=3.52u w=1.32u l=0.6u
X205 a_8326_70368# a_2170_66854# a_11222_66968# VSS nfet_06v0 ad=1.1p pd=5.88u as=0.65p ps=3.02u w=2.5u l=1u
X206 a_74894_53424# a_7876_80992# VDD VDD pfet_05v0 ad=0.8052p pd=4.54u as=0.8052p ps=4.54u w=1.83u l=0.5u
X207 a_48426_66854# a_48766_70322# a_48666_70438# VDD pfet_06v0 ad=4.4p pd=20.88u as=2.5p ps=10.5u w=10u l=1u
X208 a_64646_11598# a_64446_11482# a_64346_11598# VDD pfet_06v0 ad=4.4p pd=20.88u as=2.5p ps=10.5u w=10u l=1u
X209 a_8998_58232# a_8798_58116# a_6522_58162# VSS nfet_06v0 ad=1.3p pd=5.52u as=2.2p ps=10.88u w=5u l=1u
X210 a_31286_81052# a_34858_54008# VDD VDD pfet_06v0 ad=2.6p pd=10.52u as=4.4p ps=20.88u w=10u l=1u
X211 a_41278_66854# a_25354_66854# a_41478_66898# VSS nfet_06v0 ad=1.65p pd=5.66u as=1.25p ps=5.5u w=5u l=1u
X212 a_23852_22536# a_8798_49492# VSS ppolyf_u_1k r_width=1u r_length=76.45u
X213 VDD VSS VDD VDD pfet_06v0 ad=7.92p pd=36.88u as=0 ps=0 w=18u l=2u
X214 a_31510_44272# a_30870_40756# a_30066_44342# VDD pfet_06v0 ad=2.6p pd=10.52u as=4.4p ps=20.88u w=10u l=1u
X215 a_40876_52962# a_25694_52962# a_41076_53078# VDD pfet_06v0 ad=3.3p pd=10.66u as=2.5p ps=10.5u w=10u l=1u
X216 a_8798_40756# a_44572_9202# VDD VDD pfet_06v0 ad=0.22p pd=1.88u as=0.22p ps=1.88u w=0.5u l=1u
X217 a_26086_66854# a_25694_70322# a_26706_70438# VDD pfet_06v0 ad=4.4p pd=20.88u as=2.5p ps=10.5u w=10u l=1u
X218 a_74674_58632# a_73010_58516# VSS VSS nfet_06v0 ad=0.175p pd=1.2u as=0.308p ps=2.28u w=0.7u l=1u
X219 VDD a_17396_80992# a_17396_80992# VDD pfet_06v0 ad=0.52p pd=2.52u as=0.52p ps=2.52u w=2u l=1u
X220 S2N a_4966_4736# VSS ppolyf_u_1k r_width=1u r_length=2u
X221 a_57930_45272# a_61830_40758# a_57478_40872# VSS nfet_06v0 ad=1.1p pd=5.88u as=1.1p ps=5.88u w=2.5u l=1u
X222 a_31510_53008# a_33294_49608# VSS VSS nfet_06v0 ad=0.65p pd=3.02u as=1.1p ps=5.88u w=2.5u l=1u
X223 a_43998_16764# a_43798_16720# a_44730_16764# VSS nfet_06v0 ad=2.2p pd=10.88u as=1.25p ps=5.5u w=5u l=1u
D4 S1N VDD diode_pd2nw_06v0 pj=30u area=50p
X224 a_30870_58116# a_69610_16764# VSS VSS nfet_06v0 ad=0.44p pd=2.88u as=0.44p ps=2.88u w=1u l=1u
X225 VSS VDD VSS VSS nfet_06v0 ad=0.66p pd=3.88u as=0 ps=0 w=1.5u l=2u
X226 a_6882_61702# a_2510_61586# a_6582_61702# VDD pfet_06v0 ad=3.3p pd=10.66u as=2.5p ps=10.5u w=10u l=1u
X227 a_50756_35566# a_50556_35450# VDD VDD pfet_06v0 ad=2.5p pd=10.5u as=4.4p ps=20.88u w=10u l=1u
X228 a_44572_21636# a_59990_21186# VSS ppolyf_u_1k r_width=1u r_length=76.45u
X229 a_7886_66968# a_10558_71368# VDD VDD pfet_06v0 ad=1.3p pd=5.52u as=2.2p ps=10.88u w=5u l=1u
X230 a_45762_28748# a_4234_4736# a_43998_28748# VSS nfet_06v0 ad=0.44p pd=2.88u as=0.44p ps=2.88u w=1u l=1u
X231 a_42520_61702# a_25394_61586# VDD VDD pfet_06v0 ad=2.5p pd=10.5u as=4.4p ps=20.88u w=10u l=1u
X232 a_25394_70322# a_25694_70322# a_27318_66898# VSS nfet_06v0 ad=0.44p pd=2.88u as=0.25p ps=1.5u w=1u l=1u
X233 a_26054_25382# a_26330_16720# VSS VSS nfet_06v0 ad=0.825p pd=3.16u as=1.1p ps=5.88u w=2.5u l=1u
X234 a_22818_35450# a_23118_35450# a_34262_28748# VSS nfet_06v0 ad=0.44p pd=2.88u as=0.25p ps=1.5u w=1u l=1u
X235 a_9794_28748# a_9594_28704# VSS VSS nfet_06v0 ad=1.25p pd=5.5u as=2.2p ps=10.88u w=5u l=1u
X236 a_48766_61586# a_48766_61586# a_51422_58162# VSS nfet_06v0 ad=0.44p pd=2.88u as=0.25p ps=1.5u w=1u l=1u
X237 a_72672_59840# a_73010_58516# VSS VSS nfet_06v0 ad=0.5456p pd=3.36u as=0.5456p ps=3.36u w=1.24u l=1u
D5 S3N VDD diode_pd2nw_06v0 pj=30u area=50p
X238 a_4634_13378# a_4234_4736# a_2710_11598# VDD pfet_06v0 ad=0.484p pd=3.08u as=0.484p ps=3.08u w=1.1u l=1u
X239 a_55698_44272# a_48426_40758# a_56366_40872# VSS nfet_06v0 ad=1.1p pd=5.88u as=0.65p ps=3.02u w=2.5u l=1u
X240 a_32182_58232# a_33742_62632# VDD VDD pfet_06v0 ad=1.3p pd=5.52u as=1.3p ps=5.52u w=5u l=1u
X241 VSS VDD VSS VSS nfet_06v0 ad=0.66p pd=3.88u as=0 ps=0 w=1.5u l=2u
X242 VSS VDD VSS VSS nfet_06v0 ad=0.66p pd=3.88u as=0 ps=0 w=1.5u l=2u
X243 a_65180_34520# a_80598_34070# VSS ppolyf_u_1k r_width=1u r_length=76.45u
X244 VSS a_19658_49608# a_31930_81096# VSS nfet_06v0 ad=0.44p pd=2.88u as=0.44p ps=2.88u w=1u l=1u
X245 a_2510_61586# a_2510_61586# VDD VDD pfet_06v0 ad=0.88p pd=4.88u as=0.88p ps=4.88u w=2u l=1u
X246 a_3244_33170# a_2510_35450# a_4434_28748# VDD pfet_06v0 ad=1.65p pd=5.66u as=1.65p ps=5.66u w=5u l=1u
X247 YP a_74894_53424# VSS VSS nfet_05v0 ad=0.5808p pd=3.52u as=0.5808p ps=3.52u w=1.32u l=0.6u
X248 VSS VDD VSS VSS nfet_06v0 ad=7.92p pd=36.88u as=0 ps=0 w=18u l=2u
X249 a_59596_35566# a_43538_35450# VDD VDD pfet_06v0 ad=2.5p pd=10.5u as=4.4p ps=20.88u w=10u l=1u
X250 a_6522_49538# a_8798_49492# a_8998_49608# VSS nfet_06v0 ad=2.2p pd=10.88u as=1.3p ps=5.52u w=5u l=1u
X251 a_29706_66898# a_8798_66852# a_32182_66968# VSS nfet_06v0 ad=2.2p pd=10.88u as=1.3p ps=5.52u w=5u l=1u
X252 a_22778_16720# a_23118_23466# a_36952_23582# VDD pfet_06v0 ad=4.4p pd=20.88u as=2.5p ps=10.5u w=10u l=1u
X253 a_31510_44272# a_25354_40758# a_34406_40872# VSS nfet_06v0 ad=1.1p pd=5.88u as=0.65p ps=3.02u w=2.5u l=1u
X254 a_48666_61702# a_48466_61586# VDD VDD pfet_06v0 ad=2.5p pd=10.5u as=4.4p ps=20.88u w=10u l=1u
X255 a_2410_70438# a_2210_70322# VDD VDD pfet_06v0 ad=2.5p pd=10.5u as=4.4p ps=20.88u w=10u l=1u
X256 a_2510_11482# a_2510_11482# VDD VDD pfet_06v0 ad=0.88p pd=4.88u as=0.88p ps=4.88u w=2u l=1u
X257 a_44572_21186# a_59990_21186# VSS ppolyf_u_1k r_width=1u r_length=76.45u
X258 VSS VDD VSS VSS nfet_06v0 ad=7.92p pd=36.88u as=0 ps=0 w=18u l=2u
X259 a_3244_22536# a_11158_16764# VSS ppolyf_u_1k r_width=1u r_length=76.45u
X260 a_11158_16764# a_3244_21186# VDD VDD pfet_06v0 ad=0.22p pd=1.88u as=0.22p ps=1.88u w=0.5u l=1u
X261 VSS a_44258_81052# a_44170_81096# VSS nfet_06v0 ad=0.44p pd=2.88u as=0.44p ps=2.88u w=1u l=1u
X262 a_71650_44468# a_71650_44468# VDD VDD pfet_06v0 ad=0.52p pd=2.52u as=0.88p ps=4.88u w=2u l=1u
X263 a_29706_49538# a_25354_49494# a_29406_49538# VSS nfet_06v0 ad=1.65p pd=5.66u as=1.25p ps=5.5u w=5u l=1u
X264 a_31510_53008# a_11158_16764# a_30066_53078# VDD pfet_06v0 ad=2.6p pd=10.52u as=4.4p ps=20.88u w=10u l=1u
X265 VDD VSS VDD VDD pfet_06v0 ad=0.88p pd=4.88u as=0 ps=0 w=2u l=2u
X266 a_26086_66854# a_25354_66854# a_26286_66898# VSS nfet_06v0 ad=2.2p pd=10.88u as=1.25p ps=5.5u w=5u l=1u
X267 VDD VSS VDD VDD pfet_06v0 ad=0.88p pd=4.88u as=0 ps=0 w=2u l=2u
X268 a_6868_36450# a_2470_28704# a_8738_28748# VSS nfet_06v0 ad=2.2p pd=10.88u as=1.25p ps=5.5u w=5u l=1u
X269 a_48466_61586# a_48766_61586# a_50390_58162# VSS nfet_06v0 ad=0.44p pd=2.88u as=0.25p ps=1.5u w=1u l=1u
X270 a_26706_61702# a_25394_61586# VDD VDD pfet_06v0 ad=2.5p pd=10.5u as=4.4p ps=20.88u w=10u l=1u
X271 a_65180_33620# a_80598_34070# VSS ppolyf_u_1k r_width=1u r_length=76.45u
X272 a_48196_36450# a_48196_36450# a_50556_35450# VDD pfet_06v0 ad=4.4p pd=20.88u as=3.3p ps=10.66u w=10u l=1u
X273 a_45762_28748# a_47532_36450# VDD VDD pfet_06v0 ad=1.65p pd=5.66u as=2.2p ps=10.88u w=5u l=1u
X274 VDD a_33742_45272# a_31070_40872# VDD pfet_06v0 ad=1.3p pd=5.52u as=1.3p ps=5.52u w=5u l=1u
X275 a_30066_53078# a_25694_52962# a_29766_53078# VDD pfet_06v0 ad=3.3p pd=10.66u as=2.5p ps=10.5u w=10u l=1u
X276 S4P a_4234_16720# VSS ppolyf_u_1k r_width=1u r_length=2u
X277 a_42842_66968# a_34406_66968# VSS VSS nfet_06v0 ad=1.3p pd=5.52u as=2.2p ps=10.88u w=5u l=1u
X278 a_36952_11598# a_22818_11482# VDD VDD pfet_06v0 ad=2.5p pd=10.5u as=4.4p ps=20.88u w=10u l=1u
X279 a_31286_81052# a_34406_49608# VSS VSS nfet_06v0 ad=2.2p pd=10.88u as=1.3p ps=5.52u w=5u l=1u
X280 a_2510_44226# a_2510_44226# a_5166_40802# VSS nfet_06v0 ad=0.44p pd=2.88u as=0.25p ps=1.5u w=1u l=1u
X281 a_74516_51216# a_7876_80992# a_75916_51146# VSS nfet_06v0 ad=0.88p pd=4.88u as=0.5p ps=2.5u w=2u l=1u
X282 a_64106_4736# a_64446_11482# a_78280_11598# VDD pfet_06v0 ad=4.4p pd=20.88u as=2.5p ps=10.5u w=10u l=1u
X283 a_8998_40872# a_8798_40756# a_6522_40802# VSS nfet_06v0 ad=1.3p pd=5.52u as=2.2p ps=10.88u w=5u l=1u
X284 a_54582_61632# a_48426_58118# a_57478_58232# VSS nfet_06v0 ad=1.1p pd=5.88u as=0.65p ps=3.02u w=2.5u l=1u
X285 VSS VDD VSS VSS nfet_06v0 ad=0.66p pd=3.88u as=0 ps=0 w=1.5u l=2u
X286 a_53138_61702# a_30870_58116# a_54582_61632# VDD pfet_06v0 ad=4.4p pd=20.88u as=2.6p ps=10.52u w=10u l=1u
X287 a_6204_12482# a_6386_4736# a_5722_4736# VSS nfet_06v0 ad=1.1p pd=5.88u as=0.825p ps=3.16u w=2.5u l=1u
X288 a_53138_61702# a_48766_61586# a_52838_61702# VDD pfet_06v0 ad=3.3p pd=10.66u as=2.5p ps=10.5u w=10u l=1u
X289 a_2170_40758# a_2510_44226# a_2410_44342# VDD pfet_06v0 ad=4.4p pd=20.88u as=2.5p ps=10.5u w=10u l=1u
X290 X a_71650_44468# VSS ppolyf_u_1k r_width=1u r_length=2u
X291 a_71364_23582# a_71164_23466# VDD VDD pfet_06v0 ad=2.5p pd=10.5u as=4.4p ps=20.88u w=10u l=1u
X292 a_61830_66854# a_48766_70322# a_65592_70438# VDD pfet_06v0 ad=4.4p pd=20.88u as=2.5p ps=10.5u w=10u l=1u
X293 a_41674_81096# a_19658_58232# VDD VDD pfet_06v0 ad=1.32p pd=6.88u as=1.32p ps=6.88u w=3u l=1u
X294 VDD VSS VDD VDD pfet_06v0 ad=0.88p pd=4.88u as=0 ps=0 w=2u l=2u
X295 a_66370_16764# a_7876_75392# a_64606_16764# VSS nfet_06v0 ad=0.44p pd=2.88u as=0.44p ps=2.88u w=1u l=1u
X296 VSS a_33294_58232# a_32626_61632# VSS nfet_06v0 ad=0.65p pd=3.02u as=0.65p ps=3.02u w=2.5u l=1u
X297 a_55254_66968# a_48766_70322# a_56814_71368# VDD pfet_06v0 ad=2.2p pd=10.88u as=1.3p ps=5.52u w=5u l=1u
X298 a_39228_71322# a_25354_66854# a_40422_66898# VSS nfet_06v0 ad=2.2p pd=10.88u as=1.25p ps=5.5u w=5u l=1u
X299 a_4634_37346# a_8798_58116# cap_mim_2f0_m4m5_noshield c_width=25u c_length=4u
X300 VDD VSS VDD VDD pfet_06v0 ad=7.92p pd=36.88u as=0 ps=0 w=18u l=2u
X301 a_71730_28748# a_71530_28704# VSS VSS nfet_06v0 ad=1.25p pd=5.5u as=2.2p ps=10.88u w=5u l=1u
X302 a_52478_40802# a_49158_40758# VSS VSS nfet_06v0 ad=1.25p pd=5.5u as=2.2p ps=10.88u w=5u l=1u
X303 VDD a_33742_54008# a_31070_49608# VDD pfet_06v0 ad=1.3p pd=5.52u as=1.3p ps=5.52u w=5u l=1u
X304 VDD VSS VDD VDD pfet_06v0 ad=0.66p pd=3.88u as=0 ps=0 w=1.5u l=2u
X305 a_29766_44342# a_25394_44226# VDD VDD pfet_06v0 ad=2.5p pd=10.5u as=4.4p ps=20.88u w=10u l=1u
X306 VSS VDD VSS VSS nfet_06v0 ad=7.92p pd=36.88u as=0 ps=0 w=18u l=2u
D6 S4N VDD diode_pd2nw_06v0 pj=30u area=50p
X307 a_3244_9202# a_18662_9202# VSS ppolyf_u_1k r_width=1u r_length=76.45u
X308 a_54582_44272# a_30870_40756# a_53138_44342# VDD pfet_06v0 ad=2.6p pd=10.52u as=4.4p ps=20.88u w=10u l=1u
X309 a_32662_81096# a_32750_81052# VDD VDD pfet_06v0 ad=1.32p pd=6.88u as=1.32p ps=6.88u w=3u l=1u
X310 a_21162_82772# a_21210_81052# VSS VSS nfet_06v0 ad=0.33p pd=1.66u as=0.44p ps=2.88u w=1u l=1u
X311 VSS a_10110_66968# a_9442_70368# VSS nfet_06v0 ad=0.65p pd=3.02u as=0.65p ps=3.02u w=2.5u l=1u
X312 a_25774_16764# a_26812_24466# VDD VDD pfet_06v0 ad=1.65p pd=5.66u as=2.2p ps=10.88u w=5u l=1u
X313 VSS a_10110_49608# a_9442_53008# VSS nfet_06v0 ad=1.1p pd=5.88u as=0.65p ps=3.02u w=2.5u l=1u
X314 a_49158_66854# a_48766_70322# a_49778_70438# VDD pfet_06v0 ad=4.4p pd=20.88u as=2.5p ps=10.5u w=10u l=1u
X315 a_64646_11598# a_64446_11482# a_65458_11598# VDD pfet_06v0 ad=4.4p pd=20.88u as=2.5p ps=10.5u w=10u l=1u
X316 a_71560_58632# a_73010_58516# VSS VSS nfet_06v0 ad=0.5456p pd=3.36u as=0.5456p ps=3.36u w=1.24u l=1u
X317 a_49002_16764# a_43798_16720# a_45962_25362# VSS nfet_06v0 ad=0.825p pd=3.16u as=0.825p ps=3.16u w=2.5u l=1u
X318 a_65592_61702# a_48466_61586# VDD VDD pfet_06v0 ad=2.5p pd=10.5u as=4.4p ps=20.88u w=10u l=1u
X319 VDD a_48466_70322# a_53470_70438# VDD pfet_06v0 ad=4.4p pd=20.88u as=2.5p ps=10.5u w=10u l=1u
D7 S4P VDD diode_pd2nw_06v0 pj=30u area=50p
X320 VDD VSS VDD VDD pfet_06v0 ad=4.29p pd=20.38u as=0 ps=0 w=9.75u l=2u
X321 a_54582_53008# a_30954_81052# cap_mim_2f0_m4m5_noshield c_width=20u c_length=10u
X322 a_68322_28704# a_68322_28704# a_71530_28704# VSS nfet_06v0 ad=2.2p pd=10.88u as=1.65p ps=5.66u w=5u l=1u
X323 a_43798_16720# a_43798_16720# VSS VSS nfet_06v0 ad=0.44p pd=2.88u as=0.44p ps=2.88u w=1u l=1u
X324 a_54582_61632# a_56366_58232# VSS VSS nfet_06v0 ad=0.65p pd=3.02u as=1.1p ps=5.88u w=2.5u l=1u
X325 VSS a_19658_40872# a_25702_81096# VSS nfet_06v0 ad=0.44p pd=2.88u as=0.25p ps=1.5u w=1u l=1u
X326 a_48426_49494# a_48426_49494# VSS VSS nfet_06v0 ad=0.44p pd=2.88u as=0.44p ps=2.88u w=1u l=1u
X327 a_55698_53008# a_56366_49608# VSS VSS nfet_06v0 ad=0.65p pd=3.02u as=1.1p ps=5.88u w=2.5u l=1u
X328 a_19658_58232# a_11674_62632# VDD VDD pfet_06v0 ad=4.4p pd=20.88u as=2.6p ps=10.52u w=10u l=1u
X329 VSS VDD VSS VSS nfet_06v0 ad=4.29p pd=20.38u as=0 ps=0 w=9.75u l=2u
X330 a_54582_44272# a_48426_40758# a_57478_40872# VSS nfet_06v0 ad=1.1p pd=5.88u as=0.65p ps=3.02u w=2.5u l=1u
X331 a_7886_66968# a_2510_70322# a_11674_71368# VDD pfet_06v0 ad=2.2p pd=10.88u as=1.3p ps=5.52u w=5u l=1u
X332 a_54582_53008# a_11158_16764# a_53138_53078# VDD pfet_06v0 ad=2.6p pd=10.52u as=4.4p ps=20.88u w=10u l=1u
X333 a_11158_16764# a_3244_21186# VDD VDD pfet_06v0 ad=0.22p pd=1.88u as=0.22p ps=1.88u w=0.5u l=1u
X334 a_5166_16764# a_6204_24466# VDD VDD pfet_06v0 ad=1.65p pd=5.66u as=2.2p ps=10.88u w=5u l=1u
X335 a_34406_66968# a_39228_71322# a_34858_71368# VDD pfet_06v0 ad=2.2p pd=10.88u as=2.2p ps=10.88u w=5u l=1u
X336 VSS a_33294_40872# a_32626_44272# VSS nfet_06v0 ad=0.65p pd=3.02u as=0.65p ps=3.02u w=2.5u l=1u
X337 a_49778_61702# a_48466_61586# VDD VDD pfet_06v0 ad=2.5p pd=10.5u as=4.4p ps=20.88u w=10u l=1u
X338 a_32626_70368# a_25354_66854# a_33294_66968# VSS nfet_06v0 ad=1.1p pd=5.88u as=0.65p ps=3.02u w=2.5u l=1u
X339 a_21210_81052# a_57930_45272# VDD VDD pfet_06v0 ad=4.4p pd=20.88u as=2.6p ps=10.52u w=10u l=1u
X340 a_3522_70438# a_2210_70322# VDD VDD pfet_06v0 ad=2.5p pd=10.5u as=4.4p ps=20.88u w=10u l=1u
X341 a_7686_40756# a_4434_4780# cap_mim_2f0_m4m5_noshield c_width=25u c_length=4u
X342 a_7686_58116# a_44572_21186# VDD VDD pfet_06v0 ad=0.22p pd=1.88u as=0.22p ps=1.88u w=0.5u l=1u
X343 S3P a_4234_28704# VSS ppolyf_u_1k r_width=1u r_length=2u
X344 a_66570_13378# a_67658_4736# VSS VSS nfet_06v0 ad=0.825p pd=3.16u as=1.1p ps=5.88u w=2.5u l=1u
X345 a_71560_59840# a_50506_82772# a_17396_80992# VSS nfet_06v0 ad=1.0912p pd=5.84u as=0.6448p ps=3u w=2.48u l=1u
X346 a_64306_28748# a_64106_28704# VSS VSS nfet_06v0 ad=1.25p pd=5.5u as=2.2p ps=10.88u w=5u l=1u
X347 a_23278_28748# a_23078_28704# a_22978_28748# VSS nfet_06v0 ad=2.2p pd=10.88u as=1.25p ps=5.5u w=5u l=1u
X348 VSS a_24770_81052# a_24682_81096# VSS nfet_06v0 ad=0.44p pd=2.88u as=0.44p ps=2.88u w=1u l=1u
X349 a_11674_54008# a_15574_49494# a_11222_49608# VSS nfet_06v0 ad=1.1p pd=5.88u as=1.1p ps=5.88u w=2.5u l=1u
X350 a_8326_70368# a_10110_66968# VSS VSS nfet_06v0 ad=0.65p pd=3.02u as=0.65p ps=3.02u w=2.5u l=1u
X351 a_53470_61702# a_48766_61586# a_53138_61702# VDD pfet_06v0 ad=2.5p pd=10.5u as=3.3p ps=10.66u w=10u l=1u
X352 a_44038_23582# a_43838_23466# a_44850_23582# VDD pfet_06v0 ad=4.4p pd=20.88u as=2.5p ps=10.5u w=10u l=1u
X353 a_8326_61632# a_7686_58116# a_6882_61702# VDD pfet_06v0 ad=2.6p pd=10.52u as=4.4p ps=20.88u w=10u l=1u
X354 a_16044_62586# a_16044_62586# a_17692_61586# VDD pfet_06v0 ad=4.4p pd=20.88u as=3.3p ps=10.66u w=10u l=1u
X355 VSS VDD VSS VSS nfet_06v0 ad=7.92p pd=36.88u as=0 ps=0 w=18u l=2u
X356 a_23318_35566# a_23118_35450# a_23018_35566# VDD pfet_06v0 ad=4.4p pd=20.88u as=2.5p ps=10.5u w=10u l=1u
X357 a_71530_4736# a_64406_4736# a_71730_4780# VSS nfet_06v0 ad=1.65p pd=5.66u as=1.25p ps=5.5u w=5u l=1u
X358 VDD a_11674_45272# a_19658_40872# VDD pfet_06v0 ad=2.6p pd=10.52u as=2.6p ps=10.52u w=10u l=1u
X359 a_41478_58162# a_41278_58118# VSS VSS nfet_06v0 ad=1.25p pd=5.5u as=2.2p ps=10.88u w=5u l=1u
X360 VSS VDD VSS VSS nfet_06v0 ad=0.66p pd=3.88u as=0 ps=0 w=1.5u l=2u
X361 a_51422_40802# a_48766_44226# VSS VSS nfet_06v0 ad=0.25p pd=1.5u as=0.44p ps=2.88u w=1u l=1u
X362 a_38758_40758# a_38758_40758# a_41278_40758# VSS nfet_06v0 ad=2.2p pd=10.88u as=1.65p ps=5.66u w=5u l=1u
X363 a_8798_58116# a_3244_33170# VDD VDD pfet_06v0 ad=0.22p pd=1.88u as=0.22p ps=1.88u w=0.5u l=1u
X364 a_8998_66968# a_10558_71368# VDD VDD pfet_06v0 ad=1.3p pd=5.52u as=1.3p ps=5.52u w=5u l=1u
X365 a_9228_23466# a_2510_23466# a_9428_23582# VDD pfet_06v0 ad=3.3p pd=10.66u as=2.5p ps=10.5u w=10u l=1u
X366 a_72672_42480# a_34426_81096# a_71650_44468# VSS nfet_06v0 ad=1.0912p pd=5.84u as=0.6448p ps=3u w=2.48u l=1u
X367 a_73010_58516# a_73010_58516# a_75274_58632# VSS nfet_06v0 ad=0.308p pd=2.28u as=0.175p ps=1.2u w=0.7u l=1u
X368 a_32626_53008# a_33294_49608# VSS VSS nfet_06v0 ad=0.65p pd=3.02u as=0.65p ps=3.02u w=2.5u l=1u
X369 VSS a_56366_58232# a_55698_61632# VSS nfet_06v0 ad=0.65p pd=3.02u as=0.65p ps=3.02u w=2.5u l=1u
X370 a_54982_4780# a_43838_11482# VSS VSS nfet_06v0 ad=0.25p pd=1.5u as=0.44p ps=2.88u w=1u l=1u
X371 a_77168_35566# a_64146_35450# VDD VDD pfet_06v0 ad=2.5p pd=10.5u as=4.4p ps=20.88u w=10u l=1u
X372 a_62300_71322# a_48426_66854# a_63494_66898# VSS nfet_06v0 ad=2.2p pd=10.88u as=1.25p ps=5.5u w=5u l=1u
X373 a_47714_16720# a_43838_23466# a_52200_23582# VDD pfet_06v0 ad=4.4p pd=20.88u as=2.5p ps=10.5u w=10u l=1u
X374 a_6222_49538# a_2902_49494# VSS VSS nfet_06v0 ad=1.25p pd=5.5u as=2.2p ps=10.88u w=5u l=1u
X375 a_27318_58162# a_25694_61586# VSS VSS nfet_06v0 ad=0.25p pd=1.5u as=0.44p ps=2.88u w=1u l=1u
X376 a_2902_40758# a_2510_44226# a_3522_44342# VDD pfet_06v0 ad=4.4p pd=20.88u as=2.5p ps=10.5u w=10u l=1u
X377 a_4634_13378# a_7686_40756# cap_mim_2f0_m4m5_noshield c_width=25u c_length=4u
X378 a_26054_25382# a_25574_16720# a_23318_23582# VDD pfet_06v0 ad=0.44p pd=2.88u as=0.44p ps=2.88u w=1u l=1u
X379 VDD a_42842_66968# a_50794_82772# VDD pfet_06v0 ad=1.32p pd=6.88u as=0.75p ps=3.5u w=3u l=1u
X380 a_50554_81052# a_57930_71368# VDD VDD pfet_06v0 ad=2.6p pd=10.52u as=4.4p ps=20.88u w=10u l=1u
X381 a_30954_81052# a_57930_54008# VDD VDD pfet_06v0 ad=4.4p pd=20.88u as=2.6p ps=10.52u w=10u l=1u
X382 a_22186_81096# a_19658_40872# VDD VDD pfet_06v0 ad=1.32p pd=6.88u as=1.32p ps=6.88u w=3u l=1u
X383 VSS a_49158_58118# a_53110_58162# VSS nfet_06v0 ad=2.2p pd=10.88u as=1.25p ps=5.5u w=5u l=1u
X384 VSS VDD VSS VSS nfet_06v0 ad=4.29p pd=20.38u as=0 ps=0 w=9.75u l=2u
X385 a_10558_45272# a_15574_40758# a_10110_40872# VSS nfet_06v0 ad=1.1p pd=5.88u as=1.1p ps=5.88u w=2.5u l=1u
X386 a_54582_44272# a_56366_40872# VSS VSS nfet_06v0 ad=0.65p pd=3.02u as=1.1p ps=5.88u w=2.5u l=1u
X387 a_6582_53078# a_2210_52962# VDD VDD pfet_06v0 ad=2.5p pd=10.5u as=4.4p ps=20.88u w=10u l=1u
X388 VDD VSS VDD VDD pfet_06v0 ad=0.66p pd=3.88u as=0 ps=0 w=1.5u l=2u
X389 a_67658_4736# a_68804_12482# a_68140_12482# VDD pfet_06v0 ad=2.2p pd=10.88u as=1.65p ps=5.66u w=5u l=1u
X390 a_50390_40802# a_48766_44226# VSS VSS nfet_06v0 ad=0.25p pd=1.5u as=0.44p ps=2.88u w=1u l=1u
X391 a_6522_40802# a_2170_40758# a_6222_40802# VSS nfet_06v0 ad=1.65p pd=5.66u as=1.25p ps=5.5u w=5u l=1u
X392 a_71560_59840# a_73010_58516# VSS VSS nfet_06v0 ad=0.5456p pd=3.36u as=0.5456p ps=3.36u w=1.24u l=1u
X393 a_6204_12482# a_2510_11482# a_5166_4780# VDD pfet_06v0 ad=1.65p pd=5.66u as=1.65p ps=5.66u w=5u l=1u
X394 a_74674_41272# a_73010_41156# VSS VSS nfet_06v0 ad=0.175p pd=1.2u as=0.308p ps=2.28u w=0.7u l=1u
X395 a_56814_45272# a_61830_40758# a_56366_40872# VSS nfet_06v0 ad=1.1p pd=5.88u as=1.1p ps=5.88u w=2.5u l=1u
X396 a_43698_4780# a_43498_4736# VSS VSS nfet_06v0 ad=1.25p pd=5.5u as=2.2p ps=10.88u w=5u l=1u
X397 a_23078_16720# a_23118_23466# a_35840_23582# VDD pfet_06v0 ad=4.4p pd=20.88u as=2.5p ps=10.5u w=10u l=1u
X398 S4N a_4966_16720# VSS ppolyf_u_1k r_width=1u r_length=2u
X399 a_6386_4736# a_2510_11482# a_10872_11598# VDD pfet_06v0 ad=4.4p pd=20.88u as=2.5p ps=10.5u w=10u l=1u
X400 VDD a_11674_54008# a_19658_49608# VDD pfet_06v0 ad=2.6p pd=10.52u as=2.6p ps=10.52u w=10u l=1u
X401 a_44572_9202# a_47714_4736# a_49002_4780# VSS nfet_06v0 ad=1.1p pd=5.88u as=0.825p ps=3.16u w=2.5u l=1u
X402 VDD a_33742_45272# a_32182_40872# VDD pfet_06v0 ad=2.2p pd=10.88u as=1.3p ps=5.52u w=5u l=1u
X403 a_43998_28748# a_43798_28704# a_44730_28748# VSS nfet_06v0 ad=2.2p pd=10.88u as=1.25p ps=5.5u w=5u l=1u
X404 a_29346_16764# a_22778_16720# VSS VSS nfet_06v0 ad=1.25p pd=5.5u as=2.2p ps=10.88u w=5u l=1u
X405 a_8798_66852# a_69610_28748# VSS VSS nfet_06v0 ad=0.44p pd=2.88u as=0.44p ps=2.88u w=1u l=1u
X406 VSS VDD VSS VSS nfet_06v0 ad=4.29p pd=20.38u as=0 ps=0 w=9.75u l=2u
X407 VDD VSS VDD VDD pfet_06v0 ad=4.29p pd=20.38u as=0 ps=0 w=9.75u l=2u
X408 a_26286_58162# a_26086_58118# VSS VSS nfet_06v0 ad=1.25p pd=5.5u as=2.2p ps=10.88u w=5u l=1u
X409 a_22978_4780# a_22778_4736# VSS VSS nfet_06v0 ad=1.25p pd=5.5u as=2.2p ps=10.88u w=5u l=1u
X410 a_26054_37366# a_26330_28704# VSS VSS nfet_06v0 ad=0.825p pd=3.16u as=1.1p ps=5.88u w=2.5u l=1u
X411 a_40698_81052# a_54142_58232# cap_mim_2f0_m4m5_noshield c_width=20u c_length=10u
X412 a_72672_51216# a_32662_81096# a_7876_80992# VSS nfet_06v0 ad=1.0912p pd=5.84u as=0.6448p ps=3u w=2.48u l=1u
X413 a_7876_80992# a_7876_80992# VDD VDD pfet_06v0 ad=0.52p pd=2.52u as=0.52p ps=2.52u w=2u l=1u
X414 VSS a_10110_49608# a_8326_53008# VSS nfet_06v0 ad=0.65p pd=3.02u as=0.65p ps=3.02u w=2.5u l=1u
X415 a_23852_9202# a_26994_4736# a_28282_4780# VSS nfet_06v0 ad=1.1p pd=5.88u as=0.825p ps=3.16u w=2.5u l=1u
X416 VDD VSS VDD VDD pfet_06v0 ad=4.29p pd=20.38u as=0 ps=0 w=9.75u l=2u
X417 a_43838_23466# a_43838_23466# a_56014_16764# VSS nfet_06v0 ad=0.44p pd=2.88u as=0.25p ps=1.5u w=1u l=1u
X418 a_45762_4780# a_7876_75392# a_43998_4780# VSS nfet_06v0 ad=0.44p pd=2.88u as=0.44p ps=2.88u w=1u l=1u
X419 a_30402_4780# a_30202_4736# VSS VSS nfet_06v0 ad=1.25p pd=5.5u as=2.2p ps=10.88u w=5u l=1u
X420 a_5446_25382# a_4966_16720# a_2710_23582# VDD pfet_06v0 ad=0.44p pd=2.88u as=0.44p ps=2.88u w=1u l=1u
X421 VSS a_56366_49608# a_54582_53008# VSS nfet_06v0 ad=0.65p pd=3.02u as=0.65p ps=3.02u w=2.5u l=1u
X422 a_11222_49608# a_16044_53962# a_11674_54008# VDD pfet_06v0 ad=2.2p pd=10.88u as=2.2p ps=10.88u w=5u l=1u
X423 VDD VSS VDD VDD pfet_06v0 ad=7.92p pd=36.88u as=0 ps=0 w=18u l=2u
X424 VSS a_40698_81052# a_43426_81096# VSS nfet_06v0 ad=0.44p pd=2.88u as=0.25p ps=1.5u w=1u l=1u
X425 VSS a_33294_49608# a_31510_53008# VSS nfet_06v0 ad=1.1p pd=5.88u as=0.65p ps=3.02u w=2.5u l=1u
X426 a_22778_28704# a_23118_35450# a_36952_35566# VDD pfet_06v0 ad=4.4p pd=20.88u as=2.5p ps=10.5u w=10u l=1u
X427 a_8798_49492# a_23852_21186# VDD VDD pfet_06v0 ad=0.22p pd=1.88u as=0.22p ps=1.88u w=0.5u l=1u
X428 a_25042_4780# a_4234_28704# a_23278_4780# VSS nfet_06v0 ad=0.44p pd=2.88u as=0.44p ps=2.88u w=1u l=1u
X429 VSS VDD VSS VSS nfet_06v0 ad=7.92p pd=36.88u as=0 ps=0 w=18u l=2u
X430 a_8798_58116# a_3244_33170# VDD VDD pfet_06v0 ad=0.22p pd=1.88u as=0.22p ps=1.88u w=0.5u l=1u
X431 VDD VSS VDD VDD pfet_06v0 ad=4.29p pd=20.38u as=0 ps=0 w=9.75u l=2u
X432 a_2210_52962# a_2510_52962# a_4134_49538# VSS nfet_06v0 ad=0.44p pd=2.88u as=0.25p ps=1.5u w=1u l=1u
X433 a_74674_50008# a_73010_49892# VSS VSS nfet_06v0 ad=0.175p pd=1.2u as=0.308p ps=2.28u w=0.7u l=1u
X434 a_13654_16764# a_2510_23466# VSS VSS nfet_06v0 ad=0.25p pd=1.5u as=0.44p ps=2.88u w=1u l=1u
X435 a_50554_81052# a_57478_66968# VSS VSS nfet_06v0 ad=2.2p pd=10.88u as=1.3p ps=5.52u w=5u l=1u
X436 a_40422_58162# a_26086_58118# VSS VSS nfet_06v0 ad=1.25p pd=5.5u as=2.2p ps=10.88u w=5u l=1u
X437 VSS VDD VSS VSS nfet_06v0 ad=0.88p pd=4.88u as=0 ps=0 w=2u l=2u
X438 a_43538_23466# a_43838_23466# a_54982_16764# VSS nfet_06v0 ad=0.44p pd=2.88u as=0.25p ps=1.5u w=1u l=1u
X439 VSS a_56366_40872# a_55698_44272# VSS nfet_06v0 ad=0.65p pd=3.02u as=0.65p ps=3.02u w=2.5u l=1u
X440 VDD a_33742_54008# a_32182_49608# VDD pfet_06v0 ad=2.2p pd=10.88u as=1.3p ps=5.52u w=5u l=1u
X441 a_57930_71368# a_48766_70322# a_54142_66968# VDD pfet_06v0 ad=1.3p pd=5.52u as=2.2p ps=10.88u w=5u l=1u
X442 a_52838_53078# a_48466_52962# VDD VDD pfet_06v0 ad=2.5p pd=10.5u as=4.4p ps=20.88u w=10u l=1u
X443 a_72672_51216# a_73010_49892# VSS VSS nfet_06v0 ad=0.5456p pd=3.36u as=0.5456p ps=3.36u w=1.24u l=1u
X444 a_7886_40872# a_10558_45272# VDD VDD pfet_06v0 ad=1.3p pd=5.52u as=1.3p ps=5.52u w=5u l=1u
X445 VSS a_42494_81052# a_42406_81096# VSS nfet_06v0 ad=0.44p pd=2.88u as=0.44p ps=2.88u w=1u l=1u
X446 VDD VSS VDD VDD pfet_06v0 ad=0.66p pd=3.88u as=0 ps=0 w=1.5u l=2u
X447 a_7686_49492# a_65180_9202# VDD VDD pfet_06v0 ad=0.22p pd=1.88u as=0.22p ps=1.88u w=0.5u l=1u
X448 S1P a_7876_75392# VSS ppolyf_u_1k r_width=1u r_length=2u
X449 a_24010_16764# a_22778_16720# VSS VSS nfet_06v0 ad=1.25p pd=5.5u as=2.2p ps=10.88u w=5u l=1u
X450 a_33294_49608# a_39228_53962# a_33742_54008# VDD pfet_06v0 ad=2.2p pd=10.88u as=2.2p ps=10.88u w=5u l=1u
X451 VSS a_56366_58232# a_55698_61632# VSS nfet_06v0 ad=1.1p pd=5.88u as=0.65p ps=3.02u w=2.5u l=1u
X452 VSS VDD VSS VSS nfet_06v0 ad=7.92p pd=36.88u as=0 ps=0 w=18u l=2u
X453 a_3102_40802# a_2902_40758# VSS VSS nfet_06v0 ad=1.25p pd=5.5u as=2.2p ps=10.88u w=5u l=1u
X454 a_71364_35566# a_71164_35450# VDD VDD pfet_06v0 ad=2.5p pd=10.5u as=4.4p ps=20.88u w=10u l=1u
X455 a_61830_40758# a_61830_40758# a_64350_40758# VSS nfet_06v0 ad=2.2p pd=10.88u as=1.65p ps=5.66u w=5u l=1u
X456 a_15574_58118# a_2510_61586# a_19336_61702# VDD pfet_06v0 ad=4.4p pd=20.88u as=2.5p ps=10.5u w=10u l=1u
X457 a_66370_28748# a_4234_28704# a_64606_28748# VSS nfet_06v0 ad=0.44p pd=2.88u as=0.44p ps=2.88u w=1u l=1u
X458 a_54582_61632# a_56366_58232# VSS VSS nfet_06v0 ad=0.65p pd=3.02u as=0.65p ps=3.02u w=2.5u l=1u
X459 a_55698_53008# a_56366_49608# VSS VSS nfet_06v0 ad=0.65p pd=3.02u as=0.65p ps=3.02u w=2.5u l=1u
X460 a_30038_66898# a_25354_66854# a_29706_66898# VSS nfet_06v0 ad=1.25p pd=5.5u as=1.65p ps=5.66u w=5u l=1u
X461 a_22818_11482# a_23118_11482# a_38876_11598# VDD pfet_06v0 ad=4.4p pd=20.88u as=2.5p ps=10.5u w=10u l=1u
X462 VSS VDD VSS VSS nfet_06v0 ad=7.92p pd=36.88u as=0 ps=0 w=18u l=2u
X463 VDD VSS VDD VDD pfet_06v0 ad=7.92p pd=36.88u as=0 ps=0 w=18u l=2u
X464 a_25242_25362# a_8798_49492# cap_mim_2f0_m4m5_noshield c_width=25u c_length=4u
X465 Y a_7876_80992# VSS ppolyf_u_1k r_width=1u r_length=2u
X466 a_31070_66968# a_33742_71368# VDD VDD pfet_06v0 ad=1.3p pd=5.52u as=2.2p ps=10.88u w=5u l=1u
X467 a_25394_70322# a_25694_70322# a_28630_70438# VDD pfet_06v0 ad=4.4p pd=20.88u as=2.5p ps=10.5u w=10u l=1u
X468 a_9442_61632# a_10110_58232# VSS VSS nfet_06v0 ad=0.65p pd=3.02u as=0.65p ps=3.02u w=2.5u l=1u
X469 VDD a_56814_71368# a_55254_66968# VDD pfet_06v0 ad=1.3p pd=5.52u as=1.3p ps=5.52u w=5u l=1u
X470 a_3244_9202# a_6386_4736# a_7674_4780# VSS nfet_06v0 ad=1.1p pd=5.88u as=0.825p ps=3.16u w=2.5u l=1u
X471 a_10110_66968# a_16044_71322# a_10558_71368# VDD pfet_06v0 ad=2.2p pd=10.88u as=2.2p ps=10.88u w=5u l=1u
X472 VSS VDD VSS VSS nfet_06v0 ad=7.92p pd=36.88u as=0 ps=0 w=18u l=2u
X473 VSS VDD VSS VSS nfet_06v0 ad=4.29p pd=20.38u as=0 ps=0 w=9.75u l=2u
X474 a_8798_49492# a_23852_21186# VDD VDD pfet_06v0 ad=0.22p pd=1.88u as=0.22p ps=1.88u w=0.5u l=1u
X475 a_7886_49608# a_10558_54008# VDD VDD pfet_06v0 ad=1.3p pd=5.52u as=1.3p ps=5.52u w=5u l=1u
X476 a_56366_66968# a_62300_71322# a_56814_71368# VDD pfet_06v0 ad=2.2p pd=10.88u as=2.2p ps=10.88u w=5u l=1u
X477 a_25774_28748# a_26812_36450# VDD VDD pfet_06v0 ad=1.65p pd=5.66u as=2.2p ps=10.88u w=5u l=1u
X478 a_3402_16764# a_2170_16720# VSS VSS nfet_06v0 ad=1.25p pd=5.5u as=2.2p ps=10.88u w=5u l=1u
X479 a_71560_41272# a_73010_41156# VSS VSS nfet_06v0 ad=0.5456p pd=3.36u as=0.5456p ps=3.36u w=1.24u l=1u
X480 a_75590_4780# a_64446_11482# VSS VSS nfet_06v0 ad=0.25p pd=1.5u as=0.44p ps=2.88u w=1u l=1u
X481 a_8998_66968# a_10558_71368# VDD VDD pfet_06v0 ad=1.3p pd=5.52u as=2.2p ps=10.88u w=5u l=1u
X482 a_33742_71368# a_25694_70322# a_32182_66968# VDD pfet_06v0 ad=1.3p pd=5.52u as=2.2p ps=10.88u w=5u l=1u
X483 VSS a_57478_49608# a_30954_81052# VSS nfet_06v0 ad=1.3p pd=5.52u as=1.3p ps=5.52u w=5u l=1u
X484 a_63948_44226# a_48766_44226# a_64148_44342# VDD pfet_06v0 ad=3.3p pd=10.66u as=2.5p ps=10.5u w=10u l=1u
X485 a_49002_28748# a_43798_28704# a_45962_37346# VSS nfet_06v0 ad=0.825p pd=3.16u as=0.825p ps=3.16u w=2.5u l=1u
X486 a_18094_66854# a_2170_66854# a_18294_66898# VSS nfet_06v0 ad=1.65p pd=5.66u as=1.25p ps=5.5u w=5u l=1u
X487 a_30066_44342# a_8798_40756# a_32626_44272# VDD pfet_06v0 ad=4.4p pd=20.88u as=2.6p ps=10.52u w=10u l=1u
X488 a_64350_66854# a_48426_66854# a_64550_66898# VSS nfet_06v0 ad=1.65p pd=5.66u as=1.25p ps=5.5u w=5u l=1u
X489 VSS a_19658_66968# a_55046_81096# VSS nfet_06v0 ad=0.44p pd=2.88u as=0.25p ps=1.5u w=1u l=1u
X490 a_43798_28704# a_43798_28704# VSS VSS nfet_06v0 ad=0.44p pd=2.88u as=0.44p ps=2.88u w=1u l=1u
X491 a_41076_44342# a_40876_44226# VDD VDD pfet_06v0 ad=2.5p pd=10.5u as=4.4p ps=20.88u w=10u l=1u
X492 VDD VSS VDD VDD pfet_06v0 ad=0.88p pd=4.88u as=0 ps=0 w=2u l=2u
X493 a_28630_61702# a_25394_61586# VDD VDD pfet_06v0 ad=2.5p pd=10.5u as=4.4p ps=20.88u w=10u l=1u
X494 a_5166_49538# a_2510_52962# VSS VSS nfet_06v0 ad=0.25p pd=1.5u as=0.44p ps=2.88u w=1u l=1u
X495 a_2370_16764# a_2170_16720# VSS VSS nfet_06v0 ad=1.25p pd=5.5u as=2.2p ps=10.88u w=5u l=1u
X496 a_10110_58232# a_2170_58118# a_9442_61632# VSS nfet_06v0 ad=0.65p pd=3.02u as=1.1p ps=5.88u w=2.5u l=1u
D8 Z VDD diode_pd2nw_06v0 pj=30u area=50p
X497 a_54582_70368# a_50554_81052# cap_mim_2f0_m4m5_noshield c_width=20u c_length=10u
X498 a_64406_4736# a_64406_4736# VSS VSS nfet_06v0 ad=0.44p pd=2.88u as=0.44p ps=2.88u w=1u l=1u
X499 a_25242_25362# a_26330_16720# VSS VSS nfet_06v0 ad=0.825p pd=3.16u as=1.1p ps=5.88u w=2.5u l=1u
X500 a_5446_25382# a_5722_16720# VSS VSS nfet_06v0 ad=0.825p pd=3.16u as=1.1p ps=5.88u w=2.5u l=1u
X501 VSS a_56366_40872# a_55698_44272# VSS nfet_06v0 ad=1.1p pd=5.88u as=0.65p ps=3.02u w=2.5u l=1u
X502 X a_71650_44468# VSS ppolyf_u_1k r_width=1u r_length=2u
X503 a_2410_23582# a_2210_23466# VDD VDD pfet_06v0 ad=2.5p pd=10.5u as=4.4p ps=20.88u w=10u l=1u
X504 a_8798_58116# a_3244_33170# VDD VDD pfet_06v0 ad=0.22p pd=1.88u as=0.22p ps=1.88u w=0.5u l=1u
X505 a_5166_28748# a_6204_36450# VDD VDD pfet_06v0 ad=1.65p pd=5.66u as=2.2p ps=10.88u w=5u l=1u
X506 a_41030_81052# a_34858_62632# VDD VDD pfet_06v0 ad=4.4p pd=20.88u as=2.6p ps=10.52u w=10u l=1u
X507 a_66370_4780# a_4234_4736# a_64606_4780# VSS nfet_06v0 ad=0.44p pd=2.88u as=0.44p ps=2.88u w=1u l=1u
X508 a_71560_50008# a_73010_49892# VSS VSS nfet_06v0 ad=0.5456p pd=3.36u as=0.5456p ps=3.36u w=1.24u l=1u
X509 a_15232_23582# a_2210_23466# VDD VDD pfet_06v0 ad=2.5p pd=10.5u as=4.4p ps=20.88u w=10u l=1u
X510 a_71560_42480# a_54026_81096# a_71650_44468# VSS nfet_06v0 ad=1.0912p pd=5.84u as=0.6448p ps=3u w=2.48u l=1u
X511 a_54582_44272# a_56366_40872# VSS VSS nfet_06v0 ad=0.65p pd=3.02u as=0.65p ps=3.02u w=2.5u l=1u
X512 VSS VDD VSS VSS nfet_06v0 ad=4.29p pd=20.38u as=0 ps=0 w=9.75u l=2u
X513 a_2510_11482# a_2510_11482# a_14686_4780# VSS nfet_06v0 ad=0.44p pd=2.88u as=0.25p ps=1.5u w=1u l=1u
X514 a_30870_66852# a_44572_33170# VDD VDD pfet_06v0 ad=0.22p pd=1.88u as=0.22p ps=1.88u w=0.5u l=1u
X515 a_2170_4736# a_2470_4736# a_12622_4780# VSS nfet_06v0 ad=2.2p pd=10.88u as=1.25p ps=5.5u w=5u l=1u
X516 a_63494_58162# a_49158_58118# VSS VSS nfet_06v0 ad=1.25p pd=5.5u as=2.2p ps=10.88u w=5u l=1u
X517 a_2902_66854# a_2170_66854# a_3102_66898# VSS nfet_06v0 ad=2.2p pd=10.88u as=1.25p ps=5.5u w=5u l=1u
X518 a_52778_58162# a_30870_58116# a_54142_58232# VSS nfet_06v0 ad=2.2p pd=10.88u as=1.3p ps=5.52u w=5u l=1u
X519 a_54582_44272# a_21210_81052# cap_mim_2f0_m4m5_noshield c_width=20u c_length=10u
X520 a_9442_44272# a_10110_40872# VSS VSS nfet_06v0 ad=0.65p pd=3.02u as=0.65p ps=3.02u w=2.5u l=1u
X521 a_44038_35566# a_43838_35450# a_44850_35566# VDD pfet_06v0 ad=4.4p pd=20.88u as=2.5p ps=10.5u w=10u l=1u
X522 a_30066_53078# a_8798_49492# a_32626_53008# VDD pfet_06v0 ad=4.4p pd=20.88u as=2.6p ps=10.52u w=10u l=1u
X523 VSS a_41030_81052# a_40650_82772# VSS nfet_06v0 ad=0.44p pd=2.88u as=0.33p ps=1.66u w=1u l=1u
X524 VDD VSS VDD VDD pfet_06v0 ad=0.88p pd=4.88u as=0 ps=0 w=2u l=2u
X525 a_23852_34520# a_39270_34070# VSS ppolyf_u_1k r_width=1u r_length=76.45u
X526 a_30870_40756# a_23852_9202# VDD VDD pfet_06v0 ad=0.22p pd=1.88u as=0.22p ps=1.88u w=0.5u l=1u
X527 VDD VSS VDD VDD pfet_06v0 ad=0.88p pd=4.88u as=0 ps=0 w=2u l=2u
X528 a_73010_41156# a_73010_41156# a_75274_41272# VSS nfet_06v0 ad=0.308p pd=2.28u as=0.175p ps=1.2u w=0.7u l=1u
X529 a_69610_16764# a_64406_16720# a_66570_25362# VSS nfet_06v0 ad=0.825p pd=3.16u as=0.825p ps=3.16u w=2.5u l=1u
X530 a_9228_35450# a_2510_35450# a_9428_35566# VDD pfet_06v0 ad=3.3p pd=10.66u as=2.5p ps=10.5u w=10u l=1u
X531 a_56560_11598# a_43538_11482# VDD VDD pfet_06v0 ad=2.5p pd=10.5u as=4.4p ps=20.88u w=10u l=1u
X532 VDD VSS VDD VDD pfet_06v0 ad=0.66p pd=3.88u as=0 ps=0 w=1.5u l=2u
X533 a_64606_4780# a_64406_4736# a_64306_4780# VSS nfet_06v0 ad=2.2p pd=10.88u as=1.25p ps=5.5u w=5u l=1u
X534 VDD a_42842_66968# a_54114_81052# VDD pfet_06v0 ad=1.32p pd=6.88u as=0.99p ps=3.66u w=3u l=1u
X535 a_2210_70322# a_2510_70322# a_5446_70438# VDD pfet_06v0 ad=4.4p pd=20.88u as=2.5p ps=10.5u w=10u l=1u
X536 a_31070_66968# a_33742_71368# VDD VDD pfet_06v0 ad=1.3p pd=5.52u as=1.3p ps=5.52u w=5u l=1u
X537 a_4634_25362# a_5722_16720# VSS VSS nfet_06v0 ad=0.825p pd=3.16u as=1.1p ps=5.88u w=2.5u l=1u
X538 a_2170_66854# a_2170_66854# VSS VSS nfet_06v0 ad=0.44p pd=2.88u as=0.44p ps=2.88u w=1u l=1u
X539 a_47714_28704# a_43838_35450# a_52200_35566# VDD pfet_06v0 ad=4.4p pd=20.88u as=2.5p ps=10.5u w=10u l=1u
X540 a_75916_42410# a_71650_44468# VSS VSS nfet_06v0 ad=0.5p pd=2.5u as=0.88p ps=4.88u w=2u l=1u
X541 a_23852_33620# a_39270_34070# VSS ppolyf_u_1k r_width=1u r_length=76.45u
X542 YN YP VDD VDD pfet_05v0 ad=0.8052p pd=4.54u as=0.8052p ps=4.54u w=1.83u l=0.5u
X543 a_26054_37366# a_4966_16720# a_23318_35566# VDD pfet_06v0 ad=0.44p pd=2.88u as=0.44p ps=2.88u w=1u l=1u
X544 a_71560_51216# a_52262_81096# a_7876_80992# VSS nfet_06v0 ad=1.0912p pd=5.84u as=0.6448p ps=3u w=2.48u l=1u
X545 VSS a_26086_66854# a_30038_66898# VSS nfet_06v0 ad=2.2p pd=10.88u as=1.25p ps=5.5u w=5u l=1u
X546 VSS VDD VSS VSS nfet_06v0 ad=0.88p pd=4.88u as=0 ps=0 w=2u l=2u
X547 a_64146_11482# a_64446_11482# a_80204_11598# VDD pfet_06v0 ad=4.4p pd=20.88u as=2.5p ps=10.5u w=10u l=1u
X548 a_7686_49492# a_69610_4780# VSS VSS nfet_06v0 ad=0.44p pd=2.88u as=0.44p ps=2.88u w=1u l=1u
X549 a_71560_42480# a_73010_41156# VSS VSS nfet_06v0 ad=0.5456p pd=3.36u as=0.5456p ps=3.36u w=1.24u l=1u
X550 a_21450_82772# a_21210_81052# a_21162_82772# VDD pfet_06v0 ad=0.75p pd=3.5u as=1.32p ps=6.88u w=3u l=1u
X551 a_68804_24466# a_68804_24466# a_71164_23466# VDD pfet_06v0 ad=4.4p pd=20.88u as=3.3p ps=10.66u w=10u l=1u
X552 a_66370_16764# a_68140_24466# VDD VDD pfet_06v0 ad=1.65p pd=5.66u as=2.2p ps=10.88u w=5u l=1u
X553 VDD a_2210_52962# a_7214_53078# VDD pfet_06v0 ad=4.4p pd=20.88u as=2.5p ps=10.5u w=10u l=1u
X554 S2N a_4966_4736# VSS ppolyf_u_1k r_width=1u r_length=2u
X555 a_10110_40872# a_2170_40758# a_9442_44272# VSS nfet_06v0 ad=0.65p pd=3.02u as=1.1p ps=5.88u w=2.5u l=1u
X556 a_7886_66968# a_7686_66852# a_6522_66898# VSS nfet_06v0 ad=1.3p pd=5.52u as=2.2p ps=10.88u w=5u l=1u
X557 a_3244_34520# a_18662_34070# VSS ppolyf_u_1k r_width=1u r_length=76.45u
X558 a_8326_61632# a_10110_58232# VSS VSS nfet_06v0 ad=0.65p pd=3.02u as=1.1p ps=5.88u w=2.5u l=1u
X559 a_23852_21186# a_26994_16720# a_28282_16764# VSS nfet_06v0 ad=1.1p pd=5.88u as=0.825p ps=3.16u w=2.5u l=1u
X560 a_23078_28704# a_23118_35450# a_35840_35566# VDD pfet_06v0 ad=4.4p pd=20.88u as=2.5p ps=10.5u w=10u l=1u
X561 a_25354_49494# a_25694_52962# a_25594_53078# VDD pfet_06v0 ad=4.4p pd=20.88u as=2.5p ps=10.5u w=10u l=1u
X562 a_25354_58118# a_25354_58118# VSS VSS nfet_06v0 ad=0.44p pd=2.88u as=0.44p ps=2.88u w=1u l=1u
X563 a_29346_28748# a_22778_28704# VSS VSS nfet_06v0 ad=1.25p pd=5.5u as=2.2p ps=10.88u w=5u l=1u
X564 a_30870_58116# a_65180_21186# VDD VDD pfet_06v0 ad=0.22p pd=1.88u as=0.22p ps=1.88u w=0.5u l=1u
X565 a_68322_4736# a_64446_11482# a_72808_11598# VDD pfet_06v0 ad=4.4p pd=20.88u as=2.5p ps=10.5u w=10u l=1u
X566 a_73010_49892# a_73010_49892# a_75274_50008# VSS nfet_06v0 ad=0.308p pd=2.28u as=0.175p ps=1.2u w=0.7u l=1u
X567 a_45962_13378# a_7876_75392# a_44038_11598# VDD pfet_06v0 ad=0.484p pd=3.08u as=0.484p ps=3.08u w=1.1u l=1u
X568 a_5722_4736# a_2470_4736# a_5446_13398# VSS nfet_06v0 ad=0.825p pd=3.16u as=0.825p ps=3.16u w=2.5u l=1u
X569 a_24130_23582# a_22818_23466# VDD VDD pfet_06v0 ad=2.5p pd=10.5u as=4.4p ps=20.88u w=10u l=1u
X570 a_43738_11598# a_43538_11482# VDD VDD pfet_06v0 ad=2.5p pd=10.5u as=4.4p ps=20.88u w=10u l=1u
X571 a_55254_49608# a_7686_49492# a_52778_49538# VSS nfet_06v0 ad=1.3p pd=5.52u as=2.2p ps=10.88u w=5u l=1u
X572 S3P a_4234_28704# VSS ppolyf_u_1k r_width=1u r_length=2u
X573 a_5446_61702# a_2210_61586# VDD VDD pfet_06v0 ad=2.5p pd=10.5u as=4.4p ps=20.88u w=10u l=1u
X574 a_28282_4780# a_27476_12482# a_23852_9202# VDD pfet_06v0 ad=2.2p pd=10.88u as=1.65p ps=5.66u w=5u l=1u
X575 a_15574_49494# a_15574_49494# a_18094_49494# VSS nfet_06v0 ad=2.2p pd=10.88u as=1.65p ps=5.66u w=5u l=1u
X576 Z a_17396_80992# VSS ppolyf_u_1k r_width=1u r_length=2u
X577 VDD VSS VDD VDD pfet_06v0 ad=7.92p pd=36.88u as=0 ps=0 w=18u l=2u
X578 a_43838_35450# a_43838_35450# a_56014_28748# VSS nfet_06v0 ad=0.44p pd=2.88u as=0.25p ps=1.5u w=1u l=1u
X579 a_23852_21186# a_23118_23466# a_25042_16764# VDD pfet_06v0 ad=1.65p pd=5.66u as=1.65p ps=5.66u w=5u l=1u
X580 a_3244_33620# a_18662_34070# VSS ppolyf_u_1k r_width=1u r_length=76.45u
X581 a_5446_37366# a_4966_28704# a_2710_35566# VDD pfet_06v0 ad=0.44p pd=2.88u as=0.44p ps=2.88u w=1u l=1u
X582 a_18268_11598# a_2210_11482# VDD VDD pfet_06v0 ad=2.5p pd=10.5u as=4.4p ps=20.88u w=10u l=1u
X583 a_52778_40802# a_30870_40756# a_54142_40872# VSS nfet_06v0 ad=2.2p pd=10.88u as=1.3p ps=5.52u w=5u l=1u
X584 VDD VSS VDD VDD pfet_06v0 ad=7.92p pd=36.88u as=0 ps=0 w=18u l=2u
X585 VDD VSS VDD VDD pfet_06v0 ad=4.29p pd=20.38u as=0 ps=0 w=9.75u l=2u
X586 a_7686_66852# a_23852_33170# VDD VDD pfet_06v0 ad=0.22p pd=1.88u as=0.22p ps=1.88u w=0.5u l=1u
X587 a_71560_51216# a_73010_49892# VSS VSS nfet_06v0 ad=0.5456p pd=3.36u as=0.5456p ps=3.36u w=1.24u l=1u
X588 VDD a_33742_62632# a_31070_58232# VDD pfet_06v0 ad=2.2p pd=10.88u as=1.3p ps=5.52u w=5u l=1u
X589 S2P a_4234_4736# VSS ppolyf_u_1k r_width=1u r_length=2u
X590 a_2170_16720# a_2470_16720# a_12622_16764# VSS nfet_06v0 ad=2.2p pd=10.88u as=1.25p ps=5.5u w=5u l=1u
X591 a_7214_44342# a_2510_44226# a_6882_44342# VDD pfet_06v0 ad=2.5p pd=10.5u as=3.3p ps=10.66u w=10u l=1u
X592 VDD a_56814_71368# a_55254_66968# VDD pfet_06v0 ad=2.2p pd=10.88u as=1.3p ps=5.52u w=5u l=1u
X593 VSS VDD VSS VSS nfet_06v0 ad=4.29p pd=20.38u as=0 ps=0 w=9.75u l=2u
X594 a_13654_28748# a_2510_35450# VSS VSS nfet_06v0 ad=0.25p pd=1.5u as=0.44p ps=2.88u w=1u l=1u
X595 a_4134_66898# a_2510_70322# VSS VSS nfet_06v0 ad=0.25p pd=1.5u as=0.44p ps=2.88u w=1u l=1u
X596 a_25594_44342# a_25394_44226# VDD VDD pfet_06v0 ad=2.5p pd=10.5u as=4.4p ps=20.88u w=10u l=1u
X597 a_46774_25382# a_47050_16720# VSS VSS nfet_06v0 ad=0.825p pd=3.16u as=1.1p ps=5.88u w=2.5u l=1u
X598 a_43538_35450# a_43838_35450# a_54982_28748# VSS nfet_06v0 ad=0.44p pd=2.88u as=0.25p ps=1.5u w=1u l=1u
X599 a_68804_12482# a_64406_4736# a_70674_4780# VSS nfet_06v0 ad=2.2p pd=10.88u as=1.25p ps=5.5u w=5u l=1u
X600 VSS VDD VSS VSS nfet_06v0 ad=0.88p pd=4.88u as=0 ps=0 w=2u l=2u
X601 a_65180_9202# a_64446_11482# a_66370_4780# VDD pfet_06v0 ad=1.65p pd=5.66u as=1.65p ps=5.66u w=5u l=1u
X602 VSS a_19658_58232# a_41674_81096# VSS nfet_06v0 ad=0.44p pd=2.88u as=0.44p ps=2.88u w=1u l=1u
X603 a_52778_66898# a_48426_66854# a_52478_66898# VSS nfet_06v0 ad=1.65p pd=5.66u as=1.25p ps=5.5u w=5u l=1u
X604 a_3522_23582# a_2210_23466# VDD VDD pfet_06v0 ad=2.5p pd=10.5u as=4.4p ps=20.88u w=10u l=1u
D9 S3P VDD diode_pd2nw_06v0 pj=30u area=50p
X605 a_57478_58232# a_62300_62586# a_57930_62632# VDD pfet_06v0 ad=2.2p pd=10.88u as=2.2p ps=10.88u w=5u l=1u
X606 a_19336_53078# a_2210_52962# VDD VDD pfet_06v0 ad=2.5p pd=10.5u as=4.4p ps=20.88u w=10u l=1u
X607 a_43498_4736# a_43798_4736# a_53950_4780# VSS nfet_06v0 ad=2.2p pd=10.88u as=1.25p ps=5.5u w=5u l=1u
X608 a_16344_23582# a_2210_23466# VDD VDD pfet_06v0 ad=2.5p pd=10.5u as=4.4p ps=20.88u w=10u l=1u
X609 VDD a_56814_45272# a_54142_40872# VDD pfet_06v0 ad=2.2p pd=10.88u as=1.3p ps=5.52u w=5u l=1u
X610 a_42494_81052# a_40698_81052# VDD VDD pfet_06v0 ad=0.99p pd=3.66u as=1.32p ps=6.88u w=3u l=1u
X611 a_2470_16720# a_2470_16720# VSS VSS nfet_06v0 ad=0.44p pd=2.88u as=0.44p ps=2.88u w=1u l=1u
X612 a_24010_28748# a_22778_28704# VSS VSS nfet_06v0 ad=1.25p pd=5.5u as=2.2p ps=10.88u w=5u l=1u
X613 VSS VDD VSS VSS nfet_06v0 ad=7.92p pd=36.88u as=0 ps=0 w=18u l=2u
X614 a_26994_4736# a_23118_11482# a_31480_11598# VDD pfet_06v0 ad=4.4p pd=20.88u as=2.5p ps=10.5u w=10u l=1u
X615 a_52778_58162# a_7686_58116# a_55254_58232# VSS nfet_06v0 ad=2.2p pd=10.88u as=1.3p ps=5.52u w=5u l=1u
X616 a_55698_70368# a_48426_66854# a_56366_66968# VSS nfet_06v0 ad=1.1p pd=5.88u as=0.65p ps=3.02u w=2.5u l=1u
X617 a_23118_11482# a_23118_11482# a_35294_4780# VSS nfet_06v0 ad=0.44p pd=2.88u as=0.25p ps=1.5u w=1u l=1u
X618 a_8326_44272# a_10110_40872# VSS VSS nfet_06v0 ad=0.65p pd=3.02u as=1.1p ps=5.88u w=2.5u l=1u
X619 a_22778_4736# a_23078_4736# a_33230_4780# VSS nfet_06v0 ad=2.2p pd=10.88u as=1.25p ps=5.5u w=5u l=1u
X620 S4N a_4966_16720# VSS ppolyf_u_1k r_width=1u r_length=2u
X621 a_74894_62048# a_17396_80992# VDD VDD pfet_05v0 ad=0.8052p pd=4.54u as=0.8052p ps=4.54u w=1.83u l=0.5u
X622 a_74558_16764# a_64106_16720# VSS VSS nfet_06v0 ad=1.25p pd=5.5u as=2.2p ps=10.88u w=5u l=1u
D10 Y VDD diode_pd2nw_06v0 pj=30u area=50p
X623 a_49158_58118# a_48426_58118# a_49358_58162# VSS nfet_06v0 ad=2.2p pd=10.88u as=1.25p ps=5.5u w=5u l=1u
X624 VDD a_31286_81052# a_31194_82772# VDD pfet_06v0 ad=1.32p pd=6.88u as=0.75p ps=3.5u w=3u l=1u
X625 VDD VSS VDD VDD pfet_06v0 ad=0.66p pd=3.88u as=0 ps=0 w=1.5u l=2u
X626 VSS VDD VSS VSS nfet_06v0 ad=0.66p pd=3.88u as=0 ps=0 w=1.5u l=2u
X627 a_30398_70438# a_25694_70322# a_30066_70438# VDD pfet_06v0 ad=2.5p pd=10.5u as=3.3p ps=10.66u w=10u l=1u
X628 a_18294_58162# a_18094_58118# VSS VSS nfet_06v0 ad=1.25p pd=5.5u as=2.2p ps=10.88u w=5u l=1u
X629 a_6882_61702# a_8798_58116# a_9442_61632# VDD pfet_06v0 ad=4.4p pd=20.88u as=2.6p ps=10.52u w=10u l=1u
X630 a_31510_70368# a_25354_66854# a_34406_66968# VSS nfet_06v0 ad=1.1p pd=5.88u as=0.65p ps=3.02u w=2.5u l=1u
X631 a_19658_58232# a_11222_58232# VSS VSS nfet_06v0 ad=1.3p pd=5.52u as=2.2p ps=10.88u w=5u l=1u
X632 a_48766_52962# a_48766_52962# VDD VDD pfet_06v0 ad=0.88p pd=4.88u as=0.88p ps=4.88u w=2u l=1u
X633 VSS VDD VSS VSS nfet_06v0 ad=0.88p pd=4.88u as=0 ps=0 w=2u l=2u
X634 a_57672_11598# a_43538_11482# VDD VDD pfet_06v0 ad=2.5p pd=10.5u as=4.4p ps=20.88u w=10u l=1u
X635 a_51702_70438# a_48466_70322# VDD VDD pfet_06v0 ad=2.5p pd=10.5u as=4.4p ps=20.88u w=10u l=1u
X636 a_64550_58162# a_64350_58118# VSS VSS nfet_06v0 ad=1.25p pd=5.5u as=2.2p ps=10.88u w=5u l=1u
X637 a_39228_71322# a_39228_71322# a_40876_70322# VDD pfet_06v0 ad=4.4p pd=20.88u as=3.3p ps=10.66u w=10u l=1u
X638 a_40698_81052# a_57478_58232# VSS VSS nfet_06v0 ad=1.3p pd=5.52u as=2.2p ps=10.88u w=5u l=1u
X639 VSS VDD VSS VSS nfet_06v0 ad=0.88p pd=4.88u as=0 ps=0 w=2u l=2u
X640 a_34858_45272# a_38758_40758# a_34406_40872# VSS nfet_06v0 ad=1.1p pd=5.88u as=1.1p ps=5.88u w=2.5u l=1u
X641 a_7686_66852# a_23852_33170# VDD VDD pfet_06v0 ad=0.22p pd=1.88u as=0.22p ps=1.88u w=0.5u l=1u
X642 a_44572_10552# a_59990_10102# VSS ppolyf_u_1k r_width=1u r_length=76.45u
X643 a_3402_28748# a_2170_28704# VSS VSS nfet_06v0 ad=1.25p pd=5.5u as=2.2p ps=10.88u w=5u l=1u
X644 a_25694_61586# a_25694_61586# a_28350_58162# VSS nfet_06v0 ad=0.44p pd=2.88u as=0.25p ps=1.5u w=1u l=1u
X645 VDD a_56814_71368# a_54142_66968# VDD pfet_06v0 ad=1.3p pd=5.52u as=1.3p ps=5.52u w=5u l=1u
X646 a_6854_49538# a_2170_49494# a_6522_49538# VSS nfet_06v0 ad=1.25p pd=5.5u as=1.65p ps=5.66u w=5u l=1u
X647 VDD a_56814_54008# a_54142_49608# VDD pfet_06v0 ad=2.2p pd=10.88u as=1.3p ps=5.52u w=5u l=1u
X648 a_40876_61586# a_25694_61586# a_41076_61702# VDD pfet_06v0 ad=3.3p pd=10.66u as=2.5p ps=10.5u w=10u l=1u
D11 S2P VDD diode_pd2nw_06v0 pj=30u area=50p
X649 a_34262_16764# a_23118_23466# VSS VSS nfet_06v0 ad=0.25p pd=1.5u as=0.44p ps=2.88u w=1u l=1u
X650 a_16044_62586# a_2170_58118# a_17238_58162# VSS nfet_06v0 ad=2.2p pd=10.88u as=1.25p ps=5.5u w=5u l=1u
X651 a_23278_4780# a_23078_4736# a_24010_4780# VSS nfet_06v0 ad=2.2p pd=10.88u as=1.25p ps=5.5u w=5u l=1u
X652 a_8998_66968# a_8798_66852# a_6522_66898# VSS nfet_06v0 ad=1.3p pd=5.52u as=2.2p ps=10.88u w=5u l=1u
X653 a_65180_9202# a_80598_9202# VSS ppolyf_u_1k r_width=1u r_length=76.45u
X654 VDD VSS VDD VDD pfet_06v0 ad=7.92p pd=36.88u as=0 ps=0 w=18u l=2u
X655 VSS a_2902_40758# a_6854_40802# VSS nfet_06v0 ad=2.2p pd=10.88u as=1.25p ps=5.5u w=5u l=1u
X656 VDD a_25394_44226# a_30398_44342# VDD pfet_06v0 ad=4.4p pd=20.88u as=2.5p ps=10.5u w=10u l=1u
X657 a_9442_44272# a_8798_40756# a_6882_44342# VDD pfet_06v0 ad=2.6p pd=10.52u as=4.4p ps=20.88u w=10u l=1u
X658 a_8998_66968# a_2510_70322# a_10558_71368# VDD pfet_06v0 ad=2.2p pd=10.88u as=1.3p ps=5.52u w=5u l=1u
X659 a_48466_44226# a_48766_44226# a_51702_44342# VDD pfet_06v0 ad=4.4p pd=20.88u as=2.5p ps=10.5u w=10u l=1u
X660 VSS VDD VSS VSS nfet_06v0 ad=7.92p pd=36.88u as=0 ps=0 w=18u l=2u
X661 a_42406_81096# a_42494_81052# VDD VDD pfet_06v0 ad=1.32p pd=6.88u as=1.32p ps=6.88u w=3u l=1u
X662 a_2370_28748# a_2170_28704# VSS VSS nfet_06v0 ad=1.25p pd=5.5u as=2.2p ps=10.88u w=5u l=1u
D12 S4P VDD diode_pd2nw_06v0 pj=30u area=50p
X663 a_8738_16764# a_2170_16720# VSS VSS nfet_06v0 ad=1.25p pd=5.5u as=2.2p ps=10.88u w=5u l=1u
X664 a_56366_49608# a_48426_49494# a_55698_53008# VSS nfet_06v0 ad=0.65p pd=3.02u as=1.1p ps=5.88u w=2.5u l=1u
X665 S1P a_7876_75392# VSS ppolyf_u_1k r_width=1u r_length=2u
X666 VDD VSS VDD VDD pfet_06v0 ad=4.29p pd=20.38u as=0 ps=0 w=9.75u l=2u
X667 VSS VDD VSS VSS nfet_06v0 ad=0.66p pd=3.88u as=0 ps=0 w=1.5u l=2u
X668 a_46494_16764# a_47532_24466# VDD VDD pfet_06v0 ad=1.65p pd=5.66u as=2.2p ps=10.88u w=5u l=1u
X669 a_48766_70322# a_48766_70322# a_51422_66898# VSS nfet_06v0 ad=0.44p pd=2.88u as=0.25p ps=1.5u w=1u l=1u
X670 a_25242_37346# a_26330_28704# VSS VSS nfet_06v0 ad=0.825p pd=3.16u as=1.1p ps=5.88u w=2.5u l=1u
X671 a_5446_37366# a_5722_28704# VSS VSS nfet_06v0 ad=0.825p pd=3.16u as=1.1p ps=5.88u w=2.5u l=1u
X672 a_10558_45272# a_2510_44226# a_8998_40872# VDD pfet_06v0 ad=1.3p pd=5.52u as=2.2p ps=10.88u w=5u l=1u
X673 a_52778_40802# a_7686_40756# a_55254_40872# VSS nfet_06v0 ad=2.2p pd=10.88u as=1.3p ps=5.52u w=5u l=1u
X674 a_2410_35566# a_2210_35450# VDD VDD pfet_06v0 ad=2.5p pd=10.5u as=4.4p ps=20.88u w=10u l=1u
X675 a_8798_40756# a_45762_4780# cap_mim_2f0_m4m5_noshield c_width=25u c_length=4u
X676 a_57930_62632# a_61830_58118# a_57478_58232# VSS nfet_06v0 ad=1.1p pd=5.88u as=1.1p ps=5.88u w=2.5u l=1u
X677 VSS a_50554_81052# a_53282_81096# VSS nfet_06v0 ad=0.44p pd=2.88u as=0.25p ps=1.5u w=1u l=1u
X678 a_19658_58232# a_7886_58232# cap_mim_2f0_m4m5_noshield c_width=20u c_length=10u
X679 a_34406_49608# a_25354_49494# a_31510_53008# VSS nfet_06v0 ad=0.65p pd=3.02u as=1.1p ps=5.88u w=2.5u l=1u
X680 a_15232_35566# a_2210_35450# VDD VDD pfet_06v0 ad=2.5p pd=10.5u as=4.4p ps=20.88u w=10u l=1u
X681 VDD VSS VDD VDD pfet_06v0 ad=0.66p pd=3.88u as=0 ps=0 w=1.5u l=2u
X682 a_47714_4736# a_47714_4736# a_50922_4736# VSS nfet_06v0 ad=2.2p pd=10.88u as=1.65p ps=5.66u w=5u l=1u
X683 a_6868_24466# a_6868_24466# a_9228_23466# VDD pfet_06v0 ad=4.4p pd=20.88u as=3.3p ps=10.66u w=10u l=1u
X684 a_53138_70438# a_7686_66852# a_55698_70368# VDD pfet_06v0 ad=4.4p pd=20.88u as=2.6p ps=10.52u w=10u l=1u
X685 a_19658_40872# a_11222_40872# VSS VSS nfet_06v0 ad=1.3p pd=5.52u as=2.2p ps=10.88u w=5u l=1u
X686 a_30066_61702# a_25694_61586# a_29766_61702# VDD pfet_06v0 ad=3.3p pd=10.66u as=2.5p ps=10.5u w=10u l=1u
X687 a_9442_53008# a_8798_49492# a_6882_53078# VDD pfet_06v0 ad=2.6p pd=10.52u as=4.4p ps=20.88u w=10u l=1u
X688 a_64148_70438# a_63948_70322# VDD VDD pfet_06v0 ad=2.5p pd=10.5u as=4.4p ps=20.88u w=10u l=1u
X689 a_26994_4736# a_26994_4736# a_30202_4736# VSS nfet_06v0 ad=2.2p pd=10.88u as=1.65p ps=5.66u w=5u l=1u
X690 a_21210_81052# a_57478_40872# VSS VSS nfet_06v0 ad=1.3p pd=5.52u as=2.2p ps=10.88u w=5u l=1u
X691 a_40938_82772# a_40698_81052# a_40650_82772# VDD pfet_06v0 ad=0.75p pd=3.5u as=1.32p ps=6.88u w=3u l=1u
X692 a_48466_70322# a_48766_70322# a_50390_66898# VSS nfet_06v0 ad=0.44p pd=2.88u as=0.25p ps=1.5u w=1u l=1u
X693 VDD a_34858_71368# a_42842_66968# VDD pfet_06v0 ad=2.6p pd=10.52u as=2.6p ps=10.52u w=10u l=1u
D13 S1P VDD diode_pd2nw_06v0 pj=30u area=50p
X694 a_25694_61586# a_25694_61586# VDD VDD pfet_06v0 ad=0.88p pd=4.88u as=0.88p ps=4.88u w=2u l=1u
X695 a_54582_61632# a_40698_81052# cap_mim_2f0_m4m5_noshield c_width=20u c_length=10u
X696 a_69610_28748# a_64406_28704# a_66570_37346# VSS nfet_06v0 ad=0.825p pd=3.16u as=0.825p ps=3.16u w=2.5u l=1u
X697 VSS VDD VSS VSS nfet_06v0 ad=7.92p pd=36.88u as=0 ps=0 w=18u l=2u
X698 a_4634_37346# a_5722_28704# VSS VSS nfet_06v0 ad=0.825p pd=3.16u as=1.1p ps=5.88u w=2.5u l=1u
X699 a_17396_80992# a_17396_80992# VDD VDD pfet_06v0 ad=0.52p pd=2.52u as=0.52p ps=2.52u w=2u l=1u
X700 S1N a_25574_16720# VSS ppolyf_u_1k r_width=1u r_length=2u
X701 a_10558_54008# a_2510_52962# a_8998_49608# VDD pfet_06v0 ad=1.3p pd=5.52u as=2.2p ps=10.88u w=5u l=1u
X702 VSS VDD VSS VSS nfet_06v0 ad=0.88p pd=4.88u as=0 ps=0 w=2u l=2u
X703 a_23118_11482# a_23118_11482# VDD VDD pfet_06v0 ad=0.88p pd=4.88u as=0.88p ps=4.88u w=2u l=1u
X704 a_64406_4736# a_64446_11482# a_77168_11598# VDD pfet_06v0 ad=4.4p pd=20.88u as=2.5p ps=10.5u w=10u l=1u
X705 VDD VSS VDD VDD pfet_06v0 ad=4.29p pd=20.38u as=0 ps=0 w=9.75u l=2u
X706 a_2670_4780# a_2470_4736# a_3402_4780# VSS nfet_06v0 ad=2.2p pd=10.88u as=1.25p ps=5.5u w=5u l=1u
X707 a_31286_81052# a_31070_49608# cap_mim_2f0_m4m5_noshield c_width=20u c_length=10u
X708 a_6522_58162# a_7686_58116# a_7886_58232# VSS nfet_06v0 ad=2.2p pd=10.88u as=1.3p ps=5.52u w=5u l=1u
X709 a_50506_82772# a_50554_81052# VSS VSS nfet_06v0 ad=0.33p pd=1.66u as=0.44p ps=2.88u w=1u l=1u
X710 VDD a_10558_71368# a_7886_66968# VDD pfet_06v0 ad=2.2p pd=10.88u as=1.3p ps=5.52u w=5u l=1u
X711 a_54582_70368# a_48426_66854# a_57478_66968# VSS nfet_06v0 ad=1.1p pd=5.88u as=0.65p ps=3.02u w=2.5u l=1u
X712 a_69610_4780# a_68804_12482# a_65180_9202# VDD pfet_06v0 ad=2.2p pd=10.88u as=1.65p ps=5.66u w=5u l=1u
X713 a_54142_49608# a_11158_16764# a_52778_49538# VSS nfet_06v0 ad=1.3p pd=5.52u as=2.2p ps=10.88u w=5u l=1u
X714 VSS VDD VSS VSS nfet_06v0 ad=0.66p pd=3.88u as=0 ps=0 w=1.5u l=2u
X715 a_55254_40872# a_56814_45272# VDD VDD pfet_06v0 ad=1.3p pd=5.52u as=2.2p ps=10.88u w=5u l=1u
X716 a_2510_61586# a_2510_61586# a_5166_58162# VSS nfet_06v0 ad=0.44p pd=2.88u as=0.25p ps=1.5u w=1u l=1u
X717 a_47532_12482# a_43838_11482# a_46494_4780# VDD pfet_06v0 ad=1.65p pd=5.66u as=1.65p ps=5.66u w=5u l=1u
X718 a_68804_36450# a_68804_36450# a_71164_35450# VDD pfet_06v0 ad=4.4p pd=20.88u as=3.3p ps=10.66u w=10u l=1u
X719 a_66370_28748# a_68140_36450# VDD VDD pfet_06v0 ad=1.65p pd=5.66u as=2.2p ps=10.88u w=5u l=1u
X720 VSS a_33294_66968# a_32626_70368# VSS nfet_06v0 ad=0.65p pd=3.02u as=0.65p ps=3.02u w=2.5u l=1u
X721 VSS a_33294_49608# a_32626_53008# VSS nfet_06v0 ad=1.1p pd=5.88u as=0.65p ps=3.02u w=2.5u l=1u
X722 a_17692_52962# a_2510_52962# a_17892_53078# VDD pfet_06v0 ad=3.3p pd=10.66u as=2.5p ps=10.5u w=10u l=1u
X723 a_23852_33170# a_26994_28704# a_28282_28748# VSS nfet_06v0 ad=1.1p pd=5.88u as=0.825p ps=3.16u w=2.5u l=1u
X724 a_44572_10552# a_8798_40756# VSS ppolyf_u_1k r_width=1u r_length=76.45u
X725 a_65180_34520# a_8798_66852# VSS ppolyf_u_1k r_width=1u r_length=76.45u
X726 VDD a_71650_44468# a_71650_44468# VDD pfet_06v0 ad=0.52p pd=2.52u as=0.52p ps=2.52u w=2u l=1u
X727 a_30066_70438# a_30870_66852# a_31510_70368# VDD pfet_06v0 ad=4.4p pd=20.88u as=2.6p ps=10.52u w=10u l=1u
X728 a_8798_66852# a_65180_33170# VDD VDD pfet_06v0 ad=0.22p pd=1.88u as=0.22p ps=1.88u w=0.5u l=1u
D14 VSS X diode_nd2ps_06v0 pj=30u area=50p
X729 a_19658_58232# a_11674_62632# VDD VDD pfet_06v0 ad=2.6p pd=10.52u as=4.4p ps=20.88u w=10u l=1u
X730 VSS VDD VSS VSS nfet_06v0 ad=0.88p pd=4.88u as=0 ps=0 w=2u l=2u
X731 a_24130_35566# a_22818_35450# VDD VDD pfet_06v0 ad=2.5p pd=10.5u as=4.4p ps=20.88u w=10u l=1u
X732 a_56814_62632# a_48766_61586# a_55254_58232# VDD pfet_06v0 ad=1.3p pd=5.52u as=2.2p ps=10.88u w=5u l=1u
X733 a_33742_54008# a_38758_49494# a_33294_49608# VSS nfet_06v0 ad=1.1p pd=5.88u as=1.1p ps=5.88u w=2.5u l=1u
X734 VSS VDD VSS VSS nfet_06v0 ad=4.29p pd=20.38u as=0 ps=0 w=9.75u l=2u
X735 a_46774_25382# a_4966_16720# a_44038_23582# VDD pfet_06v0 ad=0.44p pd=2.88u as=0.44p ps=2.88u w=1u l=1u
X736 a_23852_33170# a_23118_35450# a_25042_28748# VDD pfet_06v0 ad=1.65p pd=5.66u as=1.65p ps=5.66u w=5u l=1u
X737 a_52478_58162# a_49158_58118# VSS VSS nfet_06v0 ad=1.25p pd=5.5u as=2.2p ps=10.88u w=5u l=1u
X738 VSS VDD VSS VSS nfet_06v0 ad=7.92p pd=36.88u as=0 ps=0 w=18u l=2u
X739 a_11158_16764# a_4434_16764# cap_mim_2f0_m4m5_noshield c_width=25u c_length=4u
X740 a_53110_40802# a_48426_40758# a_52778_40802# VSS nfet_06v0 ad=1.25p pd=5.5u as=1.65p ps=5.66u w=5u l=1u
X741 a_31070_66968# a_25694_70322# a_34858_71368# VDD pfet_06v0 ad=2.2p pd=10.88u as=1.3p ps=5.52u w=5u l=1u
X742 a_49358_40802# a_49158_40758# VSS VSS nfet_06v0 ad=1.25p pd=5.5u as=2.2p ps=10.88u w=5u l=1u
X743 a_55254_49608# a_56814_54008# VDD VDD pfet_06v0 ad=1.3p pd=5.52u as=2.2p ps=10.88u w=5u l=1u
X744 a_8798_40756# a_44572_9202# VDD VDD pfet_06v0 ad=0.22p pd=1.88u as=0.22p ps=1.88u w=0.5u l=1u
X745 a_43798_16720# a_43838_23466# a_56560_23582# VDD pfet_06v0 ad=4.4p pd=20.88u as=2.5p ps=10.5u w=10u l=1u
X746 a_2170_28704# a_2470_28704# a_12622_28748# VSS nfet_06v0 ad=2.2p pd=10.88u as=1.25p ps=5.5u w=5u l=1u
X747 VDD a_7876_80992# a_7876_80992# VDD pfet_06v0 ad=0.88p pd=4.88u as=0.52p ps=2.52u w=2u l=1u
X748 S4P a_4234_16720# VSS ppolyf_u_1k r_width=1u r_length=2u
X749 a_17892_44342# a_17692_44226# VDD VDD pfet_06v0 ad=2.5p pd=10.5u as=4.4p ps=20.88u w=10u l=1u
X750 a_9442_53008# a_2170_49494# a_10110_49608# VSS nfet_06v0 ad=1.1p pd=5.88u as=0.65p ps=3.02u w=2.5u l=1u
X751 a_54582_70368# a_56366_66968# VSS VSS nfet_06v0 ad=0.65p pd=3.02u as=1.1p ps=5.88u w=2.5u l=1u
X752 a_57478_49608# a_48426_49494# a_54582_53008# VSS nfet_06v0 ad=0.65p pd=3.02u as=1.1p ps=5.88u w=2.5u l=1u
X753 a_46774_37366# a_47050_28704# VSS VSS nfet_06v0 ad=0.825p pd=3.16u as=1.1p ps=5.88u w=2.5u l=1u
X754 a_25242_25362# a_7876_75392# a_23318_23582# VDD pfet_06v0 ad=0.484p pd=3.08u as=0.484p ps=3.08u w=1.1u l=1u
X755 a_34858_45272# a_25694_44226# a_31070_40872# VDD pfet_06v0 ad=1.3p pd=5.52u as=2.2p ps=10.88u w=5u l=1u
X756 a_3522_35566# a_2210_35450# VDD VDD pfet_06v0 ad=2.5p pd=10.5u as=4.4p ps=20.88u w=10u l=1u
X757 a_6522_40802# a_7686_40756# a_7886_40872# VSS nfet_06v0 ad=2.2p pd=10.88u as=1.3p ps=5.52u w=5u l=1u
X758 a_11222_58232# a_2170_58118# a_8326_61632# VSS nfet_06v0 ad=0.65p pd=3.02u as=1.1p ps=5.88u w=2.5u l=1u
D15 VSS S2N diode_nd2ps_06v0 pj=30u area=50p
X759 a_28350_40802# a_25694_44226# VSS VSS nfet_06v0 ad=0.25p pd=1.5u as=0.44p ps=2.88u w=1u l=1u
X760 a_54142_58232# a_48766_61586# a_57930_62632# VDD pfet_06v0 ad=2.2p pd=10.88u as=1.3p ps=5.52u w=5u l=1u
X761 VDD VSS VDD VDD pfet_06v0 ad=0.88p pd=4.88u as=0 ps=0 w=2u l=2u
X762 a_6882_70438# a_2510_70322# a_6582_70438# VDD pfet_06v0 ad=3.3p pd=10.66u as=2.5p ps=10.5u w=10u l=1u
X763 a_32626_53008# a_33294_49608# VSS VSS nfet_06v0 ad=0.65p pd=3.02u as=1.1p ps=5.88u w=2.5u l=1u
X764 a_16344_35566# a_2210_35450# VDD VDD pfet_06v0 ad=2.5p pd=10.5u as=4.4p ps=20.88u w=10u l=1u
X765 a_17238_40802# a_2902_40758# VSS VSS nfet_06v0 ad=1.25p pd=5.5u as=2.2p ps=10.88u w=5u l=1u
X766 VDD VSS VDD VDD pfet_06v0 ad=0.66p pd=3.88u as=0 ps=0 w=1.5u l=2u
X767 a_42520_70438# a_25394_70322# VDD VDD pfet_06v0 ad=2.5p pd=10.5u as=4.4p ps=20.88u w=10u l=1u
X768 a_2470_28704# a_2470_28704# VSS VSS nfet_06v0 ad=0.44p pd=2.88u as=0.44p ps=2.88u w=1u l=1u
X769 VSS VDD VSS VSS nfet_06v0 ad=7.92p pd=36.88u as=0 ps=0 w=18u l=2u
X770 S2N a_4966_4736# VSS ppolyf_u_1k r_width=1u r_length=2u
X771 a_32182_66968# a_33742_71368# VDD VDD pfet_06v0 ad=1.3p pd=5.52u as=1.3p ps=5.52u w=5u l=1u
X772 a_43998_16764# a_43798_16720# a_43698_16764# VSS nfet_06v0 ad=2.2p pd=10.88u as=1.25p ps=5.5u w=5u l=1u
X773 VDD a_31286_81052# a_34514_81052# VDD pfet_06v0 ad=1.32p pd=6.88u as=0.99p ps=3.66u w=3u l=1u
X774 a_42842_66968# a_31070_66968# cap_mim_2f0_m4m5_noshield c_width=20u c_length=10u
X775 a_68322_4736# a_68322_4736# a_71530_4736# VSS nfet_06v0 ad=2.2p pd=10.88u as=1.65p ps=5.66u w=5u l=1u
X776 a_64406_16720# a_64406_16720# VSS VSS nfet_06v0 ad=0.44p pd=2.88u as=0.44p ps=2.88u w=1u l=1u
X777 a_11674_62632# a_2510_61586# a_7886_58232# VDD pfet_06v0 ad=1.3p pd=5.52u as=2.2p ps=10.88u w=5u l=1u
X778 a_2510_70322# a_2510_70322# VDD VDD pfet_06v0 ad=0.88p pd=4.88u as=0.88p ps=4.88u w=2u l=1u
X779 a_74558_28748# a_64106_28704# VSS VSS nfet_06v0 ad=1.25p pd=5.5u as=2.2p ps=10.88u w=5u l=1u
X780 a_66570_13378# a_4234_4736# a_64646_11598# VDD pfet_06v0 ad=0.484p pd=3.08u as=0.484p ps=3.08u w=1.1u l=1u
X781 a_48666_70438# a_48466_70322# VDD VDD pfet_06v0 ad=2.5p pd=10.5u as=4.4p ps=20.88u w=10u l=1u
X782 a_3244_9652# a_18662_9202# VSS ppolyf_u_1k r_width=1u r_length=76.45u
X783 a_64346_11598# a_64146_11482# VDD VDD pfet_06v0 ad=2.5p pd=10.5u as=4.4p ps=20.88u w=10u l=1u
X784 a_44038_23582# a_43838_23466# a_43738_23582# VDD pfet_06v0 ad=4.4p pd=20.88u as=2.5p ps=10.5u w=10u l=1u
X785 a_45962_13378# a_47050_4736# VSS VSS nfet_06v0 ad=0.825p pd=3.16u as=1.1p ps=5.88u w=2.5u l=1u
X786 VSS VDD VSS VSS nfet_06v0 ad=0.66p pd=3.88u as=0 ps=0 w=1.5u l=2u
X787 a_62300_45226# a_62300_45226# a_63948_44226# VDD pfet_06v0 ad=4.4p pd=20.88u as=3.3p ps=10.66u w=10u l=1u
X788 a_29706_49538# a_11158_16764# a_31070_49608# VSS nfet_06v0 ad=2.2p pd=10.88u as=1.3p ps=5.52u w=5u l=1u
X789 a_41478_66898# a_41278_66854# VSS VSS nfet_06v0 ad=1.25p pd=5.5u as=2.2p ps=10.88u w=5u l=1u
X790 a_2210_23466# a_2510_23466# a_18268_23582# VDD pfet_06v0 ad=4.4p pd=20.88u as=2.5p ps=10.5u w=10u l=1u
X791 VDD a_33742_45272# a_32182_40872# VDD pfet_06v0 ad=1.3p pd=5.52u as=1.3p ps=5.52u w=5u l=1u
D16 VSS S3P diode_nd2ps_06v0 pj=30u area=50p
X792 a_34858_54008# a_25694_52962# a_31070_49608# VDD pfet_06v0 ad=1.3p pd=5.52u as=2.2p ps=10.88u w=5u l=1u
X793 a_26706_70438# a_25394_70322# VDD VDD pfet_06v0 ad=2.5p pd=10.5u as=4.4p ps=20.88u w=10u l=1u
X794 a_21542_81052# a_31070_40872# cap_mim_2f0_m4m5_noshield c_width=20u c_length=10u
X795 a_25242_13378# a_26330_4736# VSS VSS nfet_06v0 ad=0.825p pd=3.16u as=1.1p ps=5.88u w=2.5u l=1u
X796 VSS a_21210_81052# a_23938_81096# VSS nfet_06v0 ad=0.44p pd=2.88u as=0.25p ps=1.5u w=1u l=1u
X797 a_50556_11482# a_43838_11482# a_50756_11598# VDD pfet_06v0 ad=3.3p pd=10.66u as=2.5p ps=10.5u w=10u l=1u
X798 a_38758_40758# a_25694_44226# a_42520_44342# VDD pfet_06v0 ad=4.4p pd=20.88u as=2.5p ps=10.5u w=10u l=1u
X799 a_44730_16764# a_43498_16720# VSS VSS nfet_06v0 ad=1.25p pd=5.5u as=2.2p ps=10.88u w=5u l=1u
X800 a_7876_80992# a_7876_80992# VDD VDD pfet_06v0 ad=0.52p pd=2.52u as=0.52p ps=2.52u w=2u l=1u
X801 a_74894_62048# a_17396_80992# VSS VSS nfet_05v0 ad=0.5808p pd=3.52u as=0.5808p ps=3.52u w=1.32u l=0.6u
X802 VSS a_56366_58232# a_54582_61632# VSS nfet_06v0 ad=1.1p pd=5.88u as=0.65p ps=3.02u w=2.5u l=1u
X803 VSS VDD VSS VSS nfet_06v0 ad=0.88p pd=4.88u as=0 ps=0 w=2u l=2u
X804 VSS a_56366_66968# a_55698_70368# VSS nfet_06v0 ad=0.65p pd=3.02u as=0.65p ps=3.02u w=2.5u l=1u
X805 a_6582_61702# a_2210_61586# VDD VDD pfet_06v0 ad=2.5p pd=10.5u as=4.4p ps=20.88u w=10u l=1u
X806 a_22778_16720# a_23078_16720# a_33230_16764# VSS nfet_06v0 ad=2.2p pd=10.88u as=1.25p ps=5.5u w=5u l=1u
X807 a_44572_22536# a_59990_22086# VSS ppolyf_u_1k r_width=1u r_length=76.45u
X808 a_27318_66898# a_25694_70322# VSS VSS nfet_06v0 ad=0.25p pd=1.5u as=0.44p ps=2.88u w=1u l=1u
X809 VDD a_10558_62632# a_7886_58232# VDD pfet_06v0 ad=1.3p pd=5.52u as=1.3p ps=5.52u w=5u l=1u
X810 a_34262_28748# a_23118_35450# VSS VSS nfet_06v0 ad=0.25p pd=1.5u as=0.44p ps=2.88u w=1u l=1u
X811 a_51422_58162# a_48766_61586# VSS VSS nfet_06v0 ad=0.25p pd=1.5u as=0.44p ps=2.88u w=1u l=1u
D17 S2N VDD diode_pd2nw_06v0 pj=30u area=50p
X812 a_38758_58118# a_38758_58118# a_41278_58118# VSS nfet_06v0 ad=2.2p pd=10.88u as=1.65p ps=5.66u w=5u l=1u
X813 VSS a_49158_66854# a_53110_66898# VSS nfet_06v0 ad=2.2p pd=10.88u as=1.25p ps=5.5u w=5u l=1u
X814 VSS a_33294_49608# a_31510_53008# VSS nfet_06v0 ad=0.65p pd=3.02u as=0.65p ps=3.02u w=2.5u l=1u
X815 a_53138_70438# a_30870_66852# a_54582_70368# VDD pfet_06v0 ad=4.4p pd=20.88u as=2.6p ps=10.52u w=10u l=1u
X816 a_53138_70438# a_48766_70322# a_52838_70438# VDD pfet_06v0 ad=3.3p pd=10.66u as=2.5p ps=10.5u w=10u l=1u
X817 a_48426_40758# a_48766_44226# a_48666_44342# VDD pfet_06v0 ad=4.4p pd=20.88u as=2.5p ps=10.5u w=10u l=1u
X818 VDD VSS VDD VDD pfet_06v0 ad=7.92p pd=36.88u as=0 ps=0 w=18u l=2u
X819 a_43538_11482# a_43838_11482# a_59596_11598# VDD pfet_06v0 ad=4.4p pd=20.88u as=2.5p ps=10.5u w=10u l=1u
X820 a_2170_49494# a_2510_52962# a_2410_53078# VDD pfet_06v0 ad=4.4p pd=20.88u as=2.5p ps=10.5u w=10u l=1u
X821 VDD VSS VDD VDD pfet_06v0 ad=4.29p pd=20.38u as=0 ps=0 w=9.75u l=2u
X822 a_44258_81052# a_19658_58232# VDD VDD pfet_06v0 ad=0.99p pd=3.66u as=1.32p ps=6.88u w=3u l=1u
X823 a_44572_21636# a_59990_22086# VSS ppolyf_u_1k r_width=1u r_length=76.45u
X824 a_11222_40872# a_2170_40758# a_8326_44272# VSS nfet_06v0 ad=0.65p pd=3.02u as=1.1p ps=5.88u w=2.5u l=1u
X825 VDD VSS VDD VDD pfet_06v0 ad=0.66p pd=3.88u as=0 ps=0 w=1.5u l=2u
X826 a_3244_21186# a_6386_16720# a_7674_16764# VSS nfet_06v0 ad=1.1p pd=5.88u as=0.825p ps=3.16u w=2.5u l=1u
X827 VSS VDD VSS VSS nfet_06v0 ad=7.92p pd=36.88u as=0 ps=0 w=18u l=2u
X828 VSS VDD VSS VSS nfet_06v0 ad=0.66p pd=3.88u as=0 ps=0 w=1.5u l=2u
X829 a_26086_40758# a_25694_44226# a_26706_44342# VDD pfet_06v0 ad=4.4p pd=20.88u as=2.5p ps=10.5u w=10u l=1u
X830 a_29406_49538# a_26086_49494# VSS VSS nfet_06v0 ad=1.25p pd=5.5u as=2.2p ps=10.88u w=5u l=1u
X831 VDD a_33742_54008# a_32182_49608# VDD pfet_06v0 ad=1.3p pd=5.52u as=1.3p ps=5.52u w=5u l=1u
X832 a_10558_62632# a_15574_58118# a_10110_58232# VSS nfet_06v0 ad=1.1p pd=5.88u as=1.1p ps=5.88u w=2.5u l=1u
X833 VSS VDD VSS VSS nfet_06v0 ad=0.88p pd=4.88u as=0 ps=0 w=2u l=2u
X834 a_26286_66898# a_26086_66854# VSS VSS nfet_06v0 ad=1.25p pd=5.5u as=2.2p ps=10.88u w=5u l=1u
X835 a_8738_28748# a_2170_28704# VSS VSS nfet_06v0 ad=1.25p pd=5.5u as=2.2p ps=10.88u w=5u l=1u
X836 a_50390_58162# a_48766_61586# VSS VSS nfet_06v0 ad=0.25p pd=1.5u as=0.44p ps=2.88u w=1u l=1u
X837 a_25242_13378# a_30870_40756# cap_mim_2f0_m4m5_noshield c_width=25u c_length=4u
X838 a_6522_58162# a_2170_58118# a_6222_58162# VSS nfet_06v0 ad=1.65p pd=5.66u as=1.25p ps=5.5u w=5u l=1u
X839 a_11222_58232# a_16044_62586# a_11674_62632# VDD pfet_06v0 ad=2.2p pd=10.88u as=2.2p ps=10.88u w=5u l=1u
X840 a_46494_28748# a_47532_36450# VDD VDD pfet_06v0 ad=1.65p pd=5.66u as=2.2p ps=10.88u w=5u l=1u
X841 a_7886_40872# a_10558_45272# VDD VDD pfet_06v0 ad=1.3p pd=5.52u as=2.2p ps=10.88u w=5u l=1u
X842 a_29766_53078# a_25394_52962# VDD VDD pfet_06v0 ad=2.5p pd=10.5u as=4.4p ps=20.88u w=10u l=1u
X843 a_56814_62632# a_61830_58118# a_56366_58232# VSS nfet_06v0 ad=1.1p pd=5.88u as=1.1p ps=5.88u w=2.5u l=1u
X844 VSS VDD VSS VSS nfet_06v0 ad=0.66p pd=3.88u as=0 ps=0 w=1.5u l=2u
X845 a_30202_16720# a_23078_16720# a_30402_16764# VSS nfet_06v0 ad=1.65p pd=5.66u as=1.25p ps=5.5u w=5u l=1u
X846 a_29706_40802# a_25354_40758# a_29406_40802# VSS nfet_06v0 ad=1.65p pd=5.66u as=1.25p ps=5.5u w=5u l=1u
X847 a_6868_36450# a_6868_36450# a_9228_35450# VDD pfet_06v0 ad=4.4p pd=20.88u as=3.3p ps=10.66u w=10u l=1u
X848 a_78280_11598# a_64146_11482# VDD VDD pfet_06v0 ad=2.5p pd=10.5u as=4.4p ps=20.88u w=10u l=1u
X849 a_43498_16720# a_43838_23466# a_57672_23582# VDD pfet_06v0 ad=4.4p pd=20.88u as=2.5p ps=10.5u w=10u l=1u
X850 a_8326_53008# a_2170_49494# a_11222_49608# VSS nfet_06v0 ad=1.1p pd=5.88u as=0.65p ps=3.02u w=2.5u l=1u
X851 a_52838_61702# a_48466_61586# VDD VDD pfet_06v0 ad=2.5p pd=10.5u as=4.4p ps=20.88u w=10u l=1u
D18 S1N VDD diode_pd2nw_06v0 pj=30u area=50p
X852 a_2410_44342# a_2210_44226# VDD VDD pfet_06v0 ad=2.5p pd=10.5u as=4.4p ps=20.88u w=10u l=1u
X853 a_65592_70438# a_48466_70322# VDD VDD pfet_06v0 ad=2.5p pd=10.5u as=4.4p ps=20.88u w=10u l=1u
X854 a_41278_49494# a_25354_49494# a_41478_49538# VSS nfet_06v0 ad=1.65p pd=5.66u as=1.25p ps=5.5u w=5u l=1u
X855 a_31510_61632# a_33294_58232# VSS VSS nfet_06v0 ad=0.65p pd=3.02u as=0.65p ps=3.02u w=2.5u l=1u
X856 a_32626_61632# a_8798_58116# a_30066_61702# VDD pfet_06v0 ad=2.6p pd=10.52u as=4.4p ps=20.88u w=10u l=1u
X857 VSS a_56366_40872# a_54582_44272# VSS nfet_06v0 ad=1.1p pd=5.88u as=0.65p ps=3.02u w=2.5u l=1u
X858 a_9442_61632# a_10110_58232# VSS VSS nfet_06v0 ad=0.65p pd=3.02u as=1.1p ps=5.88u w=2.5u l=1u
D19 S3N VDD diode_pd2nw_06v0 pj=30u area=50p
X859 a_40422_66898# a_26086_66854# VSS VSS nfet_06v0 ad=1.25p pd=5.5u as=2.2p ps=10.88u w=5u l=1u
X860 a_64446_23466# a_64446_23466# a_76622_16764# VSS nfet_06v0 ad=0.44p pd=2.88u as=0.25p ps=1.5u w=1u l=1u
X861 a_45962_25362# a_47050_16720# VSS VSS nfet_06v0 ad=0.825p pd=3.16u as=1.1p ps=5.88u w=2.5u l=1u
X862 a_33294_58232# a_39228_62586# a_33742_62632# VDD pfet_06v0 ad=2.2p pd=10.88u as=2.2p ps=10.88u w=5u l=1u
X863 a_52350_81052# a_50554_81052# VDD VDD pfet_06v0 ad=0.99p pd=3.66u as=1.32p ps=6.88u w=3u l=1u
X864 a_7886_49608# a_10558_54008# VDD VDD pfet_06v0 ad=1.3p pd=5.52u as=2.2p ps=10.88u w=5u l=1u
X865 a_19658_66968# a_11674_71368# VDD VDD pfet_06v0 ad=4.4p pd=20.88u as=2.6p ps=10.52u w=10u l=1u
X866 a_25394_52962# a_25694_52962# a_27318_49538# VSS nfet_06v0 ad=0.44p pd=2.88u as=0.25p ps=1.5u w=1u l=1u
X867 VSS VDD VSS VSS nfet_06v0 ad=0.66p pd=3.88u as=0 ps=0 w=1.5u l=2u
X868 a_32182_58232# a_33742_62632# VDD VDD pfet_06v0 ad=1.3p pd=5.52u as=2.2p ps=10.88u w=5u l=1u
X869 VSS a_56366_66968# a_55698_70368# VSS nfet_06v0 ad=1.1p pd=5.88u as=0.65p ps=3.02u w=2.5u l=1u
X870 VSS VDD VSS VSS nfet_06v0 ad=0.66p pd=3.88u as=0 ps=0 w=1.5u l=2u
X871 a_49778_70438# a_48466_70322# VDD VDD pfet_06v0 ad=2.5p pd=10.5u as=4.4p ps=20.88u w=10u l=1u
X872 a_65458_11598# a_64146_11482# VDD VDD pfet_06v0 ad=2.5p pd=10.5u as=4.4p ps=20.88u w=10u l=1u
X873 a_75916_59770# a_17396_80992# VSS VSS nfet_06v0 ad=0.5p pd=2.5u as=0.88p ps=4.88u w=2u l=1u
X874 VDD VSS VDD VDD pfet_06v0 ad=0.88p pd=4.88u as=0 ps=0 w=2u l=2u
X875 a_64146_23466# a_64446_23466# a_75590_16764# VSS nfet_06v0 ad=0.44p pd=2.88u as=0.25p ps=1.5u w=1u l=1u
X876 a_29346_4780# a_22778_4736# VSS VSS nfet_06v0 ad=1.25p pd=5.5u as=2.2p ps=10.88u w=5u l=1u
X877 a_67102_16764# a_68140_24466# VDD VDD pfet_06v0 ad=1.65p pd=5.66u as=2.2p ps=10.88u w=5u l=1u
X878 a_54582_70368# a_56366_66968# VSS VSS nfet_06v0 ad=0.65p pd=3.02u as=0.65p ps=3.02u w=2.5u l=1u
X879 a_47532_24466# a_47714_16720# a_47050_16720# VSS nfet_06v0 ad=1.1p pd=5.88u as=0.825p ps=3.16u w=2.5u l=1u
X880 a_46494_4780# a_25574_16720# a_43998_4780# VSS nfet_06v0 ad=0.44p pd=2.88u as=0.44p ps=2.88u w=1u l=1u
X881 a_61830_40758# a_48766_44226# a_65592_44342# VDD pfet_06v0 ad=4.4p pd=20.88u as=2.5p ps=10.5u w=10u l=1u
X882 a_29706_49538# a_8798_49492# a_32182_49608# VSS nfet_06v0 ad=2.2p pd=10.88u as=1.3p ps=5.52u w=5u l=1u
X883 a_19658_58232# a_11222_58232# VSS VSS nfet_06v0 ad=2.2p pd=10.88u as=1.3p ps=5.52u w=5u l=1u
X884 a_8798_40756# a_44572_9202# VDD VDD pfet_06v0 ad=0.22p pd=1.88u as=0.22p ps=1.88u w=0.5u l=1u
X885 a_55254_40872# a_48766_44226# a_56814_45272# VDD pfet_06v0 ad=2.2p pd=10.88u as=1.3p ps=5.52u w=5u l=1u
D20 VSS S1P diode_nd2ps_06v0 pj=30u area=50p
X886 a_53470_70438# a_48766_70322# a_53138_70438# VDD pfet_06v0 ad=2.5p pd=10.5u as=3.3p ps=10.66u w=10u l=1u
X887 a_8326_70368# a_7686_66852# a_6882_70438# VDD pfet_06v0 ad=2.6p pd=10.52u as=4.4p ps=20.88u w=10u l=1u
X888 a_16044_71322# a_16044_71322# a_17692_70322# VDD pfet_06v0 ad=4.4p pd=20.88u as=3.3p ps=10.66u w=10u l=1u
X889 a_9442_70368# a_10110_66968# VSS VSS nfet_06v0 ad=0.65p pd=3.02u as=0.65p ps=3.02u w=2.5u l=1u
X890 VDD VSS VDD VDD pfet_06v0 ad=4.29p pd=20.38u as=0 ps=0 w=9.75u l=2u
X891 a_26086_49494# a_25354_49494# a_26286_49538# VSS nfet_06v0 ad=2.2p pd=10.88u as=1.25p ps=5.5u w=5u l=1u
X892 a_3102_58162# a_2902_58118# VSS VSS nfet_06v0 ad=1.25p pd=5.5u as=2.2p ps=10.88u w=5u l=1u
X893 a_56014_4780# a_43838_11482# VSS VSS nfet_06v0 ad=0.25p pd=1.5u as=0.44p ps=2.88u w=1u l=1u
X894 a_61830_58118# a_61830_58118# a_64350_58118# VSS nfet_06v0 ad=2.2p pd=10.88u as=1.65p ps=5.66u w=5u l=1u
X895 a_65180_9652# a_80598_10102# VSS ppolyf_u_1k r_width=1u r_length=76.45u
X896 VDD VSS VDD VDD pfet_06v0 ad=7.92p pd=36.88u as=0 ps=0 w=18u l=2u
X897 a_25774_4780# a_4966_28704# a_23278_4780# VSS nfet_06v0 ad=0.44p pd=2.88u as=0.44p ps=2.88u w=1u l=1u
X898 a_33294_58232# a_25354_58118# a_32626_61632# VSS nfet_06v0 ad=0.65p pd=3.02u as=1.1p ps=5.88u w=2.5u l=1u
X899 a_25702_81096# a_21542_81052# a_24770_81052# VSS nfet_06v0 ad=0.25p pd=1.5u as=0.44p ps=2.88u w=1u l=1u
X900 a_46774_37366# a_4966_4736# a_44038_35566# VDD pfet_06v0 ad=0.44p pd=2.88u as=0.44p ps=2.88u w=1u l=1u
X901 VDD VSS VDD VDD pfet_06v0 ad=4.29p pd=20.38u as=0 ps=0 w=9.75u l=2u
X902 a_31286_81052# a_34406_49608# VSS VSS nfet_06v0 ad=1.3p pd=5.52u as=2.2p ps=10.88u w=5u l=1u
X903 a_30036_23582# a_29836_23466# VDD VDD pfet_06v0 ad=2.5p pd=10.5u as=4.4p ps=20.88u w=10u l=1u
X904 a_26812_24466# a_23118_23466# a_25774_16764# VDD pfet_06v0 ad=1.65p pd=5.66u as=1.65p ps=5.66u w=5u l=1u
X905 a_48426_40758# a_48426_40758# VSS VSS nfet_06v0 ad=0.44p pd=2.88u as=0.44p ps=2.88u w=1u l=1u
X906 a_49158_40758# a_48766_44226# a_49778_44342# VDD pfet_06v0 ad=4.4p pd=20.88u as=2.5p ps=10.5u w=10u l=1u
X907 a_7876_80992# a_7876_80992# VDD VDD pfet_06v0 ad=0.52p pd=2.52u as=0.88p ps=4.88u w=2u l=1u
X908 a_2902_49494# a_2510_52962# a_3522_53078# VDD pfet_06v0 ad=4.4p pd=20.88u as=2.5p ps=10.5u w=10u l=1u
X909 VDD VSS VDD VDD pfet_06v0 ad=0.66p pd=3.88u as=0 ps=0 w=1.5u l=2u
X910 a_31510_44272# a_33294_40872# VSS VSS nfet_06v0 ad=0.65p pd=3.02u as=0.65p ps=3.02u w=2.5u l=1u
X911 a_44572_21186# a_47714_16720# a_49002_16764# VSS nfet_06v0 ad=1.1p pd=5.88u as=0.825p ps=3.16u w=2.5u l=1u
X912 VSS VDD VSS VSS nfet_06v0 ad=0.66p pd=3.88u as=0 ps=0 w=1.5u l=2u
X913 a_7674_16764# a_6868_24466# a_3244_21186# VDD pfet_06v0 ad=2.2p pd=10.88u as=1.65p ps=5.66u w=5u l=1u
X914 a_43798_28704# a_43838_35450# a_56560_35566# VDD pfet_06v0 ad=4.4p pd=20.88u as=2.5p ps=10.5u w=10u l=1u
X915 a_11158_16764# a_3244_21186# VDD VDD pfet_06v0 ad=0.22p pd=1.88u as=0.22p ps=1.88u w=0.5u l=1u
X916 a_9442_44272# a_10110_40872# VSS VSS nfet_06v0 ad=0.65p pd=3.02u as=1.1p ps=5.88u w=2.5u l=1u
X917 VDD a_48466_44226# a_53470_44342# VDD pfet_06v0 ad=4.4p pd=20.88u as=2.5p ps=10.5u w=10u l=1u
X918 a_39228_53962# a_25354_49494# a_40422_49538# VSS nfet_06v0 ad=2.2p pd=10.88u as=1.25p ps=5.5u w=5u l=1u
X919 a_55254_49608# a_48766_52962# a_56814_54008# VDD pfet_06v0 ad=2.2p pd=10.88u as=1.3p ps=5.52u w=5u l=1u
X920 S1N a_25574_16720# VSS ppolyf_u_1k r_width=1u r_length=2u
X921 VSS VDD VSS VSS nfet_06v0 ad=0.88p pd=4.88u as=0 ps=0 w=2u l=2u
X922 a_44850_23582# a_43538_23466# VDD VDD pfet_06v0 ad=2.5p pd=10.5u as=4.4p ps=20.88u w=10u l=1u
X923 a_25242_37346# a_4234_16720# a_23318_35566# VDD pfet_06v0 ad=0.484p pd=3.08u as=0.484p ps=3.08u w=1.1u l=1u
X924 a_10110_66968# a_2170_66854# a_9442_70368# VSS nfet_06v0 ad=0.65p pd=3.02u as=1.1p ps=5.88u w=2.5u l=1u
X925 a_68140_12482# a_64446_11482# a_67102_4780# VDD pfet_06v0 ad=1.65p pd=5.66u as=1.65p ps=5.66u w=5u l=1u
X926 a_11674_45272# a_15574_40758# a_11222_40872# VSS nfet_06v0 ad=1.1p pd=5.88u as=1.1p ps=5.88u w=2.5u l=1u
X927 a_44572_21186# a_43838_23466# a_45762_16764# VDD pfet_06v0 ad=1.65p pd=5.66u as=1.65p ps=5.66u w=5u l=1u
X928 a_7886_40872# a_2510_44226# a_11674_45272# VDD pfet_06v0 ad=2.2p pd=10.88u as=1.3p ps=5.52u w=5u l=1u
X929 a_9428_23582# a_9228_23466# VDD VDD pfet_06v0 ad=2.5p pd=10.5u as=4.4p ps=20.88u w=10u l=1u
X930 a_75274_58632# a_73010_58516# a_74974_58632# VSS nfet_06v0 ad=0.175p pd=1.2u as=0.175p ps=1.2u w=0.7u l=1u
X931 a_6882_61702# a_7686_58116# a_8326_61632# VDD pfet_06v0 ad=4.4p pd=20.88u as=2.6p ps=10.52u w=10u l=1u
X932 a_8738_4780# a_2170_4736# VSS VSS nfet_06v0 ad=1.25p pd=5.5u as=2.2p ps=10.88u w=5u l=1u
X933 a_19658_40872# a_11222_40872# VSS VSS nfet_06v0 ad=2.2p pd=10.88u as=1.3p ps=5.52u w=5u l=1u
X934 VDD VSS VDD VDD pfet_06v0 ad=4.29p pd=20.38u as=0 ps=0 w=9.75u l=2u
X935 a_43998_28748# a_43798_28704# a_43698_28748# VSS nfet_06v0 ad=2.2p pd=10.88u as=1.25p ps=5.5u w=5u l=1u
X936 VSS a_10110_49608# a_9442_53008# VSS nfet_06v0 ad=0.65p pd=3.02u as=0.65p ps=3.02u w=2.5u l=1u
X937 a_31070_58232# a_30870_58116# a_29706_58162# VSS nfet_06v0 ad=1.3p pd=5.52u as=2.2p ps=10.88u w=5u l=1u
X938 a_55698_61632# a_7686_58116# a_53138_61702# VDD pfet_06v0 ad=2.6p pd=10.52u as=4.4p ps=20.88u w=10u l=1u
X939 S4N a_4966_16720# VSS ppolyf_u_1k r_width=1u r_length=2u
X940 a_63494_66898# a_49158_66854# VSS VSS nfet_06v0 ad=1.25p pd=5.5u as=2.2p ps=10.88u w=5u l=1u
X941 a_64406_28704# a_64406_28704# VSS VSS nfet_06v0 ad=0.44p pd=2.88u as=0.44p ps=2.88u w=1u l=1u
X942 a_34406_40872# a_39228_45226# a_34858_45272# VDD pfet_06v0 ad=2.2p pd=10.88u as=2.2p ps=10.88u w=5u l=1u
X943 VSS VDD VSS VSS nfet_06v0 ad=0.88p pd=4.88u as=0 ps=0 w=2u l=2u
X944 a_52200_23582# a_43538_23466# VDD VDD pfet_06v0 ad=2.5p pd=10.5u as=4.4p ps=20.88u w=10u l=1u
X945 VSS a_34406_58232# a_41030_81052# VSS nfet_06v0 ad=1.3p pd=5.52u as=1.3p ps=5.52u w=5u l=1u
X946 ZN ZP VDD VDD pfet_05v0 ad=0.8052p pd=4.54u as=0.8052p ps=4.54u w=1.83u l=0.5u
X947 a_3522_44342# a_2210_44226# VDD VDD pfet_06v0 ad=2.5p pd=10.5u as=4.4p ps=20.88u w=10u l=1u
X948 a_50794_82772# a_50554_81052# a_50506_82772# VDD pfet_06v0 ad=0.75p pd=3.5u as=1.32p ps=6.88u w=3u l=1u
X949 a_52778_66898# a_30870_66852# a_54142_66968# VSS nfet_06v0 ad=2.2p pd=10.88u as=1.3p ps=5.52u w=5u l=1u
X950 VDD VSS VDD VDD pfet_06v0 ad=0.88p pd=4.88u as=0 ps=0 w=2u l=2u
X951 a_44038_35566# a_43838_35450# a_43738_35566# VDD pfet_06v0 ad=4.4p pd=20.88u as=2.5p ps=10.5u w=10u l=1u
X952 VDD a_57930_62632# a_40698_81052# VDD pfet_06v0 ad=2.6p pd=10.52u as=2.6p ps=10.52u w=10u l=1u
X953 VDD VSS VDD VDD pfet_06v0 ad=0.88p pd=4.88u as=0 ps=0 w=2u l=2u
X954 a_5166_4780# a_4966_4736# a_2670_4780# VSS nfet_06v0 ad=0.44p pd=2.88u as=0.44p ps=2.88u w=1u l=1u
X955 a_67382_25382# a_25574_16720# a_64646_23582# VDD pfet_06v0 ad=0.44p pd=2.88u as=0.44p ps=2.88u w=1u l=1u
X956 a_33294_40872# a_25354_40758# a_32626_44272# VSS nfet_06v0 ad=0.65p pd=3.02u as=1.1p ps=5.88u w=2.5u l=1u
X957 a_26330_4736# a_27476_12482# a_26812_12482# VDD pfet_06v0 ad=2.2p pd=10.88u as=1.65p ps=5.66u w=5u l=1u
X958 a_6222_40802# a_2902_40758# VSS VSS nfet_06v0 ad=1.25p pd=5.5u as=2.2p ps=10.88u w=5u l=1u
X959 a_43998_4780# a_43798_4736# a_43698_4780# VSS nfet_06v0 ad=2.2p pd=10.88u as=1.25p ps=5.5u w=5u l=1u
X960 a_2210_35450# a_2510_35450# a_18268_35566# VDD pfet_06v0 ad=4.4p pd=20.88u as=2.5p ps=10.5u w=10u l=1u
X961 a_35840_23582# a_22818_23466# VDD VDD pfet_06v0 ad=2.5p pd=10.5u as=4.4p ps=20.88u w=10u l=1u
X962 a_74894_44688# a_71650_44468# VSS VSS nfet_05v0 ad=0.5808p pd=3.52u as=0.5808p ps=3.52u w=1.32u l=0.6u
X963 a_10872_11598# a_2210_11482# VDD VDD pfet_06v0 ad=2.5p pd=10.5u as=4.4p ps=20.88u w=10u l=1u
X964 a_50922_4736# a_43798_4736# a_51122_4780# VSS nfet_06v0 ad=1.65p pd=5.66u as=1.25p ps=5.5u w=5u l=1u
X965 VDD VSS VDD VDD pfet_06v0 ad=0.88p pd=4.88u as=0 ps=0 w=2u l=2u
X966 a_44730_28748# a_43498_28704# VSS VSS nfet_06v0 ad=1.25p pd=5.5u as=2.2p ps=10.88u w=5u l=1u
X967 a_22778_28704# a_23078_28704# a_33230_28748# VSS nfet_06v0 ad=2.2p pd=10.88u as=1.25p ps=5.5u w=5u l=1u
X968 a_8998_40872# a_10558_45272# VDD VDD pfet_06v0 ad=1.3p pd=5.52u as=1.3p ps=5.52u w=5u l=1u
X969 a_7886_49608# a_2510_52962# a_11674_54008# VDD pfet_06v0 ad=2.2p pd=10.88u as=1.3p ps=5.52u w=5u l=1u
X970 VSS a_19658_49608# a_35446_81096# VSS nfet_06v0 ad=0.44p pd=2.88u as=0.25p ps=1.5u w=1u l=1u
X971 VDD a_2210_61586# a_7214_61702# VDD pfet_06v0 ad=4.4p pd=20.88u as=2.5p ps=10.5u w=10u l=1u
X972 a_64606_16764# a_64406_16720# a_65338_16764# VSS nfet_06v0 ad=2.2p pd=10.88u as=1.25p ps=5.5u w=5u l=1u
X973 a_65180_21636# a_80598_21186# VSS ppolyf_u_1k r_width=1u r_length=76.45u
X974 S4P a_4234_16720# VSS ppolyf_u_1k r_width=1u r_length=2u
X975 a_30202_4736# a_23078_4736# a_30402_4780# VSS nfet_06v0 ad=1.65p pd=5.66u as=1.25p ps=5.5u w=5u l=1u
X976 a_25354_58118# a_25694_61586# a_25594_61702# VDD pfet_06v0 ad=4.4p pd=20.88u as=2.5p ps=10.5u w=10u l=1u
X977 a_54142_58232# a_56814_62632# VDD VDD pfet_06v0 ad=1.3p pd=5.52u as=1.3p ps=5.52u w=5u l=1u
X978 a_74558_4780# a_64106_4736# VSS VSS nfet_06v0 ad=1.25p pd=5.5u as=2.2p ps=10.88u w=5u l=1u
X979 a_21210_81052# a_57930_45272# VDD VDD pfet_06v0 ad=2.6p pd=10.52u as=4.4p ps=20.88u w=10u l=1u
X980 a_32626_53008# a_25354_49494# a_33294_49608# VSS nfet_06v0 ad=1.1p pd=5.88u as=0.65p ps=3.02u w=2.5u l=1u
X981 VSS VDD VSS VSS nfet_06v0 ad=0.66p pd=3.88u as=0 ps=0 w=1.5u l=2u
X982 VSS a_19658_40872# a_22186_81096# VSS nfet_06v0 ad=0.44p pd=2.88u as=0.44p ps=2.88u w=1u l=1u
X983 a_43426_81096# a_41674_81096# a_42494_81052# VSS nfet_06v0 ad=0.25p pd=1.5u as=0.44p ps=2.88u w=1u l=1u
X984 a_54026_81096# a_54114_81052# VDD VDD pfet_06v0 ad=1.32p pd=6.88u as=1.32p ps=6.88u w=3u l=1u
X985 VSS VDD VSS VSS nfet_06v0 ad=0.88p pd=4.88u as=0 ps=0 w=2u l=2u
X986 a_15574_66854# a_2510_70322# a_19336_70438# VDD pfet_06v0 ad=4.4p pd=20.88u as=2.5p ps=10.5u w=10u l=1u
X987 a_8326_70368# a_10110_66968# VSS VSS nfet_06v0 ad=0.65p pd=3.02u as=1.1p ps=5.88u w=2.5u l=1u
X988 a_8326_53008# a_10110_49608# VSS VSS nfet_06v0 ad=0.65p pd=3.02u as=0.65p ps=3.02u w=2.5u l=1u
X989 a_22978_16764# a_22778_16720# VSS VSS nfet_06v0 ad=1.25p pd=5.5u as=2.2p ps=10.88u w=5u l=1u
X990 a_3244_33170# a_6386_28704# a_7674_28748# VSS nfet_06v0 ad=1.1p pd=5.88u as=0.825p ps=3.16u w=2.5u l=1u
X991 a_25354_66854# a_25354_66854# VSS VSS nfet_06v0 ad=0.44p pd=2.88u as=0.44p ps=2.88u w=1u l=1u
X992 a_50066_16764# a_43498_16720# VSS VSS nfet_06v0 ad=1.25p pd=5.5u as=2.2p ps=10.88u w=5u l=1u
X993 a_13654_4780# a_2510_11482# VSS VSS nfet_06v0 ad=0.25p pd=1.5u as=0.44p ps=2.88u w=1u l=1u
X994 a_23006_81052# a_21210_81052# VDD VDD pfet_06v0 ad=0.99p pd=3.66u as=1.32p ps=6.88u w=3u l=1u
X995 a_65180_21186# a_80598_21186# VSS ppolyf_u_1k r_width=1u r_length=76.45u
X996 a_29836_23466# a_23118_23466# a_30036_23582# VDD pfet_06v0 ad=3.3p pd=10.66u as=2.5p ps=10.5u w=10u l=1u
X997 a_76622_4780# a_64446_11482# VSS VSS nfet_06v0 ad=0.25p pd=1.5u as=0.44p ps=2.88u w=1u l=1u
X998 a_74894_53424# a_7876_80992# VSS VSS nfet_05v0 ad=0.5808p pd=3.52u as=0.5808p ps=3.52u w=1.32u l=0.6u
X999 a_23018_23582# a_22818_23466# VDD VDD pfet_06v0 ad=2.5p pd=10.5u as=4.4p ps=20.88u w=10u l=1u
X1000 a_30202_28704# a_23078_28704# a_30402_28748# VSS nfet_06v0 ad=1.65p pd=5.66u as=1.25p ps=5.5u w=5u l=1u
X1001 a_31070_40872# a_30870_40756# a_29706_40802# VSS nfet_06v0 ad=1.3p pd=5.52u as=2.2p ps=10.88u w=5u l=1u
X1002 a_8998_49608# a_10558_54008# VDD VDD pfet_06v0 ad=1.3p pd=5.52u as=1.3p ps=5.52u w=5u l=1u
X1003 a_2210_44226# a_2510_44226# a_4134_40802# VSS nfet_06v0 ad=0.44p pd=2.88u as=0.25p ps=1.5u w=1u l=1u
X1004 a_64646_23582# a_64446_23466# a_64346_23582# VDD pfet_06v0 ad=4.4p pd=20.88u as=2.5p ps=10.5u w=10u l=1u
X1005 VSS a_34406_40872# a_21542_81052# VSS nfet_06v0 ad=1.3p pd=5.52u as=1.3p ps=5.52u w=5u l=1u
X1006 VDD VSS VDD VDD pfet_06v0 ad=0.88p pd=4.88u as=0 ps=0 w=2u l=2u
X1007 a_62300_53962# a_48426_49494# a_63494_49538# VSS nfet_06v0 ad=2.2p pd=10.88u as=1.25p ps=5.5u w=5u l=1u
X1008 a_23852_34520# a_7686_66852# VSS ppolyf_u_1k r_width=1u r_length=76.45u
X1009 a_43498_28704# a_43838_35450# a_57672_35566# VDD pfet_06v0 ad=4.4p pd=20.88u as=2.5p ps=10.5u w=10u l=1u
X1010 a_65338_4780# a_64106_4736# VSS VSS nfet_06v0 ad=1.25p pd=5.5u as=2.2p ps=10.88u w=5u l=1u
X1011 a_7686_58116# a_44572_21186# VDD VDD pfet_06v0 ad=0.22p pd=1.88u as=0.22p ps=1.88u w=0.5u l=1u
X1012 a_30954_81052# a_57930_54008# VDD VDD pfet_06v0 ad=2.6p pd=10.52u as=4.4p ps=20.88u w=10u l=1u
X1013 a_63948_52962# a_48766_52962# a_64148_53078# VDD pfet_06v0 ad=3.3p pd=10.66u as=2.5p ps=10.5u w=10u l=1u
X1014 a_71164_11482# a_64446_11482# a_71364_11598# VDD pfet_06v0 ad=3.3p pd=10.66u as=2.5p ps=10.5u w=10u l=1u
X1015 a_19336_61702# a_2210_61586# VDD VDD pfet_06v0 ad=2.5p pd=10.5u as=4.4p ps=20.88u w=10u l=1u
X1016 a_44572_33620# a_59990_33170# VSS ppolyf_u_1k r_width=1u r_length=76.45u
X1017 a_67382_13398# a_67658_4736# VSS VSS nfet_06v0 ad=0.825p pd=3.16u as=1.1p ps=5.88u w=2.5u l=1u
X1018 a_7686_58116# a_45762_16764# cap_mim_2f0_m4m5_noshield c_width=25u c_length=4u
X1019 a_64446_35450# a_64446_35450# a_76622_28748# VSS nfet_06v0 ad=0.44p pd=2.88u as=0.25p ps=1.5u w=1u l=1u
X1020 a_45962_37346# a_47050_28704# VSS VSS nfet_06v0 ad=0.825p pd=3.16u as=1.1p ps=5.88u w=2.5u l=1u
X1021 a_38876_11598# a_22818_11482# VDD VDD pfet_06v0 ad=2.5p pd=10.5u as=4.4p ps=20.88u w=10u l=1u
X1022 a_4634_25362# a_4234_16720# a_2710_23582# VDD pfet_06v0 ad=0.484p pd=3.08u as=0.484p ps=3.08u w=1.1u l=1u
X1023 a_41076_53078# a_40876_52962# VDD VDD pfet_06v0 ad=2.5p pd=10.5u as=4.4p ps=20.88u w=10u l=1u
X1024 a_57930_45272# a_48766_44226# a_54142_40872# VDD pfet_06v0 ad=1.3p pd=5.52u as=2.2p ps=10.88u w=5u l=1u
X1025 VSS a_10110_58232# a_8326_61632# VSS nfet_06v0 ad=1.1p pd=5.88u as=0.65p ps=3.02u w=2.5u l=1u
X1026 a_28630_70438# a_25394_70322# VDD VDD pfet_06v0 ad=2.5p pd=10.5u as=4.4p ps=20.88u w=10u l=1u
X1027 a_55254_58232# a_56814_62632# VDD VDD pfet_06v0 ad=1.3p pd=5.52u as=1.3p ps=5.52u w=5u l=1u
X1028 a_32182_58232# a_8798_58116# a_29706_58162# VSS nfet_06v0 ad=1.3p pd=5.52u as=2.2p ps=10.88u w=5u l=1u
X1029 S3N a_4966_28704# VSS ppolyf_u_1k r_width=1u r_length=2u
X1030 VSS VDD VSS VSS nfet_06v0 ad=4.29p pd=20.38u as=0 ps=0 w=9.75u l=2u
X1031 a_44572_33170# a_59990_33170# VSS ppolyf_u_1k r_width=1u r_length=76.45u
X1032 a_2510_23466# a_2510_23466# VDD VDD pfet_06v0 ad=0.88p pd=4.88u as=0.88p ps=4.88u w=2u l=1u
X1033 a_25042_4780# a_26812_12482# VDD VDD pfet_06v0 ad=1.65p pd=5.66u as=2.2p ps=10.88u w=5u l=1u
X1034 a_27476_12482# a_27476_12482# a_29836_11482# VDD pfet_06v0 ad=4.4p pd=20.88u as=3.3p ps=10.66u w=10u l=1u
X1035 a_3244_34520# a_8798_58116# VSS ppolyf_u_1k r_width=1u r_length=76.45u
X1036 a_64146_11482# a_64446_11482# a_75590_4780# VSS nfet_06v0 ad=0.44p pd=2.88u as=0.25p ps=1.5u w=1u l=1u
X1037 a_42842_66968# a_34858_71368# VDD VDD pfet_06v0 ad=4.4p pd=20.88u as=2.6p ps=10.52u w=10u l=1u
X1038 a_52778_66898# a_7686_66852# a_55254_66968# VSS nfet_06v0 ad=2.2p pd=10.88u as=1.3p ps=5.52u w=5u l=1u
X1039 a_22918_81096# a_23006_81052# VDD VDD pfet_06v0 ad=1.32p pd=6.88u as=1.32p ps=6.88u w=3u l=1u
X1040 VSS VDD VSS VSS nfet_06v0 ad=7.92p pd=36.88u as=0 ps=0 w=18u l=2u
X1041 a_64146_35450# a_64446_35450# a_75590_28748# VSS nfet_06v0 ad=0.44p pd=2.88u as=0.25p ps=1.5u w=1u l=1u
X1042 VDD a_10558_62632# a_8998_58232# VDD pfet_06v0 ad=1.3p pd=5.52u as=1.3p ps=5.52u w=5u l=1u
X1043 a_67102_28748# a_68140_36450# VDD VDD pfet_06v0 ad=1.65p pd=5.66u as=2.2p ps=10.88u w=5u l=1u
X1044 a_47532_36450# a_47714_28704# a_47050_28704# VSS nfet_06v0 ad=1.1p pd=5.88u as=0.825p ps=3.16u w=2.5u l=1u
X1045 VDD a_17396_80992# a_17396_80992# VDD pfet_06v0 ad=0.88p pd=4.88u as=0.52p ps=2.52u w=2u l=1u
X1046 a_32182_58232# a_25694_61586# a_33742_62632# VDD pfet_06v0 ad=2.2p pd=10.88u as=1.3p ps=5.52u w=5u l=1u
X1047 a_49158_66854# a_48426_66854# a_49358_66898# VSS nfet_06v0 ad=2.2p pd=10.88u as=1.25p ps=5.5u w=5u l=1u
X1048 Y a_7876_80992# VSS ppolyf_u_1k r_width=1u r_length=2u
X1049 a_18294_66898# a_18094_66854# VSS VSS nfet_06v0 ad=1.25p pd=5.5u as=2.2p ps=10.88u w=5u l=1u
X1050 a_19658_66968# a_11222_66968# VSS VSS nfet_06v0 ad=1.3p pd=5.52u as=2.2p ps=10.88u w=5u l=1u
X1051 a_30870_40756# a_23852_9202# VDD VDD pfet_06v0 ad=0.22p pd=1.88u as=0.22p ps=1.88u w=0.5u l=1u
X1052 a_36952_23582# a_22818_23466# VDD VDD pfet_06v0 ad=2.5p pd=10.5u as=4.4p ps=20.88u w=10u l=1u
X1053 a_64550_66898# a_64350_66854# VSS VSS nfet_06v0 ad=1.25p pd=5.5u as=2.2p ps=10.88u w=5u l=1u
X1054 a_31070_40872# a_33742_45272# VDD VDD pfet_06v0 ad=1.3p pd=5.52u as=2.2p ps=10.88u w=5u l=1u
X1055 a_25394_44226# a_25694_44226# a_28630_44342# VDD pfet_06v0 ad=4.4p pd=20.88u as=2.5p ps=10.5u w=10u l=1u
X1056 VDD VSS VDD VDD pfet_06v0 ad=0.66p pd=3.88u as=0 ps=0 w=1.5u l=2u
X1057 VDD a_56814_45272# a_55254_40872# VDD pfet_06v0 ad=1.3p pd=5.52u as=1.3p ps=5.52u w=5u l=1u
X1058 a_50554_81052# a_57478_66968# VSS VSS nfet_06v0 ad=1.3p pd=5.52u as=2.2p ps=10.88u w=5u l=1u
X1059 a_64106_16720# a_64446_23466# a_78280_23582# VDD pfet_06v0 ad=4.4p pd=20.88u as=2.5p ps=10.5u w=10u l=1u
X1060 a_30954_81052# a_57478_49608# VSS VSS nfet_06v0 ad=2.2p pd=10.88u as=1.3p ps=5.52u w=5u l=1u
X1061 a_43838_11482# a_43838_11482# VDD VDD pfet_06v0 ad=0.88p pd=4.88u as=0.88p ps=4.88u w=2u l=1u
X1062 a_7686_40756# a_7674_4780# VSS VSS nfet_06v0 ad=0.44p pd=2.88u as=0.44p ps=2.88u w=1u l=1u
X1063 a_57930_54008# a_48766_52962# a_54142_49608# VDD pfet_06v0 ad=1.3p pd=5.52u as=2.2p ps=10.88u w=5u l=1u
X1064 a_23318_11598# a_23118_11482# a_24130_11598# VDD pfet_06v0 ad=4.4p pd=20.88u as=2.5p ps=10.5u w=10u l=1u
X1065 a_10110_40872# a_16044_45226# a_10558_45272# VDD pfet_06v0 ad=2.2p pd=10.88u as=2.2p ps=10.88u w=5u l=1u
X1066 a_47532_12482# a_47714_4736# a_47050_4736# VSS nfet_06v0 ad=1.1p pd=5.88u as=0.825p ps=3.16u w=2.5u l=1u
X1067 a_67102_16764# a_25574_16720# a_64606_16764# VSS nfet_06v0 ad=0.44p pd=2.88u as=0.44p ps=2.88u w=1u l=1u
X1068 a_30036_35566# a_29836_35450# VDD VDD pfet_06v0 ad=2.5p pd=10.5u as=4.4p ps=20.88u w=10u l=1u
X1069 a_25694_70322# a_25694_70322# a_28350_66898# VSS nfet_06v0 ad=0.44p pd=2.88u as=0.25p ps=1.5u w=1u l=1u
X1070 a_26330_16720# a_23078_16720# a_26054_25382# VSS nfet_06v0 ad=0.825p pd=3.16u as=0.825p ps=3.16u w=2.5u l=1u
X1071 a_56366_40872# a_62300_45226# a_56814_45272# VDD pfet_06v0 ad=2.2p pd=10.88u as=2.2p ps=10.88u w=5u l=1u
X1072 S2P a_4234_4736# VSS ppolyf_u_1k r_width=1u r_length=2u
X1073 a_26812_36450# a_23118_35450# a_25774_28748# VDD pfet_06v0 ad=1.65p pd=5.66u as=1.65p ps=5.66u w=5u l=1u
X1074 a_16044_71322# a_2170_66854# a_17238_66898# VSS nfet_06v0 ad=2.2p pd=10.88u as=1.25p ps=5.5u w=5u l=1u
X1075 a_5166_40802# a_2510_44226# VSS VSS nfet_06v0 ad=0.25p pd=1.5u as=0.44p ps=2.88u w=1u l=1u
X1076 a_8998_40872# a_10558_45272# VDD VDD pfet_06v0 ad=1.3p pd=5.52u as=2.2p ps=10.88u w=5u l=1u
X1077 a_34858_62632# a_38758_58118# a_34406_58232# VSS nfet_06v0 ad=1.1p pd=5.88u as=1.1p ps=5.88u w=2.5u l=1u
X1078 VDD VSS VDD VDD pfet_06v0 ad=0.88p pd=4.88u as=0 ps=0 w=2u l=2u
X1079 a_75916_51146# a_7876_80992# VSS VSS nfet_06v0 ad=0.5p pd=2.5u as=0.88p ps=4.88u w=2u l=1u
X1080 a_48196_24466# a_43798_16720# a_50066_16764# VSS nfet_06v0 ad=2.2p pd=10.88u as=1.25p ps=5.5u w=5u l=1u
X1081 a_33742_45272# a_25694_44226# a_32182_40872# VDD pfet_06v0 ad=1.3p pd=5.52u as=2.2p ps=10.88u w=5u l=1u
X1082 a_44572_33170# a_47714_28704# a_49002_28748# VSS nfet_06v0 ad=1.1p pd=5.88u as=0.825p ps=3.16u w=2.5u l=1u
X1083 a_7674_28748# a_6868_36450# a_3244_33170# VDD pfet_06v0 ad=2.2p pd=10.88u as=1.65p ps=5.66u w=5u l=1u
X1084 a_8798_58116# a_3244_33170# VDD VDD pfet_06v0 ad=0.22p pd=1.88u as=0.22p ps=1.88u w=0.5u l=1u
X1085 a_66570_25362# a_30870_58116# cap_mim_2f0_m4m5_noshield c_width=25u c_length=4u
X1086 a_74516_59840# a_17396_80992# a_17396_80992# VSS nfet_06v0 ad=0.88p pd=4.88u as=0.52p ps=2.52u w=2u l=1u
X1087 a_54142_58232# a_56814_62632# VDD VDD pfet_06v0 ad=1.3p pd=5.52u as=2.2p ps=10.88u w=5u l=1u
X1088 VSS a_19658_58232# a_45190_81096# VSS nfet_06v0 ad=0.44p pd=2.88u as=0.25p ps=1.5u w=1u l=1u
X1089 VSS a_10110_40872# a_8326_44272# VSS nfet_06v0 ad=1.1p pd=5.88u as=0.65p ps=3.02u w=2.5u l=1u
D21 VSS Y diode_nd2ps_06v0 pj=30u area=50p
X1090 a_30038_49538# a_25354_49494# a_29706_49538# VSS nfet_06v0 ad=1.25p pd=5.5u as=1.65p ps=5.66u w=5u l=1u
X1091 a_44572_9202# a_59990_9202# VSS ppolyf_u_1k r_width=1u r_length=76.45u
X1092 a_44850_35566# a_43538_35450# VDD VDD pfet_06v0 ad=2.5p pd=10.5u as=4.4p ps=20.88u w=10u l=1u
X1093 a_34262_4780# a_23118_11482# VSS VSS nfet_06v0 ad=0.25p pd=1.5u as=0.44p ps=2.88u w=1u l=1u
X1094 VSS VDD VSS VSS nfet_06v0 ad=0.88p pd=4.88u as=0 ps=0 w=2u l=2u
X1095 a_31070_49608# a_33742_54008# VDD VDD pfet_06v0 ad=1.3p pd=5.52u as=2.2p ps=10.88u w=5u l=1u
X1096 a_32182_40872# a_8798_40756# a_29706_40802# VSS nfet_06v0 ad=1.3p pd=5.52u as=2.2p ps=10.88u w=5u l=1u
X1097 VDD a_56814_54008# a_55254_49608# VDD pfet_06v0 ad=1.3p pd=5.52u as=1.3p ps=5.52u w=5u l=1u
X1098 VSS a_2902_58118# a_6854_58162# VSS nfet_06v0 ad=2.2p pd=10.88u as=1.25p ps=5.5u w=5u l=1u
X1099 a_64646_23582# a_64446_23466# a_65458_23582# VDD pfet_06v0 ad=4.4p pd=20.88u as=2.5p ps=10.5u w=10u l=1u
X1100 a_44572_33170# a_43838_35450# a_45762_28748# VDD pfet_06v0 ad=1.65p pd=5.66u as=1.65p ps=5.66u w=5u l=1u
X1101 a_17396_80992# a_40650_82772# a_71560_58632# VSS nfet_06v0 ad=0.6448p pd=3u as=1.0912p ps=5.84u w=2.48u l=1u
X1102 a_17396_80992# a_17396_80992# VDD VDD pfet_06v0 ad=0.52p pd=2.52u as=0.52p ps=2.52u w=2u l=1u
X1103 a_68140_24466# a_68322_16720# a_67658_16720# VSS nfet_06v0 ad=1.1p pd=5.88u as=0.825p ps=3.16u w=2.5u l=1u
X1104 a_9428_35566# a_9228_35450# VDD VDD pfet_06v0 ad=2.5p pd=10.5u as=4.4p ps=20.88u w=10u l=1u
X1105 a_75274_41272# a_73010_41156# a_74974_41272# VSS nfet_06v0 ad=0.175p pd=1.2u as=0.175p ps=1.2u w=0.7u l=1u
X1106 VSS VDD VSS VSS nfet_06v0 ad=0.88p pd=4.88u as=0 ps=0 w=2u l=2u
X1107 a_28282_16764# a_23078_16720# a_25242_25362# VSS nfet_06v0 ad=0.825p pd=3.16u as=0.825p ps=3.16u w=2.5u l=1u
X1108 a_5722_16720# a_2470_16720# a_5446_25382# VSS nfet_06v0 ad=0.825p pd=3.16u as=0.825p ps=3.16u w=2.5u l=1u
X1109 a_57930_71368# a_61830_66854# a_57478_66968# VSS nfet_06v0 ad=1.1p pd=5.88u as=1.1p ps=5.88u w=2.5u l=1u
X1110 a_5446_70438# a_2210_70322# VDD VDD pfet_06v0 ad=2.5p pd=10.5u as=4.4p ps=20.88u w=10u l=1u
X1111 a_7686_49492# a_65180_9202# VDD VDD pfet_06v0 ad=0.22p pd=1.88u as=0.22p ps=1.88u w=0.5u l=1u
X1112 a_43798_4736# a_43798_4736# VSS VSS nfet_06v0 ad=0.44p pd=2.88u as=0.44p ps=2.88u w=1u l=1u
X1113 a_8998_49608# a_10558_54008# VDD VDD pfet_06v0 ad=1.3p pd=5.52u as=2.2p ps=10.88u w=5u l=1u
X1114 a_52200_35566# a_43538_35450# VDD VDD pfet_06v0 ad=2.5p pd=10.5u as=4.4p ps=20.88u w=10u l=1u
X1115 a_33742_54008# a_25694_52962# a_32182_49608# VDD pfet_06v0 ad=1.3p pd=5.52u as=2.2p ps=10.88u w=5u l=1u
X1116 a_80204_11598# a_64146_11482# VDD VDD pfet_06v0 ad=2.5p pd=10.5u as=4.4p ps=20.88u w=10u l=1u
X1117 a_18094_49494# a_2170_49494# a_18294_49538# VSS nfet_06v0 ad=1.65p pd=5.66u as=1.25p ps=5.5u w=5u l=1u
X1118 VDD VSS VDD VDD pfet_06v0 ad=4.29p pd=20.38u as=0 ps=0 w=9.75u l=2u
X1119 VDD VSS VDD VDD pfet_06v0 ad=0.88p pd=4.88u as=0 ps=0 w=2u l=2u
X1120 VDD a_33742_71368# a_31070_66968# VDD pfet_06v0 ad=2.2p pd=10.88u as=1.3p ps=5.52u w=5u l=1u
X1121 a_67382_37366# a_4966_28704# a_64646_35566# VDD pfet_06v0 ad=0.44p pd=2.88u as=0.44p ps=2.88u w=1u l=1u
X1122 XP a_74894_44688# VDD VDD pfet_05v0 ad=0.8052p pd=4.54u as=0.8052p ps=4.54u w=1.83u l=0.5u
X1123 a_7214_53078# a_2510_52962# a_6882_53078# VDD pfet_06v0 ad=2.5p pd=10.5u as=3.3p ps=10.66u w=10u l=1u
X1124 VSS VDD VSS VSS nfet_06v0 ad=4.29p pd=20.38u as=0 ps=0 w=9.75u l=2u
X1125 VDD a_10558_62632# a_8998_58232# VDD pfet_06v0 ad=2.2p pd=10.88u as=1.3p ps=5.52u w=5u l=1u
X1126 a_64350_49494# a_48426_49494# a_64550_49538# VSS nfet_06v0 ad=1.65p pd=5.66u as=1.25p ps=5.5u w=5u l=1u
X1127 VSS VDD VSS VSS nfet_06v0 ad=4.29p pd=20.38u as=0 ps=0 w=9.75u l=2u
X1128 a_35840_35566# a_22818_35450# VDD VDD pfet_06v0 ad=2.5p pd=10.5u as=4.4p ps=20.88u w=10u l=1u
X1129 a_25594_53078# a_25394_52962# VDD VDD pfet_06v0 ad=2.5p pd=10.5u as=4.4p ps=20.88u w=10u l=1u
X1130 a_65180_9652# a_80598_9202# VSS ppolyf_u_1k r_width=1u r_length=76.45u
X1131 a_31070_40872# a_33742_45272# VDD VDD pfet_06v0 ad=1.3p pd=5.52u as=1.3p ps=5.52u w=5u l=1u
X1132 a_72808_11598# a_64146_11482# VDD VDD pfet_06v0 ad=2.5p pd=10.5u as=4.4p ps=20.88u w=10u l=1u
X1133 a_2210_44226# a_2510_44226# a_5446_44342# VDD pfet_06v0 ad=4.4p pd=20.88u as=2.5p ps=10.5u w=10u l=1u
X1134 a_75274_50008# a_73010_49892# a_74974_50008# VSS nfet_06v0 ad=0.175p pd=1.2u as=0.175p ps=1.2u w=0.7u l=1u
X1135 VSS VDD VSS VSS nfet_06v0 ad=4.29p pd=20.38u as=0 ps=0 w=9.75u l=2u
X1136 a_57478_66968# a_62300_71322# a_57930_71368# VDD pfet_06v0 ad=2.2p pd=10.88u as=2.2p ps=10.88u w=5u l=1u
X1137 a_64606_28748# a_64406_28704# a_65338_28748# VSS nfet_06v0 ad=2.2p pd=10.88u as=1.25p ps=5.5u w=5u l=1u
X1138 a_6522_66898# a_7686_66852# a_7886_66968# VSS nfet_06v0 ad=2.2p pd=10.88u as=1.3p ps=5.52u w=5u l=1u
X1139 a_17692_61586# a_2510_61586# a_17892_61702# VDD pfet_06v0 ad=3.3p pd=10.66u as=2.5p ps=10.5u w=10u l=1u
X1140 a_41030_81052# a_34858_62632# VDD VDD pfet_06v0 ad=2.6p pd=10.52u as=4.4p ps=20.88u w=10u l=1u
X1141 VSS a_21542_81052# a_21162_82772# VSS nfet_06v0 ad=0.44p pd=2.88u as=0.33p ps=1.66u w=1u l=1u
X1142 a_8326_53008# a_19658_49608# cap_mim_2f0_m4m5_noshield c_width=20u c_length=10u
X1143 a_2510_70322# a_2510_70322# a_5166_66898# VSS nfet_06v0 ad=0.44p pd=2.88u as=0.25p ps=1.5u w=1u l=1u
X1144 VDD VSS VDD VDD pfet_06v0 ad=0.66p pd=3.88u as=0 ps=0 w=1.5u l=2u
X1145 a_48766_61586# a_48766_61586# VDD VDD pfet_06v0 ad=0.88p pd=4.88u as=0.88p ps=4.88u w=2u l=1u
X1146 a_15574_40758# a_15574_40758# a_18094_40758# VSS nfet_06v0 ad=2.2p pd=10.88u as=1.65p ps=5.66u w=5u l=1u
X1147 a_2902_49494# a_2170_49494# a_3102_49538# VSS nfet_06v0 ad=2.2p pd=10.88u as=1.25p ps=5.5u w=5u l=1u
X1148 VSS a_30954_81052# a_33682_81096# VSS nfet_06v0 ad=0.44p pd=2.88u as=0.25p ps=1.5u w=1u l=1u
X1149 a_8798_40756# a_49002_4780# VSS VSS nfet_06v0 ad=0.44p pd=2.88u as=0.44p ps=2.88u w=1u l=1u
X1150 a_22978_28748# a_22778_28704# VSS VSS nfet_06v0 ad=1.25p pd=5.5u as=2.2p ps=10.88u w=5u l=1u
D22 VSS S4N diode_nd2ps_06v0 pj=30u area=50p
X1151 a_12622_16764# a_2170_16720# VSS VSS nfet_06v0 ad=1.25p pd=5.5u as=2.2p ps=10.88u w=5u l=1u
X1152 a_50066_28748# a_43498_28704# VSS VSS nfet_06v0 ad=1.25p pd=5.5u as=2.2p ps=10.88u w=5u l=1u
X1153 a_29836_35450# a_23118_35450# a_30036_35566# VDD pfet_06v0 ad=3.3p pd=10.66u as=2.5p ps=10.5u w=10u l=1u
X1154 VDD VSS VDD VDD pfet_06v0 ad=0.88p pd=4.88u as=0 ps=0 w=2u l=2u
X1155 a_6882_70438# a_8798_66852# a_9442_70368# VDD pfet_06v0 ad=4.4p pd=20.88u as=2.6p ps=10.52u w=10u l=1u
X1156 a_43498_16720# a_43798_16720# a_53950_16764# VSS nfet_06v0 ad=2.2p pd=10.88u as=1.25p ps=5.5u w=5u l=1u
X1157 a_23018_35566# a_22818_35450# VDD VDD pfet_06v0 ad=2.5p pd=10.5u as=4.4p ps=20.88u w=10u l=1u
X1158 a_49002_4780# a_48196_12482# a_44572_9202# VDD pfet_06v0 ad=2.2p pd=10.88u as=1.65p ps=5.66u w=5u l=1u
X1159 Z a_17396_80992# VSS ppolyf_u_1k r_width=1u r_length=2u
X1160 VSS VDD VSS VSS nfet_06v0 ad=0.88p pd=4.88u as=0 ps=0 w=2u l=2u
X1161 a_30870_40756# a_28282_4780# VSS VSS nfet_06v0 ad=0.44p pd=2.88u as=0.44p ps=2.88u w=1u l=1u
X1162 S4N a_4966_16720# VSS ppolyf_u_1k r_width=1u r_length=2u
X1163 VSS VDD VSS VSS nfet_06v0 ad=4.29p pd=20.38u as=0 ps=0 w=9.75u l=2u
X1164 a_64646_35566# a_64446_35450# a_64346_35566# VDD pfet_06v0 ad=4.4p pd=20.88u as=2.5p ps=10.5u w=10u l=1u
X1165 a_31070_49608# a_33742_54008# VDD VDD pfet_06v0 ad=1.3p pd=5.52u as=1.3p ps=5.52u w=5u l=1u
X1166 a_68140_12482# a_68322_4736# a_67658_4736# VSS nfet_06v0 ad=1.1p pd=5.88u as=0.825p ps=3.16u w=2.5u l=1u
X1167 a_52478_66898# a_49158_66854# VSS VSS nfet_06v0 ad=1.25p pd=5.5u as=2.2p ps=10.88u w=5u l=1u
X1168 a_67658_16720# a_68804_24466# a_68140_24466# VDD pfet_06v0 ad=2.2p pd=10.88u as=1.65p ps=5.66u w=5u l=1u
X1169 a_2170_49494# a_2170_49494# VSS VSS nfet_06v0 ad=0.44p pd=2.88u as=0.44p ps=2.88u w=1u l=1u
X1170 a_31510_61632# a_30870_58116# a_30066_61702# VDD pfet_06v0 ad=2.6p pd=10.52u as=4.4p ps=20.88u w=10u l=1u
X1171 a_6204_24466# a_2510_23466# a_5166_16764# VDD pfet_06v0 ad=1.65p pd=5.66u as=1.65p ps=5.66u w=5u l=1u
X1172 a_40876_70322# a_25694_70322# a_41076_70438# VDD pfet_06v0 ad=3.3p pd=10.66u as=2.5p ps=10.5u w=10u l=1u
X1173 a_23852_9652# a_39270_10102# VSS ppolyf_u_1k r_width=1u r_length=76.45u
X1174 a_30870_66852# a_44572_33170# VDD VDD pfet_06v0 ad=0.22p pd=1.88u as=0.22p ps=1.88u w=0.5u l=1u
X1175 VSS a_26086_49494# a_30038_49538# VSS nfet_06v0 ad=2.2p pd=10.88u as=1.25p ps=5.5u w=5u l=1u
X1176 a_31480_11598# a_22818_11482# VDD VDD pfet_06v0 ad=2.5p pd=10.5u as=4.4p ps=20.88u w=10u l=1u
X1177 a_6386_16720# a_2510_23466# a_10872_23582# VDD pfet_06v0 ad=4.4p pd=20.88u as=2.5p ps=10.5u w=10u l=1u
X1178 a_4434_4780# a_4234_4736# a_2670_4780# VSS nfet_06v0 ad=0.44p pd=2.88u as=0.44p ps=2.88u w=1u l=1u
X1179 a_8798_49492# a_25042_16764# cap_mim_2f0_m4m5_noshield c_width=25u c_length=4u
X1180 a_30906_82772# a_30954_81052# VSS VSS nfet_06v0 ad=0.33p pd=1.66u as=0.44p ps=2.88u w=1u l=1u
X1181 VDD a_56814_45272# a_55254_40872# VDD pfet_06v0 ad=2.2p pd=10.88u as=1.3p ps=5.52u w=5u l=1u
X1182 VDD a_25394_52962# a_30398_53078# VDD pfet_06v0 ad=4.4p pd=20.88u as=2.5p ps=10.5u w=10u l=1u
X1183 a_53110_58162# a_48426_58118# a_52778_58162# VSS nfet_06v0 ad=1.25p pd=5.5u as=1.65p ps=5.66u w=5u l=1u
X1184 VDD VSS VDD VDD pfet_06v0 ad=0.88p pd=4.88u as=0 ps=0 w=2u l=2u
X1185 a_45962_13378# a_8798_40756# cap_mim_2f0_m4m5_noshield c_width=25u c_length=4u
X1186 a_7886_49608# a_7686_49492# a_6522_49538# VSS nfet_06v0 ad=1.3p pd=5.52u as=2.2p ps=10.88u w=5u l=1u
X1187 VDD VSS VDD VDD pfet_06v0 ad=0.88p pd=4.88u as=0 ps=0 w=2u l=2u
X1188 a_30954_81052# a_54142_49608# cap_mim_2f0_m4m5_noshield c_width=20u c_length=10u
X1189 VSS VDD VSS VSS nfet_06v0 ad=4.29p pd=20.38u as=0 ps=0 w=9.75u l=2u
X1190 a_45962_25362# a_7686_58116# cap_mim_2f0_m4m5_noshield c_width=25u c_length=4u
X1191 a_49358_58162# a_49158_58118# VSS VSS nfet_06v0 ad=1.25p pd=5.5u as=2.2p ps=10.88u w=5u l=1u
X1192 a_48466_52962# a_48766_52962# a_51702_53078# VDD pfet_06v0 ad=4.4p pd=20.88u as=2.5p ps=10.5u w=10u l=1u
X1193 a_50922_16720# a_43798_16720# a_51122_16764# VSS nfet_06v0 ad=1.65p pd=5.66u as=1.25p ps=5.5u w=5u l=1u
X1194 a_4634_37346# a_4234_28704# a_2710_35566# VDD pfet_06v0 ad=0.484p pd=3.08u as=0.484p ps=3.08u w=1.1u l=1u
X1195 a_11222_66968# a_2170_66854# a_8326_70368# VSS nfet_06v0 ad=0.65p pd=3.02u as=1.1p ps=5.88u w=2.5u l=1u
X1196 VSS VDD VSS VSS nfet_06v0 ad=4.29p pd=20.38u as=0 ps=0 w=9.75u l=2u
X1197 VDD VSS VDD VDD pfet_06v0 ad=4.29p pd=20.38u as=0 ps=0 w=9.75u l=2u
D23 VSS Z diode_nd2ps_06v0 pj=30u area=50p
X1198 a_7686_49492# a_65180_9202# VDD VDD pfet_06v0 ad=0.22p pd=1.88u as=0.22p ps=1.88u w=0.5u l=1u
X1199 a_48196_12482# a_43798_4736# a_50066_4780# VSS nfet_06v0 ad=2.2p pd=10.88u as=1.25p ps=5.5u w=5u l=1u
X1200 a_2510_35450# a_2510_35450# VDD VDD pfet_06v0 ad=0.88p pd=4.88u as=0.88p ps=4.88u w=2u l=1u
X1201 a_24770_81052# a_19658_40872# VDD VDD pfet_06v0 ad=0.99p pd=3.66u as=1.32p ps=6.88u w=3u l=1u
X1202 VDD a_41674_81096# a_42494_81052# VDD pfet_06v0 ad=1.32p pd=6.88u as=0.99p ps=3.66u w=3u l=1u
X1203 VSS a_11222_58232# a_19658_58232# VSS nfet_06v0 ad=1.3p pd=5.52u as=1.3p ps=5.52u w=5u l=1u
X1204 a_17396_80992# a_17396_80992# VDD VDD pfet_06v0 ad=0.52p pd=2.52u as=0.88p ps=4.88u w=2u l=1u
X1205 a_3244_9652# a_18662_10102# VSS ppolyf_u_1k r_width=1u r_length=76.45u
X1206 a_28350_58162# a_25694_61586# VSS VSS nfet_06v0 ad=0.25p pd=1.5u as=0.44p ps=2.88u w=1u l=1u
X1207 a_2510_23466# a_2510_23466# a_14686_16764# VSS nfet_06v0 ad=0.44p pd=2.88u as=0.25p ps=1.5u w=1u l=1u
X1208 a_56014_16764# a_43838_23466# VSS VSS nfet_06v0 ad=0.25p pd=1.5u as=0.44p ps=2.88u w=1u l=1u
X1209 VSS VDD VSS VSS nfet_06v0 ad=7.92p pd=36.88u as=0 ps=0 w=18u l=2u
D24 VSS S2P diode_nd2ps_06v0 pj=30u area=50p
X1210 a_17238_58162# a_2902_58118# VSS VSS nfet_06v0 ad=1.25p pd=5.5u as=2.2p ps=10.88u w=5u l=1u
X1211 VDD a_33742_62632# a_31070_58232# VDD pfet_06v0 ad=1.3p pd=5.52u as=1.3p ps=5.52u w=5u l=1u
X1212 a_30066_70438# a_25694_70322# a_29766_70438# VDD pfet_06v0 ad=3.3p pd=10.66u as=2.5p ps=10.5u w=10u l=1u
X1213 a_6386_16720# a_6386_16720# a_9594_16720# VSS nfet_06v0 ad=2.2p pd=10.88u as=1.65p ps=5.66u w=5u l=1u
X1214 a_28282_4780# a_23078_4736# a_25242_13378# VSS nfet_06v0 ad=0.825p pd=3.16u as=0.825p ps=3.16u w=2.5u l=1u
X1215 a_6854_40802# a_2170_40758# a_6522_40802# VSS nfet_06v0 ad=1.25p pd=5.5u as=1.65p ps=5.66u w=5u l=1u
X1216 a_30398_44342# a_25694_44226# a_30066_44342# VDD pfet_06v0 ad=2.5p pd=10.5u as=3.3p ps=10.66u w=10u l=1u
X1217 VSS a_54114_81052# a_54026_81096# VSS nfet_06v0 ad=0.44p pd=2.88u as=0.44p ps=2.88u w=1u l=1u
X1218 a_36952_35566# a_22818_35450# VDD VDD pfet_06v0 ad=2.5p pd=10.5u as=4.4p ps=20.88u w=10u l=1u
X1219 VDD a_56814_54008# a_55254_49608# VDD pfet_06v0 ad=2.2p pd=10.88u as=1.3p ps=5.52u w=5u l=1u
X1220 a_5722_4736# a_6868_12482# a_6204_12482# VDD pfet_06v0 ad=2.2p pd=10.88u as=1.65p ps=5.66u w=5u l=1u
X1221 VSS VDD VSS VSS nfet_06v0 ad=0.66p pd=3.88u as=0 ps=0 w=1.5u l=2u
X1222 a_4134_49538# a_2510_52962# VSS VSS nfet_06v0 ad=0.25p pd=1.5u as=0.44p ps=2.88u w=1u l=1u
X1223 a_9794_4780# a_9594_4736# VSS VSS nfet_06v0 ad=1.25p pd=5.5u as=2.2p ps=10.88u w=5u l=1u
X1224 a_64106_28704# a_64446_35450# a_78280_35566# VDD pfet_06v0 ad=4.4p pd=20.88u as=2.5p ps=10.5u w=10u l=1u
X1225 a_51702_44342# a_48466_44226# VDD VDD pfet_06v0 ad=2.5p pd=10.5u as=4.4p ps=20.88u w=10u l=1u
X1226 a_30870_58116# a_65180_21186# VDD VDD pfet_06v0 ad=0.22p pd=1.88u as=0.22p ps=1.88u w=0.5u l=1u
X1227 a_34426_81096# a_34514_81052# VDD VDD pfet_06v0 ad=1.32p pd=6.88u as=1.32p ps=6.88u w=3u l=1u
X1228 a_39228_45226# a_39228_45226# a_40876_44226# VDD pfet_06v0 ad=4.4p pd=20.88u as=3.3p ps=10.66u w=10u l=1u
X1229 a_25694_70322# a_25694_70322# VDD VDD pfet_06v0 ad=0.88p pd=4.88u as=0.88p ps=4.88u w=2u l=1u
X1230 VSS a_56366_66968# a_54582_70368# VSS nfet_06v0 ad=1.1p pd=5.88u as=0.65p ps=3.02u w=2.5u l=1u
X1231 a_8798_66852# a_66370_28748# cap_mim_2f0_m4m5_noshield c_width=25u c_length=4u
X1232 a_52778_49538# a_48426_49494# a_52478_49538# VSS nfet_06v0 ad=1.65p pd=5.66u as=1.25p ps=5.5u w=5u l=1u
X1233 a_2170_58118# a_2510_61586# a_2410_61702# VDD pfet_06v0 ad=4.4p pd=20.88u as=2.5p ps=10.5u w=10u l=1u
X1234 a_54982_16764# a_43838_23466# VSS VSS nfet_06v0 ad=0.25p pd=1.5u as=0.44p ps=2.88u w=1u l=1u
X1235 a_67102_28748# a_4966_28704# a_64606_28748# VSS nfet_06v0 ad=0.44p pd=2.88u as=0.44p ps=2.88u w=1u l=1u
X1236 a_2710_11598# a_2510_11482# a_2410_11598# VDD pfet_06v0 ad=4.4p pd=20.88u as=2.5p ps=10.5u w=10u l=1u
X1237 a_26330_28704# a_23078_28704# a_26054_37366# VSS nfet_06v0 ad=0.825p pd=3.16u as=0.825p ps=3.16u w=2.5u l=1u
X1238 a_51422_66898# a_48766_70322# VSS VSS nfet_06v0 ad=0.25p pd=1.5u as=0.44p ps=2.88u w=1u l=1u
X1239 a_38758_66854# a_38758_66854# a_41278_66854# VSS nfet_06v0 ad=2.2p pd=10.88u as=1.65p ps=5.66u w=5u l=1u
X1240 VDD a_56814_45272# a_54142_40872# VDD pfet_06v0 ad=1.3p pd=5.52u as=1.3p ps=5.52u w=5u l=1u
X1241 VDD VSS VDD VDD pfet_06v0 ad=4.29p pd=20.38u as=0 ps=0 w=9.75u l=2u
X1242 a_2470_4736# a_2510_11482# a_15232_11598# VDD pfet_06v0 ad=4.4p pd=20.88u as=2.5p ps=10.5u w=10u l=1u
X1243 VDD VSS VDD VDD pfet_06v0 ad=0.88p pd=4.88u as=0 ps=0 w=2u l=2u
X1244 VDD VSS VDD VDD pfet_06v0 ad=0.66p pd=3.88u as=0 ps=0 w=1.5u l=2u
X1245 a_48196_36450# a_43798_28704# a_50066_28748# VSS nfet_06v0 ad=2.2p pd=10.88u as=1.25p ps=5.5u w=5u l=1u
X1246 a_73010_58516# a_73010_58516# VDD VDD pfet_06v0 ad=0.88p pd=4.88u as=0.88p ps=4.88u w=2u l=1u
X1247 a_53282_81096# a_51530_81096# a_52350_81052# VSS nfet_06v0 ad=0.25p pd=1.5u as=0.44p ps=2.88u w=1u l=1u
X1248 a_22818_23466# a_23118_23466# a_38876_23582# VDD pfet_06v0 ad=4.4p pd=20.88u as=2.5p ps=10.5u w=10u l=1u
X1249 a_74516_42480# a_71650_44468# a_71650_44468# VSS nfet_06v0 ad=0.88p pd=4.88u as=0.52p ps=2.52u w=2u l=1u
X1250 a_55698_53008# a_48426_49494# a_56366_49608# VSS nfet_06v0 ad=1.1p pd=5.88u as=0.65p ps=3.02u w=2.5u l=1u
X1251 a_29766_61702# a_25394_61586# VDD VDD pfet_06v0 ad=2.5p pd=10.5u as=4.4p ps=20.88u w=10u l=1u
X1252 a_8998_40872# a_2510_44226# a_10558_45272# VDD pfet_06v0 ad=2.2p pd=10.88u as=1.3p ps=5.52u w=5u l=1u
X1253 a_31510_61632# a_33294_58232# VSS VSS nfet_06v0 ad=0.65p pd=3.02u as=1.1p ps=5.88u w=2.5u l=1u
X1254 a_23852_21636# a_39270_21186# VSS ppolyf_u_1k r_width=1u r_length=76.45u
X1255 a_31510_53008# a_25354_49494# a_34406_49608# VSS nfet_06v0 ad=1.1p pd=5.88u as=0.65p ps=3.02u w=2.5u l=1u
X1256 a_10558_71368# a_15574_66854# a_10110_66968# VSS nfet_06v0 ad=1.1p pd=5.88u as=1.1p ps=5.88u w=2.5u l=1u
X1257 VSS VDD VSS VSS nfet_06v0 ad=0.66p pd=3.88u as=0 ps=0 w=1.5u l=2u
X1258 a_54582_61632# a_30870_58116# a_53138_61702# VDD pfet_06v0 ad=2.6p pd=10.52u as=4.4p ps=20.88u w=10u l=1u
X1259 a_50390_66898# a_48766_70322# VSS VSS nfet_06v0 ad=0.25p pd=1.5u as=0.44p ps=2.88u w=1u l=1u
X1260 a_71650_44468# a_44170_81096# a_71560_41272# VSS nfet_06v0 ad=0.6448p pd=3u as=1.0912p ps=5.84u w=2.48u l=1u
X1261 a_6522_66898# a_2170_66854# a_6222_66898# VSS nfet_06v0 ad=1.65p pd=5.66u as=1.25p ps=5.5u w=5u l=1u
X1262 a_50554_81052# a_54142_66968# cap_mim_2f0_m4m5_noshield c_width=20u c_length=10u
X1263 a_64646_35566# a_64446_35450# a_65458_35566# VDD pfet_06v0 ad=4.4p pd=20.88u as=2.5p ps=10.5u w=10u l=1u
X1264 a_56814_71368# a_61830_66854# a_56366_66968# VSS nfet_06v0 ad=1.1p pd=5.88u as=1.1p ps=5.88u w=2.5u l=1u
X1265 VSS a_11222_40872# a_19658_40872# VSS nfet_06v0 ad=1.3p pd=5.52u as=1.3p ps=5.52u w=5u l=1u
X1266 a_68140_36450# a_68322_28704# a_67658_28704# VSS nfet_06v0 ad=1.1p pd=5.88u as=0.825p ps=3.16u w=2.5u l=1u
X1267 a_19658_66968# a_11674_71368# VDD VDD pfet_06v0 ad=2.6p pd=10.52u as=4.4p ps=20.88u w=10u l=1u
X1268 a_28282_28748# a_23078_28704# a_25242_37346# VSS nfet_06v0 ad=0.825p pd=3.16u as=0.825p ps=3.16u w=2.5u l=1u
X1269 a_5722_28704# a_2470_28704# a_5446_37366# VSS nfet_06v0 ad=0.825p pd=3.16u as=0.825p ps=3.16u w=2.5u l=1u
X1270 VSS VDD VSS VSS nfet_06v0 ad=0.66p pd=3.88u as=0 ps=0 w=1.5u l=2u
X1271 a_56814_71368# a_48766_70322# a_55254_66968# VDD pfet_06v0 ad=1.3p pd=5.52u as=2.2p ps=10.88u w=5u l=1u
X1272 a_67658_4736# a_64406_4736# a_67382_13398# VSS nfet_06v0 ad=0.825p pd=3.16u as=0.825p ps=3.16u w=2.5u l=1u
X1273 a_23852_21186# a_39270_21186# VSS ppolyf_u_1k r_width=1u r_length=76.45u
X1274 VDD a_56814_54008# a_54142_49608# VDD pfet_06v0 ad=1.3p pd=5.52u as=1.3p ps=5.52u w=5u l=1u
X1275 a_6522_58162# a_8798_58116# a_8998_58232# VSS nfet_06v0 ad=2.2p pd=10.88u as=1.3p ps=5.52u w=5u l=1u
X1276 Y a_7876_80992# VSS ppolyf_u_1k r_width=1u r_length=2u
X1277 a_7674_4780# a_2470_4736# a_4634_13378# VSS nfet_06v0 ad=0.825p pd=3.16u as=0.825p ps=3.16u w=2.5u l=1u
X1278 a_2510_44226# a_2510_44226# VDD VDD pfet_06v0 ad=0.88p pd=4.88u as=0.88p ps=4.88u w=2u l=1u
X1279 a_64446_11482# a_64446_11482# VDD VDD pfet_06v0 ad=0.88p pd=4.88u as=0.88p ps=4.88u w=2u l=1u
X1280 a_53138_44342# a_7686_40756# a_55698_44272# VDD pfet_06v0 ad=4.4p pd=20.88u as=2.6p ps=10.52u w=10u l=1u
X1281 a_74516_51216# a_7876_80992# a_7876_80992# VSS nfet_06v0 ad=0.88p pd=4.88u as=0.52p ps=2.52u w=2u l=1u
X1282 a_29706_58162# a_25354_58118# a_29406_58162# VSS nfet_06v0 ad=1.65p pd=5.66u as=1.25p ps=5.5u w=5u l=1u
X1283 a_21210_81052# a_54142_40872# cap_mim_2f0_m4m5_noshield c_width=20u c_length=10u
X1284 a_8998_49608# a_8798_49492# a_6522_49538# VSS nfet_06v0 ad=1.3p pd=5.52u as=2.2p ps=10.88u w=5u l=1u
X1285 a_64148_44342# a_63948_44226# VDD VDD pfet_06v0 ad=2.5p pd=10.5u as=4.4p ps=20.88u w=10u l=1u
X1286 a_8998_49608# a_2510_52962# a_10558_54008# VDD pfet_06v0 ad=2.2p pd=10.88u as=1.3p ps=5.52u w=5u l=1u
X1287 a_31510_70368# a_33294_66968# VSS VSS nfet_06v0 ad=0.65p pd=3.02u as=0.65p ps=3.02u w=2.5u l=1u
X1288 a_44572_22536# a_7686_58116# VSS ppolyf_u_1k r_width=1u r_length=76.45u
X1289 a_3244_21636# a_18662_21186# VSS ppolyf_u_1k r_width=1u r_length=76.45u
X1290 a_9442_70368# a_10110_66968# VSS VSS nfet_06v0 ad=0.65p pd=3.02u as=1.1p ps=5.88u w=2.5u l=1u
X1291 a_17892_53078# a_17692_52962# VDD VDD pfet_06v0 ad=2.5p pd=10.5u as=4.4p ps=20.88u w=10u l=1u
X1292 a_6386_4736# a_6386_4736# a_9594_4736# VSS nfet_06v0 ad=2.2p pd=10.88u as=1.65p ps=5.66u w=5u l=1u
X1293 a_11158_16764# a_7674_16764# VSS VSS nfet_06v0 ad=0.44p pd=2.88u as=0.44p ps=2.88u w=1u l=1u
X1294 a_41030_81052# a_34406_58232# VSS VSS nfet_06v0 ad=2.2p pd=10.88u as=1.3p ps=5.52u w=5u l=1u
X1295 VDD a_34858_45272# a_21542_81052# VDD pfet_06v0 ad=2.6p pd=10.52u as=2.6p ps=10.52u w=10u l=1u
X1296 a_7876_80992# a_42406_81096# a_71560_50008# VSS nfet_06v0 ad=0.6448p pd=3u as=1.0912p ps=5.84u w=2.48u l=1u
X1297 VSS VDD VSS VSS nfet_06v0 ad=0.66p pd=3.88u as=0 ps=0 w=1.5u l=2u
X1298 S2P a_4234_4736# VSS ppolyf_u_1k r_width=1u r_length=2u
X1299 VDD VSS VDD VDD pfet_06v0 ad=0.66p pd=3.88u as=0 ps=0 w=1.5u l=2u
X1300 a_55046_81096# a_42842_66968# a_54114_81052# VSS nfet_06v0 ad=0.25p pd=1.5u as=0.44p ps=2.88u w=1u l=1u
X1301 VSS VDD VSS VSS nfet_06v0 ad=0.88p pd=4.88u as=0 ps=0 w=2u l=2u
X1302 a_40698_81052# a_57930_62632# VDD VDD pfet_06v0 ad=4.4p pd=20.88u as=2.6p ps=10.52u w=10u l=1u
X1303 a_48766_52962# a_48766_52962# a_51422_49538# VSS nfet_06v0 ad=0.44p pd=2.88u as=0.25p ps=1.5u w=1u l=1u
X1304 VSS VDD VSS VSS nfet_06v0 ad=0.88p pd=4.88u as=0 ps=0 w=2u l=2u
X1305 a_54142_66968# a_48766_70322# a_57930_71368# VDD pfet_06v0 ad=2.2p pd=10.88u as=1.3p ps=5.52u w=5u l=1u
X1306 VDD a_22186_81096# a_23006_81052# VDD pfet_06v0 ad=1.32p pd=6.88u as=0.99p ps=3.66u w=3u l=1u
X1307 VDD VSS VDD VDD pfet_06v0 ad=0.66p pd=3.88u as=0 ps=0 w=1.5u l=2u
X1308 S4P a_4234_16720# VSS ppolyf_u_1k r_width=1u r_length=2u
X1309 VSS VDD VSS VSS nfet_06v0 ad=0.66p pd=3.88u as=0 ps=0 w=1.5u l=2u
X1310 VSS VDD VSS VSS nfet_06v0 ad=0.66p pd=3.88u as=0 ps=0 w=1.5u l=2u
X1311 a_3244_21186# a_18662_21186# VSS ppolyf_u_1k r_width=1u r_length=76.45u
D25 VSS X diode_nd2ps_06v0 pj=30u area=50p
X1312 a_4434_4780# a_6204_12482# VDD VDD pfet_06v0 ad=1.65p pd=5.66u as=2.2p ps=10.88u w=5u l=1u
X1313 VDD a_10558_45272# a_7886_40872# VDD pfet_06v0 ad=2.2p pd=10.88u as=1.3p ps=5.52u w=5u l=1u
X1314 a_31510_44272# a_33294_40872# VSS VSS nfet_06v0 ad=0.65p pd=3.02u as=1.1p ps=5.88u w=2.5u l=1u
X1315 VDD VSS VDD VDD pfet_06v0 ad=0.88p pd=4.88u as=0 ps=0 w=2u l=2u
X1316 a_47050_4736# a_48196_12482# a_47532_12482# VDD pfet_06v0 ad=2.2p pd=10.88u as=1.65p ps=5.66u w=5u l=1u
X1317 a_19658_66968# a_11222_66968# VSS VSS nfet_06v0 ad=2.2p pd=10.88u as=1.3p ps=5.52u w=5u l=1u
X1318 VDD a_11674_62632# a_19658_58232# VDD pfet_06v0 ad=2.6p pd=10.52u as=2.6p ps=10.52u w=10u l=1u
X1319 a_53138_53078# a_7686_49492# a_55698_53008# VDD pfet_06v0 ad=4.4p pd=20.88u as=2.6p ps=10.52u w=10u l=1u
X1320 a_11674_71368# a_2510_70322# a_7886_66968# VDD pfet_06v0 ad=1.3p pd=5.52u as=2.2p ps=10.88u w=5u l=1u
X1321 a_8798_49492# a_23852_21186# VDD VDD pfet_06v0 ad=0.22p pd=1.88u as=0.22p ps=1.88u w=0.5u l=1u
X1322 a_33742_45272# a_38758_40758# a_33294_40872# VSS nfet_06v0 ad=1.1p pd=5.88u as=1.1p ps=5.88u w=2.5u l=1u
X1323 a_8326_70368# a_19658_66968# cap_mim_2f0_m4m5_noshield c_width=20u c_length=10u
X1324 a_56560_23582# a_43538_23466# VDD VDD pfet_06v0 ad=2.5p pd=10.5u as=4.4p ps=20.88u w=10u l=1u
X1325 a_12622_28748# a_2170_28704# VSS VSS nfet_06v0 ad=1.25p pd=5.5u as=2.2p ps=10.88u w=5u l=1u
X1326 a_3102_66898# a_2902_66854# VSS VSS nfet_06v0 ad=1.25p pd=5.5u as=2.2p ps=10.88u w=5u l=1u
X1327 a_48466_52962# a_48766_52962# a_50390_49538# VSS nfet_06v0 ad=0.44p pd=2.88u as=0.25p ps=1.5u w=1u l=1u
X1328 a_61830_66854# a_61830_66854# a_64350_66854# VSS nfet_06v0 ad=2.2p pd=10.88u as=1.65p ps=5.66u w=5u l=1u
X1329 a_43498_28704# a_43798_28704# a_53950_28748# VSS nfet_06v0 ad=2.2p pd=10.88u as=1.25p ps=5.5u w=5u l=1u
X1330 a_62300_53962# a_62300_53962# a_63948_52962# VDD pfet_06v0 ad=4.4p pd=20.88u as=3.3p ps=10.66u w=10u l=1u
X1331 a_33294_66968# a_25354_66854# a_32626_70368# VSS nfet_06v0 ad=0.65p pd=3.02u as=1.1p ps=5.88u w=2.5u l=1u
X1332 VDD a_34858_54008# a_31286_81052# VDD pfet_06v0 ad=2.6p pd=10.52u as=2.6p ps=10.52u w=10u l=1u
X1333 a_30066_44342# a_30870_40756# a_31510_44272# VDD pfet_06v0 ad=4.4p pd=20.88u as=2.6p ps=10.52u w=10u l=1u
X1334 a_2902_58118# a_2510_61586# a_3522_61702# VDD pfet_06v0 ad=4.4p pd=20.88u as=2.5p ps=10.5u w=10u l=1u
X1335 a_2710_11598# a_2510_11482# a_3522_11598# VDD pfet_06v0 ad=4.4p pd=20.88u as=2.5p ps=10.5u w=10u l=1u
X1336 a_6522_40802# a_8798_40756# a_8998_40872# VSS nfet_06v0 ad=2.2p pd=10.88u as=1.3p ps=5.52u w=5u l=1u
X1337 X a_71650_44468# VSS ppolyf_u_1k r_width=1u r_length=2u
X1338 a_64146_23466# a_64446_23466# a_80204_23582# VDD pfet_06v0 ad=4.4p pd=20.88u as=2.5p ps=10.5u w=10u l=1u
X1339 VSS a_10110_58232# a_9442_61632# VSS nfet_06v0 ad=1.1p pd=5.88u as=0.65p ps=3.02u w=2.5u l=1u
X1340 a_2170_4736# a_2510_11482# a_16344_11598# VDD pfet_06v0 ad=4.4p pd=20.88u as=2.5p ps=10.5u w=10u l=1u
X1341 a_38758_49494# a_25694_52962# a_42520_53078# VDD pfet_06v0 ad=4.4p pd=20.88u as=2.5p ps=10.5u w=10u l=1u
X1342 ZN ZP VSS VSS nfet_05v0 ad=0.5808p pd=3.52u as=0.5808p ps=3.52u w=1.32u l=0.6u
X1343 a_6582_70438# a_2210_70322# VDD VDD pfet_06v0 ad=2.5p pd=10.5u as=4.4p ps=20.88u w=10u l=1u
X1344 a_67658_28704# a_68804_36450# a_68140_36450# VDD pfet_06v0 ad=2.2p pd=10.88u as=1.65p ps=5.66u w=5u l=1u
X1345 VSS VDD VSS VSS nfet_06v0 ad=0.66p pd=3.88u as=0 ps=0 w=1.5u l=2u
X1346 a_8326_44272# a_19658_40872# cap_mim_2f0_m4m5_noshield c_width=20u c_length=10u
X1347 a_6204_36450# a_2510_35450# a_5166_28748# VDD pfet_06v0 ad=1.65p pd=5.66u as=1.65p ps=5.66u w=5u l=1u
X1348 a_54582_53008# a_48426_49494# a_57478_49608# VSS nfet_06v0 ad=1.1p pd=5.88u as=0.65p ps=3.02u w=2.5u l=1u
X1349 VDD a_10558_71368# a_7886_66968# VDD pfet_06v0 ad=1.3p pd=5.52u as=1.3p ps=5.52u w=5u l=1u
X1350 a_73010_49892# a_73010_49892# VDD VDD pfet_06v0 ad=0.88p pd=4.88u as=0.88p ps=4.88u w=2u l=1u
X1351 VDD a_10558_54008# a_7886_49608# VDD pfet_06v0 ad=2.2p pd=10.88u as=1.3p ps=5.52u w=5u l=1u
X1352 a_31070_40872# a_25694_44226# a_34858_45272# VDD pfet_06v0 ad=2.2p pd=10.88u as=1.3p ps=5.52u w=5u l=1u
X1353 a_32750_81052# a_30954_81052# VDD VDD pfet_06v0 ad=0.99p pd=3.66u as=1.32p ps=6.88u w=3u l=1u
X1354 VDD VSS VDD VDD pfet_06v0 ad=7.92p pd=36.88u as=0 ps=0 w=18u l=2u
X1355 a_6386_28704# a_2510_35450# a_10872_35566# VDD pfet_06v0 ad=4.4p pd=20.88u as=2.5p ps=10.5u w=10u l=1u
X1356 a_43698_16764# a_43498_16720# VSS VSS nfet_06v0 ad=1.25p pd=5.5u as=2.2p ps=10.88u w=5u l=1u
X1357 VDD a_33742_62632# a_32182_58232# VDD pfet_06v0 ad=2.2p pd=10.88u as=1.3p ps=5.52u w=5u l=1u
X1358 a_23078_16720# a_23078_16720# VSS VSS nfet_06v0 ad=0.44p pd=2.88u as=0.44p ps=2.88u w=1u l=1u
X1359 a_21542_81052# a_34406_40872# VSS VSS nfet_06v0 ad=2.2p pd=10.88u as=1.3p ps=5.52u w=5u l=1u
X1360 VSS a_33294_49608# a_32626_53008# VSS nfet_06v0 ad=0.65p pd=3.02u as=0.65p ps=3.02u w=2.5u l=1u
X1361 a_48426_49494# a_48766_52962# a_48666_53078# VDD pfet_06v0 ad=4.4p pd=20.88u as=2.5p ps=10.5u w=10u l=1u
X1362 a_48426_58118# a_48426_58118# VSS VSS nfet_06v0 ad=0.44p pd=2.88u as=0.44p ps=2.88u w=1u l=1u
X1363 a_68322_16720# a_64446_23466# a_72808_23582# VDD pfet_06v0 ad=4.4p pd=20.88u as=2.5p ps=10.5u w=10u l=1u
X1364 a_55698_61632# a_56366_58232# VSS VSS nfet_06v0 ad=0.65p pd=3.02u as=1.1p ps=5.88u w=2.5u l=1u
X1365 VDD VSS VDD VDD pfet_06v0 ad=4.29p pd=20.38u as=0 ps=0 w=9.75u l=2u
X1366 a_45962_25362# a_4234_16720# a_44038_23582# VDD pfet_06v0 ad=0.484p pd=3.08u as=0.484p ps=3.08u w=1.1u l=1u
X1367 VDD VSS VDD VDD pfet_06v0 ad=7.92p pd=36.88u as=0 ps=0 w=18u l=2u
X1368 a_43738_23582# a_43538_23466# VDD VDD pfet_06v0 ad=2.5p pd=10.5u as=4.4p ps=20.88u w=10u l=1u
X1369 a_28282_16764# a_27476_24466# a_23852_21186# VDD pfet_06v0 ad=2.2p pd=10.88u as=1.65p ps=5.66u w=5u l=1u
X1370 a_50922_28704# a_43798_28704# a_51122_28748# VSS nfet_06v0 ad=1.65p pd=5.66u as=1.25p ps=5.5u w=5u l=1u
X1371 a_26086_49494# a_25694_52962# a_26706_53078# VDD pfet_06v0 ad=4.4p pd=20.88u as=2.5p ps=10.5u w=10u l=1u
X1372 VDD a_71650_44468# a_71650_44468# VDD pfet_06v0 ad=0.52p pd=2.52u as=0.52p ps=2.52u w=2u l=1u
X1373 VSS VDD VSS VSS nfet_06v0 ad=7.92p pd=36.88u as=0 ps=0 w=18u l=2u
X1374 a_18268_23582# a_2210_23466# VDD VDD pfet_06v0 ad=2.5p pd=10.5u as=4.4p ps=20.88u w=10u l=1u
X1375 a_30066_53078# a_11158_16764# a_31510_53008# VDD pfet_06v0 ad=4.4p pd=20.88u as=2.6p ps=10.52u w=10u l=1u
X1376 a_11222_66968# a_16044_71322# a_11674_71368# VDD pfet_06v0 ad=2.2p pd=10.88u as=2.2p ps=10.88u w=5u l=1u
X1377 a_65180_21186# a_68322_16720# a_69610_16764# VSS nfet_06v0 ad=1.1p pd=5.88u as=0.825p ps=3.16u w=2.5u l=1u
X1378 a_6882_44342# a_2510_44226# a_6582_44342# VDD pfet_06v0 ad=3.3p pd=10.66u as=2.5p ps=10.5u w=10u l=1u
X1379 a_50756_11598# a_50556_11482# VDD VDD pfet_06v0 ad=2.5p pd=10.5u as=4.4p ps=20.88u w=10u l=1u
X1380 a_7674_16764# a_2470_16720# a_4634_25362# VSS nfet_06v0 ad=0.825p pd=3.16u as=0.825p ps=3.16u w=2.5u l=1u
X1381 a_42520_44342# a_25394_44226# VDD VDD pfet_06v0 ad=2.5p pd=10.5u as=4.4p ps=20.88u w=10u l=1u
X1382 a_33230_16764# a_22778_16720# VSS VSS nfet_06v0 ad=1.25p pd=5.5u as=2.2p ps=10.88u w=5u l=1u
X1383 a_31070_66968# a_30870_66852# a_29706_66898# VSS nfet_06v0 ad=1.3p pd=5.52u as=2.2p ps=10.88u w=5u l=1u
X1384 a_11674_62632# a_15574_58118# a_11222_58232# VSS nfet_06v0 ad=1.1p pd=5.88u as=1.1p ps=5.88u w=2.5u l=1u
X1385 a_32182_40872# a_33742_45272# VDD VDD pfet_06v0 ad=1.3p pd=5.52u as=1.3p ps=5.52u w=5u l=1u
X1386 VSS a_34406_66968# a_42842_66968# VSS nfet_06v0 ad=1.3p pd=5.52u as=1.3p ps=5.52u w=5u l=1u
X1387 a_56014_28748# a_43838_35450# VSS VSS nfet_06v0 ad=0.25p pd=1.5u as=0.44p ps=2.88u w=1u l=1u
X1388 a_2510_35450# a_2510_35450# a_14686_28748# VSS nfet_06v0 ad=0.44p pd=2.88u as=0.25p ps=1.5u w=1u l=1u
X1389 a_31070_49608# a_25694_52962# a_34858_54008# VDD pfet_06v0 ad=2.2p pd=10.88u as=1.3p ps=5.52u w=5u l=1u
X1390 a_65180_10552# a_80598_10102# VSS ppolyf_u_1k r_width=1u r_length=76.45u
X1391 a_25242_37346# a_7686_66852# cap_mim_2f0_m4m5_noshield c_width=25u c_length=4u
X1392 a_3244_9202# a_2510_11482# a_4434_4780# VDD pfet_06v0 ad=1.65p pd=5.66u as=1.65p ps=5.66u w=5u l=1u
X1393 a_6386_28704# a_6386_28704# a_9594_28704# VSS nfet_06v0 ad=2.2p pd=10.88u as=1.65p ps=5.66u w=5u l=1u
X1394 a_65180_21186# a_64446_23466# a_66370_16764# VDD pfet_06v0 ad=1.65p pd=5.66u as=1.65p ps=5.66u w=5u l=1u
X1395 VDD a_7876_80992# a_7876_80992# VDD pfet_06v0 ad=0.52p pd=2.52u as=0.52p ps=2.52u w=2u l=1u
X1396 a_52838_70438# a_48466_70322# VDD VDD pfet_06v0 ad=2.5p pd=10.5u as=4.4p ps=20.88u w=10u l=1u
X1397 a_48666_44342# a_48466_44226# VDD VDD pfet_06v0 ad=2.5p pd=10.5u as=4.4p ps=20.88u w=10u l=1u
X1398 Z a_17396_80992# VSS ppolyf_u_1k r_width=1u r_length=2u
X1399 a_59596_11598# a_43538_11482# VDD VDD pfet_06v0 ad=2.5p pd=10.5u as=4.4p ps=20.88u w=10u l=1u
X1400 a_2410_53078# a_2210_52962# VDD VDD pfet_06v0 ad=2.5p pd=10.5u as=4.4p ps=20.88u w=10u l=1u
D26 X VDD diode_pd2nw_06v0 pj=30u area=50p
X1401 a_7886_58232# a_10558_62632# VDD VDD pfet_06v0 ad=1.3p pd=5.52u as=1.3p ps=5.52u w=5u l=1u
X1402 VSS a_10110_40872# a_9442_44272# VSS nfet_06v0 ad=1.1p pd=5.88u as=0.65p ps=3.02u w=2.5u l=1u
X1403 a_54582_53008# a_56366_49608# VSS VSS nfet_06v0 ad=0.65p pd=3.02u as=1.1p ps=5.88u w=2.5u l=1u
X1404 VSS VDD VSS VSS nfet_06v0 ad=4.29p pd=20.38u as=0 ps=0 w=9.75u l=2u
X1405 a_8798_66852# a_65180_33170# VDD VDD pfet_06v0 ad=0.22p pd=1.88u as=0.22p ps=1.88u w=0.5u l=1u
X1406 a_32626_70368# a_8798_66852# a_30066_70438# VDD pfet_06v0 ad=2.6p pd=10.52u as=4.4p ps=20.88u w=10u l=1u
X1407 a_26706_44342# a_25394_44226# VDD VDD pfet_06v0 ad=2.5p pd=10.5u as=4.4p ps=20.88u w=10u l=1u
X1408 a_32626_61632# a_33294_58232# VSS VSS nfet_06v0 ad=0.65p pd=3.02u as=0.65p ps=3.02u w=2.5u l=1u
X1409 S3P a_4234_28704# VSS ppolyf_u_1k r_width=1u r_length=2u
X1410 a_45762_4780# a_47532_12482# VDD VDD pfet_06v0 ad=1.65p pd=5.66u as=2.2p ps=10.88u w=5u l=1u
X1411 a_26994_16720# a_23118_23466# a_31480_23582# VDD pfet_06v0 ad=4.4p pd=20.88u as=2.5p ps=10.5u w=10u l=1u
X1412 a_48196_12482# a_48196_12482# a_50556_11482# VDD pfet_06v0 ad=4.4p pd=20.88u as=3.3p ps=10.66u w=10u l=1u
X1413 a_33294_66968# a_39228_71322# a_33742_71368# VDD pfet_06v0 ad=2.2p pd=10.88u as=2.2p ps=10.88u w=5u l=1u
X1414 a_54982_28748# a_43838_35450# VSS VSS nfet_06v0 ad=0.25p pd=1.5u as=0.44p ps=2.88u w=1u l=1u
X1415 a_6222_58162# a_2902_58118# VSS VSS nfet_06v0 ad=1.25p pd=5.5u as=2.2p ps=10.88u w=5u l=1u
X1416 VSS a_52350_81052# a_52262_81096# VSS nfet_06v0 ad=0.44p pd=2.88u as=0.44p ps=2.88u w=1u l=1u
X1417 a_30402_16764# a_30202_16720# VSS VSS nfet_06v0 ad=1.25p pd=5.5u as=2.2p ps=10.88u w=5u l=1u
X1418 a_66570_13378# a_7686_49492# cap_mim_2f0_m4m5_noshield c_width=25u c_length=4u
X1419 a_29406_40802# a_26086_40758# VSS VSS nfet_06v0 ad=1.25p pd=5.5u as=2.2p ps=10.88u w=5u l=1u
X1420 a_32182_66968# a_33742_71368# VDD VDD pfet_06v0 ad=1.3p pd=5.52u as=2.2p ps=10.88u w=5u l=1u
X1421 a_22818_35450# a_23118_35450# a_38876_35566# VDD pfet_06v0 ad=4.4p pd=20.88u as=2.5p ps=10.5u w=10u l=1u
X1422 a_55698_44272# a_56366_40872# VSS VSS nfet_06v0 ad=0.65p pd=3.02u as=1.1p ps=5.88u w=2.5u l=1u
X1423 a_32182_49608# a_33742_54008# VDD VDD pfet_06v0 ad=1.3p pd=5.52u as=1.3p ps=5.52u w=5u l=1u
X1424 S1N a_25574_16720# VSS ppolyf_u_1k r_width=1u r_length=2u
X1425 a_53138_44342# a_30870_40756# a_54582_44272# VDD pfet_06v0 ad=4.4p pd=20.88u as=2.6p ps=10.52u w=10u l=1u
X1426 a_7686_49492# a_66370_4780# cap_mim_2f0_m4m5_noshield c_width=25u c_length=4u
X1427 a_57672_23582# a_43538_23466# VDD VDD pfet_06v0 ad=2.5p pd=10.5u as=4.4p ps=20.88u w=10u l=1u
X1428 a_53138_44342# a_48766_44226# a_52838_44342# VDD pfet_06v0 ad=3.3p pd=10.66u as=2.5p ps=10.5u w=10u l=1u
X1429 a_53950_4780# a_43498_4736# VSS VSS nfet_06v0 ad=1.25p pd=5.5u as=2.2p ps=10.88u w=5u l=1u
X1430 VDD VSS VDD VDD pfet_06v0 ad=0.88p pd=4.88u as=0 ps=0 w=2u l=2u
X1431 a_61830_49494# a_48766_52962# a_65592_53078# VDD pfet_06v0 ad=4.4p pd=20.88u as=2.5p ps=10.5u w=10u l=1u
X1432 VSS VDD VSS VSS nfet_06v0 ad=0.66p pd=3.88u as=0 ps=0 w=1.5u l=2u
X1433 a_17396_80992# a_30906_82772# a_72672_59840# VSS nfet_06v0 ad=0.6448p pd=3u as=1.0912p ps=5.84u w=2.48u l=1u
X1434 a_41478_49538# a_41278_49494# VSS VSS nfet_06v0 ad=1.25p pd=5.5u as=2.2p ps=10.88u w=5u l=1u
D27 S2N VDD diode_pd2nw_06v0 pj=30u area=50p
X1435 a_31194_82772# a_30954_81052# a_30906_82772# VDD pfet_06v0 ad=0.75p pd=3.5u as=1.32p ps=6.88u w=3u l=1u
X1436 VDD VSS VDD VDD pfet_06v0 ad=4.29p pd=20.38u as=0 ps=0 w=9.75u l=2u
X1437 VSS a_10110_58232# a_8326_61632# VSS nfet_06v0 ad=0.65p pd=3.02u as=0.65p ps=3.02u w=2.5u l=1u
X1438 a_17396_80992# a_21162_82772# a_76660_59840# VSS nfet_06v0 ad=0.6448p pd=3u as=1.0912p ps=5.84u w=2.48u l=1u
X1439 a_23118_23466# a_23118_23466# a_35294_16764# VSS nfet_06v0 ad=0.44p pd=2.88u as=0.25p ps=1.5u w=1u l=1u
X1440 a_47050_16720# a_43798_16720# a_46774_25382# VSS nfet_06v0 ad=0.825p pd=3.16u as=0.825p ps=3.16u w=2.5u l=1u
X1441 a_76622_16764# a_64446_23466# VSS VSS nfet_06v0 ad=0.25p pd=1.5u as=0.44p ps=2.88u w=1u l=1u
X1442 a_63948_61586# a_48766_61586# a_64148_61702# VDD pfet_06v0 ad=3.3p pd=10.66u as=2.5p ps=10.5u w=10u l=1u
X1443 VSS a_56366_58232# a_54582_61632# VSS nfet_06v0 ad=0.65p pd=3.02u as=0.65p ps=3.02u w=2.5u l=1u
X1444 a_41278_40758# a_25354_40758# a_41478_40802# VSS nfet_06v0 ad=1.65p pd=5.66u as=1.25p ps=5.5u w=5u l=1u
X1445 VSS a_56366_49608# a_55698_53008# VSS nfet_06v0 ad=0.65p pd=3.02u as=0.65p ps=3.02u w=2.5u l=1u
X1446 VDD VSS VDD VDD pfet_06v0 ad=4.29p pd=20.38u as=0 ps=0 w=9.75u l=2u
X1447 VDD VSS VDD VDD pfet_06v0 ad=0.88p pd=4.88u as=0 ps=0 w=2u l=2u
X1448 VDD VSS VDD VDD pfet_06v0 ad=0.66p pd=3.88u as=0 ps=0 w=1.5u l=2u
X1449 a_27318_49538# a_25694_52962# VSS VSS nfet_06v0 ad=0.25p pd=1.5u as=0.44p ps=2.88u w=1u l=1u
X1450 VSS a_33294_58232# a_31510_61632# VSS nfet_06v0 ad=1.1p pd=5.88u as=0.65p ps=3.02u w=2.5u l=1u
X1451 a_30066_61702# a_8798_58116# a_32626_61632# VDD pfet_06v0 ad=4.4p pd=20.88u as=2.6p ps=10.52u w=10u l=1u
X1452 a_49158_49494# a_48766_52962# a_49778_53078# VDD pfet_06v0 ad=4.4p pd=20.88u as=2.5p ps=10.5u w=10u l=1u
X1453 a_2210_61586# a_2510_61586# a_4134_58162# VSS nfet_06v0 ad=0.44p pd=2.88u as=0.25p ps=1.5u w=1u l=1u
X1454 VSS a_49158_49494# a_53110_49538# VSS nfet_06v0 ad=2.2p pd=10.88u as=1.25p ps=5.5u w=5u l=1u
X1455 a_41076_61702# a_40876_61586# VDD VDD pfet_06v0 ad=2.5p pd=10.5u as=4.4p ps=20.88u w=10u l=1u
X1456 a_53138_53078# a_11158_16764# a_54582_53008# VDD pfet_06v0 ad=4.4p pd=20.88u as=2.6p ps=10.52u w=10u l=1u
X1457 a_27476_12482# a_23078_4736# a_29346_4780# VSS nfet_06v0 ad=2.2p pd=10.88u as=1.25p ps=5.5u w=5u l=1u
X1458 a_25394_44226# a_25694_44226# a_27318_40802# VSS nfet_06v0 ad=0.44p pd=2.88u as=0.25p ps=1.5u w=1u l=1u
X1459 a_44730_4780# a_43498_4736# VSS VSS nfet_06v0 ad=1.25p pd=5.5u as=2.2p ps=10.88u w=5u l=1u
X1460 a_75590_16764# a_64446_23466# VSS VSS nfet_06v0 ad=0.25p pd=1.5u as=0.44p ps=2.88u w=1u l=1u
X1461 a_32626_44272# a_33294_40872# VSS VSS nfet_06v0 ad=0.65p pd=3.02u as=0.65p ps=3.02u w=2.5u l=1u
X1462 a_65592_44342# a_48466_44226# VDD VDD pfet_06v0 ad=2.5p pd=10.5u as=4.4p ps=20.88u w=10u l=1u
X1463 VDD a_48466_52962# a_53470_53078# VDD pfet_06v0 ad=4.4p pd=20.88u as=2.5p ps=10.5u w=10u l=1u
D28 S3P VDD diode_pd2nw_06v0 pj=30u area=50p
X1464 VSS VDD VSS VSS nfet_06v0 ad=0.88p pd=4.88u as=0 ps=0 w=2u l=2u
X1465 a_4634_25362# a_11158_16764# cap_mim_2f0_m4m5_noshield c_width=25u c_length=4u
X1466 a_8798_58116# a_7674_28748# VSS VSS nfet_06v0 ad=0.44p pd=2.88u as=0.44p ps=2.88u w=1u l=1u
X1467 a_19658_49608# a_7886_49608# cap_mim_2f0_m4m5_noshield c_width=20u c_length=10u
X1468 VSS a_10110_66968# a_8326_70368# VSS nfet_06v0 ad=1.1p pd=5.88u as=0.65p ps=3.02u w=2.5u l=1u
X1469 a_24010_4780# a_22778_4736# VSS VSS nfet_06v0 ad=1.25p pd=5.5u as=2.2p ps=10.88u w=5u l=1u
X1470 a_26286_49538# a_26086_49494# VSS VSS nfet_06v0 ad=1.25p pd=5.5u as=2.2p ps=10.88u w=5u l=1u
X1471 a_65180_10552# a_7686_49492# VSS ppolyf_u_1k r_width=1u r_length=76.45u
X1472 a_32182_66968# a_8798_66852# a_29706_66898# VSS nfet_06v0 ad=1.3p pd=5.52u as=2.2p ps=10.88u w=5u l=1u
X1473 a_19658_40872# a_11674_45272# VDD VDD pfet_06v0 ad=4.4p pd=20.88u as=2.6p ps=10.52u w=10u l=1u
X1474 a_76660_42480# a_73010_41156# VSS VSS nfet_06v0 ad=0.5456p pd=3.36u as=0.5456p ps=3.36u w=1.24u l=1u
X1475 a_26086_40758# a_25354_40758# a_26286_40802# VSS nfet_06v0 ad=2.2p pd=10.88u as=1.25p ps=5.5u w=5u l=1u
X1476 a_6882_70438# a_7686_66852# a_8326_70368# VDD pfet_06v0 ad=4.4p pd=20.88u as=2.6p ps=10.52u w=10u l=1u
X1477 VDD VSS VDD VDD pfet_06v0 ad=4.29p pd=20.38u as=0 ps=0 w=9.75u l=2u
X1478 VDD VSS VDD VDD pfet_06v0 ad=0.88p pd=4.88u as=0 ps=0 w=2u l=2u
X1479 a_55698_70368# a_7686_66852# a_53138_70438# VDD pfet_06v0 ad=2.6p pd=10.52u as=4.4p ps=20.88u w=10u l=1u
X1480 a_49778_44342# a_48466_44226# VDD VDD pfet_06v0 ad=2.5p pd=10.5u as=4.4p ps=20.88u w=10u l=1u
X1481 a_34406_49608# a_39228_53962# a_34858_54008# VDD pfet_06v0 ad=2.2p pd=10.88u as=2.2p ps=10.88u w=5u l=1u
X1482 a_55698_61632# a_56366_58232# VSS VSS nfet_06v0 ad=0.65p pd=3.02u as=0.65p ps=3.02u w=2.5u l=1u
X1483 VDD VSS VDD VDD pfet_06v0 ad=0.66p pd=3.88u as=0 ps=0 w=1.5u l=2u
X1484 a_3522_53078# a_2210_52962# VDD VDD pfet_06v0 ad=2.5p pd=10.5u as=4.4p ps=20.88u w=10u l=1u
X1485 a_7686_66852# a_23852_33170# VDD VDD pfet_06v0 ad=0.22p pd=1.88u as=0.22p ps=1.88u w=0.5u l=1u
X1486 a_56560_35566# a_43538_35450# VDD VDD pfet_06v0 ad=2.5p pd=10.5u as=4.4p ps=20.88u w=10u l=1u
X1487 VSS a_10110_40872# a_8326_44272# VSS nfet_06v0 ad=0.65p pd=3.02u as=0.65p ps=3.02u w=2.5u l=1u
X1488 VDD a_57930_71368# a_50554_81052# VDD pfet_06v0 ad=2.6p pd=10.52u as=2.6p ps=10.52u w=10u l=1u
X1489 a_51530_81096# a_19658_66968# VDD VDD pfet_06v0 ad=1.32p pd=6.88u as=1.32p ps=6.88u w=3u l=1u
X1490 a_53470_44342# a_48766_44226# a_53138_44342# VDD pfet_06v0 ad=2.5p pd=10.5u as=3.3p ps=10.66u w=10u l=1u
X1491 a_64406_16720# a_64446_23466# a_77168_23582# VDD pfet_06v0 ad=4.4p pd=20.88u as=2.5p ps=10.5u w=10u l=1u
X1492 a_23118_23466# a_23118_23466# VDD VDD pfet_06v0 ad=0.88p pd=4.88u as=0.88p ps=4.88u w=2u l=1u
X1493 a_16044_45226# a_16044_45226# a_17692_44226# VDD pfet_06v0 ad=4.4p pd=20.88u as=3.3p ps=10.66u w=10u l=1u
X1494 a_8326_44272# a_7686_40756# a_6882_44342# VDD pfet_06v0 ad=2.6p pd=10.52u as=4.4p ps=20.88u w=10u l=1u
X1495 VSS a_56366_40872# a_54582_44272# VSS nfet_06v0 ad=0.65p pd=3.02u as=0.65p ps=3.02u w=2.5u l=1u
X1496 a_40422_49538# a_26086_49494# VSS VSS nfet_06v0 ad=1.25p pd=5.5u as=2.2p ps=10.88u w=5u l=1u
X1497 S1P a_7876_75392# VSS ppolyf_u_1k r_width=1u r_length=2u
X1498 a_23318_11598# a_23118_11482# a_23018_11598# VDD pfet_06v0 ad=4.4p pd=20.88u as=2.5p ps=10.5u w=10u l=1u
X1499 a_69610_16764# a_68804_24466# a_65180_21186# VDD pfet_06v0 ad=2.2p pd=10.88u as=1.65p ps=5.66u w=5u l=1u
X1500 VSS a_33294_40872# a_31510_44272# VSS nfet_06v0 ad=1.1p pd=5.88u as=0.65p ps=3.02u w=2.5u l=1u
X1501 a_64146_35450# a_64446_35450# a_80204_35566# VDD pfet_06v0 ad=4.4p pd=20.88u as=2.5p ps=10.5u w=10u l=1u
X1502 XN XP VSS VSS nfet_05v0 ad=0.5808p pd=3.52u as=0.5808p ps=3.52u w=1.32u l=0.6u
X1503 a_47532_24466# a_43838_23466# a_46494_16764# VDD pfet_06v0 ad=1.65p pd=5.66u as=1.65p ps=5.66u w=5u l=1u
X1504 a_7686_40756# a_3244_9202# VDD VDD pfet_06v0 ad=0.22p pd=1.88u as=0.22p ps=1.88u w=0.5u l=1u
X1505 a_19658_49608# a_11674_54008# VDD VDD pfet_06v0 ad=4.4p pd=20.88u as=2.6p ps=10.52u w=10u l=1u
X1506 VSS a_57478_58232# a_40698_81052# VSS nfet_06v0 ad=1.3p pd=5.52u as=1.3p ps=5.52u w=5u l=1u
X1507 a_39228_45226# a_25354_40758# a_40422_40802# VSS nfet_06v0 ad=2.2p pd=10.88u as=1.25p ps=5.5u w=5u l=1u
X1508 VDD a_2210_70322# a_7214_70438# VDD pfet_06v0 ad=4.4p pd=20.88u as=2.5p ps=10.5u w=10u l=1u
X1509 a_6868_12482# a_2470_4736# a_8738_4780# VSS nfet_06v0 ad=2.2p pd=10.88u as=1.25p ps=5.5u w=5u l=1u
X1510 a_34858_71368# a_38758_66854# a_34406_66968# VSS nfet_06v0 ad=1.1p pd=5.88u as=1.1p ps=5.88u w=2.5u l=1u
X1511 a_8798_49492# a_28282_16764# VSS VSS nfet_06v0 ad=0.44p pd=2.88u as=0.44p ps=2.88u w=1u l=1u
X1512 a_77168_11598# a_64146_11482# VDD VDD pfet_06v0 ad=2.5p pd=10.5u as=4.4p ps=20.88u w=10u l=1u
X1513 VSS a_56366_49608# a_55698_53008# VSS nfet_06v0 ad=1.1p pd=5.88u as=0.65p ps=3.02u w=2.5u l=1u
X1514 a_25354_66854# a_25694_70322# a_25594_70438# VDD pfet_06v0 ad=4.4p pd=20.88u as=2.5p ps=10.5u w=10u l=1u
X1515 a_54142_66968# a_56814_71368# VDD VDD pfet_06v0 ad=1.3p pd=5.52u as=1.3p ps=5.52u w=5u l=1u
X1516 a_43698_28748# a_43498_28704# VSS VSS nfet_06v0 ad=1.25p pd=5.5u as=2.2p ps=10.88u w=5u l=1u
X1517 a_23078_28704# a_23078_28704# VSS VSS nfet_06v0 ad=0.44p pd=2.88u as=0.44p ps=2.88u w=1u l=1u
X1518 a_8326_61632# a_19658_58232# cap_mim_2f0_m4m5_noshield c_width=20u c_length=10u
X1519 a_68322_28704# a_64446_35450# a_72808_35566# VDD pfet_06v0 ad=4.4p pd=20.88u as=2.5p ps=10.5u w=10u l=1u
X1520 a_54582_53008# a_56366_49608# VSS VSS nfet_06v0 ad=0.65p pd=3.02u as=0.65p ps=3.02u w=2.5u l=1u
X1521 VSS VDD VSS VSS nfet_06v0 ad=0.88p pd=4.88u as=0 ps=0 w=2u l=2u
X1522 a_45962_37346# a_4234_4736# a_44038_35566# VDD pfet_06v0 ad=0.484p pd=3.08u as=0.484p ps=3.08u w=1.1u l=1u
X1523 a_5166_58162# a_2510_61586# VSS VSS nfet_06v0 ad=0.25p pd=1.5u as=0.44p ps=2.88u w=1u l=1u
X1524 a_43738_35566# a_43538_35450# VDD VDD pfet_06v0 ad=2.5p pd=10.5u as=4.4p ps=20.88u w=10u l=1u
X1525 a_28282_28748# a_27476_36450# a_23852_33170# VDD pfet_06v0 ad=2.2p pd=10.88u as=1.65p ps=5.66u w=5u l=1u
X1526 a_8326_53008# a_7686_49492# a_6882_53078# VDD pfet_06v0 ad=2.6p pd=10.52u as=4.4p ps=20.88u w=10u l=1u
X1527 S4P a_4234_16720# VSS ppolyf_u_1k r_width=1u r_length=2u
X1528 VSS a_2902_66854# a_6854_66898# VSS nfet_06v0 ad=2.2p pd=10.88u as=1.25p ps=5.5u w=5u l=1u
X1529 a_9442_53008# a_10110_49608# VSS VSS nfet_06v0 ad=0.65p pd=3.02u as=0.65p ps=3.02u w=2.5u l=1u
X1530 S3N a_4966_28704# VSS ppolyf_u_1k r_width=1u r_length=2u
X1531 VSS VDD VSS VSS nfet_06v0 ad=7.92p pd=36.88u as=0 ps=0 w=18u l=2u
X1532 a_18268_35566# a_2210_35450# VDD VDD pfet_06v0 ad=2.5p pd=10.5u as=4.4p ps=20.88u w=10u l=1u
X1533 VSS VDD VSS VSS nfet_06v0 ad=4.29p pd=20.38u as=0 ps=0 w=9.75u l=2u
X1534 VSS a_23006_81052# a_22918_81096# VSS nfet_06v0 ad=0.44p pd=2.88u as=0.44p ps=2.88u w=1u l=1u
X1535 a_68804_24466# a_64406_16720# a_70674_16764# VSS nfet_06v0 ad=2.2p pd=10.88u as=1.25p ps=5.5u w=5u l=1u
X1536 a_19658_66968# a_7886_66968# cap_mim_2f0_m4m5_noshield c_width=20u c_length=10u
X1537 a_65180_33170# a_68322_28704# a_69610_28748# VSS nfet_06v0 ad=1.1p pd=5.88u as=0.825p ps=3.16u w=2.5u l=1u
X1538 YN YP VSS VSS nfet_05v0 ad=0.5808p pd=3.52u as=0.5808p ps=3.52u w=1.32u l=0.6u
X1539 a_7674_28748# a_2470_28704# a_4634_37346# VSS nfet_06v0 ad=0.825p pd=3.16u as=0.825p ps=3.16u w=2.5u l=1u
X1540 a_7686_58116# a_44572_21186# VDD VDD pfet_06v0 ad=0.22p pd=1.88u as=0.22p ps=1.88u w=0.5u l=1u
X1541 a_33230_28748# a_22778_28704# VSS VSS nfet_06v0 ad=1.25p pd=5.5u as=2.2p ps=10.88u w=5u l=1u
X1542 a_55698_44272# a_56366_40872# VSS VSS nfet_06v0 ad=0.65p pd=3.02u as=0.65p ps=3.02u w=2.5u l=1u
X1543 VSS VDD VSS VSS nfet_06v0 ad=4.29p pd=20.38u as=0 ps=0 w=9.75u l=2u
X1544 a_35446_81096# a_31286_81052# a_34514_81052# VSS nfet_06v0 ad=0.25p pd=1.5u as=0.44p ps=2.88u w=1u l=1u
X1545 a_7214_61702# a_2510_61586# a_6882_61702# VDD pfet_06v0 ad=2.5p pd=10.5u as=3.3p ps=10.66u w=10u l=1u
X1546 VDD VSS VDD VDD pfet_06v0 ad=7.92p pd=36.88u as=0 ps=0 w=18u l=2u
X1547 a_65338_16764# a_64106_16720# VSS VSS nfet_06v0 ad=1.25p pd=5.5u as=2.2p ps=10.88u w=5u l=1u
X1548 VSS a_42842_66968# a_50506_82772# VSS nfet_06v0 ad=0.44p pd=2.88u as=0.33p ps=1.66u w=1u l=1u
X1549 a_64106_4736# a_64406_4736# a_74558_4780# VSS nfet_06v0 ad=2.2p pd=10.88u as=1.25p ps=5.5u w=5u l=1u
X1550 a_65180_22536# a_80598_22086# VSS ppolyf_u_1k r_width=1u r_length=76.45u
X1551 a_25594_61702# a_25394_61586# VDD VDD pfet_06v0 ad=2.5p pd=10.5u as=4.4p ps=20.88u w=10u l=1u
X1552 a_65180_33170# a_64446_35450# a_66370_28748# VDD pfet_06v0 ad=1.65p pd=5.66u as=1.65p ps=5.66u w=5u l=1u
D29 S1P VDD diode_pd2nw_06v0 pj=30u area=50p
X1553 a_22778_4736# a_23118_11482# a_36952_11598# VDD pfet_06v0 ad=4.4p pd=20.88u as=2.5p ps=10.5u w=10u l=1u
X1554 a_19658_40872# a_7886_40872# cap_mim_2f0_m4m5_noshield c_width=20u c_length=10u
X1555 a_7686_40756# a_3244_9202# VDD VDD pfet_06v0 ad=0.22p pd=1.88u as=0.22p ps=1.88u w=0.5u l=1u
D30 VSS S1N diode_nd2ps_06v0 pj=30u area=50p
X1556 a_19336_70438# a_2210_70322# VDD VDD pfet_06v0 ad=2.5p pd=10.5u as=4.4p ps=20.88u w=10u l=1u
X1557 a_2210_11482# a_2510_11482# a_13654_4780# VSS nfet_06v0 ad=0.44p pd=2.88u as=0.25p ps=1.5u w=1u l=1u
X1558 VSS a_57478_40872# a_21210_81052# VSS nfet_06v0 ad=1.3p pd=5.52u as=1.3p ps=5.52u w=5u l=1u
X1559 a_10110_49608# a_2170_49494# a_9442_53008# VSS nfet_06v0 ad=0.65p pd=3.02u as=1.1p ps=5.88u w=2.5u l=1u
X1560 VDD a_56814_62632# a_54142_58232# VDD pfet_06v0 ad=2.2p pd=10.88u as=1.3p ps=5.52u w=5u l=1u
X1561 a_64446_11482# a_64446_11482# a_76622_4780# VSS nfet_06v0 ad=0.44p pd=2.88u as=0.25p ps=1.5u w=1u l=1u
X1562 a_65180_21636# a_80598_22086# VSS ppolyf_u_1k r_width=1u r_length=76.45u
X1563 VDD VSS VDD VDD pfet_06v0 ad=7.92p pd=36.88u as=0 ps=0 w=18u l=2u
X1564 a_26994_28704# a_23118_35450# a_31480_35566# VDD pfet_06v0 ad=4.4p pd=20.88u as=2.5p ps=10.5u w=10u l=1u
X1565 a_4634_13378# a_5722_4736# VSS VSS nfet_06v0 ad=0.825p pd=3.16u as=1.1p ps=5.88u w=2.5u l=1u
X1566 a_55254_66968# a_56814_71368# VDD VDD pfet_06v0 ad=1.3p pd=5.52u as=1.3p ps=5.52u w=5u l=1u
X1567 a_30402_28748# a_30202_28704# VSS VSS nfet_06v0 ad=1.25p pd=5.5u as=2.2p ps=10.88u w=5u l=1u
X1568 a_67382_25382# a_67658_16720# VSS VSS nfet_06v0 ad=0.825p pd=3.16u as=1.1p ps=5.88u w=2.5u l=1u
X1569 a_66570_25362# a_7876_75392# a_64646_23582# VDD pfet_06v0 ad=0.484p pd=3.08u as=0.484p ps=3.08u w=1.1u l=1u
X1570 a_64346_23582# a_64146_23466# VDD VDD pfet_06v0 ad=2.5p pd=10.5u as=4.4p ps=20.88u w=10u l=1u
X1571 VSS VDD VSS VSS nfet_06v0 ad=0.88p pd=4.88u as=0 ps=0 w=2u l=2u
X1572 a_44572_9652# a_59990_9202# VSS ppolyf_u_1k r_width=1u r_length=76.45u
X1573 a_63494_49538# a_49158_49494# VSS VSS nfet_06v0 ad=1.25p pd=5.5u as=2.2p ps=10.88u w=5u l=1u
X1574 a_64606_4780# a_64406_4736# a_65338_4780# VSS nfet_06v0 ad=2.2p pd=10.88u as=1.25p ps=5.5u w=5u l=1u
X1575 a_57672_35566# a_43538_35450# VDD VDD pfet_06v0 ad=2.5p pd=10.5u as=4.4p ps=20.88u w=10u l=1u
X1576 a_52778_49538# a_11158_16764# a_54142_49608# VSS nfet_06v0 ad=2.2p pd=10.88u as=1.3p ps=5.52u w=5u l=1u
X1577 a_44170_81096# a_44258_81052# VDD VDD pfet_06v0 ad=1.32p pd=6.88u as=1.32p ps=6.88u w=3u l=1u
X1578 VDD a_10558_71368# a_8998_66968# VDD pfet_06v0 ad=1.3p pd=5.52u as=1.3p ps=5.52u w=5u l=1u
X1579 a_71650_44468# a_34426_81096# a_72672_42480# VSS nfet_06v0 ad=0.6448p pd=3u as=1.0912p ps=5.84u w=2.48u l=1u
X1580 a_15574_40758# a_2510_44226# a_19336_44342# VDD pfet_06v0 ad=4.4p pd=20.88u as=2.5p ps=10.5u w=10u l=1u
X1581 a_32182_66968# a_25694_70322# a_33742_71368# VDD pfet_06v0 ad=2.2p pd=10.88u as=1.3p ps=5.52u w=5u l=1u
X1582 a_71364_11598# a_71164_11482# VDD VDD pfet_06v0 ad=2.5p pd=10.5u as=4.4p ps=20.88u w=10u l=1u
X1583 a_50556_23466# a_43838_23466# a_50756_23582# VDD pfet_06v0 ad=3.3p pd=10.66u as=2.5p ps=10.5u w=10u l=1u
X1584 a_62300_45226# a_48426_40758# a_63494_40802# VSS nfet_06v0 ad=2.2p pd=10.88u as=1.25p ps=5.5u w=5u l=1u
X1585 a_9594_16720# a_2470_16720# a_9794_16764# VSS nfet_06v0 ad=1.65p pd=5.66u as=1.25p ps=5.5u w=5u l=1u
X1586 a_44572_34520# a_59990_34070# VSS ppolyf_u_1k r_width=1u r_length=76.45u
X1587 a_71650_44468# a_24682_81096# a_76660_42480# VSS nfet_06v0 ad=0.6448p pd=3u as=1.0912p ps=5.84u w=2.48u l=1u
X1588 a_55254_58232# a_7686_58116# a_52778_58162# VSS nfet_06v0 ad=1.3p pd=5.52u as=2.2p ps=10.88u w=5u l=1u
X1589 a_76622_28748# a_64446_35450# VSS VSS nfet_06v0 ad=0.25p pd=1.5u as=0.44p ps=2.88u w=1u l=1u
X1590 a_47050_28704# a_43798_28704# a_46774_37366# VSS nfet_06v0 ad=0.825p pd=3.16u as=0.825p ps=3.16u w=2.5u l=1u
X1591 a_23118_35450# a_23118_35450# a_35294_28748# VSS nfet_06v0 ad=0.44p pd=2.88u as=0.25p ps=1.5u w=1u l=1u
X1592 a_15574_58118# a_15574_58118# a_18094_58118# VSS nfet_06v0 ad=2.2p pd=10.88u as=1.65p ps=5.66u w=5u l=1u
X1593 a_25394_52962# a_25694_52962# a_28630_53078# VDD pfet_06v0 ad=4.4p pd=20.88u as=2.5p ps=10.5u w=10u l=1u
X1594 a_10110_49608# a_16044_53962# a_10558_54008# VDD pfet_06v0 ad=2.2p pd=10.88u as=2.2p ps=10.88u w=5u l=1u
X1595 Y a_7876_80992# VSS ppolyf_u_1k r_width=1u r_length=2u
X1596 a_66570_25362# a_67658_16720# VSS VSS nfet_06v0 ad=0.825p pd=3.16u as=1.1p ps=5.88u w=2.5u l=1u
X1597 a_26812_12482# a_26994_4736# a_26330_4736# VSS nfet_06v0 ad=1.1p pd=5.88u as=0.825p ps=3.16u w=2.5u l=1u
X1598 a_43538_23466# a_43838_23466# a_59596_23582# VDD pfet_06v0 ad=4.4p pd=20.88u as=2.5p ps=10.5u w=10u l=1u
X1599 a_9442_61632# a_8798_58116# a_6882_61702# VDD pfet_06v0 ad=2.6p pd=10.52u as=4.4p ps=20.88u w=10u l=1u
X1600 a_23938_81096# a_22186_81096# a_23006_81052# VSS nfet_06v0 ad=0.25p pd=1.5u as=0.44p ps=2.88u w=1u l=1u
X1601 S2N a_4966_4736# VSS ppolyf_u_1k r_width=1u r_length=2u
X1602 VDD a_25394_61586# a_30398_61702# VDD pfet_06v0 ad=4.4p pd=20.88u as=2.5p ps=10.5u w=10u l=1u
X1603 a_56366_49608# a_62300_53962# a_56814_54008# VDD pfet_06v0 ad=2.2p pd=10.88u as=2.2p ps=10.88u w=5u l=1u
X1604 VSS VDD VSS VSS nfet_06v0 ad=0.88p pd=4.88u as=0 ps=0 w=2u l=2u
X1605 a_44572_33620# a_59990_34070# VSS ppolyf_u_1k r_width=1u r_length=76.45u
X1606 a_25774_4780# a_26812_12482# VDD VDD pfet_06v0 ad=1.65p pd=5.66u as=2.2p ps=10.88u w=5u l=1u
X1607 a_48466_61586# a_48766_61586# a_51702_61702# VDD pfet_06v0 ad=4.4p pd=20.88u as=2.5p ps=10.5u w=10u l=1u
X1608 a_75590_28748# a_64446_35450# VSS VSS nfet_06v0 ad=0.25p pd=1.5u as=0.44p ps=2.88u w=1u l=1u
X1609 a_53110_66898# a_48426_66854# a_52778_66898# VSS nfet_06v0 ad=1.25p pd=5.5u as=1.65p ps=5.66u w=5u l=1u
X1610 a_7876_80992# a_32662_81096# a_72672_51216# VSS nfet_06v0 ad=0.6448p pd=3u as=1.0912p ps=5.84u w=2.48u l=1u
X1611 a_8326_53008# a_10110_49608# VSS VSS nfet_06v0 ad=0.65p pd=3.02u as=1.1p ps=5.88u w=2.5u l=1u
X1612 VSS VDD VSS VSS nfet_06v0 ad=4.29p pd=20.38u as=0 ps=0 w=9.75u l=2u
X1613 VDD VSS VDD VDD pfet_06v0 ad=0.66p pd=3.88u as=0 ps=0 w=1.5u l=2u
X1614 a_54142_66968# a_56814_71368# VDD VDD pfet_06v0 ad=1.3p pd=5.52u as=2.2p ps=10.88u w=5u l=1u
X1615 a_49358_66898# a_49158_66854# VSS VSS nfet_06v0 ad=1.25p pd=5.5u as=2.2p ps=10.88u w=5u l=1u
X1616 S2P a_4234_4736# VSS ppolyf_u_1k r_width=1u r_length=2u
X1617 a_10558_62632# a_2510_61586# a_8998_58232# VDD pfet_06v0 ad=1.3p pd=5.52u as=2.2p ps=10.88u w=5u l=1u
X1618 a_25354_49494# a_25354_49494# VSS VSS nfet_06v0 ad=0.44p pd=2.88u as=0.44p ps=2.88u w=1u l=1u
X1619 a_7876_80992# a_22918_81096# a_76660_51216# VSS nfet_06v0 ad=0.6448p pd=3u as=1.0912p ps=5.84u w=2.48u l=1u
X1620 a_23852_9202# a_39270_9202# VSS ppolyf_u_1k r_width=1u r_length=76.45u
X1621 VDD VSS VDD VDD pfet_06v0 ad=7.92p pd=36.88u as=0 ps=0 w=18u l=2u
X1622 a_28630_44342# a_25394_44226# VDD VDD pfet_06v0 ad=2.5p pd=10.5u as=4.4p ps=20.88u w=10u l=1u
X1623 a_78280_23582# a_64146_23466# VDD VDD pfet_06v0 ad=2.5p pd=10.5u as=4.4p ps=20.88u w=10u l=1u
X1624 VSS a_11222_66968# a_19658_66968# VSS nfet_06v0 ad=1.3p pd=5.52u as=1.3p ps=5.52u w=5u l=1u
X1625 VDD VSS VDD VDD pfet_06v0 ad=4.29p pd=20.38u as=0 ps=0 w=9.75u l=2u
X1626 a_25774_16764# a_25574_16720# a_23278_16764# VSS nfet_06v0 ad=0.44p pd=2.88u as=0.44p ps=2.88u w=1u l=1u
X1627 a_28350_66898# a_25694_70322# VSS VSS nfet_06v0 ad=0.25p pd=1.5u as=0.44p ps=2.88u w=1u l=1u
X1628 a_5166_4780# a_6204_12482# VDD VDD pfet_06v0 ad=1.65p pd=5.66u as=2.2p ps=10.88u w=5u l=1u
X1629 a_23078_4736# a_23078_4736# VSS VSS nfet_06v0 ad=0.44p pd=2.88u as=0.44p ps=2.88u w=1u l=1u
X1630 a_21542_81052# a_34858_45272# VDD VDD pfet_06v0 ad=4.4p pd=20.88u as=2.6p ps=10.52u w=10u l=1u
X1631 a_7686_40756# a_3244_9202# VDD VDD pfet_06v0 ad=0.22p pd=1.88u as=0.22p ps=1.88u w=0.5u l=1u
X1632 a_17238_66898# a_2902_66854# VSS VSS nfet_06v0 ad=1.25p pd=5.5u as=2.2p ps=10.88u w=5u l=1u
X1633 a_71530_16720# a_64406_16720# a_71730_16764# VSS nfet_06v0 ad=1.65p pd=5.66u as=1.25p ps=5.5u w=5u l=1u
X1634 a_74894_44688# a_71650_44468# VDD VDD pfet_05v0 ad=0.8052p pd=4.54u as=0.8052p ps=4.54u w=1.83u l=0.5u
X1635 a_43538_11482# a_43838_11482# a_54982_4780# VSS nfet_06v0 ad=0.44p pd=2.88u as=0.25p ps=1.5u w=1u l=1u
X1636 VSS VDD VSS VSS nfet_06v0 ad=0.66p pd=3.88u as=0 ps=0 w=1.5u l=2u
X1637 a_8798_40756# a_44572_9202# VDD VDD pfet_06v0 ad=0.22p pd=1.88u as=0.22p ps=1.88u w=0.5u l=1u
X1638 a_55254_40872# a_7686_40756# a_52778_40802# VSS nfet_06v0 ad=1.3p pd=5.52u as=2.2p ps=10.88u w=5u l=1u
X1639 VDD VSS VDD VDD pfet_06v0 ad=0.88p pd=4.88u as=0 ps=0 w=2u l=2u
X1640 a_64406_28704# a_64446_35450# a_77168_35566# VDD pfet_06v0 ad=4.4p pd=20.88u as=2.5p ps=10.5u w=10u l=1u
X1641 a_23118_35450# a_23118_35450# VDD VDD pfet_06v0 ad=0.88p pd=4.88u as=0.88p ps=4.88u w=2u l=1u
X1642 VDD VSS VDD VDD pfet_06v0 ad=0.66p pd=3.88u as=0 ps=0 w=1.5u l=2u
X1643 a_44038_11598# a_43838_11482# a_44850_11598# VDD pfet_06v0 ad=4.4p pd=20.88u as=2.5p ps=10.5u w=10u l=1u
X1644 a_22818_11482# a_23118_11482# a_34262_4780# VSS nfet_06v0 ad=0.44p pd=2.88u as=0.25p ps=1.5u w=1u l=1u
X1645 VSS VDD VSS VSS nfet_06v0 ad=0.88p pd=4.88u as=0 ps=0 w=2u l=2u
X1646 VDD a_10558_71368# a_8998_66968# VDD pfet_06v0 ad=2.2p pd=10.88u as=1.3p ps=5.52u w=5u l=1u
X1647 a_23852_10552# a_39270_10102# VSS ppolyf_u_1k r_width=1u r_length=76.45u
X1648 a_69610_28748# a_68804_36450# a_65180_33170# VDD pfet_06v0 ad=2.2p pd=10.88u as=1.65p ps=5.66u w=5u l=1u
X1649 a_6854_58162# a_2170_58118# a_6522_58162# VSS nfet_06v0 ad=1.25p pd=5.5u as=1.65p ps=5.66u w=5u l=1u
X1650 a_47532_36450# a_43838_35450# a_46494_28748# VDD pfet_06v0 ad=1.65p pd=5.66u as=1.65p ps=5.66u w=5u l=1u
X1651 a_55254_58232# a_56814_62632# VDD VDD pfet_06v0 ad=1.3p pd=5.52u as=2.2p ps=10.88u w=5u l=1u
X1652 a_65458_23582# a_64146_23466# VDD VDD pfet_06v0 ad=2.5p pd=10.5u as=4.4p ps=20.88u w=10u l=1u
X1653 a_9228_11482# a_2510_11482# a_9428_11598# VDD pfet_06v0 ad=3.3p pd=10.66u as=2.5p ps=10.5u w=10u l=1u
D31 VSS S3N diode_nd2ps_06v0 pj=30u area=50p
X1654 a_26994_16720# a_26994_16720# a_30202_16720# VSS nfet_06v0 ad=2.2p pd=10.88u as=1.65p ps=5.66u w=5u l=1u
X1655 a_30038_40802# a_25354_40758# a_29706_40802# VSS nfet_06v0 ad=1.25p pd=5.5u as=1.65p ps=5.66u w=5u l=1u
X1656 a_2210_52962# a_2510_52962# a_5446_53078# VDD pfet_06v0 ad=4.4p pd=20.88u as=2.5p ps=10.5u w=10u l=1u
X1657 a_17692_70322# a_2510_70322# a_17892_70438# VDD pfet_06v0 ad=3.3p pd=10.66u as=2.5p ps=10.5u w=10u l=1u
X1658 a_7686_66852# a_28282_28748# VSS VSS nfet_06v0 ad=0.44p pd=2.88u as=0.44p ps=2.88u w=1u l=1u
X1659 VDD VSS VDD VDD pfet_06v0 ad=0.66p pd=3.88u as=0 ps=0 w=1.5u l=2u
X1660 a_42842_66968# a_34858_71368# VDD VDD pfet_06v0 ad=2.6p pd=10.52u as=4.4p ps=20.88u w=10u l=1u
X1661 a_23278_4780# a_23078_4736# a_22978_4780# VSS nfet_06v0 ad=2.2p pd=10.88u as=1.25p ps=5.5u w=5u l=1u
X1662 a_7686_58116# a_44572_21186# VDD VDD pfet_06v0 ad=0.22p pd=1.88u as=0.22p ps=1.88u w=0.5u l=1u
X1663 a_31286_81052# a_34858_54008# VDD VDD pfet_06v0 ad=4.4p pd=20.88u as=2.6p ps=10.52u w=10u l=1u
X1664 a_47714_4736# a_43838_11482# a_52200_11598# VDD pfet_06v0 ad=4.4p pd=20.88u as=2.5p ps=10.5u w=10u l=1u
X1665 a_52778_49538# a_7686_49492# a_55254_49608# VSS nfet_06v0 ad=2.2p pd=10.88u as=1.3p ps=5.52u w=5u l=1u
X1666 a_26054_13398# a_4966_28704# a_23318_11598# VDD pfet_06v0 ad=0.44p pd=2.88u as=0.44p ps=2.88u w=1u l=1u
X1667 a_71560_58632# a_40650_82772# a_17396_80992# VSS nfet_06v0 ad=1.0912p pd=5.84u as=0.6448p ps=3u w=2.48u l=1u
X1668 VSS VDD VSS VSS nfet_06v0 ad=4.29p pd=20.38u as=0 ps=0 w=9.75u l=2u
X1669 VDD a_17396_80992# a_17396_80992# VDD pfet_06v0 ad=0.52p pd=2.52u as=0.52p ps=2.52u w=2u l=1u
X1670 a_48766_70322# a_48766_70322# VDD VDD pfet_06v0 ad=0.88p pd=4.88u as=0.88p ps=4.88u w=2u l=1u
X1671 a_31510_70368# a_33294_66968# VSS VSS nfet_06v0 ad=0.65p pd=3.02u as=1.1p ps=5.88u w=2.5u l=1u
X1672 a_49158_49494# a_48426_49494# a_49358_49538# VSS nfet_06v0 ad=2.2p pd=10.88u as=1.25p ps=5.5u w=5u l=1u
X1673 a_18294_49538# a_18094_49494# VSS VSS nfet_06v0 ad=1.25p pd=5.5u as=2.2p ps=10.88u w=5u l=1u
X1674 a_19658_49608# a_11222_49608# VSS VSS nfet_06v0 ad=1.3p pd=5.52u as=2.2p ps=10.88u w=5u l=1u
X1675 a_56366_58232# a_48426_58118# a_55698_61632# VSS nfet_06v0 ad=0.65p pd=3.02u as=1.1p ps=5.88u w=2.5u l=1u
X1676 VSS VDD VSS VSS nfet_06v0 ad=0.88p pd=4.88u as=0 ps=0 w=2u l=2u
X1677 VDD VSS VDD VDD pfet_06v0 ad=7.92p pd=36.88u as=0 ps=0 w=18u l=2u
X1678 a_3244_10552# a_18662_10102# VSS ppolyf_u_1k r_width=1u r_length=76.45u
X1679 a_64550_49538# a_64350_49494# VSS VSS nfet_06v0 ad=1.25p pd=5.5u as=2.2p ps=10.88u w=5u l=1u
X1680 VSS VDD VSS VSS nfet_06v0 ad=0.66p pd=3.88u as=0 ps=0 w=1.5u l=2u
X1681 a_23078_4736# a_23118_11482# a_35840_11598# VDD pfet_06v0 ad=4.4p pd=20.88u as=2.5p ps=10.5u w=10u l=1u
X1682 a_30954_81052# a_57478_49608# VSS VSS nfet_06v0 ad=1.3p pd=5.52u as=2.2p ps=10.88u w=5u l=1u
X1683 a_68804_36450# a_64406_28704# a_70674_28748# VSS nfet_06v0 ad=2.2p pd=10.88u as=1.25p ps=5.5u w=5u l=1u
X1684 a_18094_40758# a_2170_40758# a_18294_40802# VSS nfet_06v0 ad=1.65p pd=5.66u as=1.25p ps=5.5u w=5u l=1u
X1685 a_34406_58232# a_25354_58118# a_31510_61632# VSS nfet_06v0 ad=0.65p pd=3.02u as=1.1p ps=5.88u w=2.5u l=1u
X1686 VSS a_34514_81052# a_34426_81096# VSS nfet_06v0 ad=0.44p pd=2.88u as=0.44p ps=2.88u w=1u l=1u
X1687 a_30870_66852# a_44572_33170# VDD VDD pfet_06v0 ad=0.22p pd=1.88u as=0.22p ps=1.88u w=0.5u l=1u
X1688 a_64606_16764# a_64406_16720# a_64306_16764# VSS nfet_06v0 ad=2.2p pd=10.88u as=1.25p ps=5.5u w=5u l=1u
X1689 VDD a_51530_81096# a_52350_81052# VDD pfet_06v0 ad=1.32p pd=6.88u as=0.99p ps=3.66u w=3u l=1u
X1690 a_64350_40758# a_48426_40758# a_64550_40802# VSS nfet_06v0 ad=1.65p pd=5.66u as=1.25p ps=5.5u w=5u l=1u
X1691 a_25694_52962# a_25694_52962# a_28350_49538# VSS nfet_06v0 ad=0.44p pd=2.88u as=0.25p ps=1.5u w=1u l=1u
X1692 a_6522_66898# a_8798_66852# a_8998_66968# VSS nfet_06v0 ad=2.2p pd=10.88u as=1.3p ps=5.52u w=5u l=1u
X1693 a_5446_44342# a_2210_44226# VDD VDD pfet_06v0 ad=2.5p pd=10.5u as=4.4p ps=20.88u w=10u l=1u
X1694 a_65338_28748# a_64106_28704# VSS VSS nfet_06v0 ad=1.25p pd=5.5u as=2.2p ps=10.88u w=5u l=1u
X1695 a_17892_61702# a_17692_61586# VDD VDD pfet_06v0 ad=2.5p pd=10.5u as=4.4p ps=20.88u w=10u l=1u
X1696 a_2370_4780# a_2170_4736# VSS VSS nfet_06v0 ad=1.25p pd=5.5u as=2.2p ps=10.88u w=5u l=1u
X1697 a_16044_53962# a_2170_49494# a_17238_49538# VSS nfet_06v0 ad=2.2p pd=10.88u as=1.25p ps=5.5u w=5u l=1u
X1698 a_31510_70368# a_30870_66852# a_30066_70438# VDD pfet_06v0 ad=2.6p pd=10.52u as=4.4p ps=20.88u w=10u l=1u
X1699 a_29706_66898# a_25354_66854# a_29406_66898# VSS nfet_06v0 ad=1.65p pd=5.66u as=1.25p ps=5.5u w=5u l=1u
X1700 a_5446_13398# a_4966_4736# a_2710_11598# VDD pfet_06v0 ad=0.44p pd=2.88u as=0.44p ps=2.88u w=1u l=1u
X1701 Z a_17396_80992# VSS ppolyf_u_1k r_width=1u r_length=2u
X1702 a_34858_62632# a_25694_61586# a_31070_58232# VDD pfet_06v0 ad=1.3p pd=5.52u as=2.2p ps=10.88u w=5u l=1u
X1703 VDD a_33742_45272# a_31070_40872# VDD pfet_06v0 ad=2.2p pd=10.88u as=1.3p ps=5.52u w=5u l=1u
X1704 a_68140_24466# a_64446_23466# a_67102_16764# VDD pfet_06v0 ad=1.65p pd=5.66u as=1.65p ps=5.66u w=5u l=1u
X1705 a_30870_40756# a_23852_9202# VDD VDD pfet_06v0 ad=0.22p pd=1.88u as=0.22p ps=1.88u w=0.5u l=1u
X1706 VSS VDD VSS VSS nfet_06v0 ad=7.92p pd=36.88u as=0 ps=0 w=18u l=2u
X1707 a_33682_81096# a_31930_81096# a_32750_81052# VSS nfet_06v0 ad=0.25p pd=1.5u as=0.44p ps=2.88u w=1u l=1u
X1708 VDD VSS VDD VDD pfet_06v0 ad=4.29p pd=20.38u as=0 ps=0 w=9.75u l=2u
X1709 a_42842_66968# a_34406_66968# VSS VSS nfet_06v0 ad=2.2p pd=10.88u as=1.3p ps=5.52u w=5u l=1u
X1710 a_23278_16764# a_23078_16720# a_24010_16764# VSS nfet_06v0 ad=2.2p pd=10.88u as=1.25p ps=5.5u w=5u l=1u
X1711 a_25694_44226# a_25694_44226# VDD VDD pfet_06v0 ad=0.88p pd=4.88u as=0.88p ps=4.88u w=2u l=1u
X1712 VDD VSS VDD VDD pfet_06v0 ad=7.92p pd=36.88u as=0 ps=0 w=18u l=2u
X1713 VSS VDD VSS VSS nfet_06v0 ad=0.88p pd=4.88u as=0 ps=0 w=2u l=2u
D32 VSS S4N diode_nd2ps_06v0 pj=30u area=50p
X1714 a_2902_40758# a_2170_40758# a_3102_40802# VSS nfet_06v0 ad=2.2p pd=10.88u as=1.25p ps=5.5u w=5u l=1u
X1715 a_31930_81096# a_19658_49608# VDD VDD pfet_06v0 ad=1.32p pd=6.88u as=1.32p ps=6.88u w=3u l=1u
X1716 a_54142_58232# a_30870_58116# a_52778_58162# VSS nfet_06v0 ad=1.3p pd=5.52u as=2.2p ps=10.88u w=5u l=1u
X1717 a_66570_37346# a_4234_28704# a_64646_35566# VDD pfet_06v0 ad=0.484p pd=3.08u as=0.484p ps=3.08u w=1.1u l=1u
X1718 VDD VSS VDD VDD pfet_06v0 ad=4.29p pd=20.38u as=0 ps=0 w=9.75u l=2u
X1719 a_67382_37366# a_67658_28704# VSS VSS nfet_06v0 ad=0.825p pd=3.16u as=1.1p ps=5.88u w=2.5u l=1u
X1720 a_57478_40872# a_62300_45226# a_57930_45272# VDD pfet_06v0 ad=2.2p pd=10.88u as=2.2p ps=10.88u w=5u l=1u
X1721 a_64346_35566# a_64146_35450# VDD VDD pfet_06v0 ad=2.5p pd=10.5u as=4.4p ps=20.88u w=10u l=1u
X1722 a_57930_54008# a_61830_49494# a_57478_49608# VSS nfet_06v0 ad=1.1p pd=5.88u as=1.1p ps=5.88u w=2.5u l=1u
X1723 VSS VDD VSS VSS nfet_06v0 ad=0.66p pd=3.88u as=0 ps=0 w=1.5u l=2u
X1724 S1N a_25574_16720# VSS ppolyf_u_1k r_width=1u r_length=2u
X1725 a_26330_16720# a_27476_24466# a_26812_24466# VDD pfet_06v0 ad=2.2p pd=10.88u as=1.65p ps=5.66u w=5u l=1u
X1726 VSS a_33294_58232# a_32626_61632# VSS nfet_06v0 ad=1.1p pd=5.88u as=0.65p ps=3.02u w=2.5u l=1u
X1727 a_62300_62586# a_62300_62586# a_63948_61586# VDD pfet_06v0 ad=4.4p pd=20.88u as=3.3p ps=10.66u w=10u l=1u
X1728 a_74974_58632# a_73010_58516# a_74674_58632# VSS nfet_06v0 ad=0.175p pd=1.2u as=0.175p ps=1.2u w=0.7u l=1u
X1729 a_56366_40872# a_48426_40758# a_55698_44272# VSS nfet_06v0 ad=0.65p pd=3.02u as=1.1p ps=5.88u w=2.5u l=1u
X1730 VDD a_33742_62632# a_32182_58232# VDD pfet_06v0 ad=1.3p pd=5.52u as=1.3p ps=5.52u w=5u l=1u
X1731 a_23852_10552# a_30870_40756# VSS ppolyf_u_1k r_width=1u r_length=76.45u
X1732 S3N a_4966_28704# VSS ppolyf_u_1k r_width=1u r_length=2u
D33 VSS S4P diode_nd2ps_06v0 pj=30u area=50p
X1733 a_10872_23582# a_2210_23466# VDD VDD pfet_06v0 ad=2.5p pd=10.5u as=4.4p ps=20.88u w=10u l=1u
X1734 VDD a_33742_54008# a_31070_49608# VDD pfet_06v0 ad=2.2p pd=10.88u as=1.3p ps=5.52u w=5u l=1u
X1735 VDD a_33742_71368# a_31070_66968# VDD pfet_06v0 ad=1.3p pd=5.52u as=1.3p ps=5.52u w=5u l=1u
X1736 a_50556_35450# a_43838_35450# a_50756_35566# VDD pfet_06v0 ad=3.3p pd=10.66u as=2.5p ps=10.5u w=10u l=1u
X1737 a_2170_40758# a_2170_40758# VSS VSS nfet_06v0 ad=0.44p pd=2.88u as=0.44p ps=2.88u w=1u l=1u
X1738 a_38758_58118# a_25694_61586# a_42520_61702# VDD pfet_06v0 ad=4.4p pd=20.88u as=2.5p ps=10.5u w=10u l=1u
X1739 a_9594_28704# a_2470_28704# a_9794_28748# VSS nfet_06v0 ad=1.65p pd=5.66u as=1.25p ps=5.5u w=5u l=1u
X1740 a_34406_40872# a_25354_40758# a_31510_44272# VSS nfet_06v0 ad=0.65p pd=3.02u as=1.1p ps=5.88u w=2.5u l=1u
X1741 a_30398_53078# a_25694_52962# a_30066_53078# VDD pfet_06v0 ad=2.5p pd=10.5u as=3.3p ps=10.66u w=10u l=1u
X1742 VSS a_26086_40758# a_30038_40802# VSS nfet_06v0 ad=2.2p pd=10.88u as=1.25p ps=5.5u w=5u l=1u
X1743 a_6882_44342# a_8798_40756# a_9442_44272# VDD pfet_06v0 ad=4.4p pd=20.88u as=2.6p ps=10.52u w=10u l=1u
X1744 VSS VDD VSS VSS nfet_06v0 ad=0.88p pd=4.88u as=0 ps=0 w=2u l=2u
X1745 a_65180_33620# a_80598_33170# VSS ppolyf_u_1k r_width=1u r_length=76.45u
X1746 a_33742_62632# a_38758_58118# a_33294_58232# VSS nfet_06v0 ad=1.1p pd=5.88u as=1.1p ps=5.88u w=2.5u l=1u
X1747 a_51702_53078# a_48466_52962# VDD VDD pfet_06v0 ad=2.5p pd=10.5u as=4.4p ps=20.88u w=10u l=1u
X1748 VSS a_10110_66968# a_9442_70368# VSS nfet_06v0 ad=1.1p pd=5.88u as=0.65p ps=3.02u w=2.5u l=1u
X1749 a_39228_53962# a_39228_53962# a_40876_52962# VDD pfet_06v0 ad=4.4p pd=20.88u as=3.3p ps=10.66u w=10u l=1u
X1750 a_8798_58116# a_4434_28748# cap_mim_2f0_m4m5_noshield c_width=25u c_length=4u
X1751 a_66570_37346# a_67658_28704# VSS VSS nfet_06v0 ad=0.825p pd=3.16u as=1.1p ps=5.88u w=2.5u l=1u
X1752 a_43538_35450# a_43838_35450# a_59596_35566# VDD pfet_06v0 ad=4.4p pd=20.88u as=2.5p ps=10.5u w=10u l=1u
X1753 a_48426_58118# a_48766_61586# a_48666_61702# VDD pfet_06v0 ad=4.4p pd=20.88u as=2.5p ps=10.5u w=10u l=1u
X1754 a_2170_66854# a_2510_70322# a_2410_70438# VDD pfet_06v0 ad=4.4p pd=20.88u as=2.5p ps=10.5u w=10u l=1u
X1755 a_30870_40756# a_23852_9202# VDD VDD pfet_06v0 ad=0.22p pd=1.88u as=0.22p ps=1.88u w=0.5u l=1u
X1756 a_6522_49538# a_7686_49492# a_7886_49608# VSS nfet_06v0 ad=2.2p pd=10.88u as=1.3p ps=5.52u w=5u l=1u
X1757 a_40876_44226# a_25694_44226# a_41076_44342# VDD pfet_06v0 ad=3.3p pd=10.66u as=2.5p ps=10.5u w=10u l=1u
X1758 VDD VSS VDD VDD pfet_06v0 ad=0.66p pd=3.88u as=0 ps=0 w=1.5u l=2u
X1759 YP a_74894_53424# VDD VDD pfet_05v0 ad=0.8052p pd=4.54u as=0.8052p ps=4.54u w=1.83u l=0.5u
X1760 a_76660_59840# a_21162_82772# a_17396_80992# VSS nfet_06v0 ad=1.0912p pd=5.84u as=0.6448p ps=3u w=2.48u l=1u
X1761 VSS VDD VSS VSS nfet_06v0 ad=0.88p pd=4.88u as=0 ps=0 w=2u l=2u
X1762 a_9442_61632# a_2170_58118# a_10110_58232# VSS nfet_06v0 ad=1.1p pd=5.88u as=0.65p ps=3.02u w=2.5u l=1u
X1763 a_2510_52962# a_2510_52962# a_5166_49538# VSS nfet_06v0 ad=0.44p pd=2.88u as=0.25p ps=1.5u w=1u l=1u
X1764 a_26086_58118# a_25694_61586# a_26706_61702# VDD pfet_06v0 ad=4.4p pd=20.88u as=2.5p ps=10.5u w=10u l=1u
X1765 a_3244_10552# a_7686_40756# VSS ppolyf_u_1k r_width=1u r_length=76.45u
X1766 a_51122_4780# a_50922_4736# VSS VSS nfet_06v0 ad=1.25p pd=5.5u as=2.2p ps=10.88u w=5u l=1u
X1767 a_65180_33170# a_80598_33170# VSS ppolyf_u_1k r_width=1u r_length=76.45u
X1768 a_48426_66854# a_48426_66854# VSS VSS nfet_06v0 ad=0.44p pd=2.88u as=0.44p ps=2.88u w=1u l=1u
X1769 a_14686_16764# a_2510_23466# VSS VSS nfet_06v0 ad=0.25p pd=1.5u as=0.44p ps=2.88u w=1u l=1u
X1770 a_57478_58232# a_48426_58118# a_54582_61632# VSS nfet_06v0 ad=0.65p pd=3.02u as=1.1p ps=5.88u w=2.5u l=1u
X1771 a_55698_70368# a_56366_66968# VSS VSS nfet_06v0 ad=0.65p pd=3.02u as=1.1p ps=5.88u w=2.5u l=1u
X1772 VSS a_31286_81052# a_30906_82772# VSS nfet_06v0 ad=0.44p pd=2.88u as=0.33p ps=1.66u w=1u l=1u
X1773 a_29766_70438# a_25394_70322# VDD VDD pfet_06v0 ad=2.5p pd=10.5u as=4.4p ps=20.88u w=10u l=1u
X1774 a_7886_58232# a_10558_62632# VDD VDD pfet_06v0 ad=1.3p pd=5.52u as=2.2p ps=10.88u w=5u l=1u
X1775 a_54114_81052# a_19658_66968# VDD VDD pfet_06v0 ad=0.99p pd=3.66u as=1.32p ps=6.88u w=3u l=1u
X1776 a_6882_53078# a_8798_49492# a_9442_53008# VDD pfet_06v0 ad=4.4p pd=20.88u as=2.6p ps=10.52u w=10u l=1u
X1777 a_9594_4736# a_2470_4736# a_9794_4780# VSS nfet_06v0 ad=1.65p pd=5.66u as=1.25p ps=5.5u w=5u l=1u
X1778 VDD VSS VDD VDD pfet_06v0 ad=7.92p pd=36.88u as=0 ps=0 w=18u l=2u
X1779 a_54142_40872# a_30870_40756# a_52778_40802# VSS nfet_06v0 ad=1.3p pd=5.52u as=2.2p ps=10.88u w=5u l=1u
X1780 a_32626_61632# a_33294_58232# VSS VSS nfet_06v0 ad=0.65p pd=3.02u as=1.1p ps=5.88u w=2.5u l=1u
X1781 a_54582_70368# a_30870_66852# a_53138_70438# VDD pfet_06v0 ad=2.6p pd=10.52u as=4.4p ps=20.88u w=10u l=1u
X1782 a_78280_35566# a_64146_35450# VDD VDD pfet_06v0 ad=2.5p pd=10.5u as=4.4p ps=20.88u w=10u l=1u
X1783 a_25042_16764# a_7876_75392# a_23278_16764# VSS nfet_06v0 ad=0.44p pd=2.88u as=0.44p ps=2.88u w=1u l=1u
X1784 VSS a_33294_40872# a_32626_44272# VSS nfet_06v0 ad=1.1p pd=5.88u as=0.65p ps=3.02u w=2.5u l=1u
X1785 a_71164_23466# a_64446_23466# a_71364_23582# VDD pfet_06v0 ad=3.3p pd=10.66u as=2.5p ps=10.5u w=10u l=1u
X1786 a_52478_49538# a_49158_49494# VSS VSS nfet_06v0 ad=1.25p pd=5.5u as=2.2p ps=10.88u w=5u l=1u
X1787 a_2410_61702# a_2210_61586# VDD VDD pfet_06v0 ad=2.5p pd=10.5u as=4.4p ps=20.88u w=10u l=1u
X1788 a_25774_28748# a_4966_16720# a_23278_28748# VSS nfet_06v0 ad=0.44p pd=2.88u as=0.44p ps=2.88u w=1u l=1u
X1789 a_11674_71368# a_15574_66854# a_11222_66968# VSS nfet_06v0 ad=1.1p pd=5.88u as=1.1p ps=5.88u w=2.5u l=1u
X1790 a_4134_40802# a_2510_44226# VSS VSS nfet_06v0 ad=0.25p pd=1.5u as=0.44p ps=2.88u w=1u l=1u
X1791 a_2410_11598# a_2210_11482# VDD VDD pfet_06v0 ad=2.5p pd=10.5u as=4.4p ps=20.88u w=10u l=1u
X1792 a_76660_59840# a_73010_58516# VSS VSS nfet_06v0 ad=0.5456p pd=3.36u as=0.5456p ps=3.36u w=1.24u l=1u
X1793 a_15232_11598# a_2210_11482# VDD VDD pfet_06v0 ad=2.5p pd=10.5u as=4.4p ps=20.88u w=10u l=1u
X1794 a_71530_28704# a_64406_28704# a_71730_28748# VSS nfet_06v0 ad=1.65p pd=5.66u as=1.25p ps=5.5u w=5u l=1u
X1795 a_2510_52962# a_2510_52962# VDD VDD pfet_06v0 ad=0.88p pd=4.88u as=0.88p ps=4.88u w=2u l=1u
X1796 a_52778_40802# a_48426_40758# a_52478_40802# VSS nfet_06v0 ad=1.65p pd=5.66u as=1.25p ps=5.5u w=5u l=1u
X1797 a_29706_58162# a_30870_58116# a_31070_58232# VSS nfet_06v0 ad=2.2p pd=10.88u as=1.3p ps=5.52u w=5u l=1u
D34 S4N VDD diode_pd2nw_06v0 pj=30u area=50p
X1798 a_38876_23582# a_22818_23466# VDD VDD pfet_06v0 ad=2.5p pd=10.5u as=4.4p ps=20.88u w=10u l=1u
X1799 a_30066_44342# a_25694_44226# a_29766_44342# VDD pfet_06v0 ad=3.3p pd=10.66u as=2.5p ps=10.5u w=10u l=1u
X1800 a_64148_53078# a_63948_52962# VDD VDD pfet_06v0 ad=2.5p pd=10.5u as=4.4p ps=20.88u w=10u l=1u
D35 VSS Z diode_nd2ps_06v0 pj=30u area=50p
X1801 X a_71650_44468# VSS ppolyf_u_1k r_width=1u r_length=2u
X1802 Y a_7876_80992# VSS ppolyf_u_1k r_width=1u r_length=2u
X1803 a_74516_42480# a_71650_44468# a_75916_42410# VSS nfet_06v0 ad=0.88p pd=4.88u as=0.5p ps=2.5u w=2u l=1u
X1804 a_32626_70368# a_33294_66968# VSS VSS nfet_06v0 ad=0.65p pd=3.02u as=0.65p ps=3.02u w=2.5u l=1u
X1805 a_23852_22536# a_39270_22086# VSS ppolyf_u_1k r_width=1u r_length=76.45u
X1806 a_27476_24466# a_27476_24466# a_29836_23466# VDD pfet_06v0 ad=4.4p pd=20.88u as=3.3p ps=10.66u w=10u l=1u
X1807 a_25042_16764# a_26812_24466# VDD VDD pfet_06v0 ad=1.65p pd=5.66u as=2.2p ps=10.88u w=5u l=1u
X1808 a_40650_82772# a_40698_81052# VSS VSS nfet_06v0 ad=0.33p pd=1.66u as=0.44p ps=2.88u w=1u l=1u
X1809 a_11222_49608# a_2170_49494# a_8326_53008# VSS nfet_06v0 ad=0.65p pd=3.02u as=1.1p ps=5.88u w=2.5u l=1u
X1810 a_6222_66898# a_2902_66854# VSS VSS nfet_06v0 ad=1.25p pd=5.5u as=2.2p ps=10.88u w=5u l=1u
X1811 a_4434_16764# a_4234_16720# a_2670_16764# VSS nfet_06v0 ad=0.44p pd=2.88u as=0.44p ps=2.88u w=1u l=1u
X1812 a_65458_35566# a_64146_35450# VDD VDD pfet_06v0 ad=2.5p pd=10.5u as=4.4p ps=20.88u w=10u l=1u
X1813 a_50554_81052# a_57930_71368# VDD VDD pfet_06v0 ad=4.4p pd=20.88u as=2.6p ps=10.52u w=10u l=1u
X1814 a_26994_28704# a_26994_28704# a_30202_28704# VSS nfet_06v0 ad=2.2p pd=10.88u as=1.65p ps=5.66u w=5u l=1u
X1815 a_9442_44272# a_2170_40758# a_10110_40872# VSS nfet_06v0 ad=1.1p pd=5.88u as=0.65p ps=3.02u w=2.5u l=1u
X1816 a_71650_44468# a_71650_44468# VDD VDD pfet_06v0 ad=0.52p pd=2.52u as=0.52p ps=2.52u w=2u l=1u
X1817 VSS a_33294_58232# a_31510_61632# VSS nfet_06v0 ad=0.65p pd=3.02u as=0.65p ps=3.02u w=2.5u l=1u
X1818 a_61830_58118# a_48766_61586# a_65592_61702# VDD pfet_06v0 ad=4.4p pd=20.88u as=2.5p ps=10.5u w=10u l=1u
X1819 a_57478_40872# a_48426_40758# a_54582_44272# VSS nfet_06v0 ad=0.65p pd=3.02u as=1.1p ps=5.88u w=2.5u l=1u
X1820 a_30870_66852# a_44572_33170# VDD VDD pfet_06v0 ad=0.22p pd=1.88u as=0.22p ps=1.88u w=0.5u l=1u
X1821 a_8798_49492# a_23852_21186# VDD VDD pfet_06v0 ad=0.22p pd=1.88u as=0.22p ps=1.88u w=0.5u l=1u
X1822 a_67102_4780# a_4966_4736# a_64606_4780# VSS nfet_06v0 ad=0.44p pd=2.88u as=0.44p ps=2.88u w=1u l=1u
X1823 a_55254_58232# a_48766_61586# a_56814_62632# VDD pfet_06v0 ad=2.2p pd=10.88u as=1.3p ps=5.52u w=5u l=1u
X1824 a_23852_21636# a_39270_22086# VSS ppolyf_u_1k r_width=1u r_length=76.45u
X1825 a_71560_41272# a_44170_81096# a_71650_44468# VSS nfet_06v0 ad=1.0912p pd=5.84u as=0.6448p ps=3u w=2.48u l=1u
X1826 S2P a_4234_4736# VSS ppolyf_u_1k r_width=1u r_length=2u
X1827 a_29406_58162# a_26086_58118# VSS VSS nfet_06v0 ad=1.25p pd=5.5u as=2.2p ps=10.88u w=5u l=1u
X1828 VDD a_11674_71368# a_19658_66968# VDD pfet_06v0 ad=2.6p pd=10.52u as=2.6p ps=10.52u w=10u l=1u
X1829 a_43838_23466# a_43838_23466# VDD VDD pfet_06v0 ad=0.88p pd=4.88u as=0.88p ps=4.88u w=2u l=1u
X1830 a_32626_44272# a_33294_40872# VSS VSS nfet_06v0 ad=0.65p pd=3.02u as=1.1p ps=5.88u w=2.5u l=1u
X1831 a_66370_4780# a_68140_12482# VDD VDD pfet_06v0 ad=1.65p pd=5.66u as=2.2p ps=10.88u w=5u l=1u
X1832 a_68804_12482# a_68804_12482# a_71164_11482# VDD pfet_06v0 ad=4.4p pd=20.88u as=3.3p ps=10.66u w=10u l=1u
X1833 a_23318_23582# a_23118_23466# a_24130_23582# VDD pfet_06v0 ad=4.4p pd=20.88u as=2.5p ps=10.5u w=10u l=1u
X1834 VSS VDD VSS VSS nfet_06v0 ad=0.66p pd=3.88u as=0 ps=0 w=1.5u l=2u
X1835 a_17396_80992# a_50506_82772# a_71560_59840# VSS nfet_06v0 ad=0.6448p pd=3u as=1.0912p ps=5.84u w=2.48u l=1u
D36 Y VDD diode_pd2nw_06v0 pj=30u area=50p
X1836 VSS VDD VSS VSS nfet_06v0 ad=0.88p pd=4.88u as=0 ps=0 w=2u l=2u
X1837 VDD VSS VDD VDD pfet_06v0 ad=7.92p pd=36.88u as=0 ps=0 w=18u l=2u
X1838 VDD VSS VDD VDD pfet_06v0 ad=0.66p pd=3.88u as=0 ps=0 w=1.5u l=2u
X1839 a_3244_22536# a_18662_22086# VSS ppolyf_u_1k r_width=1u r_length=76.45u
X1840 VSS a_10110_66968# a_8326_70368# VSS nfet_06v0 ad=0.65p pd=3.02u as=0.65p ps=3.02u w=2.5u l=1u
X1841 VSS VDD VSS VSS nfet_06v0 ad=0.88p pd=4.88u as=0 ps=0 w=2u l=2u
X1842 a_49158_58118# a_48766_61586# a_49778_61702# VDD pfet_06v0 ad=4.4p pd=20.88u as=2.5p ps=10.5u w=10u l=1u
X1843 a_2902_66854# a_2510_70322# a_3522_70438# VDD pfet_06v0 ad=4.4p pd=20.88u as=2.5p ps=10.5u w=10u l=1u
X1844 VSS a_56366_66968# a_54582_70368# VSS nfet_06v0 ad=0.65p pd=3.02u as=0.65p ps=3.02u w=2.5u l=1u
X1845 a_7686_49492# a_65180_9202# VDD VDD pfet_06v0 ad=0.22p pd=1.88u as=0.22p ps=1.88u w=0.5u l=1u
X1846 a_19658_40872# a_11674_45272# VDD VDD pfet_06v0 ad=2.6p pd=10.52u as=4.4p ps=20.88u w=10u l=1u
X1847 VSS a_56366_49608# a_54582_53008# VSS nfet_06v0 ad=1.1p pd=5.88u as=0.65p ps=3.02u w=2.5u l=1u
X1848 a_64606_28748# a_64406_28704# a_64306_28748# VSS nfet_06v0 ad=2.2p pd=10.88u as=1.25p ps=5.5u w=5u l=1u
X1849 a_7686_58116# a_49002_16764# VSS VSS nfet_06v0 ad=0.44p pd=2.88u as=0.44p ps=2.88u w=1u l=1u
X1850 a_24130_11598# a_22818_11482# VDD VDD pfet_06v0 ad=2.5p pd=10.5u as=4.4p ps=20.88u w=10u l=1u
X1851 VSS a_33294_66968# a_31510_70368# VSS nfet_06v0 ad=1.1p pd=5.88u as=0.65p ps=3.02u w=2.5u l=1u
X1852 a_56814_45272# a_48766_44226# a_55254_40872# VDD pfet_06v0 ad=1.3p pd=5.52u as=2.2p ps=10.88u w=5u l=1u
X1853 a_51422_49538# a_48766_52962# VSS VSS nfet_06v0 ad=0.25p pd=1.5u as=0.44p ps=2.88u w=1u l=1u
X1854 a_29706_40802# a_30870_40756# a_31070_40872# VSS nfet_06v0 ad=2.2p pd=10.88u as=1.3p ps=5.52u w=5u l=1u
X1855 a_8326_61632# a_2170_58118# a_11222_58232# VSS nfet_06v0 ad=1.1p pd=5.88u as=0.65p ps=3.02u w=2.5u l=1u
X1856 a_38758_49494# a_38758_49494# a_41278_49494# VSS nfet_06v0 ad=2.2p pd=10.88u as=1.65p ps=5.66u w=5u l=1u
X1857 VDD a_48466_61586# a_53470_61702# VDD pfet_06v0 ad=4.4p pd=20.88u as=2.5p ps=10.5u w=10u l=1u
D37 S2P VDD diode_pd2nw_06v0 pj=30u area=50p
X1858 a_23852_9202# a_23118_11482# a_25042_4780# VDD pfet_06v0 ad=1.65p pd=5.66u as=1.65p ps=5.66u w=5u l=1u
X1859 a_3244_21636# a_18662_22086# VSS ppolyf_u_1k r_width=1u r_length=76.45u
X1860 VDD VSS VDD VDD pfet_06v0 ad=4.29p pd=20.38u as=0 ps=0 w=9.75u l=2u
X1861 a_2210_70322# a_2510_70322# a_4134_66898# VSS nfet_06v0 ad=0.44p pd=2.88u as=0.25p ps=1.5u w=1u l=1u
X1862 a_65180_9202# a_68322_4736# a_69610_4780# VSS nfet_06v0 ad=1.1p pd=5.88u as=0.825p ps=3.16u w=2.5u l=1u
X1863 a_71560_50008# a_42406_81096# a_7876_80992# VSS nfet_06v0 ad=1.0912p pd=5.84u as=0.6448p ps=3u w=2.48u l=1u
X1864 a_41278_58118# a_25354_58118# a_41478_58162# VSS nfet_06v0 ad=1.65p pd=5.66u as=1.25p ps=5.5u w=5u l=1u
X1865 a_71730_4780# a_71530_4736# VSS VSS nfet_06v0 ad=1.25p pd=5.5u as=2.2p ps=10.88u w=5u l=1u
X1866 a_47050_4736# a_43798_4736# a_46774_13398# VSS nfet_06v0 ad=0.825p pd=3.16u as=0.825p ps=3.16u w=2.5u l=1u
X1867 a_48766_44226# a_48766_44226# a_51422_40802# VSS nfet_06v0 ad=0.44p pd=2.88u as=0.25p ps=1.5u w=1u l=1u
X1868 a_67658_16720# a_64406_16720# a_67382_25382# VSS nfet_06v0 ad=0.825p pd=3.16u as=0.825p ps=3.16u w=2.5u l=1u
X1869 VSS a_32750_81052# a_32662_81096# VSS nfet_06v0 ad=0.44p pd=2.88u as=0.44p ps=2.88u w=1u l=1u
X1870 a_68140_36450# a_64446_35450# a_67102_28748# VDD pfet_06v0 ad=1.65p pd=5.66u as=1.65p ps=5.66u w=5u l=1u
X1871 VDD a_33742_71368# a_32182_66968# VDD pfet_06v0 ad=2.2p pd=10.88u as=1.3p ps=5.52u w=5u l=1u
X1872 VSS VDD VSS VSS nfet_06v0 ad=7.92p pd=36.88u as=0 ps=0 w=18u l=2u
X1873 S3P a_4234_28704# VSS ppolyf_u_1k r_width=1u r_length=2u
X1874 VSS VDD VSS VSS nfet_06v0 ad=7.92p pd=36.88u as=0 ps=0 w=18u l=2u
X1875 a_7886_58232# a_2510_61586# a_11674_62632# VDD pfet_06v0 ad=2.2p pd=10.88u as=1.3p ps=5.52u w=5u l=1u
X1876 a_23278_28748# a_23078_28704# a_24010_28748# VSS nfet_06v0 ad=2.2p pd=10.88u as=1.25p ps=5.5u w=5u l=1u
X1877 a_26330_4736# a_23078_4736# a_26054_13398# VSS nfet_06v0 ad=0.825p pd=3.16u as=0.825p ps=3.16u w=2.5u l=1u
X1878 a_10558_54008# a_15574_49494# a_10110_49608# VSS nfet_06v0 ad=1.1p pd=5.88u as=1.1p ps=5.88u w=2.5u l=1u
X1879 a_30870_58116# a_65180_21186# VDD VDD pfet_06v0 ad=0.22p pd=1.88u as=0.22p ps=1.88u w=0.5u l=1u
X1880 a_45190_81096# a_41030_81052# a_44258_81052# VSS nfet_06v0 ad=0.25p pd=1.5u as=0.44p ps=2.88u w=1u l=1u
X1881 a_50390_49538# a_48766_52962# VSS VSS nfet_06v0 ad=0.25p pd=1.5u as=0.44p ps=2.88u w=1u l=1u
X1882 a_6522_49538# a_2170_49494# a_6222_49538# VSS nfet_06v0 ad=1.65p pd=5.66u as=1.25p ps=5.5u w=5u l=1u
X1883 a_25394_61586# a_25694_61586# a_27318_58162# VSS nfet_06v0 ad=0.44p pd=2.88u as=0.25p ps=1.5u w=1u l=1u
X1884 VDD VSS VDD VDD pfet_06v0 ad=0.66p pd=3.88u as=0 ps=0 w=1.5u l=2u
X1885 VSS a_33294_40872# a_31510_44272# VSS nfet_06v0 ad=0.65p pd=3.02u as=0.65p ps=3.02u w=2.5u l=1u
X1886 VSS VDD VSS VSS nfet_06v0 ad=0.66p pd=3.88u as=0 ps=0 w=1.5u l=2u
X1887 VSS VDD VSS VSS nfet_06v0 ad=7.92p pd=36.88u as=0 ps=0 w=18u l=2u
X1888 a_56814_54008# a_61830_49494# a_56366_49608# VSS nfet_06v0 ad=1.1p pd=5.88u as=1.1p ps=5.88u w=2.5u l=1u
X1889 a_34406_58232# a_39228_62586# a_34858_62632# VDD pfet_06v0 ad=2.2p pd=10.88u as=2.2p ps=10.88u w=5u l=1u
X1890 a_19658_49608# a_11674_54008# VDD VDD pfet_06v0 ad=2.6p pd=10.52u as=4.4p ps=20.88u w=10u l=1u
X1891 a_3522_61702# a_2210_61586# VDD VDD pfet_06v0 ad=2.5p pd=10.5u as=4.4p ps=20.88u w=10u l=1u
X1892 a_3522_11598# a_2210_11482# VDD VDD pfet_06v0 ad=2.5p pd=10.5u as=4.4p ps=20.88u w=10u l=1u
X1893 a_54142_40872# a_48766_44226# a_57930_45272# VDD pfet_06v0 ad=2.2p pd=10.88u as=1.3p ps=5.52u w=5u l=1u
X1894 a_80204_23582# a_64146_23466# VDD VDD pfet_06v0 ad=2.5p pd=10.5u as=4.4p ps=20.88u w=10u l=1u
X1895 a_6882_53078# a_2510_52962# a_6582_53078# VDD pfet_06v0 ad=3.3p pd=10.66u as=2.5p ps=10.5u w=10u l=1u
X1896 a_48466_44226# a_48766_44226# a_50390_40802# VSS nfet_06v0 ad=0.44p pd=2.88u as=0.25p ps=1.5u w=1u l=1u
X1897 a_56814_54008# a_48766_52962# a_55254_49608# VDD pfet_06v0 ad=1.3p pd=5.52u as=2.2p ps=10.88u w=5u l=1u
X1898 a_42520_53078# a_25394_52962# VDD VDD pfet_06v0 ad=2.5p pd=10.5u as=4.4p ps=20.88u w=10u l=1u
X1899 a_26812_24466# a_26994_16720# a_26330_16720# VSS nfet_06v0 ad=1.1p pd=5.88u as=0.825p ps=3.16u w=2.5u l=1u
X1900 a_16344_11598# a_2210_11482# VDD VDD pfet_06v0 ad=2.5p pd=10.5u as=4.4p ps=20.88u w=10u l=1u
X1901 a_5166_16764# a_4966_16720# a_2670_16764# VSS nfet_06v0 ad=0.44p pd=2.88u as=0.44p ps=2.88u w=1u l=1u
X1902 a_74974_41272# a_73010_41156# a_74674_41272# VSS nfet_06v0 ad=0.175p pd=1.2u as=0.175p ps=1.2u w=0.7u l=1u
X1903 a_26330_28704# a_27476_36450# a_26812_36450# VDD pfet_06v0 ad=2.2p pd=10.88u as=1.65p ps=5.66u w=5u l=1u
X1904 a_29706_58162# a_8798_58116# a_32182_58232# VSS nfet_06v0 ad=2.2p pd=10.88u as=1.3p ps=5.52u w=5u l=1u
X1905 a_55698_70368# a_56366_66968# VSS VSS nfet_06v0 ad=0.65p pd=3.02u as=0.65p ps=3.02u w=2.5u l=1u
X1906 VDD VSS VDD VDD pfet_06v0 ad=0.66p pd=3.88u as=0 ps=0 w=1.5u l=2u
X1907 a_27476_24466# a_23078_16720# a_29346_16764# VSS nfet_06v0 ad=2.2p pd=10.88u as=1.25p ps=5.5u w=5u l=1u
X1908 a_10872_35566# a_2210_35450# VDD VDD pfet_06v0 ad=2.5p pd=10.5u as=4.4p ps=20.88u w=10u l=1u
X1909 a_11674_45272# a_2510_44226# a_7886_40872# VDD pfet_06v0 ad=1.3p pd=5.52u as=2.2p ps=10.88u w=5u l=1u
X1910 a_26086_58118# a_25354_58118# a_26286_58162# VSS nfet_06v0 ad=2.2p pd=10.88u as=1.25p ps=5.5u w=5u l=1u
X1911 a_8998_58232# a_10558_62632# VDD VDD pfet_06v0 ad=1.3p pd=5.52u as=1.3p ps=5.52u w=5u l=1u
X1912 a_31510_53008# a_33294_49608# VSS VSS nfet_06v0 ad=0.65p pd=3.02u as=0.65p ps=3.02u w=2.5u l=1u
X1913 a_48666_53078# a_48466_52962# VDD VDD pfet_06v0 ad=2.5p pd=10.5u as=4.4p ps=20.88u w=10u l=1u
X1914 a_72808_23582# a_64146_23466# VDD VDD pfet_06v0 ad=2.5p pd=10.5u as=4.4p ps=20.88u w=10u l=1u
X1915 a_9442_53008# a_10110_49608# VSS VSS nfet_06v0 ad=0.65p pd=3.02u as=1.1p ps=5.88u w=2.5u l=1u
X1916 a_7886_66968# a_10558_71368# VDD VDD pfet_06v0 ad=1.3p pd=5.52u as=1.3p ps=5.52u w=5u l=1u
X1917 a_41030_81052# a_34406_58232# VSS VSS nfet_06v0 ad=1.3p pd=5.52u as=2.2p ps=10.88u w=5u l=1u
X1918 a_31510_53008# a_31286_81052# cap_mim_2f0_m4m5_noshield c_width=20u c_length=10u
X1919 VDD VSS VDD VDD pfet_06v0 ad=0.88p pd=4.88u as=0 ps=0 w=2u l=2u
X1920 VDD VSS VDD VDD pfet_06v0 ad=7.92p pd=36.88u as=0 ps=0 w=18u l=2u
X1921 a_8326_44272# a_2170_40758# a_11222_40872# VSS nfet_06v0 ad=1.1p pd=5.88u as=0.65p ps=3.02u w=2.5u l=1u
X1922 a_26706_53078# a_25394_52962# VDD VDD pfet_06v0 ad=2.5p pd=10.5u as=4.4p ps=20.88u w=10u l=1u
X1923 a_40698_81052# a_57930_62632# VDD VDD pfet_06v0 ad=2.6p pd=10.52u as=4.4p ps=20.88u w=10u l=1u
X1924 VSS a_57478_66968# a_50554_81052# VSS nfet_06v0 ad=1.3p pd=5.52u as=1.3p ps=5.52u w=5u l=1u
X1925 Z a_17396_80992# VSS ppolyf_u_1k r_width=1u r_length=2u
X1926 a_54142_49608# a_48766_52962# a_57930_54008# VDD pfet_06v0 ad=2.2p pd=10.88u as=1.3p ps=5.52u w=5u l=1u
X1927 a_6204_24466# a_6386_16720# a_5722_16720# VSS nfet_06v0 ad=1.1p pd=5.88u as=0.825p ps=3.16u w=2.5u l=1u
X1928 a_6582_44342# a_2210_44226# VDD VDD pfet_06v0 ad=2.5p pd=10.5u as=4.4p ps=20.88u w=10u l=1u
X1929 a_76660_42480# a_24682_81096# a_71650_44468# VSS nfet_06v0 ad=1.0912p pd=5.84u as=0.6448p ps=3u w=2.48u l=1u
X1930 a_74974_50008# a_73010_49892# a_74674_50008# VSS nfet_06v0 ad=0.175p pd=1.2u as=0.175p ps=1.2u w=0.7u l=1u
X1931 VDD a_10558_45272# a_7886_40872# VDD pfet_06v0 ad=1.3p pd=5.52u as=1.3p ps=5.52u w=5u l=1u
X1932 VSS VDD VSS VSS nfet_06v0 ad=0.66p pd=3.88u as=0 ps=0 w=1.5u l=2u
X1933 a_2210_23466# a_2510_23466# a_13654_16764# VSS nfet_06v0 ad=0.44p pd=2.88u as=0.25p ps=1.5u w=1u l=1u
X1934 VDD a_31930_81096# a_32750_81052# VDD pfet_06v0 ad=1.32p pd=6.88u as=0.99p ps=3.66u w=3u l=1u
D38 VSS Y diode_nd2ps_06v0 pj=30u area=50p
X1935 a_39228_62586# a_25354_58118# a_40422_58162# VSS nfet_06v0 ad=2.2p pd=10.88u as=1.25p ps=5.5u w=5u l=1u
X1936 a_14686_28748# a_2510_35450# VSS VSS nfet_06v0 ad=0.25p pd=1.5u as=0.44p ps=2.88u w=1u l=1u
X1937 a_19658_49608# a_11222_49608# VSS VSS nfet_06v0 ad=2.2p pd=10.88u as=1.3p ps=5.52u w=5u l=1u
X1938 VDD VSS VDD VDD pfet_06v0 ad=4.29p pd=20.38u as=0 ps=0 w=9.75u l=2u
X1939 a_53138_53078# a_48766_52962# a_52838_53078# VDD pfet_06v0 ad=3.3p pd=10.66u as=2.5p ps=10.5u w=10u l=1u
X1940 a_11674_54008# a_2510_52962# a_7886_49608# VDD pfet_06v0 ad=1.3p pd=5.52u as=2.2p ps=10.88u w=5u l=1u
X1941 a_5166_66898# a_2510_70322# VSS VSS nfet_06v0 ad=0.25p pd=1.5u as=0.44p ps=2.88u w=1u l=1u
X1942 a_49002_16764# a_48196_24466# a_44572_21186# VDD pfet_06v0 ad=2.2p pd=10.88u as=1.65p ps=5.66u w=5u l=1u
X1943 a_61830_49494# a_61830_49494# a_64350_49494# VSS nfet_06v0 ad=2.2p pd=10.88u as=1.65p ps=5.66u w=5u l=1u
X1944 a_3102_49538# a_2902_49494# VSS VSS nfet_06v0 ad=1.25p pd=5.5u as=2.2p ps=10.88u w=5u l=1u
X1945 a_33294_49608# a_25354_49494# a_32626_53008# VSS nfet_06v0 ad=0.65p pd=3.02u as=1.1p ps=5.88u w=2.5u l=1u
X1946 VDD VSS VDD VDD pfet_06v0 ad=4.29p pd=20.38u as=0 ps=0 w=9.75u l=2u
X1947 S1N a_25574_16720# VSS ppolyf_u_1k r_width=1u r_length=2u
X1948 VDD VSS VDD VDD pfet_06v0 ad=7.92p pd=36.88u as=0 ps=0 w=18u l=2u
X1949 a_25042_28748# a_4234_16720# a_23278_28748# VSS nfet_06v0 ad=0.44p pd=2.88u as=0.44p ps=2.88u w=1u l=1u
X1950 a_11222_40872# a_16044_45226# a_11674_45272# VDD pfet_06v0 ad=2.2p pd=10.88u as=2.2p ps=10.88u w=5u l=1u
D39 Z VDD diode_pd2nw_06v0 pj=30u area=50p
D40 X VDD diode_pd2nw_06v0 pj=30u area=50p
X1951 a_53950_16764# a_43498_16720# VSS VSS nfet_06v0 ad=1.25p pd=5.5u as=2.2p ps=10.88u w=5u l=1u
X1952 a_29706_40802# a_8798_40756# a_32182_40872# VSS nfet_06v0 ad=2.2p pd=10.88u as=1.3p ps=5.52u w=5u l=1u
X1953 VSS a_10110_58232# a_9442_61632# VSS nfet_06v0 ad=0.65p pd=3.02u as=0.65p ps=3.02u w=2.5u l=1u
X1954 a_24682_81096# a_24770_81052# VDD VDD pfet_06v0 ad=1.32p pd=6.88u as=1.32p ps=6.88u w=3u l=1u
X1955 a_63948_70322# a_48766_70322# a_64148_70438# VDD pfet_06v0 ad=3.3p pd=10.66u as=2.5p ps=10.5u w=10u l=1u
X1956 a_46494_4780# a_47532_12482# VDD VDD pfet_06v0 ad=1.65p pd=5.66u as=2.2p ps=10.88u w=5u l=1u
X1957 a_31480_23582# a_22818_23466# VDD VDD pfet_06v0 ad=2.5p pd=10.5u as=4.4p ps=20.88u w=10u l=1u
X1958 a_71164_35450# a_64446_35450# a_71364_35566# VDD pfet_06v0 ad=3.3p pd=10.66u as=2.5p ps=10.5u w=10u l=1u
X1959 VDD VSS VDD VDD pfet_06v0 ad=4.29p pd=20.38u as=0 ps=0 w=9.75u l=2u
X1960 a_76660_51216# a_22918_81096# a_7876_80992# VSS nfet_06v0 ad=1.0912p pd=5.84u as=0.6448p ps=3u w=2.48u l=1u
X1961 VDD a_41030_81052# a_40938_82772# VDD pfet_06v0 ad=1.32p pd=6.88u as=0.75p ps=3.5u w=3u l=1u
X1962 XN XP VDD VDD pfet_05v0 ad=0.8052p pd=4.54u as=0.8052p ps=4.54u w=1.83u l=0.5u
X1963 VDD a_10558_54008# a_7886_49608# VDD pfet_06v0 ad=1.3p pd=5.52u as=1.3p ps=5.52u w=5u l=1u
X1964 a_30066_70438# a_8798_66852# a_32626_70368# VDD pfet_06v0 ad=4.4p pd=20.88u as=2.6p ps=10.52u w=10u l=1u
X1965 a_6868_12482# a_6868_12482# a_9228_11482# VDD pfet_06v0 ad=4.4p pd=20.88u as=3.3p ps=10.66u w=10u l=1u
X1966 a_38876_35566# a_22818_35450# VDD VDD pfet_06v0 ad=2.5p pd=10.5u as=4.4p ps=20.88u w=10u l=1u
X1967 a_41076_70438# a_40876_70322# VDD VDD pfet_06v0 ad=2.5p pd=10.5u as=4.4p ps=20.88u w=10u l=1u
X1968 S1P a_7876_75392# VSS ppolyf_u_1k r_width=1u r_length=2u
X1969 a_52838_44342# a_48466_44226# VDD VDD pfet_06v0 ad=2.5p pd=10.5u as=4.4p ps=20.88u w=10u l=1u
X1970 a_57930_62632# a_48766_61586# a_54142_58232# VDD pfet_06v0 ad=1.3p pd=5.52u as=2.2p ps=10.88u w=5u l=1u
X1971 a_21542_81052# a_34406_40872# VSS VSS nfet_06v0 ad=1.3p pd=5.52u as=2.2p ps=10.88u w=5u l=1u
X1972 VDD VSS VDD VDD pfet_06v0 ad=0.88p pd=4.88u as=0 ps=0 w=2u l=2u
X1973 VSS VDD VSS VSS nfet_06v0 ad=0.88p pd=4.88u as=0 ps=0 w=2u l=2u
X1974 a_30870_58116# a_65180_21186# VDD VDD pfet_06v0 ad=0.22p pd=1.88u as=0.22p ps=1.88u w=0.5u l=1u
X1975 a_72672_42480# a_73010_41156# VSS VSS nfet_06v0 ad=0.5456p pd=3.36u as=0.5456p ps=3.36u w=1.24u l=1u
X1976 a_65592_53078# a_48466_52962# VDD VDD pfet_06v0 ad=2.5p pd=10.5u as=4.4p ps=20.88u w=10u l=1u
X1977 a_2670_16764# a_2470_16720# a_3402_16764# VSS nfet_06v0 ad=2.2p pd=10.88u as=1.25p ps=5.5u w=5u l=1u
X1978 a_27476_36450# a_27476_36450# a_29836_35450# VDD pfet_06v0 ad=4.4p pd=20.88u as=3.3p ps=10.66u w=10u l=1u
X1979 a_25042_28748# a_26812_36450# VDD VDD pfet_06v0 ad=1.65p pd=5.66u as=2.2p ps=10.88u w=5u l=1u
X1980 a_32626_44272# a_8798_40756# a_30066_44342# VDD pfet_06v0 ad=2.6p pd=10.52u as=4.4p ps=20.88u w=10u l=1u
X1981 S4N a_4966_16720# VSS ppolyf_u_1k r_width=1u r_length=2u
X1982 a_4434_28748# a_4234_28704# a_2670_28748# VSS nfet_06v0 ad=0.44p pd=2.88u as=0.44p ps=2.88u w=1u l=1u
X1983 a_46494_16764# a_4966_16720# a_43998_16764# VSS nfet_06v0 ad=0.44p pd=2.88u as=0.44p ps=2.88u w=1u l=1u
X1984 a_51122_16764# a_50922_16720# VSS VSS nfet_06v0 ad=1.25p pd=5.5u as=2.2p ps=10.88u w=5u l=1u
X1985 a_33294_40872# a_39228_45226# a_33742_45272# VDD pfet_06v0 ad=2.2p pd=10.88u as=2.2p ps=10.88u w=5u l=1u
X1986 a_35294_16764# a_23118_23466# VSS VSS nfet_06v0 ad=0.25p pd=1.5u as=0.44p ps=2.88u w=1u l=1u
X1987 a_32626_61632# a_25354_58118# a_33294_58232# VSS nfet_06v0 ad=1.1p pd=5.88u as=0.65p ps=3.02u w=2.5u l=1u
X1988 a_66570_37346# a_8798_66852# cap_mim_2f0_m4m5_noshield c_width=25u c_length=4u
X1989 a_41478_40802# a_41278_40758# VSS VSS nfet_06v0 ad=1.25p pd=5.5u as=2.2p ps=10.88u w=5u l=1u
X1990 a_76660_51216# a_73010_49892# VSS VSS nfet_06v0 ad=0.5456p pd=3.36u as=0.5456p ps=3.36u w=1.24u l=1u
X1991 a_7686_66852# a_23852_33170# VDD VDD pfet_06v0 ad=0.22p pd=1.88u as=0.22p ps=1.88u w=0.5u l=1u
X1992 a_31070_49608# a_11158_16764# a_29706_49538# VSS nfet_06v0 ad=1.3p pd=5.52u as=2.2p ps=10.88u w=5u l=1u
X1993 a_41030_81052# a_31070_58232# cap_mim_2f0_m4m5_noshield c_width=20u c_length=10u
X1994 a_32182_40872# a_33742_45272# VDD VDD pfet_06v0 ad=1.3p pd=5.52u as=2.2p ps=10.88u w=5u l=1u
X1995 a_5722_16720# a_6868_24466# a_6204_24466# VDD pfet_06v0 ad=2.2p pd=10.88u as=1.65p ps=5.66u w=5u l=1u
X1996 VSS a_34406_49608# a_31286_81052# VSS nfet_06v0 ad=1.3p pd=5.52u as=1.3p ps=5.52u w=5u l=1u
X1997 a_8326_61632# a_10110_58232# VSS VSS nfet_06v0 ad=0.65p pd=3.02u as=0.65p ps=3.02u w=2.5u l=1u
X1998 a_31070_58232# a_33742_62632# VDD VDD pfet_06v0 ad=1.3p pd=5.52u as=2.2p ps=10.88u w=5u l=1u
X1999 a_25394_61586# a_25694_61586# a_28630_61702# VDD pfet_06v0 ad=4.4p pd=20.88u as=2.5p ps=10.5u w=10u l=1u
X2000 VDD a_56814_62632# a_55254_58232# VDD pfet_06v0 ad=1.3p pd=5.52u as=1.3p ps=5.52u w=5u l=1u
X2001 VDD VSS VDD VDD pfet_06v0 ad=0.88p pd=4.88u as=0 ps=0 w=2u l=2u
X2002 a_2670_16764# a_2470_16720# a_2370_16764# VSS nfet_06v0 ad=2.2p pd=10.88u as=1.25p ps=5.5u w=5u l=1u
X2003 a_43838_35450# a_43838_35450# VDD VDD pfet_06v0 ad=0.88p pd=4.88u as=0.88p ps=4.88u w=2u l=1u
X2004 a_71650_44468# a_54026_81096# a_71560_42480# VSS nfet_06v0 ad=0.6448p pd=3u as=1.0912p ps=5.84u w=2.48u l=1u
X2005 a_49778_53078# a_48466_52962# VDD VDD pfet_06v0 ad=2.5p pd=10.5u as=4.4p ps=20.88u w=10u l=1u
X2006 a_23318_35566# a_23118_35450# a_24130_35566# VDD pfet_06v0 ad=4.4p pd=20.88u as=2.5p ps=10.5u w=10u l=1u
X2007 a_43998_4780# a_43798_4736# a_44730_4780# VSS nfet_06v0 ad=2.2p pd=10.88u as=1.25p ps=5.5u w=5u l=1u
X2008 VDD a_7876_80992# a_7876_80992# VDD pfet_06v0 ad=0.52p pd=2.52u as=0.52p ps=2.52u w=2u l=1u
X2009 a_10110_58232# a_16044_62586# a_10558_62632# VDD pfet_06v0 ad=2.2p pd=10.88u as=2.2p ps=10.88u w=5u l=1u
X2010 a_27318_40802# a_25694_44226# VSS VSS nfet_06v0 ad=0.25p pd=1.5u as=0.44p ps=2.88u w=1u l=1u
X2011 VSS VDD VSS VSS nfet_06v0 ad=4.29p pd=20.38u as=0 ps=0 w=9.75u l=2u
X2012 a_55254_66968# a_7686_66852# a_52778_66898# VSS nfet_06v0 ad=1.3p pd=5.52u as=2.2p ps=10.88u w=5u l=1u
X2013 a_2710_23582# a_2510_23466# a_2410_23582# VDD pfet_06v0 ad=4.4p pd=20.88u as=2.5p ps=10.5u w=10u l=1u
X2014 VSS a_10110_40872# a_9442_44272# VSS nfet_06v0 ad=0.65p pd=3.02u as=0.65p ps=3.02u w=2.5u l=1u
X2015 a_53470_53078# a_48766_52962# a_53138_53078# VDD pfet_06v0 ad=2.5p pd=10.5u as=3.3p ps=10.66u w=10u l=1u
X2016 a_15574_66854# a_15574_66854# a_18094_66854# VSS nfet_06v0 ad=2.2p pd=10.88u as=1.65p ps=5.66u w=5u l=1u
X2017 VSS a_49158_40758# a_53110_40802# VSS nfet_06v0 ad=2.2p pd=10.88u as=1.25p ps=5.5u w=5u l=1u
X2018 a_56366_58232# a_62300_62586# a_56814_62632# VDD pfet_06v0 ad=2.2p pd=10.88u as=2.2p ps=10.88u w=5u l=1u
X2019 a_32626_53008# a_8798_49492# a_30066_53078# VDD pfet_06v0 ad=2.6p pd=10.52u as=4.4p ps=20.88u w=10u l=1u
X2020 a_16044_53962# a_16044_53962# a_17692_52962# VDD pfet_06v0 ad=4.4p pd=20.88u as=3.3p ps=10.66u w=10u l=1u
X2021 a_47714_16720# a_47714_16720# a_50922_16720# VSS nfet_06v0 ad=2.2p pd=10.88u as=1.65p ps=5.66u w=5u l=1u
X2022 a_65180_22536# a_30870_58116# VSS ppolyf_u_1k r_width=1u r_length=76.45u
X2023 a_2470_16720# a_2510_23466# a_15232_23582# VDD pfet_06v0 ad=4.4p pd=20.88u as=2.5p ps=10.5u w=10u l=1u
D41 VSS S3P diode_nd2ps_06v0 pj=30u area=50p
X2024 a_8998_58232# a_10558_62632# VDD VDD pfet_06v0 ad=1.3p pd=5.52u as=2.2p ps=10.88u w=5u l=1u
X2025 a_33742_62632# a_25694_61586# a_32182_58232# VDD pfet_06v0 ad=1.3p pd=5.52u as=2.2p ps=10.88u w=5u l=1u
X2026 VSS VDD VSS VSS nfet_06v0 ad=7.92p pd=36.88u as=0 ps=0 w=18u l=2u
X2027 a_62300_62586# a_48426_58118# a_63494_58162# VSS nfet_06v0 ad=2.2p pd=10.88u as=1.25p ps=5.5u w=5u l=1u
X2028 a_30870_66852# a_49002_28748# VSS VSS nfet_06v0 ad=0.44p pd=2.88u as=0.44p ps=2.88u w=1u l=1u
X2029 a_14686_4780# a_2510_11482# VSS VSS nfet_06v0 ad=0.25p pd=1.5u as=0.44p ps=2.88u w=1u l=1u
X2030 a_12622_4780# a_2170_4736# VSS VSS nfet_06v0 ad=1.25p pd=5.5u as=2.2p ps=10.88u w=5u l=1u
X2031 a_46774_13398# a_25574_16720# a_44038_11598# VDD pfet_06v0 ad=0.44p pd=2.88u as=0.44p ps=2.88u w=1u l=1u
X2032 VDD VSS VDD VDD pfet_06v0 ad=0.66p pd=3.88u as=0 ps=0 w=1.5u l=2u
X2033 VSS VDD VSS VSS nfet_06v0 ad=0.66p pd=3.88u as=0 ps=0 w=1.5u l=2u
X2034 a_23852_33620# a_39270_33170# VSS ppolyf_u_1k r_width=1u r_length=76.45u
X2035 a_26286_40802# a_26086_40758# VSS VSS nfet_06v0 ad=1.25p pd=5.5u as=2.2p ps=10.88u w=5u l=1u
X2036 a_32182_49608# a_33742_54008# VDD VDD pfet_06v0 ad=1.3p pd=5.52u as=2.2p ps=10.88u w=5u l=1u
X2037 X a_71650_44468# VSS ppolyf_u_1k r_width=1u r_length=2u
X2038 VDD VSS VDD VDD pfet_06v0 ad=7.92p pd=36.88u as=0 ps=0 w=18u l=2u
X2039 a_30870_66852# a_45762_28748# cap_mim_2f0_m4m5_noshield c_width=25u c_length=4u
X2040 a_67658_28704# a_64406_28704# a_67382_37366# VSS nfet_06v0 ad=0.825p pd=3.16u as=0.825p ps=3.16u w=2.5u l=1u
X2041 VSS VDD VSS VSS nfet_06v0 ad=0.88p pd=4.88u as=0 ps=0 w=2u l=2u
X2042 a_7876_80992# a_52262_81096# a_71560_51216# VSS nfet_06v0 ad=0.6448p pd=3u as=1.0912p ps=5.84u w=2.48u l=1u
X2043 a_43798_4736# a_43838_11482# a_56560_11598# VDD pfet_06v0 ad=4.4p pd=20.88u as=2.5p ps=10.5u w=10u l=1u
X2044 VDD VSS VDD VDD pfet_06v0 ad=0.66p pd=3.88u as=0 ps=0 w=1.5u l=2u
X2045 VDD VSS VDD VDD pfet_06v0 ad=7.92p pd=36.88u as=0 ps=0 w=18u l=2u
X2046 a_64306_4780# a_64106_4736# VSS VSS nfet_06v0 ad=1.25p pd=5.5u as=2.2p ps=10.88u w=5u l=1u
X2047 a_8798_66852# a_65180_33170# VDD VDD pfet_06v0 ad=0.22p pd=1.88u as=0.22p ps=1.88u w=0.5u l=1u
X2048 a_23852_33170# a_39270_33170# VSS ppolyf_u_1k r_width=1u r_length=76.45u
X2049 a_32626_44272# a_25354_40758# a_33294_40872# VSS nfet_06v0 ad=1.1p pd=5.88u as=0.65p ps=3.02u w=2.5u l=1u
X2050 a_25242_13378# a_4234_28704# a_23318_11598# VDD pfet_06v0 ad=0.484p pd=3.08u as=0.484p ps=3.08u w=1.1u l=1u
X2051 a_49002_4780# a_43798_4736# a_45962_13378# VSS nfet_06v0 ad=0.825p pd=3.16u as=0.825p ps=3.16u w=2.5u l=1u
X2052 a_17396_80992# a_17396_80992# a_74516_59840# VSS nfet_06v0 ad=0.52p pd=2.52u as=0.88p ps=4.88u w=2u l=1u
X2053 a_64446_23466# a_64446_23466# VDD VDD pfet_06v0 ad=0.88p pd=4.88u as=0.88p ps=4.88u w=2u l=1u
X2054 VDD a_21542_81052# a_21450_82772# VDD pfet_06v0 ad=1.32p pd=6.88u as=0.75p ps=3.5u w=3u l=1u
X2055 a_80204_35566# a_64146_35450# VDD VDD pfet_06v0 ad=2.5p pd=10.5u as=4.4p ps=20.88u w=10u l=1u
X2056 VSS VDD VSS VSS nfet_06v0 ad=4.29p pd=20.38u as=0 ps=0 w=9.75u l=2u
X2057 a_8326_44272# a_10110_40872# VSS VSS nfet_06v0 ad=0.65p pd=3.02u as=0.65p ps=3.02u w=2.5u l=1u
D42 VSS S2P diode_nd2ps_06v0 pj=30u area=50p
X2058 a_26812_36450# a_26994_28704# a_26330_28704# VSS nfet_06v0 ad=1.1p pd=5.88u as=0.825p ps=3.16u w=2.5u l=1u
X2059 a_5166_28748# a_4966_28704# a_2670_28748# VSS nfet_06v0 ad=0.44p pd=2.88u as=0.44p ps=2.88u w=1u l=1u
X2060 a_40422_40802# a_26086_40758# VSS VSS nfet_06v0 ad=1.25p pd=5.5u as=2.2p ps=10.88u w=5u l=1u
X2061 a_44572_34520# a_30870_66852# VSS ppolyf_u_1k r_width=1u r_length=76.45u
X2062 a_3244_33620# a_18662_33170# VSS ppolyf_u_1k r_width=1u r_length=76.45u
X2063 a_6882_44342# a_7686_40756# a_8326_44272# VDD pfet_06v0 ad=4.4p pd=20.88u as=2.6p ps=10.52u w=10u l=1u
X2064 a_7214_70438# a_2510_70322# a_6882_70438# VDD pfet_06v0 ad=2.5p pd=10.5u as=3.3p ps=10.66u w=10u l=1u
X2065 S3N a_4966_28704# VSS ppolyf_u_1k r_width=1u r_length=2u
X2066 a_55698_44272# a_7686_40756# a_53138_44342# VDD pfet_06v0 ad=2.6p pd=10.52u as=4.4p ps=20.88u w=10u l=1u
X2067 a_27476_36450# a_23078_28704# a_29346_28748# VSS nfet_06v0 ad=2.2p pd=10.88u as=1.25p ps=5.5u w=5u l=1u
X2068 a_25594_70438# a_25394_70322# VDD VDD pfet_06v0 ad=2.5p pd=10.5u as=4.4p ps=20.88u w=10u l=1u
X2069 a_2470_4736# a_2470_4736# VSS VSS nfet_06v0 ad=0.44p pd=2.88u as=0.44p ps=2.88u w=1u l=1u
X2070 a_40698_81052# a_57478_58232# VSS VSS nfet_06v0 ad=2.2p pd=10.88u as=1.3p ps=5.52u w=5u l=1u
X2071 VDD a_57930_45272# a_21210_81052# VDD pfet_06v0 ad=2.6p pd=10.52u as=2.6p ps=10.52u w=10u l=1u
X2072 a_44038_11598# a_43838_11482# a_43738_11598# VDD pfet_06v0 ad=4.4p pd=20.88u as=2.5p ps=10.5u w=10u l=1u
X2073 a_72808_35566# a_64146_35450# VDD VDD pfet_06v0 ad=2.5p pd=10.5u as=4.4p ps=20.88u w=10u l=1u
X2074 a_31070_58232# a_33742_62632# VDD VDD pfet_06v0 ad=1.3p pd=5.52u as=1.3p ps=5.52u w=5u l=1u
X2075 a_2210_61586# a_2510_61586# a_5446_61702# VDD pfet_06v0 ad=4.4p pd=20.88u as=2.5p ps=10.5u w=10u l=1u
X2076 VSS a_19658_66968# a_51530_81096# VSS nfet_06v0 ad=0.44p pd=2.88u as=0.44p ps=2.88u w=1u l=1u
D43 VSS S4P diode_nd2ps_06v0 pj=30u area=50p
X2077 a_3244_33170# a_18662_33170# VSS ppolyf_u_1k r_width=1u r_length=76.45u
X2078 S2N a_4966_4736# VSS ppolyf_u_1k r_width=1u r_length=2u
X2079 VDD VSS VDD VDD pfet_06v0 ad=7.92p pd=36.88u as=0 ps=0 w=18u l=2u
X2080 a_2210_11482# a_2510_11482# a_18268_11598# VDD pfet_06v0 ad=4.4p pd=20.88u as=2.5p ps=10.5u w=10u l=1u
X2081 a_4434_16764# a_6204_24466# VDD VDD pfet_06v0 ad=1.65p pd=5.66u as=2.2p ps=10.88u w=5u l=1u
X2082 VSS a_10110_49608# a_8326_53008# VSS nfet_06v0 ad=1.1p pd=5.88u as=0.65p ps=3.02u w=2.5u l=1u
X2083 VDD VSS VDD VDD pfet_06v0 ad=0.66p pd=3.88u as=0 ps=0 w=1.5u l=2u
X2084 VDD a_56814_71368# a_54142_66968# VDD pfet_06v0 ad=2.2p pd=10.88u as=1.3p ps=5.52u w=5u l=1u
X2085 a_6854_66898# a_2170_66854# a_6522_66898# VSS nfet_06v0 ad=1.25p pd=5.5u as=1.65p ps=5.66u w=5u l=1u
.ends
