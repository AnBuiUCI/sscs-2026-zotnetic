* netlist plana generada por flatten_spice.py (top: B26_A)
* 1539 MOSFETs; nets fusionadas por V=0: x_core_x5_net11->VSS, x_core_x5_net12->VSS, x_core_x5_net10->VSS, x_core_x5_net13->VSS, x_core_x6_net11->VSS, x_core_x6_net12->VSS, x_core_x6_net10->VSS, x_core_x6_net13->VSS, x_core_x7_net11->VSS, x_core_x7_net12->VSS, x_core_x7_net10->VSS, x_core_x7_net13->VSS
* nombres: los del esquematico; solo llevan la ruta de instancias (Mx1_M4) los 1383 que chocaban
* m -> fingers: Mx_core_x5_XM2: m=6 nf=1 -> nf=6; Mx_core_x5_XM3: m=2 nf=1 -> nf=2; Mx_core_x5_XM5: m=2 nf=1 -> nf=2; Mx_core_x5_XM1: m=2 nf=1 -> nf=2; Mx_core_x5_XM9: m=2 nf=1 -> nf=2; Mx_core_x5_XM11: m=2 nf=1 -> nf=2; Mx_core_x5_XMF1: m=2 nf=1 -> nf=2; Mx_core_x6_XM2: m=6 nf=1 -> nf=6; Mx_core_x6_XM3: m=2 nf=1 -> nf=2; Mx_core_x6_XM5: m=2 nf=1 -> nf=2; Mx_core_x6_XM1: m=2 nf=1 -> nf=2; Mx_core_x6_XM9: m=2 nf=1 -> nf=2; Mx_core_x6_XM11: m=2 nf=1 -> nf=2; Mx_core_x6_XMF1: m=2 nf=1 -> nf=2; Mx_core_x7_XM2: m=6 nf=1 -> nf=6; Mx_core_x7_XM3: m=2 nf=1 -> nf=2; Mx_core_x7_XM5: m=2 nf=1 -> nf=2; Mx_core_x7_XM1: m=2 nf=1 -> nf=2; Mx_core_x7_XM9: m=2 nf=1 -> nf=2; Mx_core_x7_XM11: m=2 nf=1 -> nf=2; Mx_core_x7_XMF1: m=2 nf=1 -> nf=2; Mx_core_x1_x4_x2_XM15: m=2 nf=1 -> nf=2; Mx_core_x1_x4_x2_XM16: m=2 nf=1 -> nf=2; Mx_core_x1_x4_x2_XM21: m=2 nf=1 -> nf=2; Mx_core_x1_x4_x2_XM22: m=2 nf=1 -> nf=2; Mx_core_x1_x4_x2_XM29: m=2 nf=1 -> nf=2; Mx_core_x1_x4_x2_XM30: m=2 nf=1 -> nf=2; Mx_core_x1_x4_x2_XM31: m=4 nf=1 -> nf=4; Mx_core_x1_x4_x2_XM35: m=4 nf=1 -> nf=4; Mx_core_x1_x4_x2_XM23: m=2 nf=1 -> nf=2; Mx_core_x1_x4_x2_XM24: m=2 nf=1 -> nf=2; Mx_core_x1_x4_x2_XM25: m=4 nf=1 -> nf=4; Mx_core_x1_x4_x2_XM26: m=4 nf=1 -> nf=4; Mx_core_x1_x4_x2_XM43: m=3 nf=1 -> nf=3; Mx_core_x1_x4_x2_XM44: m=3 nf=1 -> nf=3; Mx_core_x1_x5_x2_XM15: m=2 nf=1 -> nf=2; Mx_core_x1_x5_x2_XM16: m=2 nf=1 -> nf=2; Mx_core_x1_x5_x2_XM21: m=2 nf=1 -> nf=2; Mx_core_x1_x5_x2_XM22: m=2 nf=1 -> nf=2; Mx_core_x1_x5_x2_XM29: m=2 nf=1 -> nf=2; Mx_core_x1_x5_x2_XM30: m=2 nf=1 -> nf=2; Mx_core_x1_x5_x2_XM31: m=4 nf=1 -> nf=4; Mx_core_x1_x5_x2_XM35: m=4 nf=1 -> nf=4; Mx_core_x1_x5_x2_XM23: m=2 nf=1 -> nf=2; Mx_core_x1_x5_x2_XM24: m=2 nf=1 -> nf=2; Mx_core_x1_x5_x2_XM25: m=4 nf=1 -> nf=4; Mx_core_x1_x5_x2_XM26: m=4 nf=1 -> nf=4; Mx_core_x1_x5_x2_XM43: m=3 nf=1 -> nf=3; Mx_core_x1_x5_x2_XM44: m=3 nf=1 -> nf=3; Mx_core_x1_x6_x2_XM15: m=2 nf=1 -> nf=2; Mx_core_x1_x6_x2_XM16: m=2 nf=1 -> nf=2; Mx_core_x1_x6_x2_XM21: m=2 nf=1 -> nf=2; Mx_core_x1_x6_x2_XM22: m=2 nf=1 -> nf=2; Mx_core_x1_x6_x2_XM29: m=2 nf=1 -> nf=2; Mx_core_x1_x6_x2_XM30: m=2 nf=1 -> nf=2; Mx_core_x1_x6_x2_XM31: m=4 nf=1 -> nf=4; Mx_core_x1_x6_x2_XM35: m=4 nf=1 -> nf=4; Mx_core_x1_x6_x2_XM23: m=2 nf=1 -> nf=2; Mx_core_x1_x6_x2_XM24: m=2 nf=1 -> nf=2; Mx_core_x1_x6_x2_XM25: m=4 nf=1 -> nf=4; Mx_core_x1_x6_x2_XM26: m=4 nf=1 -> nf=4; Mx_core_x1_x6_x2_XM43: m=3 nf=1 -> nf=3; Mx_core_x1_x6_x2_XM44: m=3 nf=1 -> nf=3; Mx_core_x2_x4_x2_XM15: m=2 nf=1 -> nf=2; Mx_core_x2_x4_x2_XM16: m=2 nf=1 -> nf=2; Mx_core_x2_x4_x2_XM21: m=2 nf=1 -> nf=2; Mx_core_x2_x4_x2_XM22: m=2 nf=1 -> nf=2; Mx_core_x2_x4_x2_XM29: m=2 nf=1 -> nf=2; Mx_core_x2_x4_x2_XM30: m=2 nf=1 -> nf=2; Mx_core_x2_x4_x2_XM31: m=4 nf=1 -> nf=4; Mx_core_x2_x4_x2_XM35: m=4 nf=1 -> nf=4; Mx_core_x2_x4_x2_XM23: m=2 nf=1 -> nf=2; Mx_core_x2_x4_x2_XM24: m=2 nf=1 -> nf=2; Mx_core_x2_x4_x2_XM25: m=4 nf=1 -> nf=4; Mx_core_x2_x4_x2_XM26: m=4 nf=1 -> nf=4; Mx_core_x2_x4_x2_XM43: m=3 nf=1 -> nf=3; Mx_core_x2_x4_x2_XM44: m=3 nf=1 -> nf=3; Mx_core_x2_x5_x2_XM15: m=2 nf=1 -> nf=2; Mx_core_x2_x5_x2_XM16: m=2 nf=1 -> nf=2; Mx_core_x2_x5_x2_XM21: m=2 nf=1 -> nf=2; Mx_core_x2_x5_x2_XM22: m=2 nf=1 -> nf=2; Mx_core_x2_x5_x2_XM29: m=2 nf=1 -> nf=2; Mx_core_x2_x5_x2_XM30: m=2 nf=1 -> nf=2; Mx_core_x2_x5_x2_XM31: m=4 nf=1 -> nf=4; Mx_core_x2_x5_x2_XM35: m=4 nf=1 -> nf=4; Mx_core_x2_x5_x2_XM23: m=2 nf=1 -> nf=2; Mx_core_x2_x5_x2_XM24: m=2 nf=1 -> nf=2; Mx_core_x2_x5_x2_XM25: m=4 nf=1 -> nf=4; Mx_core_x2_x5_x2_XM26: m=4 nf=1 -> nf=4; Mx_core_x2_x5_x2_XM43: m=3 nf=1 -> nf=3; Mx_core_x2_x5_x2_XM44: m=3 nf=1 -> nf=3; Mx_core_x2_x6_x2_XM15: m=2 nf=1 -> nf=2; Mx_core_x2_x6_x2_XM16: m=2 nf=1 -> nf=2; Mx_core_x2_x6_x2_XM21: m=2 nf=1 -> nf=2; Mx_core_x2_x6_x2_XM22: m=2 nf=1 -> nf=2; Mx_core_x2_x6_x2_XM29: m=2 nf=1 -> nf=2; Mx_core_x2_x6_x2_XM30: m=2 nf=1 -> nf=2; Mx_core_x2_x6_x2_XM31: m=4 nf=1 -> nf=4; Mx_core_x2_x6_x2_XM35: m=4 nf=1 -> nf=4; Mx_core_x2_x6_x2_XM23: m=2 nf=1 -> nf=2; Mx_core_x2_x6_x2_XM24: m=2 nf=1 -> nf=2; Mx_core_x2_x6_x2_XM25: m=4 nf=1 -> nf=4; Mx_core_x2_x6_x2_XM26: m=4 nf=1 -> nf=4; Mx_core_x2_x6_x2_XM43: m=3 nf=1 -> nf=3; Mx_core_x2_x6_x2_XM44: m=3 nf=1 -> nf=3; Mx_core_x3_x4_x2_XM15: m=2 nf=1 -> nf=2; Mx_core_x3_x4_x2_XM16: m=2 nf=1 -> nf=2; Mx_core_x3_x4_x2_XM21: m=2 nf=1 -> nf=2; Mx_core_x3_x4_x2_XM22: m=2 nf=1 -> nf=2; Mx_core_x3_x4_x2_XM29: m=2 nf=1 -> nf=2; Mx_core_x3_x4_x2_XM30: m=2 nf=1 -> nf=2; Mx_core_x3_x4_x2_XM31: m=4 nf=1 -> nf=4; Mx_core_x3_x4_x2_XM35: m=4 nf=1 -> nf=4; Mx_core_x3_x4_x2_XM23: m=2 nf=1 -> nf=2; Mx_core_x3_x4_x2_XM24: m=2 nf=1 -> nf=2; Mx_core_x3_x4_x2_XM25: m=4 nf=1 -> nf=4; Mx_core_x3_x4_x2_XM26: m=4 nf=1 -> nf=4; Mx_core_x3_x4_x2_XM43: m=3 nf=1 -> nf=3; Mx_core_x3_x4_x2_XM44: m=3 nf=1 -> nf=3; Mx_core_x3_x5_x2_XM15: m=2 nf=1 -> nf=2; Mx_core_x3_x5_x2_XM16: m=2 nf=1 -> nf=2; Mx_core_x3_x5_x2_XM21: m=2 nf=1 -> nf=2; Mx_core_x3_x5_x2_XM22: m=2 nf=1 -> nf=2; Mx_core_x3_x5_x2_XM29: m=2 nf=1 -> nf=2; Mx_core_x3_x5_x2_XM30: m=2 nf=1 -> nf=2; Mx_core_x3_x5_x2_XM31: m=4 nf=1 -> nf=4; Mx_core_x3_x5_x2_XM35: m=4 nf=1 -> nf=4; Mx_core_x3_x5_x2_XM23: m=2 nf=1 -> nf=2; Mx_core_x3_x5_x2_XM24: m=2 nf=1 -> nf=2; Mx_core_x3_x5_x2_XM25: m=4 nf=1 -> nf=4; Mx_core_x3_x5_x2_XM26: m=4 nf=1 -> nf=4; Mx_core_x3_x5_x2_XM43: m=3 nf=1 -> nf=3; Mx_core_x3_x5_x2_XM44: m=3 nf=1 -> nf=3; Mx_core_x3_x6_x2_XM15: m=2 nf=1 -> nf=2; Mx_core_x3_x6_x2_XM16: m=2 nf=1 -> nf=2; Mx_core_x3_x6_x2_XM21: m=2 nf=1 -> nf=2; Mx_core_x3_x6_x2_XM22: m=2 nf=1 -> nf=2; Mx_core_x3_x6_x2_XM29: m=2 nf=1 -> nf=2; Mx_core_x3_x6_x2_XM30: m=2 nf=1 -> nf=2; Mx_core_x3_x6_x2_XM31: m=4 nf=1 -> nf=4; Mx_core_x3_x6_x2_XM35: m=4 nf=1 -> nf=4; Mx_core_x3_x6_x2_XM23: m=2 nf=1 -> nf=2; Mx_core_x3_x6_x2_XM24: m=2 nf=1 -> nf=2; Mx_core_x3_x6_x2_XM25: m=4 nf=1 -> nf=4; Mx_core_x3_x6_x2_XM26: m=4 nf=1 -> nf=4; Mx_core_x3_x6_x2_XM43: m=3 nf=1 -> nf=3; Mx_core_x3_x6_x2_XM44: m=3 nf=1 -> nf=3; Mx_core_x4_x4_x2_XM15: m=2 nf=1 -> nf=2; Mx_core_x4_x4_x2_XM16: m=2 nf=1 -> nf=2; Mx_core_x4_x4_x2_XM21: m=2 nf=1 -> nf=2; Mx_core_x4_x4_x2_XM22: m=2 nf=1 -> nf=2; Mx_core_x4_x4_x2_XM29: m=2 nf=1 -> nf=2; Mx_core_x4_x4_x2_XM30: m=2 nf=1 -> nf=2; Mx_core_x4_x4_x2_XM31: m=4 nf=1 -> nf=4; Mx_core_x4_x4_x2_XM35: m=4 nf=1 -> nf=4; Mx_core_x4_x4_x2_XM23: m=2 nf=1 -> nf=2; Mx_core_x4_x4_x2_XM24: m=2 nf=1 -> nf=2; Mx_core_x4_x4_x2_XM25: m=4 nf=1 -> nf=4; Mx_core_x4_x4_x2_XM26: m=4 nf=1 -> nf=4; Mx_core_x4_x4_x2_XM43: m=3 nf=1 -> nf=3; Mx_core_x4_x4_x2_XM44: m=3 nf=1 -> nf=3; Mx_core_x4_x5_x2_XM15: m=2 nf=1 -> nf=2; Mx_core_x4_x5_x2_XM16: m=2 nf=1 -> nf=2; Mx_core_x4_x5_x2_XM21: m=2 nf=1 -> nf=2; Mx_core_x4_x5_x2_XM22: m=2 nf=1 -> nf=2; Mx_core_x4_x5_x2_XM29: m=2 nf=1 -> nf=2; Mx_core_x4_x5_x2_XM30: m=2 nf=1 -> nf=2; Mx_core_x4_x5_x2_XM31: m=4 nf=1 -> nf=4; Mx_core_x4_x5_x2_XM35: m=4 nf=1 -> nf=4; Mx_core_x4_x5_x2_XM23: m=2 nf=1 -> nf=2; Mx_core_x4_x5_x2_XM24: m=2 nf=1 -> nf=2; Mx_core_x4_x5_x2_XM25: m=4 nf=1 -> nf=4; Mx_core_x4_x5_x2_XM26: m=4 nf=1 -> nf=4; Mx_core_x4_x5_x2_XM43: m=3 nf=1 -> nf=3; Mx_core_x4_x5_x2_XM44: m=3 nf=1 -> nf=3; Mx_core_x4_x6_x2_XM15: m=2 nf=1 -> nf=2; Mx_core_x4_x6_x2_XM16: m=2 nf=1 -> nf=2; Mx_core_x4_x6_x2_XM21: m=2 nf=1 -> nf=2; Mx_core_x4_x6_x2_XM22: m=2 nf=1 -> nf=2; Mx_core_x4_x6_x2_XM29: m=2 nf=1 -> nf=2; Mx_core_x4_x6_x2_XM30: m=2 nf=1 -> nf=2; Mx_core_x4_x6_x2_XM31: m=4 nf=1 -> nf=4; Mx_core_x4_x6_x2_XM35: m=4 nf=1 -> nf=4; Mx_core_x4_x6_x2_XM23: m=2 nf=1 -> nf=2; Mx_core_x4_x6_x2_XM24: m=2 nf=1 -> nf=2; Mx_core_x4_x6_x2_XM25: m=4 nf=1 -> nf=4; Mx_core_x4_x6_x2_XM26: m=4 nf=1 -> nf=4; Mx_core_x4_x6_x2_XM43: m=3 nf=1 -> nf=3; Mx_core_x4_x6_x2_XM44: m=3 nf=1 -> nf=3
* para LVS: cada dedo, un transistor en paralelo
.subckt B26_A S1P S1N S2P S2N S3P S3N S4P S4N XP X XN YP Y YN ZP Z ZN VDD VSS
Mx_core_x5_XM2_f1 X_I X_I VDD VDD pfet_06v0 L=1u W=2u
Mx_core_x5_XM2_f2 X_I X_I VDD VDD pfet_06v0 L=1u W=2u
Mx_core_x5_XM2_f3 X_I X_I VDD VDD pfet_06v0 L=1u W=2u
Mx_core_x5_XM2_f4 X_I X_I VDD VDD pfet_06v0 L=1u W=2u
Mx_core_x5_XM2_f5 X_I X_I VDD VDD pfet_06v0 L=1u W=2u
Mx_core_x5_XM2_f6 X_I X_I VDD VDD pfet_06v0 L=1u W=2u
Mx_core_x5_XM3_f1 X_I x_core_X4 x_core_x5_net1 VSS nfet_06v0 L=1u W=2.48u
Mx_core_x5_XM3_f2 X_I x_core_X4 x_core_x5_net1 VSS nfet_06v0 L=1u W=2.48u
Mx_core_x5_XM5_f1 X_I x_core_X2 x_core_x5_net2 VSS nfet_06v0 L=1u W=2.48u
Mx_core_x5_XM5_f2 X_I x_core_X2 x_core_x5_net2 VSS nfet_06v0 L=1u W=2.48u
Mx_core_x5_XM6 x_core_x5_net2 x_core_x5_IN VSS VSS nfet_06v0 L=1u W=1.24u
Mx_core_x5_XM1_f1 X_I X_I x_core_x5_net3 VSS nfet_06v0 L=1u W=2u
Mx_core_x5_XM1_f2 X_I X_I x_core_x5_net3 VSS nfet_06v0 L=1u W=2u
Mx_core_x5_XM7 x_core_x5_net3 X_I x_core_x5_net4 VSS nfet_06v0 L=1u W=2u
Mx_core_x5_XM8 x_core_x5_net4 X_I VSS VSS nfet_06v0 L=1u W=2u
Mx_core_x5_XM9_f1 X_I x_core_X1 x_core_x5_net5 VSS nfet_06v0 L=1u W=2.48u
Mx_core_x5_XM9_f2 X_I x_core_X1 x_core_x5_net5 VSS nfet_06v0 L=1u W=2.48u
Mx_core_x5_XM10 x_core_x5_net5 x_core_x5_IN VSS VSS nfet_06v0 L=1u W=1.24u
Mx_core_x5_XM11_f1 X_I x_core_X3 x_core_x5_net6 VSS nfet_06v0 L=1u W=2.48u
Mx_core_x5_XM11_f2 X_I x_core_X3 x_core_x5_net6 VSS nfet_06v0 L=1u W=2.48u
Mx_core_x5_XM12 x_core_x5_net6 x_core_x5_IN VSS VSS nfet_06v0 L=1u W=1.24u
Mx_core_x5_XM4 x_core_x5_net1 x_core_x5_IN VSS VSS nfet_06v0 L=1u W=1.24u
Mx_core_x5_XM13 x_core_x5_IN x_core_x5_IN VDD VDD pfet_06v0 L=1u W=2u
Mx_core_x5_XM14 x_core_x5_net8 x_core_x5_IN x_core_x5_net9 VSS nfet_06v0 L=1u W=0.7u
Mx_core_x5_XM15 x_core_x5_net7 x_core_x5_IN x_core_x5_net8 VSS nfet_06v0 L=1u W=0.7u
Mx_core_x5_XM16 x_core_x5_IN x_core_x5_IN x_core_x5_net7 VSS nfet_06v0 L=1u W=0.7u
Mx_core_x5_XM17 x_core_x5_net9 x_core_x5_IN VSS VSS nfet_06v0 L=1u W=0.7u
Mx_core_x5_XMF1_f1 X_I VDD x_core_x5_netF VSS nfet_06v0 L=1u W=2.48u
Mx_core_x5_XMF1_f2 X_I VDD x_core_x5_netF VSS nfet_06v0 L=1u W=2.48u
Mx_core_x5_XMF2 x_core_x5_netF x_core_x5_IN VSS VSS nfet_06v0 L=1u W=1.24u
Mx_core_x6_XM2_f1 Y_I Y_I VDD VDD pfet_06v0 L=1u W=2u
Mx_core_x6_XM2_f2 Y_I Y_I VDD VDD pfet_06v0 L=1u W=2u
Mx_core_x6_XM2_f3 Y_I Y_I VDD VDD pfet_06v0 L=1u W=2u
Mx_core_x6_XM2_f4 Y_I Y_I VDD VDD pfet_06v0 L=1u W=2u
Mx_core_x6_XM2_f5 Y_I Y_I VDD VDD pfet_06v0 L=1u W=2u
Mx_core_x6_XM2_f6 Y_I Y_I VDD VDD pfet_06v0 L=1u W=2u
Mx_core_x6_XM3_f1 Y_I x_core_Y4 x_core_x6_net1 VSS nfet_06v0 L=1u W=2.48u
Mx_core_x6_XM3_f2 Y_I x_core_Y4 x_core_x6_net1 VSS nfet_06v0 L=1u W=2.48u
Mx_core_x6_XM5_f1 Y_I x_core_Y2 x_core_x6_net2 VSS nfet_06v0 L=1u W=2.48u
Mx_core_x6_XM5_f2 Y_I x_core_Y2 x_core_x6_net2 VSS nfet_06v0 L=1u W=2.48u
Mx_core_x6_XM6 x_core_x6_net2 x_core_x6_IN VSS VSS nfet_06v0 L=1u W=1.24u
Mx_core_x6_XM1_f1 Y_I Y_I x_core_x6_net3 VSS nfet_06v0 L=1u W=2u
Mx_core_x6_XM1_f2 Y_I Y_I x_core_x6_net3 VSS nfet_06v0 L=1u W=2u
Mx_core_x6_XM7 x_core_x6_net3 Y_I x_core_x6_net4 VSS nfet_06v0 L=1u W=2u
Mx_core_x6_XM8 x_core_x6_net4 Y_I VSS VSS nfet_06v0 L=1u W=2u
Mx_core_x6_XM9_f1 Y_I x_core_Y1 x_core_x6_net5 VSS nfet_06v0 L=1u W=2.48u
Mx_core_x6_XM9_f2 Y_I x_core_Y1 x_core_x6_net5 VSS nfet_06v0 L=1u W=2.48u
Mx_core_x6_XM10 x_core_x6_net5 x_core_x6_IN VSS VSS nfet_06v0 L=1u W=1.24u
Mx_core_x6_XM11_f1 Y_I x_core_Y3 x_core_x6_net6 VSS nfet_06v0 L=1u W=2.48u
Mx_core_x6_XM11_f2 Y_I x_core_Y3 x_core_x6_net6 VSS nfet_06v0 L=1u W=2.48u
Mx_core_x6_XM12 x_core_x6_net6 x_core_x6_IN VSS VSS nfet_06v0 L=1u W=1.24u
Mx_core_x6_XM4 x_core_x6_net1 x_core_x6_IN VSS VSS nfet_06v0 L=1u W=1.24u
Mx_core_x6_XM13 x_core_x6_IN x_core_x6_IN VDD VDD pfet_06v0 L=1u W=2u
Mx_core_x6_XM14 x_core_x6_net8 x_core_x6_IN x_core_x6_net9 VSS nfet_06v0 L=1u W=0.7u
Mx_core_x6_XM15 x_core_x6_net7 x_core_x6_IN x_core_x6_net8 VSS nfet_06v0 L=1u W=0.7u
Mx_core_x6_XM16 x_core_x6_IN x_core_x6_IN x_core_x6_net7 VSS nfet_06v0 L=1u W=0.7u
Mx_core_x6_XM17 x_core_x6_net9 x_core_x6_IN VSS VSS nfet_06v0 L=1u W=0.7u
Mx_core_x6_XMF1_f1 Y_I VDD x_core_x6_netF VSS nfet_06v0 L=1u W=2.48u
Mx_core_x6_XMF1_f2 Y_I VDD x_core_x6_netF VSS nfet_06v0 L=1u W=2.48u
Mx_core_x6_XMF2 x_core_x6_netF x_core_x6_IN VSS VSS nfet_06v0 L=1u W=1.24u
Mx_core_x7_XM2_f1 Z_I Z_I VDD VDD pfet_06v0 L=1u W=2u
Mx_core_x7_XM2_f2 Z_I Z_I VDD VDD pfet_06v0 L=1u W=2u
Mx_core_x7_XM2_f3 Z_I Z_I VDD VDD pfet_06v0 L=1u W=2u
Mx_core_x7_XM2_f4 Z_I Z_I VDD VDD pfet_06v0 L=1u W=2u
Mx_core_x7_XM2_f5 Z_I Z_I VDD VDD pfet_06v0 L=1u W=2u
Mx_core_x7_XM2_f6 Z_I Z_I VDD VDD pfet_06v0 L=1u W=2u
Mx_core_x7_XM3_f1 Z_I x_core_Z4 x_core_x7_net1 VSS nfet_06v0 L=1u W=2.48u
Mx_core_x7_XM3_f2 Z_I x_core_Z4 x_core_x7_net1 VSS nfet_06v0 L=1u W=2.48u
Mx_core_x7_XM5_f1 Z_I x_core_Z2 x_core_x7_net2 VSS nfet_06v0 L=1u W=2.48u
Mx_core_x7_XM5_f2 Z_I x_core_Z2 x_core_x7_net2 VSS nfet_06v0 L=1u W=2.48u
Mx_core_x7_XM6 x_core_x7_net2 x_core_x7_IN VSS VSS nfet_06v0 L=1u W=1.24u
Mx_core_x7_XM1_f1 Z_I Z_I x_core_x7_net3 VSS nfet_06v0 L=1u W=2u
Mx_core_x7_XM1_f2 Z_I Z_I x_core_x7_net3 VSS nfet_06v0 L=1u W=2u
Mx_core_x7_XM7 x_core_x7_net3 Z_I x_core_x7_net4 VSS nfet_06v0 L=1u W=2u
Mx_core_x7_XM8 x_core_x7_net4 Z_I VSS VSS nfet_06v0 L=1u W=2u
Mx_core_x7_XM9_f1 Z_I x_core_Z1 x_core_x7_net5 VSS nfet_06v0 L=1u W=2.48u
Mx_core_x7_XM9_f2 Z_I x_core_Z1 x_core_x7_net5 VSS nfet_06v0 L=1u W=2.48u
Mx_core_x7_XM10 x_core_x7_net5 x_core_x7_IN VSS VSS nfet_06v0 L=1u W=1.24u
Mx_core_x7_XM11_f1 Z_I x_core_Z3 x_core_x7_net6 VSS nfet_06v0 L=1u W=2.48u
Mx_core_x7_XM11_f2 Z_I x_core_Z3 x_core_x7_net6 VSS nfet_06v0 L=1u W=2.48u
Mx_core_x7_XM12 x_core_x7_net6 x_core_x7_IN VSS VSS nfet_06v0 L=1u W=1.24u
Mx_core_x7_XM4 x_core_x7_net1 x_core_x7_IN VSS VSS nfet_06v0 L=1u W=1.24u
Mx_core_x7_XM13 x_core_x7_IN x_core_x7_IN VDD VDD pfet_06v0 L=1u W=2u
Mx_core_x7_XM14 x_core_x7_net8 x_core_x7_IN x_core_x7_net9 VSS nfet_06v0 L=1u W=0.7u
Mx_core_x7_XM15 x_core_x7_net7 x_core_x7_IN x_core_x7_net8 VSS nfet_06v0 L=1u W=0.7u
Mx_core_x7_XM16 x_core_x7_IN x_core_x7_IN x_core_x7_net7 VSS nfet_06v0 L=1u W=0.7u
Mx_core_x7_XM17 x_core_x7_net9 x_core_x7_IN VSS VSS nfet_06v0 L=1u W=0.7u
Mx_core_x7_XMF1_f1 Z_I VDD x_core_x7_netF VSS nfet_06v0 L=1u W=2.48u
Mx_core_x7_XMF1_f2 Z_I VDD x_core_x7_netF VSS nfet_06v0 L=1u W=2.48u
Mx_core_x7_XMF2 x_core_x7_netF x_core_x7_IN VSS VSS nfet_06v0 L=1u W=1.24u
Mx_core_x8_x1_XM3 x_core_x8_net1 X_I VDD VDD pfet_05v0 L=0.5u W=1.83u
Mx_core_x8_x1_XM4 x_core_x8_net1 X_I VSS VSS nfet_05v0 L=0.6u W=1.32u
Mx_core_x8_x2_XM3 XN x_core_x8_net1 VDD VDD pfet_05v0 L=0.5u W=1.83u
Mx_core_x8_x2_XM4 XN x_core_x8_net1 VSS VSS nfet_05v0 L=0.6u W=1.32u
Mx_core_x8_x3_XM3 XP XN VDD VDD pfet_05v0 L=0.5u W=1.83u
Mx_core_x8_x3_XM4 XP XN VSS VSS nfet_05v0 L=0.6u W=1.32u
Mx_core_x9_x1_XM3 x_core_x9_net1 Y_I VDD VDD pfet_05v0 L=0.5u W=1.83u
Mx_core_x9_x1_XM4 x_core_x9_net1 Y_I VSS VSS nfet_05v0 L=0.6u W=1.32u
Mx_core_x9_x2_XM3 YN x_core_x9_net1 VDD VDD pfet_05v0 L=0.5u W=1.83u
Mx_core_x9_x2_XM4 YN x_core_x9_net1 VSS VSS nfet_05v0 L=0.6u W=1.32u
Mx_core_x9_x3_XM3 YP YN VDD VDD pfet_05v0 L=0.5u W=1.83u
Mx_core_x9_x3_XM4 YP YN VSS VSS nfet_05v0 L=0.6u W=1.32u
Mx_core_x10_x1_XM3 x_core_x10_net1 Z_I VDD VDD pfet_05v0 L=0.5u W=1.83u
Mx_core_x10_x1_XM4 x_core_x10_net1 Z_I VSS VSS nfet_05v0 L=0.6u W=1.32u
Mx_core_x10_x2_XM3 ZN x_core_x10_net1 VDD VDD pfet_05v0 L=0.5u W=1.83u
Mx_core_x10_x2_XM4 ZN x_core_x10_net1 VSS VSS nfet_05v0 L=0.6u W=1.32u
Mx_core_x10_x3_XM3 ZP ZN VDD VDD pfet_05v0 L=0.5u W=1.83u
Mx_core_x10_x3_XM4 ZP ZN VSS VSS nfet_05v0 L=0.6u W=1.32u
Mx_core_x1_x4_x1_XM4 x_core_x1_x4_x1_net3 x_core_x1_x4_net4 VDD VDD pfet_06v0 L=1.0u W=10.0u
Mx_core_x1_x4_x1_XM5 x_core_x1_x4_net2 x_core_x1_x4_net3 x_core_x1_x4_x1_net3 VDD pfet_06v0 L=1.0u W=10.0u
Mx_core_x1_x4_x1_XM6 x_core_x1_x4_net2 x_core_x1_x4_net2 VSS VSS nfet_06v0 L=1.0u W=1.0u
Mx_core_x1_x4_x1_XM7 x_core_x1_x4_x1_net2 x_core_x1_x4_net4 VDD VDD pfet_06v0 L=1.0u W=10.0u
Mx_core_x1_x4_x1_XM8 x_core_x1_x4_net1 x_core_x1_x4_net3 x_core_x1_x4_x1_net2 VDD pfet_06v0 L=1.0u W=10.0u
Mx_core_x1_x4_x1_XM9 x_core_x1_x4_net1 x_core_x1_x4_net2 x_core_x1_x4_x1_net1 VSS nfet_06v0 L=1.0u W=5.0u
Mx_core_x1_x4_x1_XM10 x_core_x1_x4_x1_net1 x_core_x1_x4_net1 VSS VSS nfet_06v0 L=1.0u W=5.0u
Mx_core_x1_x4_x1_XM1 x_core_x1_x4_net3 x_core_x1_x4_net3 VDD VDD pfet_06v0 L=1.0u W=2u
Mx_core_x1_x4_x1_XM2 x_core_x1_x4_x1_net4 x_core_x1_x4_net4 VDD VDD pfet_06v0 L=1.0u W=10.0u
Mx_core_x1_x4_x1_XM3 x_core_x1_x4_net4 x_core_x1_x4_net3 x_core_x1_x4_x1_net4 VDD pfet_06v0 L=1.0u W=10.0u
Mx_core_x1_x4_x1_XM47 x_core_x1_x4_x1_net5 x_core_x1_x4_net3 VSS VSS nfet_06v0 L=1.0u W=1.0u
Mx_core_x1_x4_x1_XM48 x_core_x1_x4_x1_net6 x_core_x1_x4_net3 VSS VSS nfet_06v0 L=1.0u W=1.0u
Mx_core_x1_x4_x1_XM49 x_core_x1_x4_net3 x_core_x1_x4_net3 x_core_x1_x4_x1_net6 VSS nfet_06v0 L=1.0u W=1.0u
Mx_core_x1_x4_x1_XM50 x_core_x1_x4_net4 x_core_x1_x4_net3 x_core_x1_x4_x1_net5 VSS nfet_06v0 L=1.0u W=1.0u
Mx_core_x1_x4_x2_XM11 x_core_x1_x4_x2_net2 x_core_x1_x4_net4 VDD VDD pfet_06v0 L=1.0u W=10.0u
Mx_core_x1_x4_x2_XM12 x_core_x1_x4_x2_net7 x_core_x1_x4_net3 x_core_x1_x4_x2_net2 VDD pfet_06v0 L=1.0u W=10.0u
Mx_core_x1_x4_x2_XM13 x_core_x1_x4_x2_net19 x_core_x1_x4_net4 VDD VDD pfet_06v0 L=1.0u W=10.0u
Mx_core_x1_x4_x2_XM14 x_core_x1_x4_x2_net7 x_core_x1_x4_net3 x_core_x1_x4_x2_net19 VDD pfet_06v0 L=1.0u W=10.0u
Mx_core_x1_x4_x2_XM15_f1 x_core_x1_x4_x2_net5 x_core_x1_SY x_core_x1_x4_x2_net7 VDD pfet_06v0 L=1.0u W=10.0u
Mx_core_x1_x4_x2_XM15_f2 x_core_x1_x4_x2_net5 x_core_x1_SY x_core_x1_x4_x2_net7 VDD pfet_06v0 L=1.0u W=10.0u
Mx_core_x1_x4_x2_XM16_f1 x_core_x1_x4_x2_net4 x_core_x1_SX x_core_x1_x4_x2_net7 VDD pfet_06v0 L=1.0u W=10.0u
Mx_core_x1_x4_x2_XM16_f2 x_core_x1_x4_x2_net4 x_core_x1_SX x_core_x1_x4_x2_net7 VDD pfet_06v0 L=1.0u W=10.0u
Mx_core_x1_x4_x2_XM17 x_core_x1_x4_x2_net8 x_core_x1_x4_net2 x_core_x1_x4_x2_net1 VSS nfet_06v0 L=1.0u W=5.0u
Mx_core_x1_x4_x2_XM18 x_core_x1_x4_x2_net1 x_core_x1_x4_net1 VSS VSS nfet_06v0 L=1.0u W=5.0u
Mx_core_x1_x4_x2_XM19 x_core_x1_x4_x2_net8 x_core_x1_x4_net2 x_core_x1_x4_x2_net20 VSS nfet_06v0 L=1.0u W=5.0u
Mx_core_x1_x4_x2_XM20 x_core_x1_x4_x2_net20 x_core_x1_x4_net1 VSS VSS nfet_06v0 L=1.0u W=5.0u
Mx_core_x1_x4_x2_XM21_f1 x_core_x1_x4_x2_net6 x_core_x1_SY x_core_x1_x4_x2_net8 VSS nfet_06v0 L=1.0u W=5u
Mx_core_x1_x4_x2_XM21_f2 x_core_x1_x4_x2_net6 x_core_x1_SY x_core_x1_x4_x2_net8 VSS nfet_06v0 L=1.0u W=5u
Mx_core_x1_x4_x2_XM22_f1 x_core_x1_x4_x2_net3 x_core_x1_SX x_core_x1_x4_x2_net8 VSS nfet_06v0 L=1.0u W=5u
Mx_core_x1_x4_x2_XM22_f2 x_core_x1_x4_x2_net3 x_core_x1_SX x_core_x1_x4_x2_net8 VSS nfet_06v0 L=1.0u W=5u
Mx_core_x1_x4_x2_XM29_f1 x_core_x1_x4_x2_net9 x_core_x1_x4_net3 x_core_x1_x4_x2_net3 VDD pfet_06v0 L=1.0u W=5u
Mx_core_x1_x4_x2_XM29_f2 x_core_x1_x4_x2_net9 x_core_x1_x4_net3 x_core_x1_x4_x2_net3 VDD pfet_06v0 L=1.0u W=5u
Mx_core_x1_x4_x2_XM30_f1 x_core_x1_x4_x2_net12 x_core_x1_x4_net3 x_core_x1_x4_x2_net6 VDD pfet_06v0 L=1.0u W=5.0u
Mx_core_x1_x4_x2_XM30_f2 x_core_x1_x4_x2_net12 x_core_x1_x4_net3 x_core_x1_x4_x2_net6 VDD pfet_06v0 L=1.0u W=5.0u
Mx_core_x1_x4_x2_XM31_f1 x_core_x1_x4_x2_net3 x_core_x1_x4_x2_net9 VDD VDD pfet_06v0 L=1.0u W=5u
Mx_core_x1_x4_x2_XM31_f2 x_core_x1_x4_x2_net3 x_core_x1_x4_x2_net9 VDD VDD pfet_06v0 L=1.0u W=5u
Mx_core_x1_x4_x2_XM31_f3 x_core_x1_x4_x2_net3 x_core_x1_x4_x2_net9 VDD VDD pfet_06v0 L=1.0u W=5u
Mx_core_x1_x4_x2_XM31_f4 x_core_x1_x4_x2_net3 x_core_x1_x4_x2_net9 VDD VDD pfet_06v0 L=1.0u W=5u
Mx_core_x1_x4_x2_XM35_f1 x_core_x1_x4_x2_net6 x_core_x1_x4_x2_net9 VDD VDD pfet_06v0 L=1.0u W=5.0u
Mx_core_x1_x4_x2_XM35_f2 x_core_x1_x4_x2_net6 x_core_x1_x4_x2_net9 VDD VDD pfet_06v0 L=1.0u W=5.0u
Mx_core_x1_x4_x2_XM35_f3 x_core_x1_x4_x2_net6 x_core_x1_x4_x2_net9 VDD VDD pfet_06v0 L=1.0u W=5.0u
Mx_core_x1_x4_x2_XM35_f4 x_core_x1_x4_x2_net6 x_core_x1_x4_x2_net9 VDD VDD pfet_06v0 L=1.0u W=5.0u
Mx_core_x1_x4_x2_XM32 x_core_x1_x4_x2_net10 x_core_x1_x4_x2_net21 x_core_x1_x4_x2_net9 VDD pfet_06v0 L=1.0u W=5u
Mx_core_x1_x4_x2_XM33 x_core_x1_x4_x2_net22 x_core_x1_x4_x2_net21 x_core_x1_x4_x2_net12 VDD pfet_06v0 L=1.0u W=5.0u
Mx_core_x1_x4_x2_XM23_f1 x_core_x1_x4_x2_net10 x_core_x1_x4_net2 x_core_x1_x4_x2_net4 VSS nfet_06v0 L=1.0u W=2.5u
Mx_core_x1_x4_x2_XM23_f2 x_core_x1_x4_x2_net10 x_core_x1_x4_net2 x_core_x1_x4_x2_net4 VSS nfet_06v0 L=1.0u W=2.5u
Mx_core_x1_x4_x2_XM24_f1 x_core_x1_x4_x2_net22 x_core_x1_x4_net2 x_core_x1_x4_x2_net5 VSS nfet_06v0 L=1.0u W=2.5u
Mx_core_x1_x4_x2_XM24_f2 x_core_x1_x4_x2_net22 x_core_x1_x4_net2 x_core_x1_x4_x2_net5 VSS nfet_06v0 L=1.0u W=2.5u
Mx_core_x1_x4_x2_XM25_f1 x_core_x1_x4_x2_net4 x_core_x1_x4_x2_net10 VSS VSS nfet_06v0 L=1.0u W=2.5u
Mx_core_x1_x4_x2_XM25_f2 x_core_x1_x4_x2_net4 x_core_x1_x4_x2_net10 VSS VSS nfet_06v0 L=1.0u W=2.5u
Mx_core_x1_x4_x2_XM25_f3 x_core_x1_x4_x2_net4 x_core_x1_x4_x2_net10 VSS VSS nfet_06v0 L=1.0u W=2.5u
Mx_core_x1_x4_x2_XM25_f4 x_core_x1_x4_x2_net4 x_core_x1_x4_x2_net10 VSS VSS nfet_06v0 L=1.0u W=2.5u
Mx_core_x1_x4_x2_XM26_f1 x_core_x1_x4_x2_net5 x_core_x1_x4_x2_net10 VSS VSS nfet_06v0 L=1.0u W=2.5u
Mx_core_x1_x4_x2_XM26_f2 x_core_x1_x4_x2_net5 x_core_x1_x4_x2_net10 VSS VSS nfet_06v0 L=1.0u W=2.5u
Mx_core_x1_x4_x2_XM26_f3 x_core_x1_x4_x2_net5 x_core_x1_x4_x2_net10 VSS VSS nfet_06v0 L=1.0u W=2.5u
Mx_core_x1_x4_x2_XM26_f4 x_core_x1_x4_x2_net5 x_core_x1_x4_x2_net10 VSS VSS nfet_06v0 L=1.0u W=2.5u
Mx_core_x1_x4_x2_XM27 x_core_x1_x4_x2_net9 x_core_x1_x4_x2_net11 x_core_x1_x4_x2_net10 VSS nfet_06v0 L=1.0u W=2.5u
Mx_core_x1_x4_x2_XM28 x_core_x1_x4_x2_net12 x_core_x1_x4_x2_net11 x_core_x1_x4_x2_net22 VSS nfet_06v0 L=1.0u W=2.5u
Mx_core_x1_x4_x2_XM34 x_core_x1_x4_x2_net13 x_core_x1_x4_x2_net14 VDD VDD pfet_06v0 L=1.0u W=10.0u
Mx_core_x1_x4_x2_XM36 x_core_x1_x4_x2_net14 x_core_x1_x4_net3 x_core_x1_x4_x2_net13 VDD pfet_06v0 L=1.0u W=10.0u
Mx_core_x1_x4_x2_XM37 x_core_x1_x4_x2_net21 x_core_x1_x4_x2_net21 x_core_x1_x4_x2_net14 VDD pfet_06v0 L=1.0u W=10.0u
Mx_core_x1_x4_x2_XM38 x_core_x1_x4_x2_net21 x_core_x1_x4_net2 x_core_x1_x4_x2_net15 VSS nfet_06v0 L=1.0u W=5.0u
Mx_core_x1_x4_x2_XM39 x_core_x1_x4_x2_net15 x_core_x1_x4_net1 VSS VSS nfet_06v0 L=1.0u W=5.0u
Mx_core_x1_x4_x2_XM45 x_core_x1_x4_x2_net16 x_core_x1_x4_net4 VDD VDD pfet_06v0 L=1.0u W=10.0u
Mx_core_x1_x4_x2_XM46 x_core_x1_x4_x2_net11 x_core_x1_x4_net3 x_core_x1_x4_x2_net16 VDD pfet_06v0 L=1.0u W=10.0u
Mx_core_x1_x4_x2_XM40 x_core_x1_x4_x2_net11 x_core_x1_x4_x2_net11 x_core_x1_x4_x2_net18 VSS nfet_06v0 L=1.0u W=5.0u
Mx_core_x1_x4_x2_XM41 x_core_x1_x4_x2_net18 x_core_x1_x4_net2 x_core_x1_x4_x2_net17 VSS nfet_06v0 L=1.0u W=5.0u
Mx_core_x1_x4_x2_XM42 x_core_x1_x4_x2_net17 x_core_x1_x4_x2_net18 VSS VSS nfet_06v0 L=1.0u W=5.0u
Mx_core_x1_x4_x2_XM43_f1 x_core_x1_net1 x_core_x1_x4_x2_net12 VDD VDD pfet_06v0 L=1.0u W=10u
Mx_core_x1_x4_x2_XM43_f2 x_core_x1_net1 x_core_x1_x4_x2_net12 VDD VDD pfet_06v0 L=1.0u W=10u
Mx_core_x1_x4_x2_XM43_f3 x_core_x1_net1 x_core_x1_x4_x2_net12 VDD VDD pfet_06v0 L=1.0u W=10u
Mx_core_x1_x4_x2_XM44_f1 x_core_x1_net1 x_core_x1_x4_x2_net22 VSS VSS nfet_06v0 L=1.0u W=5u
Mx_core_x1_x4_x2_XM44_f2 x_core_x1_net1 x_core_x1_x4_x2_net22 VSS VSS nfet_06v0 L=1.0u W=5u
Mx_core_x1_x4_x2_XM44_f3 x_core_x1_net1 x_core_x1_x4_x2_net22 VSS VSS nfet_06v0 L=1.0u W=5u
Mx_core_x1_x5_x1_XM4 x_core_x1_x5_x1_net3 x_core_x1_x5_net4 VDD VDD pfet_06v0 L=1.0u W=10.0u
Mx_core_x1_x5_x1_XM5 x_core_x1_x5_net2 x_core_x1_x5_net3 x_core_x1_x5_x1_net3 VDD pfet_06v0 L=1.0u W=10.0u
Mx_core_x1_x5_x1_XM6 x_core_x1_x5_net2 x_core_x1_x5_net2 VSS VSS nfet_06v0 L=1.0u W=1.0u
Mx_core_x1_x5_x1_XM7 x_core_x1_x5_x1_net2 x_core_x1_x5_net4 VDD VDD pfet_06v0 L=1.0u W=10.0u
Mx_core_x1_x5_x1_XM8 x_core_x1_x5_net1 x_core_x1_x5_net3 x_core_x1_x5_x1_net2 VDD pfet_06v0 L=1.0u W=10.0u
Mx_core_x1_x5_x1_XM9 x_core_x1_x5_net1 x_core_x1_x5_net2 x_core_x1_x5_x1_net1 VSS nfet_06v0 L=1.0u W=5.0u
Mx_core_x1_x5_x1_XM10 x_core_x1_x5_x1_net1 x_core_x1_x5_net1 VSS VSS nfet_06v0 L=1.0u W=5.0u
Mx_core_x1_x5_x1_XM1 x_core_x1_x5_net3 x_core_x1_x5_net3 VDD VDD pfet_06v0 L=1.0u W=2u
Mx_core_x1_x5_x1_XM2 x_core_x1_x5_x1_net4 x_core_x1_x5_net4 VDD VDD pfet_06v0 L=1.0u W=10.0u
Mx_core_x1_x5_x1_XM3 x_core_x1_x5_net4 x_core_x1_x5_net3 x_core_x1_x5_x1_net4 VDD pfet_06v0 L=1.0u W=10.0u
Mx_core_x1_x5_x1_XM47 x_core_x1_x5_x1_net5 x_core_x1_x5_net3 VSS VSS nfet_06v0 L=1.0u W=1.0u
Mx_core_x1_x5_x1_XM48 x_core_x1_x5_x1_net6 x_core_x1_x5_net3 VSS VSS nfet_06v0 L=1.0u W=1.0u
Mx_core_x1_x5_x1_XM49 x_core_x1_x5_net3 x_core_x1_x5_net3 x_core_x1_x5_x1_net6 VSS nfet_06v0 L=1.0u W=1.0u
Mx_core_x1_x5_x1_XM50 x_core_x1_x5_net4 x_core_x1_x5_net3 x_core_x1_x5_x1_net5 VSS nfet_06v0 L=1.0u W=1.0u
Mx_core_x1_x5_x2_XM11 x_core_x1_x5_x2_net2 x_core_x1_x5_net4 VDD VDD pfet_06v0 L=1.0u W=10.0u
Mx_core_x1_x5_x2_XM12 x_core_x1_x5_x2_net7 x_core_x1_x5_net3 x_core_x1_x5_x2_net2 VDD pfet_06v0 L=1.0u W=10.0u
Mx_core_x1_x5_x2_XM13 x_core_x1_x5_x2_net19 x_core_x1_x5_net4 VDD VDD pfet_06v0 L=1.0u W=10.0u
Mx_core_x1_x5_x2_XM14 x_core_x1_x5_x2_net7 x_core_x1_x5_net3 x_core_x1_x5_x2_net19 VDD pfet_06v0 L=1.0u W=10.0u
Mx_core_x1_x5_x2_XM15_f1 x_core_x1_x5_x2_net5 x_core_x1_SZ x_core_x1_x5_x2_net7 VDD pfet_06v0 L=1.0u W=10.0u
Mx_core_x1_x5_x2_XM15_f2 x_core_x1_x5_x2_net5 x_core_x1_SZ x_core_x1_x5_x2_net7 VDD pfet_06v0 L=1.0u W=10.0u
Mx_core_x1_x5_x2_XM16_f1 x_core_x1_x5_x2_net4 x_core_x1_SX x_core_x1_x5_x2_net7 VDD pfet_06v0 L=1.0u W=10.0u
Mx_core_x1_x5_x2_XM16_f2 x_core_x1_x5_x2_net4 x_core_x1_SX x_core_x1_x5_x2_net7 VDD pfet_06v0 L=1.0u W=10.0u
Mx_core_x1_x5_x2_XM17 x_core_x1_x5_x2_net8 x_core_x1_x5_net2 x_core_x1_x5_x2_net1 VSS nfet_06v0 L=1.0u W=5.0u
Mx_core_x1_x5_x2_XM18 x_core_x1_x5_x2_net1 x_core_x1_x5_net1 VSS VSS nfet_06v0 L=1.0u W=5.0u
Mx_core_x1_x5_x2_XM19 x_core_x1_x5_x2_net8 x_core_x1_x5_net2 x_core_x1_x5_x2_net20 VSS nfet_06v0 L=1.0u W=5.0u
Mx_core_x1_x5_x2_XM20 x_core_x1_x5_x2_net20 x_core_x1_x5_net1 VSS VSS nfet_06v0 L=1.0u W=5.0u
Mx_core_x1_x5_x2_XM21_f1 x_core_x1_x5_x2_net6 x_core_x1_SZ x_core_x1_x5_x2_net8 VSS nfet_06v0 L=1.0u W=5u
Mx_core_x1_x5_x2_XM21_f2 x_core_x1_x5_x2_net6 x_core_x1_SZ x_core_x1_x5_x2_net8 VSS nfet_06v0 L=1.0u W=5u
Mx_core_x1_x5_x2_XM22_f1 x_core_x1_x5_x2_net3 x_core_x1_SX x_core_x1_x5_x2_net8 VSS nfet_06v0 L=1.0u W=5u
Mx_core_x1_x5_x2_XM22_f2 x_core_x1_x5_x2_net3 x_core_x1_SX x_core_x1_x5_x2_net8 VSS nfet_06v0 L=1.0u W=5u
Mx_core_x1_x5_x2_XM29_f1 x_core_x1_x5_x2_net9 x_core_x1_x5_net3 x_core_x1_x5_x2_net3 VDD pfet_06v0 L=1.0u W=5u
Mx_core_x1_x5_x2_XM29_f2 x_core_x1_x5_x2_net9 x_core_x1_x5_net3 x_core_x1_x5_x2_net3 VDD pfet_06v0 L=1.0u W=5u
Mx_core_x1_x5_x2_XM30_f1 x_core_x1_x5_x2_net12 x_core_x1_x5_net3 x_core_x1_x5_x2_net6 VDD pfet_06v0 L=1.0u W=5.0u
Mx_core_x1_x5_x2_XM30_f2 x_core_x1_x5_x2_net12 x_core_x1_x5_net3 x_core_x1_x5_x2_net6 VDD pfet_06v0 L=1.0u W=5.0u
Mx_core_x1_x5_x2_XM31_f1 x_core_x1_x5_x2_net3 x_core_x1_x5_x2_net9 VDD VDD pfet_06v0 L=1.0u W=5u
Mx_core_x1_x5_x2_XM31_f2 x_core_x1_x5_x2_net3 x_core_x1_x5_x2_net9 VDD VDD pfet_06v0 L=1.0u W=5u
Mx_core_x1_x5_x2_XM31_f3 x_core_x1_x5_x2_net3 x_core_x1_x5_x2_net9 VDD VDD pfet_06v0 L=1.0u W=5u
Mx_core_x1_x5_x2_XM31_f4 x_core_x1_x5_x2_net3 x_core_x1_x5_x2_net9 VDD VDD pfet_06v0 L=1.0u W=5u
Mx_core_x1_x5_x2_XM35_f1 x_core_x1_x5_x2_net6 x_core_x1_x5_x2_net9 VDD VDD pfet_06v0 L=1.0u W=5.0u
Mx_core_x1_x5_x2_XM35_f2 x_core_x1_x5_x2_net6 x_core_x1_x5_x2_net9 VDD VDD pfet_06v0 L=1.0u W=5.0u
Mx_core_x1_x5_x2_XM35_f3 x_core_x1_x5_x2_net6 x_core_x1_x5_x2_net9 VDD VDD pfet_06v0 L=1.0u W=5.0u
Mx_core_x1_x5_x2_XM35_f4 x_core_x1_x5_x2_net6 x_core_x1_x5_x2_net9 VDD VDD pfet_06v0 L=1.0u W=5.0u
Mx_core_x1_x5_x2_XM32 x_core_x1_x5_x2_net10 x_core_x1_x5_x2_net21 x_core_x1_x5_x2_net9 VDD pfet_06v0 L=1.0u W=5u
Mx_core_x1_x5_x2_XM33 x_core_x1_x5_x2_net22 x_core_x1_x5_x2_net21 x_core_x1_x5_x2_net12 VDD pfet_06v0 L=1.0u W=5.0u
Mx_core_x1_x5_x2_XM23_f1 x_core_x1_x5_x2_net10 x_core_x1_x5_net2 x_core_x1_x5_x2_net4 VSS nfet_06v0 L=1.0u W=2.5u
Mx_core_x1_x5_x2_XM23_f2 x_core_x1_x5_x2_net10 x_core_x1_x5_net2 x_core_x1_x5_x2_net4 VSS nfet_06v0 L=1.0u W=2.5u
Mx_core_x1_x5_x2_XM24_f1 x_core_x1_x5_x2_net22 x_core_x1_x5_net2 x_core_x1_x5_x2_net5 VSS nfet_06v0 L=1.0u W=2.5u
Mx_core_x1_x5_x2_XM24_f2 x_core_x1_x5_x2_net22 x_core_x1_x5_net2 x_core_x1_x5_x2_net5 VSS nfet_06v0 L=1.0u W=2.5u
Mx_core_x1_x5_x2_XM25_f1 x_core_x1_x5_x2_net4 x_core_x1_x5_x2_net10 VSS VSS nfet_06v0 L=1.0u W=2.5u
Mx_core_x1_x5_x2_XM25_f2 x_core_x1_x5_x2_net4 x_core_x1_x5_x2_net10 VSS VSS nfet_06v0 L=1.0u W=2.5u
Mx_core_x1_x5_x2_XM25_f3 x_core_x1_x5_x2_net4 x_core_x1_x5_x2_net10 VSS VSS nfet_06v0 L=1.0u W=2.5u
Mx_core_x1_x5_x2_XM25_f4 x_core_x1_x5_x2_net4 x_core_x1_x5_x2_net10 VSS VSS nfet_06v0 L=1.0u W=2.5u
Mx_core_x1_x5_x2_XM26_f1 x_core_x1_x5_x2_net5 x_core_x1_x5_x2_net10 VSS VSS nfet_06v0 L=1.0u W=2.5u
Mx_core_x1_x5_x2_XM26_f2 x_core_x1_x5_x2_net5 x_core_x1_x5_x2_net10 VSS VSS nfet_06v0 L=1.0u W=2.5u
Mx_core_x1_x5_x2_XM26_f3 x_core_x1_x5_x2_net5 x_core_x1_x5_x2_net10 VSS VSS nfet_06v0 L=1.0u W=2.5u
Mx_core_x1_x5_x2_XM26_f4 x_core_x1_x5_x2_net5 x_core_x1_x5_x2_net10 VSS VSS nfet_06v0 L=1.0u W=2.5u
Mx_core_x1_x5_x2_XM27 x_core_x1_x5_x2_net9 x_core_x1_x5_x2_net11 x_core_x1_x5_x2_net10 VSS nfet_06v0 L=1.0u W=2.5u
Mx_core_x1_x5_x2_XM28 x_core_x1_x5_x2_net12 x_core_x1_x5_x2_net11 x_core_x1_x5_x2_net22 VSS nfet_06v0 L=1.0u W=2.5u
Mx_core_x1_x5_x2_XM34 x_core_x1_x5_x2_net13 x_core_x1_x5_x2_net14 VDD VDD pfet_06v0 L=1.0u W=10.0u
Mx_core_x1_x5_x2_XM36 x_core_x1_x5_x2_net14 x_core_x1_x5_net3 x_core_x1_x5_x2_net13 VDD pfet_06v0 L=1.0u W=10.0u
Mx_core_x1_x5_x2_XM37 x_core_x1_x5_x2_net21 x_core_x1_x5_x2_net21 x_core_x1_x5_x2_net14 VDD pfet_06v0 L=1.0u W=10.0u
Mx_core_x1_x5_x2_XM38 x_core_x1_x5_x2_net21 x_core_x1_x5_net2 x_core_x1_x5_x2_net15 VSS nfet_06v0 L=1.0u W=5.0u
Mx_core_x1_x5_x2_XM39 x_core_x1_x5_x2_net15 x_core_x1_x5_net1 VSS VSS nfet_06v0 L=1.0u W=5.0u
Mx_core_x1_x5_x2_XM45 x_core_x1_x5_x2_net16 x_core_x1_x5_net4 VDD VDD pfet_06v0 L=1.0u W=10.0u
Mx_core_x1_x5_x2_XM46 x_core_x1_x5_x2_net11 x_core_x1_x5_net3 x_core_x1_x5_x2_net16 VDD pfet_06v0 L=1.0u W=10.0u
Mx_core_x1_x5_x2_XM40 x_core_x1_x5_x2_net11 x_core_x1_x5_x2_net11 x_core_x1_x5_x2_net18 VSS nfet_06v0 L=1.0u W=5.0u
Mx_core_x1_x5_x2_XM41 x_core_x1_x5_x2_net18 x_core_x1_x5_net2 x_core_x1_x5_x2_net17 VSS nfet_06v0 L=1.0u W=5.0u
Mx_core_x1_x5_x2_XM42 x_core_x1_x5_x2_net17 x_core_x1_x5_x2_net18 VSS VSS nfet_06v0 L=1.0u W=5.0u
Mx_core_x1_x5_x2_XM43_f1 x_core_x1_net2 x_core_x1_x5_x2_net12 VDD VDD pfet_06v0 L=1.0u W=10u
Mx_core_x1_x5_x2_XM43_f2 x_core_x1_net2 x_core_x1_x5_x2_net12 VDD VDD pfet_06v0 L=1.0u W=10u
Mx_core_x1_x5_x2_XM43_f3 x_core_x1_net2 x_core_x1_x5_x2_net12 VDD VDD pfet_06v0 L=1.0u W=10u
Mx_core_x1_x5_x2_XM44_f1 x_core_x1_net2 x_core_x1_x5_x2_net22 VSS VSS nfet_06v0 L=1.0u W=5u
Mx_core_x1_x5_x2_XM44_f2 x_core_x1_net2 x_core_x1_x5_x2_net22 VSS VSS nfet_06v0 L=1.0u W=5u
Mx_core_x1_x5_x2_XM44_f3 x_core_x1_net2 x_core_x1_x5_x2_net22 VSS VSS nfet_06v0 L=1.0u W=5u
Mx_core_x1_x6_x1_XM4 x_core_x1_x6_x1_net3 x_core_x1_x6_net4 VDD VDD pfet_06v0 L=1.0u W=10.0u
Mx_core_x1_x6_x1_XM5 x_core_x1_x6_net2 x_core_x1_x6_net3 x_core_x1_x6_x1_net3 VDD pfet_06v0 L=1.0u W=10.0u
Mx_core_x1_x6_x1_XM6 x_core_x1_x6_net2 x_core_x1_x6_net2 VSS VSS nfet_06v0 L=1.0u W=1.0u
Mx_core_x1_x6_x1_XM7 x_core_x1_x6_x1_net2 x_core_x1_x6_net4 VDD VDD pfet_06v0 L=1.0u W=10.0u
Mx_core_x1_x6_x1_XM8 x_core_x1_x6_net1 x_core_x1_x6_net3 x_core_x1_x6_x1_net2 VDD pfet_06v0 L=1.0u W=10.0u
Mx_core_x1_x6_x1_XM9 x_core_x1_x6_net1 x_core_x1_x6_net2 x_core_x1_x6_x1_net1 VSS nfet_06v0 L=1.0u W=5.0u
Mx_core_x1_x6_x1_XM10 x_core_x1_x6_x1_net1 x_core_x1_x6_net1 VSS VSS nfet_06v0 L=1.0u W=5.0u
Mx_core_x1_x6_x1_XM1 x_core_x1_x6_net3 x_core_x1_x6_net3 VDD VDD pfet_06v0 L=1.0u W=2u
Mx_core_x1_x6_x1_XM2 x_core_x1_x6_x1_net4 x_core_x1_x6_net4 VDD VDD pfet_06v0 L=1.0u W=10.0u
Mx_core_x1_x6_x1_XM3 x_core_x1_x6_net4 x_core_x1_x6_net3 x_core_x1_x6_x1_net4 VDD pfet_06v0 L=1.0u W=10.0u
Mx_core_x1_x6_x1_XM47 x_core_x1_x6_x1_net5 x_core_x1_x6_net3 VSS VSS nfet_06v0 L=1.0u W=1.0u
Mx_core_x1_x6_x1_XM48 x_core_x1_x6_x1_net6 x_core_x1_x6_net3 VSS VSS nfet_06v0 L=1.0u W=1.0u
Mx_core_x1_x6_x1_XM49 x_core_x1_x6_net3 x_core_x1_x6_net3 x_core_x1_x6_x1_net6 VSS nfet_06v0 L=1.0u W=1.0u
Mx_core_x1_x6_x1_XM50 x_core_x1_x6_net4 x_core_x1_x6_net3 x_core_x1_x6_x1_net5 VSS nfet_06v0 L=1.0u W=1.0u
Mx_core_x1_x6_x2_XM11 x_core_x1_x6_x2_net2 x_core_x1_x6_net4 VDD VDD pfet_06v0 L=1.0u W=10.0u
Mx_core_x1_x6_x2_XM12 x_core_x1_x6_x2_net7 x_core_x1_x6_net3 x_core_x1_x6_x2_net2 VDD pfet_06v0 L=1.0u W=10.0u
Mx_core_x1_x6_x2_XM13 x_core_x1_x6_x2_net19 x_core_x1_x6_net4 VDD VDD pfet_06v0 L=1.0u W=10.0u
Mx_core_x1_x6_x2_XM14 x_core_x1_x6_x2_net7 x_core_x1_x6_net3 x_core_x1_x6_x2_net19 VDD pfet_06v0 L=1.0u W=10.0u
Mx_core_x1_x6_x2_XM15_f1 x_core_x1_x6_x2_net5 x_core_x1_SZ x_core_x1_x6_x2_net7 VDD pfet_06v0 L=1.0u W=10.0u
Mx_core_x1_x6_x2_XM15_f2 x_core_x1_x6_x2_net5 x_core_x1_SZ x_core_x1_x6_x2_net7 VDD pfet_06v0 L=1.0u W=10.0u
Mx_core_x1_x6_x2_XM16_f1 x_core_x1_x6_x2_net4 x_core_x1_SY x_core_x1_x6_x2_net7 VDD pfet_06v0 L=1.0u W=10.0u
Mx_core_x1_x6_x2_XM16_f2 x_core_x1_x6_x2_net4 x_core_x1_SY x_core_x1_x6_x2_net7 VDD pfet_06v0 L=1.0u W=10.0u
Mx_core_x1_x6_x2_XM17 x_core_x1_x6_x2_net8 x_core_x1_x6_net2 x_core_x1_x6_x2_net1 VSS nfet_06v0 L=1.0u W=5.0u
Mx_core_x1_x6_x2_XM18 x_core_x1_x6_x2_net1 x_core_x1_x6_net1 VSS VSS nfet_06v0 L=1.0u W=5.0u
Mx_core_x1_x6_x2_XM19 x_core_x1_x6_x2_net8 x_core_x1_x6_net2 x_core_x1_x6_x2_net20 VSS nfet_06v0 L=1.0u W=5.0u
Mx_core_x1_x6_x2_XM20 x_core_x1_x6_x2_net20 x_core_x1_x6_net1 VSS VSS nfet_06v0 L=1.0u W=5.0u
Mx_core_x1_x6_x2_XM21_f1 x_core_x1_x6_x2_net6 x_core_x1_SZ x_core_x1_x6_x2_net8 VSS nfet_06v0 L=1.0u W=5u
Mx_core_x1_x6_x2_XM21_f2 x_core_x1_x6_x2_net6 x_core_x1_SZ x_core_x1_x6_x2_net8 VSS nfet_06v0 L=1.0u W=5u
Mx_core_x1_x6_x2_XM22_f1 x_core_x1_x6_x2_net3 x_core_x1_SY x_core_x1_x6_x2_net8 VSS nfet_06v0 L=1.0u W=5u
Mx_core_x1_x6_x2_XM22_f2 x_core_x1_x6_x2_net3 x_core_x1_SY x_core_x1_x6_x2_net8 VSS nfet_06v0 L=1.0u W=5u
Mx_core_x1_x6_x2_XM29_f1 x_core_x1_x6_x2_net9 x_core_x1_x6_net3 x_core_x1_x6_x2_net3 VDD pfet_06v0 L=1.0u W=5u
Mx_core_x1_x6_x2_XM29_f2 x_core_x1_x6_x2_net9 x_core_x1_x6_net3 x_core_x1_x6_x2_net3 VDD pfet_06v0 L=1.0u W=5u
Mx_core_x1_x6_x2_XM30_f1 x_core_x1_x6_x2_net12 x_core_x1_x6_net3 x_core_x1_x6_x2_net6 VDD pfet_06v0 L=1.0u W=5.0u
Mx_core_x1_x6_x2_XM30_f2 x_core_x1_x6_x2_net12 x_core_x1_x6_net3 x_core_x1_x6_x2_net6 VDD pfet_06v0 L=1.0u W=5.0u
Mx_core_x1_x6_x2_XM31_f1 x_core_x1_x6_x2_net3 x_core_x1_x6_x2_net9 VDD VDD pfet_06v0 L=1.0u W=5u
Mx_core_x1_x6_x2_XM31_f2 x_core_x1_x6_x2_net3 x_core_x1_x6_x2_net9 VDD VDD pfet_06v0 L=1.0u W=5u
Mx_core_x1_x6_x2_XM31_f3 x_core_x1_x6_x2_net3 x_core_x1_x6_x2_net9 VDD VDD pfet_06v0 L=1.0u W=5u
Mx_core_x1_x6_x2_XM31_f4 x_core_x1_x6_x2_net3 x_core_x1_x6_x2_net9 VDD VDD pfet_06v0 L=1.0u W=5u
Mx_core_x1_x6_x2_XM35_f1 x_core_x1_x6_x2_net6 x_core_x1_x6_x2_net9 VDD VDD pfet_06v0 L=1.0u W=5.0u
Mx_core_x1_x6_x2_XM35_f2 x_core_x1_x6_x2_net6 x_core_x1_x6_x2_net9 VDD VDD pfet_06v0 L=1.0u W=5.0u
Mx_core_x1_x6_x2_XM35_f3 x_core_x1_x6_x2_net6 x_core_x1_x6_x2_net9 VDD VDD pfet_06v0 L=1.0u W=5.0u
Mx_core_x1_x6_x2_XM35_f4 x_core_x1_x6_x2_net6 x_core_x1_x6_x2_net9 VDD VDD pfet_06v0 L=1.0u W=5.0u
Mx_core_x1_x6_x2_XM32 x_core_x1_x6_x2_net10 x_core_x1_x6_x2_net21 x_core_x1_x6_x2_net9 VDD pfet_06v0 L=1.0u W=5u
Mx_core_x1_x6_x2_XM33 x_core_x1_x6_x2_net22 x_core_x1_x6_x2_net21 x_core_x1_x6_x2_net12 VDD pfet_06v0 L=1.0u W=5.0u
Mx_core_x1_x6_x2_XM23_f1 x_core_x1_x6_x2_net10 x_core_x1_x6_net2 x_core_x1_x6_x2_net4 VSS nfet_06v0 L=1.0u W=2.5u
Mx_core_x1_x6_x2_XM23_f2 x_core_x1_x6_x2_net10 x_core_x1_x6_net2 x_core_x1_x6_x2_net4 VSS nfet_06v0 L=1.0u W=2.5u
Mx_core_x1_x6_x2_XM24_f1 x_core_x1_x6_x2_net22 x_core_x1_x6_net2 x_core_x1_x6_x2_net5 VSS nfet_06v0 L=1.0u W=2.5u
Mx_core_x1_x6_x2_XM24_f2 x_core_x1_x6_x2_net22 x_core_x1_x6_net2 x_core_x1_x6_x2_net5 VSS nfet_06v0 L=1.0u W=2.5u
Mx_core_x1_x6_x2_XM25_f1 x_core_x1_x6_x2_net4 x_core_x1_x6_x2_net10 VSS VSS nfet_06v0 L=1.0u W=2.5u
Mx_core_x1_x6_x2_XM25_f2 x_core_x1_x6_x2_net4 x_core_x1_x6_x2_net10 VSS VSS nfet_06v0 L=1.0u W=2.5u
Mx_core_x1_x6_x2_XM25_f3 x_core_x1_x6_x2_net4 x_core_x1_x6_x2_net10 VSS VSS nfet_06v0 L=1.0u W=2.5u
Mx_core_x1_x6_x2_XM25_f4 x_core_x1_x6_x2_net4 x_core_x1_x6_x2_net10 VSS VSS nfet_06v0 L=1.0u W=2.5u
Mx_core_x1_x6_x2_XM26_f1 x_core_x1_x6_x2_net5 x_core_x1_x6_x2_net10 VSS VSS nfet_06v0 L=1.0u W=2.5u
Mx_core_x1_x6_x2_XM26_f2 x_core_x1_x6_x2_net5 x_core_x1_x6_x2_net10 VSS VSS nfet_06v0 L=1.0u W=2.5u
Mx_core_x1_x6_x2_XM26_f3 x_core_x1_x6_x2_net5 x_core_x1_x6_x2_net10 VSS VSS nfet_06v0 L=1.0u W=2.5u
Mx_core_x1_x6_x2_XM26_f4 x_core_x1_x6_x2_net5 x_core_x1_x6_x2_net10 VSS VSS nfet_06v0 L=1.0u W=2.5u
Mx_core_x1_x6_x2_XM27 x_core_x1_x6_x2_net9 x_core_x1_x6_x2_net11 x_core_x1_x6_x2_net10 VSS nfet_06v0 L=1.0u W=2.5u
Mx_core_x1_x6_x2_XM28 x_core_x1_x6_x2_net12 x_core_x1_x6_x2_net11 x_core_x1_x6_x2_net22 VSS nfet_06v0 L=1.0u W=2.5u
Mx_core_x1_x6_x2_XM34 x_core_x1_x6_x2_net13 x_core_x1_x6_x2_net14 VDD VDD pfet_06v0 L=1.0u W=10.0u
Mx_core_x1_x6_x2_XM36 x_core_x1_x6_x2_net14 x_core_x1_x6_net3 x_core_x1_x6_x2_net13 VDD pfet_06v0 L=1.0u W=10.0u
Mx_core_x1_x6_x2_XM37 x_core_x1_x6_x2_net21 x_core_x1_x6_x2_net21 x_core_x1_x6_x2_net14 VDD pfet_06v0 L=1.0u W=10.0u
Mx_core_x1_x6_x2_XM38 x_core_x1_x6_x2_net21 x_core_x1_x6_net2 x_core_x1_x6_x2_net15 VSS nfet_06v0 L=1.0u W=5.0u
Mx_core_x1_x6_x2_XM39 x_core_x1_x6_x2_net15 x_core_x1_x6_net1 VSS VSS nfet_06v0 L=1.0u W=5.0u
Mx_core_x1_x6_x2_XM45 x_core_x1_x6_x2_net16 x_core_x1_x6_net4 VDD VDD pfet_06v0 L=1.0u W=10.0u
Mx_core_x1_x6_x2_XM46 x_core_x1_x6_x2_net11 x_core_x1_x6_net3 x_core_x1_x6_x2_net16 VDD pfet_06v0 L=1.0u W=10.0u
Mx_core_x1_x6_x2_XM40 x_core_x1_x6_x2_net11 x_core_x1_x6_x2_net11 x_core_x1_x6_x2_net18 VSS nfet_06v0 L=1.0u W=5.0u
Mx_core_x1_x6_x2_XM41 x_core_x1_x6_x2_net18 x_core_x1_x6_net2 x_core_x1_x6_x2_net17 VSS nfet_06v0 L=1.0u W=5.0u
Mx_core_x1_x6_x2_XM42 x_core_x1_x6_x2_net17 x_core_x1_x6_x2_net18 VSS VSS nfet_06v0 L=1.0u W=5.0u
Mx_core_x1_x6_x2_XM43_f1 x_core_x1_net3 x_core_x1_x6_x2_net12 VDD VDD pfet_06v0 L=1.0u W=10u
Mx_core_x1_x6_x2_XM43_f2 x_core_x1_net3 x_core_x1_x6_x2_net12 VDD VDD pfet_06v0 L=1.0u W=10u
Mx_core_x1_x6_x2_XM43_f3 x_core_x1_net3 x_core_x1_x6_x2_net12 VDD VDD pfet_06v0 L=1.0u W=10u
Mx_core_x1_x6_x2_XM44_f1 x_core_x1_net3 x_core_x1_x6_x2_net22 VSS VSS nfet_06v0 L=1.0u W=5u
Mx_core_x1_x6_x2_XM44_f2 x_core_x1_net3 x_core_x1_x6_x2_net22 VSS VSS nfet_06v0 L=1.0u W=5u
Mx_core_x1_x6_x2_XM44_f3 x_core_x1_net3 x_core_x1_x6_x2_net22 VSS VSS nfet_06v0 L=1.0u W=5u
Mx_core_x1_x7_x2_x2_XM4 x_core_x1_x7_x2_net1 x_core_x1_net1 VDD VDD pfet_06v0 L=1.0u W=3.0u
Mx_core_x1_x7_x2_x2_XM5 VSS x_core_x1_net1 x_core_x1_x7_x2_net1 VSS nfet_06v0 L=1u W=1u
Mx_core_x1_x7_x2_x3_XM4 x_core_Y1 x_core_x1_x7_x2_x3_net1 VDD VDD pfet_06v0 L=1.0u W=3.0u
Mx_core_x1_x7_x2_x3_XM5 VSS x_core_x1_x7_x2_x3_net1 x_core_Y1 VSS nfet_06v0 L=1u W=1u
Mx_core_x1_x7_x2_x3_XM2 VDD x_core_x1_net3 x_core_x1_x7_x2_x3_net1 VDD pfet_06v0 L=1.0u W=3.0u
Mx_core_x1_x7_x2_x3_XM1 VDD x_core_x1_x7_x2_net1 x_core_x1_x7_x2_x3_net1 VDD pfet_06v0 L=1.0u W=3.0u
Mx_core_x1_x7_x2_x3_XM3 VSS x_core_x1_net3 x_core_x1_x7_x2_x3_net2 VSS nfet_06v0 L=1u W=1u
Mx_core_x1_x7_x2_x3_XM6 x_core_x1_x7_x2_x3_net2 x_core_x1_x7_x2_net1 x_core_x1_x7_x2_x3_net1 VSS nfet_06v0 L=1u W=1u
Mx_core_x1_x7_x1_XM4 x_core_x1_x7_x1_net1 x_core_x1_net3 x_core_Z1 VDD pfet_06v0 L=1.0u W=3.0u
Mx_core_x1_x7_x1_XM5 VDD x_core_x1_net2 x_core_x1_x7_x1_net1 VDD pfet_06v0 L=1.0u W=3.0u
Mx_core_x1_x7_x1_XM7 VSS x_core_x1_net3 x_core_Z1 VSS nfet_06v0 L=1u W=1u
Mx_core_x1_x7_x1_XM1 VSS x_core_x1_net2 x_core_Z1 VSS nfet_06v0 L=1u W=1u
Mx_core_x1_x7_x3_x2_XM4 x_core_X1 x_core_x1_x7_x3_x2_net1 VDD VDD pfet_06v0 L=1.0u W=3.0u
Mx_core_x1_x7_x3_x2_XM5 VSS x_core_x1_x7_x3_x2_net1 x_core_X1 VSS nfet_06v0 L=1u W=1u
Mx_core_x1_x7_x3_x2_XM2 VDD x_core_x1_net1 x_core_x1_x7_x3_x2_net1 VDD pfet_06v0 L=1.0u W=3.0u
Mx_core_x1_x7_x3_x2_XM1 VDD x_core_x1_net2 x_core_x1_x7_x3_x2_net1 VDD pfet_06v0 L=1.0u W=3.0u
Mx_core_x1_x7_x3_x2_XM3 VSS x_core_x1_net1 x_core_x1_x7_x3_x2_net2 VSS nfet_06v0 L=1u W=1u
Mx_core_x1_x7_x3_x2_XM6 x_core_x1_x7_x3_x2_net2 x_core_x1_net2 x_core_x1_x7_x3_x2_net1 VSS nfet_06v0 L=1u W=1u
Mx_core_x1_x8_x1_XM4 x_core_x1_x8_x1_net3 x_core_x1_x8_net3 VDD VDD pfet_06v0 L=1.0u W=10.0u
Mx_core_x1_x8_x1_XM5 x_core_x1_x8_net2 x_core_x1_x8_net4 x_core_x1_x8_x1_net3 VDD pfet_06v0 L=1.0u W=10.0u
Mx_core_x1_x8_x1_XM6 x_core_x1_x8_net2 x_core_x1_x8_net2 VSS VSS nfet_06v0 L=1.0u W=1.0u
Mx_core_x1_x8_x1_XM7 x_core_x1_x8_x1_net2 x_core_x1_x8_net3 VDD VDD pfet_06v0 L=1.0u W=10.0u
Mx_core_x1_x8_x1_XM8 x_core_x1_x8_net1 x_core_x1_x8_net4 x_core_x1_x8_x1_net2 VDD pfet_06v0 L=1.0u W=10.0u
Mx_core_x1_x8_x1_XM9 x_core_x1_x8_net1 x_core_x1_x8_net2 x_core_x1_x8_x1_net1 VSS nfet_06v0 L=1.0u W=5.0u
Mx_core_x1_x8_x1_XM10 x_core_x1_x8_x1_net1 x_core_x1_x8_net1 VSS VSS nfet_06v0 L=1.0u W=5.0u
Mx_core_x1_x8_x1_XM1 x_core_x1_x8_net4 x_core_x1_x8_net4 VDD VDD pfet_06v0 L=1.0u W=2u
Mx_core_x1_x8_x1_XM2 x_core_x1_x8_x1_net4 x_core_x1_x8_net3 VDD VDD pfet_06v0 L=1.0u W=10.0u
Mx_core_x1_x8_x1_XM3 x_core_x1_x8_net3 x_core_x1_x8_net4 x_core_x1_x8_x1_net4 VDD pfet_06v0 L=1.0u W=10.0u
Mx_core_x1_x8_x1_XM47 x_core_x1_x8_x1_net5 x_core_x1_x8_net4 VSS VSS nfet_06v0 L=1.0u W=1.0u
Mx_core_x1_x8_x1_XM48 x_core_x1_x8_x1_net6 x_core_x1_x8_net4 VSS VSS nfet_06v0 L=1.0u W=1.0u
Mx_core_x1_x8_x1_XM49 x_core_x1_x8_net4 x_core_x1_x8_net4 x_core_x1_x8_x1_net6 VSS nfet_06v0 L=1.0u W=1.0u
Mx_core_x1_x8_x1_XM50 x_core_x1_x8_net3 x_core_x1_x8_net4 x_core_x1_x8_x1_net5 VSS nfet_06v0 L=1.0u W=1.0u
Mx_core_x1_x8_x2_XM11 x_core_x1_x8_x2_net2 x_core_x1_x8_net3 VDD VDD pfet_06v0 L=1.0u W=10.0u
Mx_core_x1_x8_x2_XM12 x_core_x1_x8_x2_net7 x_core_x1_x8_net4 x_core_x1_x8_x2_net2 VDD pfet_06v0 L=1.0u W=10.0u
Mx_core_x1_x8_x2_XM13 x_core_x1_x8_x2_net18 x_core_x1_x8_net3 VDD VDD pfet_06v0 L=1.0u W=10.0u
Mx_core_x1_x8_x2_XM14 x_core_x1_x8_x2_net7 x_core_x1_x8_net4 x_core_x1_x8_x2_net18 VDD pfet_06v0 L=1.0u W=10.0u
Mx_core_x1_x8_x2_XM15 x_core_x1_x8_x2_net5 S1P_I x_core_x1_x8_x2_net7 VDD pfet_06v0 L=1.0u W=0.55u
Mx_core_x1_x8_x2_XM16 x_core_x1_x8_x2_net4 S1N_I x_core_x1_x8_x2_net7 VDD pfet_06v0 L=1.0u W=0.5u
Mx_core_x1_x8_x2_XM17 x_core_x1_x8_x2_net8 x_core_x1_x8_net2 x_core_x1_x8_x2_net1 VSS nfet_06v0 L=1.0u W=5.0u
Mx_core_x1_x8_x2_XM18 x_core_x1_x8_x2_net1 x_core_x1_x8_net1 VSS VSS nfet_06v0 L=1.0u W=5.0u
Mx_core_x1_x8_x2_XM19 x_core_x1_x8_x2_net8 x_core_x1_x8_net2 x_core_x1_x8_x2_net19 VSS nfet_06v0 L=1.0u W=5.0u
Mx_core_x1_x8_x2_XM20 x_core_x1_x8_x2_net19 x_core_x1_x8_net1 VSS VSS nfet_06v0 L=1.0u W=5.0u
Mx_core_x1_x8_x2_XM21 x_core_x1_x8_x2_net6 S1P_I x_core_x1_x8_x2_net8 VSS nfet_06v0 L=1.0u W=7.5u
Mx_core_x1_x8_x2_XM22 x_core_x1_x8_x2_net3 S1N_I x_core_x1_x8_x2_net8 VSS nfet_06v0 L=1.0u W=8.5u
Mx_core_x1_x8_x2_XM29 x_core_x1_x8_x2_net9 x_core_x1_x8_net4 x_core_x1_x8_x2_net3 VDD pfet_06v0 L=1.0u W=10u
Mx_core_x1_x8_x2_XM30 x_core_x1_x8_x2_G_OUT_P x_core_x1_x8_net4 x_core_x1_x8_x2_net6 VDD pfet_06v0 L=1.0u W=10u
Mx_core_x1_x8_x2_XM31 x_core_x1_x8_x2_net3 x_core_x1_x8_x2_net9 VDD VDD pfet_06v0 L=1.0u W=5u
Mx_core_x1_x8_x2_XM35 x_core_x1_x8_x2_net6 x_core_x1_x8_x2_net9 VDD VDD pfet_06v0 L=1.0u W=5u
Mx_core_x1_x8_x2_XM32 x_core_x1_x8_x2_net10 x_core_x1_x8_x2_net20 x_core_x1_x8_x2_net9 VDD pfet_06v0 L=1.0u W=4.0u
Mx_core_x1_x8_x2_XM33 x_core_x1_x8_x2_net21 x_core_x1_x8_x2_net20 x_core_x1_x8_x2_G_OUT_P VDD pfet_06v0 L=1.0u W=4.0u
Mx_core_x1_x8_x2_XM23 x_core_x1_x8_x2_net10 x_core_x1_x8_net2 x_core_x1_x8_x2_net4 VSS nfet_06v0 L=1.0u W=2.5u
Mx_core_x1_x8_x2_XM24 x_core_x1_x8_x2_net21 x_core_x1_x8_net2 x_core_x1_x8_x2_net5 VSS nfet_06v0 L=1.0u W=2.5u
Mx_core_x1_x8_x2_XM25 x_core_x1_x8_x2_net4 x_core_x1_x8_x2_net10 VSS VSS nfet_06v0 L=1.0u W=2.5u
Mx_core_x1_x8_x2_XM26 x_core_x1_x8_x2_net5 x_core_x1_x8_x2_net10 VSS VSS nfet_06v0 L=1.0u W=2.5u
Mx_core_x1_x8_x2_XM27 x_core_x1_x8_x2_net9 x_core_x1_x8_x2_net11 x_core_x1_x8_x2_net10 VSS nfet_06v0 L=1.0u W=2.0u
Mx_core_x1_x8_x2_XM28 x_core_x1_x8_x2_G_OUT_P x_core_x1_x8_x2_net11 x_core_x1_x8_x2_net21 VSS nfet_06v0 L=1.0u W=2.0u
Mx_core_x1_x8_x2_XM34 x_core_x1_x8_x2_net12 x_core_x1_x8_x2_net13 VDD VDD pfet_06v0 L=1.0u W=10.0u
Mx_core_x1_x8_x2_XM36 x_core_x1_x8_x2_net13 x_core_x1_x8_net4 x_core_x1_x8_x2_net12 VDD pfet_06v0 L=1.0u W=10.0u
Mx_core_x1_x8_x2_XM37 x_core_x1_x8_x2_net20 x_core_x1_x8_x2_net20 x_core_x1_x8_x2_net13 VDD pfet_06v0 L=1.0u W=10.0u
Mx_core_x1_x8_x2_XM38 x_core_x1_x8_x2_net20 x_core_x1_x8_net2 x_core_x1_x8_x2_net14 VSS nfet_06v0 L=1.0u W=5.0u
Mx_core_x1_x8_x2_XM39 x_core_x1_x8_x2_net14 x_core_x1_x8_net1 VSS VSS nfet_06v0 L=1.0u W=5.0u
Mx_core_x1_x8_x2_XM45 x_core_x1_x8_x2_net15 x_core_x1_x8_net3 VDD VDD pfet_06v0 L=1.0u W=10.0u
Mx_core_x1_x8_x2_XM46 x_core_x1_x8_x2_net11 x_core_x1_x8_net4 x_core_x1_x8_x2_net15 VDD pfet_06v0 L=1.0u W=10.0u
Mx_core_x1_x8_x2_XM40 x_core_x1_x8_x2_net11 x_core_x1_x8_x2_net11 x_core_x1_x8_x2_net17 VSS nfet_06v0 L=1.0u W=5.0u
Mx_core_x1_x8_x2_XM41 x_core_x1_x8_x2_net17 x_core_x1_x8_net2 x_core_x1_x8_x2_net16 VSS nfet_06v0 L=1.0u W=5.0u
Mx_core_x1_x8_x2_XM42 x_core_x1_x8_x2_net16 x_core_x1_x8_x2_net17 VSS VSS nfet_06v0 L=1.0u W=5.0u
Mx_core_x1_x8_x2_XM43_m1 x_core_x1_SX x_core_x1_x8_x2_G_OUT_P VDD VDD pfet_06v0 L=1.0u W=1.0u
Mx_core_x1_x8_x2_XM43_m2 x_core_x1_SX x_core_x1_x8_x2_G_OUT_P VDD VDD pfet_06v0 L=1.0u W=1.0u
Mx_core_x1_x8_x2_XM43_m3 x_core_x1_SX x_core_x1_x8_x2_G_OUT_P VDD VDD pfet_06v0 L=1.0u W=1.0u
Mx_core_x1_x8_x2_XM43_m4 x_core_x1_SX x_core_x1_x8_x2_G_OUT_P VDD VDD pfet_06v0 L=1.0u W=1.0u
Mx_core_x1_x8_x2_XM44 x_core_x1_SX x_core_x1_x8_x2_net21 VSS VSS nfet_06v0 L=1.0u W=1.0u
Mx_core_x1_x1_x1_XM4 x_core_x1_x1_x1_net3 x_core_x1_x1_net3 VDD VDD pfet_06v0 L=1.0u W=10.0u
Mx_core_x1_x1_x1_XM5 x_core_x1_x1_net2 x_core_x1_x1_net4 x_core_x1_x1_x1_net3 VDD pfet_06v0 L=1.0u W=10.0u
Mx_core_x1_x1_x1_XM6 x_core_x1_x1_net2 x_core_x1_x1_net2 VSS VSS nfet_06v0 L=1.0u W=1.0u
Mx_core_x1_x1_x1_XM7 x_core_x1_x1_x1_net2 x_core_x1_x1_net3 VDD VDD pfet_06v0 L=1.0u W=10.0u
Mx_core_x1_x1_x1_XM8 x_core_x1_x1_net1 x_core_x1_x1_net4 x_core_x1_x1_x1_net2 VDD pfet_06v0 L=1.0u W=10.0u
Mx_core_x1_x1_x1_XM9 x_core_x1_x1_net1 x_core_x1_x1_net2 x_core_x1_x1_x1_net1 VSS nfet_06v0 L=1.0u W=5.0u
Mx_core_x1_x1_x1_XM10 x_core_x1_x1_x1_net1 x_core_x1_x1_net1 VSS VSS nfet_06v0 L=1.0u W=5.0u
Mx_core_x1_x1_x1_XM1 x_core_x1_x1_net4 x_core_x1_x1_net4 VDD VDD pfet_06v0 L=1.0u W=2u
Mx_core_x1_x1_x1_XM2 x_core_x1_x1_x1_net4 x_core_x1_x1_net3 VDD VDD pfet_06v0 L=1.0u W=10.0u
Mx_core_x1_x1_x1_XM3 x_core_x1_x1_net3 x_core_x1_x1_net4 x_core_x1_x1_x1_net4 VDD pfet_06v0 L=1.0u W=10.0u
Mx_core_x1_x1_x1_XM47 x_core_x1_x1_x1_net5 x_core_x1_x1_net4 VSS VSS nfet_06v0 L=1.0u W=1.0u
Mx_core_x1_x1_x1_XM48 x_core_x1_x1_x1_net6 x_core_x1_x1_net4 VSS VSS nfet_06v0 L=1.0u W=1.0u
Mx_core_x1_x1_x1_XM49 x_core_x1_x1_net4 x_core_x1_x1_net4 x_core_x1_x1_x1_net6 VSS nfet_06v0 L=1.0u W=1.0u
Mx_core_x1_x1_x1_XM50 x_core_x1_x1_net3 x_core_x1_x1_net4 x_core_x1_x1_x1_net5 VSS nfet_06v0 L=1.0u W=1.0u
Mx_core_x1_x1_x2_XM11 x_core_x1_x1_x2_net2 x_core_x1_x1_net3 VDD VDD pfet_06v0 L=1.0u W=10.0u
Mx_core_x1_x1_x2_XM12 x_core_x1_x1_x2_net7 x_core_x1_x1_net4 x_core_x1_x1_x2_net2 VDD pfet_06v0 L=1.0u W=10.0u
Mx_core_x1_x1_x2_XM13 x_core_x1_x1_x2_net18 x_core_x1_x1_net3 VDD VDD pfet_06v0 L=1.0u W=10.0u
Mx_core_x1_x1_x2_XM14 x_core_x1_x1_x2_net7 x_core_x1_x1_net4 x_core_x1_x1_x2_net18 VDD pfet_06v0 L=1.0u W=10.0u
Mx_core_x1_x1_x2_XM15 x_core_x1_x1_x2_net5 S2P_I x_core_x1_x1_x2_net7 VDD pfet_06v0 L=1.0u W=0.55u
Mx_core_x1_x1_x2_XM16 x_core_x1_x1_x2_net4 S2N_I x_core_x1_x1_x2_net7 VDD pfet_06v0 L=1.0u W=0.5u
Mx_core_x1_x1_x2_XM17 x_core_x1_x1_x2_net8 x_core_x1_x1_net2 x_core_x1_x1_x2_net1 VSS nfet_06v0 L=1.0u W=5.0u
Mx_core_x1_x1_x2_XM18 x_core_x1_x1_x2_net1 x_core_x1_x1_net1 VSS VSS nfet_06v0 L=1.0u W=5.0u
Mx_core_x1_x1_x2_XM19 x_core_x1_x1_x2_net8 x_core_x1_x1_net2 x_core_x1_x1_x2_net19 VSS nfet_06v0 L=1.0u W=5.0u
Mx_core_x1_x1_x2_XM20 x_core_x1_x1_x2_net19 x_core_x1_x1_net1 VSS VSS nfet_06v0 L=1.0u W=5.0u
Mx_core_x1_x1_x2_XM21 x_core_x1_x1_x2_net6 S2P_I x_core_x1_x1_x2_net8 VSS nfet_06v0 L=1.0u W=7.5u
Mx_core_x1_x1_x2_XM22 x_core_x1_x1_x2_net3 S2N_I x_core_x1_x1_x2_net8 VSS nfet_06v0 L=1.0u W=8.5u
Mx_core_x1_x1_x2_XM29 x_core_x1_x1_x2_net9 x_core_x1_x1_net4 x_core_x1_x1_x2_net3 VDD pfet_06v0 L=1.0u W=10u
Mx_core_x1_x1_x2_XM30 x_core_x1_x1_x2_G_OUT_P x_core_x1_x1_net4 x_core_x1_x1_x2_net6 VDD pfet_06v0 L=1.0u W=10u
Mx_core_x1_x1_x2_XM31 x_core_x1_x1_x2_net3 x_core_x1_x1_x2_net9 VDD VDD pfet_06v0 L=1.0u W=5u
Mx_core_x1_x1_x2_XM35 x_core_x1_x1_x2_net6 x_core_x1_x1_x2_net9 VDD VDD pfet_06v0 L=1.0u W=5u
Mx_core_x1_x1_x2_XM32 x_core_x1_x1_x2_net10 x_core_x1_x1_x2_net20 x_core_x1_x1_x2_net9 VDD pfet_06v0 L=1.0u W=4.0u
Mx_core_x1_x1_x2_XM33 x_core_x1_x1_x2_net21 x_core_x1_x1_x2_net20 x_core_x1_x1_x2_G_OUT_P VDD pfet_06v0 L=1.0u W=4.0u
Mx_core_x1_x1_x2_XM23 x_core_x1_x1_x2_net10 x_core_x1_x1_net2 x_core_x1_x1_x2_net4 VSS nfet_06v0 L=1.0u W=2.5u
Mx_core_x1_x1_x2_XM24 x_core_x1_x1_x2_net21 x_core_x1_x1_net2 x_core_x1_x1_x2_net5 VSS nfet_06v0 L=1.0u W=2.5u
Mx_core_x1_x1_x2_XM25 x_core_x1_x1_x2_net4 x_core_x1_x1_x2_net10 VSS VSS nfet_06v0 L=1.0u W=2.5u
Mx_core_x1_x1_x2_XM26 x_core_x1_x1_x2_net5 x_core_x1_x1_x2_net10 VSS VSS nfet_06v0 L=1.0u W=2.5u
Mx_core_x1_x1_x2_XM27 x_core_x1_x1_x2_net9 x_core_x1_x1_x2_net11 x_core_x1_x1_x2_net10 VSS nfet_06v0 L=1.0u W=2.0u
Mx_core_x1_x1_x2_XM28 x_core_x1_x1_x2_G_OUT_P x_core_x1_x1_x2_net11 x_core_x1_x1_x2_net21 VSS nfet_06v0 L=1.0u W=2.0u
Mx_core_x1_x1_x2_XM34 x_core_x1_x1_x2_net12 x_core_x1_x1_x2_net13 VDD VDD pfet_06v0 L=1.0u W=10.0u
Mx_core_x1_x1_x2_XM36 x_core_x1_x1_x2_net13 x_core_x1_x1_net4 x_core_x1_x1_x2_net12 VDD pfet_06v0 L=1.0u W=10.0u
Mx_core_x1_x1_x2_XM37 x_core_x1_x1_x2_net20 x_core_x1_x1_x2_net20 x_core_x1_x1_x2_net13 VDD pfet_06v0 L=1.0u W=10.0u
Mx_core_x1_x1_x2_XM38 x_core_x1_x1_x2_net20 x_core_x1_x1_net2 x_core_x1_x1_x2_net14 VSS nfet_06v0 L=1.0u W=5.0u
Mx_core_x1_x1_x2_XM39 x_core_x1_x1_x2_net14 x_core_x1_x1_net1 VSS VSS nfet_06v0 L=1.0u W=5.0u
Mx_core_x1_x1_x2_XM45 x_core_x1_x1_x2_net15 x_core_x1_x1_net3 VDD VDD pfet_06v0 L=1.0u W=10.0u
Mx_core_x1_x1_x2_XM46 x_core_x1_x1_x2_net11 x_core_x1_x1_net4 x_core_x1_x1_x2_net15 VDD pfet_06v0 L=1.0u W=10.0u
Mx_core_x1_x1_x2_XM40 x_core_x1_x1_x2_net11 x_core_x1_x1_x2_net11 x_core_x1_x1_x2_net17 VSS nfet_06v0 L=1.0u W=5.0u
Mx_core_x1_x1_x2_XM41 x_core_x1_x1_x2_net17 x_core_x1_x1_net2 x_core_x1_x1_x2_net16 VSS nfet_06v0 L=1.0u W=5.0u
Mx_core_x1_x1_x2_XM42 x_core_x1_x1_x2_net16 x_core_x1_x1_x2_net17 VSS VSS nfet_06v0 L=1.0u W=5.0u
Mx_core_x1_x1_x2_XM43_m1 x_core_x1_SY x_core_x1_x1_x2_G_OUT_P VDD VDD pfet_06v0 L=1.0u W=1.0u
Mx_core_x1_x1_x2_XM43_m2 x_core_x1_SY x_core_x1_x1_x2_G_OUT_P VDD VDD pfet_06v0 L=1.0u W=1.0u
Mx_core_x1_x1_x2_XM43_m3 x_core_x1_SY x_core_x1_x1_x2_G_OUT_P VDD VDD pfet_06v0 L=1.0u W=1.0u
Mx_core_x1_x1_x2_XM43_m4 x_core_x1_SY x_core_x1_x1_x2_G_OUT_P VDD VDD pfet_06v0 L=1.0u W=1.0u
Mx_core_x1_x1_x2_XM44 x_core_x1_SY x_core_x1_x1_x2_net21 VSS VSS nfet_06v0 L=1.0u W=1.0u
Mx_core_x1_x2_x1_XM4 x_core_x1_x2_x1_net3 x_core_x1_x2_net3 VDD VDD pfet_06v0 L=1.0u W=10.0u
Mx_core_x1_x2_x1_XM5 x_core_x1_x2_net2 x_core_x1_x2_net4 x_core_x1_x2_x1_net3 VDD pfet_06v0 L=1.0u W=10.0u
Mx_core_x1_x2_x1_XM6 x_core_x1_x2_net2 x_core_x1_x2_net2 VSS VSS nfet_06v0 L=1.0u W=1.0u
Mx_core_x1_x2_x1_XM7 x_core_x1_x2_x1_net2 x_core_x1_x2_net3 VDD VDD pfet_06v0 L=1.0u W=10.0u
Mx_core_x1_x2_x1_XM8 x_core_x1_x2_net1 x_core_x1_x2_net4 x_core_x1_x2_x1_net2 VDD pfet_06v0 L=1.0u W=10.0u
Mx_core_x1_x2_x1_XM9 x_core_x1_x2_net1 x_core_x1_x2_net2 x_core_x1_x2_x1_net1 VSS nfet_06v0 L=1.0u W=5.0u
Mx_core_x1_x2_x1_XM10 x_core_x1_x2_x1_net1 x_core_x1_x2_net1 VSS VSS nfet_06v0 L=1.0u W=5.0u
Mx_core_x1_x2_x1_XM1 x_core_x1_x2_net4 x_core_x1_x2_net4 VDD VDD pfet_06v0 L=1.0u W=2u
Mx_core_x1_x2_x1_XM2 x_core_x1_x2_x1_net4 x_core_x1_x2_net3 VDD VDD pfet_06v0 L=1.0u W=10.0u
Mx_core_x1_x2_x1_XM3 x_core_x1_x2_net3 x_core_x1_x2_net4 x_core_x1_x2_x1_net4 VDD pfet_06v0 L=1.0u W=10.0u
Mx_core_x1_x2_x1_XM47 x_core_x1_x2_x1_net5 x_core_x1_x2_net4 VSS VSS nfet_06v0 L=1.0u W=1.0u
Mx_core_x1_x2_x1_XM48 x_core_x1_x2_x1_net6 x_core_x1_x2_net4 VSS VSS nfet_06v0 L=1.0u W=1.0u
Mx_core_x1_x2_x1_XM49 x_core_x1_x2_net4 x_core_x1_x2_net4 x_core_x1_x2_x1_net6 VSS nfet_06v0 L=1.0u W=1.0u
Mx_core_x1_x2_x1_XM50 x_core_x1_x2_net3 x_core_x1_x2_net4 x_core_x1_x2_x1_net5 VSS nfet_06v0 L=1.0u W=1.0u
Mx_core_x1_x2_x2_XM11 x_core_x1_x2_x2_net2 x_core_x1_x2_net3 VDD VDD pfet_06v0 L=1.0u W=10.0u
Mx_core_x1_x2_x2_XM12 x_core_x1_x2_x2_net7 x_core_x1_x2_net4 x_core_x1_x2_x2_net2 VDD pfet_06v0 L=1.0u W=10.0u
Mx_core_x1_x2_x2_XM13 x_core_x1_x2_x2_net18 x_core_x1_x2_net3 VDD VDD pfet_06v0 L=1.0u W=10.0u
Mx_core_x1_x2_x2_XM14 x_core_x1_x2_x2_net7 x_core_x1_x2_net4 x_core_x1_x2_x2_net18 VDD pfet_06v0 L=1.0u W=10.0u
Mx_core_x1_x2_x2_XM15 x_core_x1_x2_x2_net5 S3P_I x_core_x1_x2_x2_net7 VDD pfet_06v0 L=1.0u W=0.55u
Mx_core_x1_x2_x2_XM16 x_core_x1_x2_x2_net4 S3N_I x_core_x1_x2_x2_net7 VDD pfet_06v0 L=1.0u W=0.5u
Mx_core_x1_x2_x2_XM17 x_core_x1_x2_x2_net8 x_core_x1_x2_net2 x_core_x1_x2_x2_net1 VSS nfet_06v0 L=1.0u W=5.0u
Mx_core_x1_x2_x2_XM18 x_core_x1_x2_x2_net1 x_core_x1_x2_net1 VSS VSS nfet_06v0 L=1.0u W=5.0u
Mx_core_x1_x2_x2_XM19 x_core_x1_x2_x2_net8 x_core_x1_x2_net2 x_core_x1_x2_x2_net19 VSS nfet_06v0 L=1.0u W=5.0u
Mx_core_x1_x2_x2_XM20 x_core_x1_x2_x2_net19 x_core_x1_x2_net1 VSS VSS nfet_06v0 L=1.0u W=5.0u
Mx_core_x1_x2_x2_XM21 x_core_x1_x2_x2_net6 S3P_I x_core_x1_x2_x2_net8 VSS nfet_06v0 L=1.0u W=7.5u
Mx_core_x1_x2_x2_XM22 x_core_x1_x2_x2_net3 S3N_I x_core_x1_x2_x2_net8 VSS nfet_06v0 L=1.0u W=8.5u
Mx_core_x1_x2_x2_XM29 x_core_x1_x2_x2_net9 x_core_x1_x2_net4 x_core_x1_x2_x2_net3 VDD pfet_06v0 L=1.0u W=10u
Mx_core_x1_x2_x2_XM30 x_core_x1_x2_x2_G_OUT_P x_core_x1_x2_net4 x_core_x1_x2_x2_net6 VDD pfet_06v0 L=1.0u W=10u
Mx_core_x1_x2_x2_XM31 x_core_x1_x2_x2_net3 x_core_x1_x2_x2_net9 VDD VDD pfet_06v0 L=1.0u W=5u
Mx_core_x1_x2_x2_XM35 x_core_x1_x2_x2_net6 x_core_x1_x2_x2_net9 VDD VDD pfet_06v0 L=1.0u W=5u
Mx_core_x1_x2_x2_XM32 x_core_x1_x2_x2_net10 x_core_x1_x2_x2_net20 x_core_x1_x2_x2_net9 VDD pfet_06v0 L=1.0u W=4.0u
Mx_core_x1_x2_x2_XM33 x_core_x1_x2_x2_net21 x_core_x1_x2_x2_net20 x_core_x1_x2_x2_G_OUT_P VDD pfet_06v0 L=1.0u W=4.0u
Mx_core_x1_x2_x2_XM23 x_core_x1_x2_x2_net10 x_core_x1_x2_net2 x_core_x1_x2_x2_net4 VSS nfet_06v0 L=1.0u W=2.5u
Mx_core_x1_x2_x2_XM24 x_core_x1_x2_x2_net21 x_core_x1_x2_net2 x_core_x1_x2_x2_net5 VSS nfet_06v0 L=1.0u W=2.5u
Mx_core_x1_x2_x2_XM25 x_core_x1_x2_x2_net4 x_core_x1_x2_x2_net10 VSS VSS nfet_06v0 L=1.0u W=2.5u
Mx_core_x1_x2_x2_XM26 x_core_x1_x2_x2_net5 x_core_x1_x2_x2_net10 VSS VSS nfet_06v0 L=1.0u W=2.5u
Mx_core_x1_x2_x2_XM27 x_core_x1_x2_x2_net9 x_core_x1_x2_x2_net11 x_core_x1_x2_x2_net10 VSS nfet_06v0 L=1.0u W=2.0u
Mx_core_x1_x2_x2_XM28 x_core_x1_x2_x2_G_OUT_P x_core_x1_x2_x2_net11 x_core_x1_x2_x2_net21 VSS nfet_06v0 L=1.0u W=2.0u
Mx_core_x1_x2_x2_XM34 x_core_x1_x2_x2_net12 x_core_x1_x2_x2_net13 VDD VDD pfet_06v0 L=1.0u W=10.0u
Mx_core_x1_x2_x2_XM36 x_core_x1_x2_x2_net13 x_core_x1_x2_net4 x_core_x1_x2_x2_net12 VDD pfet_06v0 L=1.0u W=10.0u
Mx_core_x1_x2_x2_XM37 x_core_x1_x2_x2_net20 x_core_x1_x2_x2_net20 x_core_x1_x2_x2_net13 VDD pfet_06v0 L=1.0u W=10.0u
Mx_core_x1_x2_x2_XM38 x_core_x1_x2_x2_net20 x_core_x1_x2_net2 x_core_x1_x2_x2_net14 VSS nfet_06v0 L=1.0u W=5.0u
Mx_core_x1_x2_x2_XM39 x_core_x1_x2_x2_net14 x_core_x1_x2_net1 VSS VSS nfet_06v0 L=1.0u W=5.0u
Mx_core_x1_x2_x2_XM45 x_core_x1_x2_x2_net15 x_core_x1_x2_net3 VDD VDD pfet_06v0 L=1.0u W=10.0u
Mx_core_x1_x2_x2_XM46 x_core_x1_x2_x2_net11 x_core_x1_x2_net4 x_core_x1_x2_x2_net15 VDD pfet_06v0 L=1.0u W=10.0u
Mx_core_x1_x2_x2_XM40 x_core_x1_x2_x2_net11 x_core_x1_x2_x2_net11 x_core_x1_x2_x2_net17 VSS nfet_06v0 L=1.0u W=5.0u
Mx_core_x1_x2_x2_XM41 x_core_x1_x2_x2_net17 x_core_x1_x2_net2 x_core_x1_x2_x2_net16 VSS nfet_06v0 L=1.0u W=5.0u
Mx_core_x1_x2_x2_XM42 x_core_x1_x2_x2_net16 x_core_x1_x2_x2_net17 VSS VSS nfet_06v0 L=1.0u W=5.0u
Mx_core_x1_x2_x2_XM43_m1 x_core_x1_SZ x_core_x1_x2_x2_G_OUT_P VDD VDD pfet_06v0 L=1.0u W=1.0u
Mx_core_x1_x2_x2_XM43_m2 x_core_x1_SZ x_core_x1_x2_x2_G_OUT_P VDD VDD pfet_06v0 L=1.0u W=1.0u
Mx_core_x1_x2_x2_XM43_m3 x_core_x1_SZ x_core_x1_x2_x2_G_OUT_P VDD VDD pfet_06v0 L=1.0u W=1.0u
Mx_core_x1_x2_x2_XM43_m4 x_core_x1_SZ x_core_x1_x2_x2_G_OUT_P VDD VDD pfet_06v0 L=1.0u W=1.0u
Mx_core_x1_x2_x2_XM44 x_core_x1_SZ x_core_x1_x2_x2_net21 VSS VSS nfet_06v0 L=1.0u W=1.0u
Mx_core_x2_x4_x1_XM4 x_core_x2_x4_x1_net3 x_core_x2_x4_net4 VDD VDD pfet_06v0 L=1.0u W=10.0u
Mx_core_x2_x4_x1_XM5 x_core_x2_x4_net2 x_core_x2_x4_net3 x_core_x2_x4_x1_net3 VDD pfet_06v0 L=1.0u W=10.0u
Mx_core_x2_x4_x1_XM6 x_core_x2_x4_net2 x_core_x2_x4_net2 VSS VSS nfet_06v0 L=1.0u W=1.0u
Mx_core_x2_x4_x1_XM7 x_core_x2_x4_x1_net2 x_core_x2_x4_net4 VDD VDD pfet_06v0 L=1.0u W=10.0u
Mx_core_x2_x4_x1_XM8 x_core_x2_x4_net1 x_core_x2_x4_net3 x_core_x2_x4_x1_net2 VDD pfet_06v0 L=1.0u W=10.0u
Mx_core_x2_x4_x1_XM9 x_core_x2_x4_net1 x_core_x2_x4_net2 x_core_x2_x4_x1_net1 VSS nfet_06v0 L=1.0u W=5.0u
Mx_core_x2_x4_x1_XM10 x_core_x2_x4_x1_net1 x_core_x2_x4_net1 VSS VSS nfet_06v0 L=1.0u W=5.0u
Mx_core_x2_x4_x1_XM1 x_core_x2_x4_net3 x_core_x2_x4_net3 VDD VDD pfet_06v0 L=1.0u W=2u
Mx_core_x2_x4_x1_XM2 x_core_x2_x4_x1_net4 x_core_x2_x4_net4 VDD VDD pfet_06v0 L=1.0u W=10.0u
Mx_core_x2_x4_x1_XM3 x_core_x2_x4_net4 x_core_x2_x4_net3 x_core_x2_x4_x1_net4 VDD pfet_06v0 L=1.0u W=10.0u
Mx_core_x2_x4_x1_XM47 x_core_x2_x4_x1_net5 x_core_x2_x4_net3 VSS VSS nfet_06v0 L=1.0u W=1.0u
Mx_core_x2_x4_x1_XM48 x_core_x2_x4_x1_net6 x_core_x2_x4_net3 VSS VSS nfet_06v0 L=1.0u W=1.0u
Mx_core_x2_x4_x1_XM49 x_core_x2_x4_net3 x_core_x2_x4_net3 x_core_x2_x4_x1_net6 VSS nfet_06v0 L=1.0u W=1.0u
Mx_core_x2_x4_x1_XM50 x_core_x2_x4_net4 x_core_x2_x4_net3 x_core_x2_x4_x1_net5 VSS nfet_06v0 L=1.0u W=1.0u
Mx_core_x2_x4_x2_XM11 x_core_x2_x4_x2_net2 x_core_x2_x4_net4 VDD VDD pfet_06v0 L=1.0u W=10.0u
Mx_core_x2_x4_x2_XM12 x_core_x2_x4_x2_net7 x_core_x2_x4_net3 x_core_x2_x4_x2_net2 VDD pfet_06v0 L=1.0u W=10.0u
Mx_core_x2_x4_x2_XM13 x_core_x2_x4_x2_net19 x_core_x2_x4_net4 VDD VDD pfet_06v0 L=1.0u W=10.0u
Mx_core_x2_x4_x2_XM14 x_core_x2_x4_x2_net7 x_core_x2_x4_net3 x_core_x2_x4_x2_net19 VDD pfet_06v0 L=1.0u W=10.0u
Mx_core_x2_x4_x2_XM15_f1 x_core_x2_x4_x2_net5 x_core_x2_SY x_core_x2_x4_x2_net7 VDD pfet_06v0 L=1.0u W=10.0u
Mx_core_x2_x4_x2_XM15_f2 x_core_x2_x4_x2_net5 x_core_x2_SY x_core_x2_x4_x2_net7 VDD pfet_06v0 L=1.0u W=10.0u
Mx_core_x2_x4_x2_XM16_f1 x_core_x2_x4_x2_net4 x_core_x2_SX x_core_x2_x4_x2_net7 VDD pfet_06v0 L=1.0u W=10.0u
Mx_core_x2_x4_x2_XM16_f2 x_core_x2_x4_x2_net4 x_core_x2_SX x_core_x2_x4_x2_net7 VDD pfet_06v0 L=1.0u W=10.0u
Mx_core_x2_x4_x2_XM17 x_core_x2_x4_x2_net8 x_core_x2_x4_net2 x_core_x2_x4_x2_net1 VSS nfet_06v0 L=1.0u W=5.0u
Mx_core_x2_x4_x2_XM18 x_core_x2_x4_x2_net1 x_core_x2_x4_net1 VSS VSS nfet_06v0 L=1.0u W=5.0u
Mx_core_x2_x4_x2_XM19 x_core_x2_x4_x2_net8 x_core_x2_x4_net2 x_core_x2_x4_x2_net20 VSS nfet_06v0 L=1.0u W=5.0u
Mx_core_x2_x4_x2_XM20 x_core_x2_x4_x2_net20 x_core_x2_x4_net1 VSS VSS nfet_06v0 L=1.0u W=5.0u
Mx_core_x2_x4_x2_XM21_f1 x_core_x2_x4_x2_net6 x_core_x2_SY x_core_x2_x4_x2_net8 VSS nfet_06v0 L=1.0u W=5u
Mx_core_x2_x4_x2_XM21_f2 x_core_x2_x4_x2_net6 x_core_x2_SY x_core_x2_x4_x2_net8 VSS nfet_06v0 L=1.0u W=5u
Mx_core_x2_x4_x2_XM22_f1 x_core_x2_x4_x2_net3 x_core_x2_SX x_core_x2_x4_x2_net8 VSS nfet_06v0 L=1.0u W=5u
Mx_core_x2_x4_x2_XM22_f2 x_core_x2_x4_x2_net3 x_core_x2_SX x_core_x2_x4_x2_net8 VSS nfet_06v0 L=1.0u W=5u
Mx_core_x2_x4_x2_XM29_f1 x_core_x2_x4_x2_net9 x_core_x2_x4_net3 x_core_x2_x4_x2_net3 VDD pfet_06v0 L=1.0u W=5u
Mx_core_x2_x4_x2_XM29_f2 x_core_x2_x4_x2_net9 x_core_x2_x4_net3 x_core_x2_x4_x2_net3 VDD pfet_06v0 L=1.0u W=5u
Mx_core_x2_x4_x2_XM30_f1 x_core_x2_x4_x2_net12 x_core_x2_x4_net3 x_core_x2_x4_x2_net6 VDD pfet_06v0 L=1.0u W=5.0u
Mx_core_x2_x4_x2_XM30_f2 x_core_x2_x4_x2_net12 x_core_x2_x4_net3 x_core_x2_x4_x2_net6 VDD pfet_06v0 L=1.0u W=5.0u
Mx_core_x2_x4_x2_XM31_f1 x_core_x2_x4_x2_net3 x_core_x2_x4_x2_net9 VDD VDD pfet_06v0 L=1.0u W=5u
Mx_core_x2_x4_x2_XM31_f2 x_core_x2_x4_x2_net3 x_core_x2_x4_x2_net9 VDD VDD pfet_06v0 L=1.0u W=5u
Mx_core_x2_x4_x2_XM31_f3 x_core_x2_x4_x2_net3 x_core_x2_x4_x2_net9 VDD VDD pfet_06v0 L=1.0u W=5u
Mx_core_x2_x4_x2_XM31_f4 x_core_x2_x4_x2_net3 x_core_x2_x4_x2_net9 VDD VDD pfet_06v0 L=1.0u W=5u
Mx_core_x2_x4_x2_XM35_f1 x_core_x2_x4_x2_net6 x_core_x2_x4_x2_net9 VDD VDD pfet_06v0 L=1.0u W=5.0u
Mx_core_x2_x4_x2_XM35_f2 x_core_x2_x4_x2_net6 x_core_x2_x4_x2_net9 VDD VDD pfet_06v0 L=1.0u W=5.0u
Mx_core_x2_x4_x2_XM35_f3 x_core_x2_x4_x2_net6 x_core_x2_x4_x2_net9 VDD VDD pfet_06v0 L=1.0u W=5.0u
Mx_core_x2_x4_x2_XM35_f4 x_core_x2_x4_x2_net6 x_core_x2_x4_x2_net9 VDD VDD pfet_06v0 L=1.0u W=5.0u
Mx_core_x2_x4_x2_XM32 x_core_x2_x4_x2_net10 x_core_x2_x4_x2_net21 x_core_x2_x4_x2_net9 VDD pfet_06v0 L=1.0u W=5u
Mx_core_x2_x4_x2_XM33 x_core_x2_x4_x2_net22 x_core_x2_x4_x2_net21 x_core_x2_x4_x2_net12 VDD pfet_06v0 L=1.0u W=5.0u
Mx_core_x2_x4_x2_XM23_f1 x_core_x2_x4_x2_net10 x_core_x2_x4_net2 x_core_x2_x4_x2_net4 VSS nfet_06v0 L=1.0u W=2.5u
Mx_core_x2_x4_x2_XM23_f2 x_core_x2_x4_x2_net10 x_core_x2_x4_net2 x_core_x2_x4_x2_net4 VSS nfet_06v0 L=1.0u W=2.5u
Mx_core_x2_x4_x2_XM24_f1 x_core_x2_x4_x2_net22 x_core_x2_x4_net2 x_core_x2_x4_x2_net5 VSS nfet_06v0 L=1.0u W=2.5u
Mx_core_x2_x4_x2_XM24_f2 x_core_x2_x4_x2_net22 x_core_x2_x4_net2 x_core_x2_x4_x2_net5 VSS nfet_06v0 L=1.0u W=2.5u
Mx_core_x2_x4_x2_XM25_f1 x_core_x2_x4_x2_net4 x_core_x2_x4_x2_net10 VSS VSS nfet_06v0 L=1.0u W=2.5u
Mx_core_x2_x4_x2_XM25_f2 x_core_x2_x4_x2_net4 x_core_x2_x4_x2_net10 VSS VSS nfet_06v0 L=1.0u W=2.5u
Mx_core_x2_x4_x2_XM25_f3 x_core_x2_x4_x2_net4 x_core_x2_x4_x2_net10 VSS VSS nfet_06v0 L=1.0u W=2.5u
Mx_core_x2_x4_x2_XM25_f4 x_core_x2_x4_x2_net4 x_core_x2_x4_x2_net10 VSS VSS nfet_06v0 L=1.0u W=2.5u
Mx_core_x2_x4_x2_XM26_f1 x_core_x2_x4_x2_net5 x_core_x2_x4_x2_net10 VSS VSS nfet_06v0 L=1.0u W=2.5u
Mx_core_x2_x4_x2_XM26_f2 x_core_x2_x4_x2_net5 x_core_x2_x4_x2_net10 VSS VSS nfet_06v0 L=1.0u W=2.5u
Mx_core_x2_x4_x2_XM26_f3 x_core_x2_x4_x2_net5 x_core_x2_x4_x2_net10 VSS VSS nfet_06v0 L=1.0u W=2.5u
Mx_core_x2_x4_x2_XM26_f4 x_core_x2_x4_x2_net5 x_core_x2_x4_x2_net10 VSS VSS nfet_06v0 L=1.0u W=2.5u
Mx_core_x2_x4_x2_XM27 x_core_x2_x4_x2_net9 x_core_x2_x4_x2_net11 x_core_x2_x4_x2_net10 VSS nfet_06v0 L=1.0u W=2.5u
Mx_core_x2_x4_x2_XM28 x_core_x2_x4_x2_net12 x_core_x2_x4_x2_net11 x_core_x2_x4_x2_net22 VSS nfet_06v0 L=1.0u W=2.5u
Mx_core_x2_x4_x2_XM34 x_core_x2_x4_x2_net13 x_core_x2_x4_x2_net14 VDD VDD pfet_06v0 L=1.0u W=10.0u
Mx_core_x2_x4_x2_XM36 x_core_x2_x4_x2_net14 x_core_x2_x4_net3 x_core_x2_x4_x2_net13 VDD pfet_06v0 L=1.0u W=10.0u
Mx_core_x2_x4_x2_XM37 x_core_x2_x4_x2_net21 x_core_x2_x4_x2_net21 x_core_x2_x4_x2_net14 VDD pfet_06v0 L=1.0u W=10.0u
Mx_core_x2_x4_x2_XM38 x_core_x2_x4_x2_net21 x_core_x2_x4_net2 x_core_x2_x4_x2_net15 VSS nfet_06v0 L=1.0u W=5.0u
Mx_core_x2_x4_x2_XM39 x_core_x2_x4_x2_net15 x_core_x2_x4_net1 VSS VSS nfet_06v0 L=1.0u W=5.0u
Mx_core_x2_x4_x2_XM45 x_core_x2_x4_x2_net16 x_core_x2_x4_net4 VDD VDD pfet_06v0 L=1.0u W=10.0u
Mx_core_x2_x4_x2_XM46 x_core_x2_x4_x2_net11 x_core_x2_x4_net3 x_core_x2_x4_x2_net16 VDD pfet_06v0 L=1.0u W=10.0u
Mx_core_x2_x4_x2_XM40 x_core_x2_x4_x2_net11 x_core_x2_x4_x2_net11 x_core_x2_x4_x2_net18 VSS nfet_06v0 L=1.0u W=5.0u
Mx_core_x2_x4_x2_XM41 x_core_x2_x4_x2_net18 x_core_x2_x4_net2 x_core_x2_x4_x2_net17 VSS nfet_06v0 L=1.0u W=5.0u
Mx_core_x2_x4_x2_XM42 x_core_x2_x4_x2_net17 x_core_x2_x4_x2_net18 VSS VSS nfet_06v0 L=1.0u W=5.0u
Mx_core_x2_x4_x2_XM43_f1 x_core_x2_net1 x_core_x2_x4_x2_net12 VDD VDD pfet_06v0 L=1.0u W=10u
Mx_core_x2_x4_x2_XM43_f2 x_core_x2_net1 x_core_x2_x4_x2_net12 VDD VDD pfet_06v0 L=1.0u W=10u
Mx_core_x2_x4_x2_XM43_f3 x_core_x2_net1 x_core_x2_x4_x2_net12 VDD VDD pfet_06v0 L=1.0u W=10u
Mx_core_x2_x4_x2_XM44_f1 x_core_x2_net1 x_core_x2_x4_x2_net22 VSS VSS nfet_06v0 L=1.0u W=5u
Mx_core_x2_x4_x2_XM44_f2 x_core_x2_net1 x_core_x2_x4_x2_net22 VSS VSS nfet_06v0 L=1.0u W=5u
Mx_core_x2_x4_x2_XM44_f3 x_core_x2_net1 x_core_x2_x4_x2_net22 VSS VSS nfet_06v0 L=1.0u W=5u
Mx_core_x2_x5_x1_XM4 x_core_x2_x5_x1_net3 x_core_x2_x5_net4 VDD VDD pfet_06v0 L=1.0u W=10.0u
Mx_core_x2_x5_x1_XM5 x_core_x2_x5_net2 x_core_x2_x5_net3 x_core_x2_x5_x1_net3 VDD pfet_06v0 L=1.0u W=10.0u
Mx_core_x2_x5_x1_XM6 x_core_x2_x5_net2 x_core_x2_x5_net2 VSS VSS nfet_06v0 L=1.0u W=1.0u
Mx_core_x2_x5_x1_XM7 x_core_x2_x5_x1_net2 x_core_x2_x5_net4 VDD VDD pfet_06v0 L=1.0u W=10.0u
Mx_core_x2_x5_x1_XM8 x_core_x2_x5_net1 x_core_x2_x5_net3 x_core_x2_x5_x1_net2 VDD pfet_06v0 L=1.0u W=10.0u
Mx_core_x2_x5_x1_XM9 x_core_x2_x5_net1 x_core_x2_x5_net2 x_core_x2_x5_x1_net1 VSS nfet_06v0 L=1.0u W=5.0u
Mx_core_x2_x5_x1_XM10 x_core_x2_x5_x1_net1 x_core_x2_x5_net1 VSS VSS nfet_06v0 L=1.0u W=5.0u
Mx_core_x2_x5_x1_XM1 x_core_x2_x5_net3 x_core_x2_x5_net3 VDD VDD pfet_06v0 L=1.0u W=2u
Mx_core_x2_x5_x1_XM2 x_core_x2_x5_x1_net4 x_core_x2_x5_net4 VDD VDD pfet_06v0 L=1.0u W=10.0u
Mx_core_x2_x5_x1_XM3 x_core_x2_x5_net4 x_core_x2_x5_net3 x_core_x2_x5_x1_net4 VDD pfet_06v0 L=1.0u W=10.0u
Mx_core_x2_x5_x1_XM47 x_core_x2_x5_x1_net5 x_core_x2_x5_net3 VSS VSS nfet_06v0 L=1.0u W=1.0u
Mx_core_x2_x5_x1_XM48 x_core_x2_x5_x1_net6 x_core_x2_x5_net3 VSS VSS nfet_06v0 L=1.0u W=1.0u
Mx_core_x2_x5_x1_XM49 x_core_x2_x5_net3 x_core_x2_x5_net3 x_core_x2_x5_x1_net6 VSS nfet_06v0 L=1.0u W=1.0u
Mx_core_x2_x5_x1_XM50 x_core_x2_x5_net4 x_core_x2_x5_net3 x_core_x2_x5_x1_net5 VSS nfet_06v0 L=1.0u W=1.0u
Mx_core_x2_x5_x2_XM11 x_core_x2_x5_x2_net2 x_core_x2_x5_net4 VDD VDD pfet_06v0 L=1.0u W=10.0u
Mx_core_x2_x5_x2_XM12 x_core_x2_x5_x2_net7 x_core_x2_x5_net3 x_core_x2_x5_x2_net2 VDD pfet_06v0 L=1.0u W=10.0u
Mx_core_x2_x5_x2_XM13 x_core_x2_x5_x2_net19 x_core_x2_x5_net4 VDD VDD pfet_06v0 L=1.0u W=10.0u
Mx_core_x2_x5_x2_XM14 x_core_x2_x5_x2_net7 x_core_x2_x5_net3 x_core_x2_x5_x2_net19 VDD pfet_06v0 L=1.0u W=10.0u
Mx_core_x2_x5_x2_XM15_f1 x_core_x2_x5_x2_net5 x_core_x2_SZ x_core_x2_x5_x2_net7 VDD pfet_06v0 L=1.0u W=10.0u
Mx_core_x2_x5_x2_XM15_f2 x_core_x2_x5_x2_net5 x_core_x2_SZ x_core_x2_x5_x2_net7 VDD pfet_06v0 L=1.0u W=10.0u
Mx_core_x2_x5_x2_XM16_f1 x_core_x2_x5_x2_net4 x_core_x2_SX x_core_x2_x5_x2_net7 VDD pfet_06v0 L=1.0u W=10.0u
Mx_core_x2_x5_x2_XM16_f2 x_core_x2_x5_x2_net4 x_core_x2_SX x_core_x2_x5_x2_net7 VDD pfet_06v0 L=1.0u W=10.0u
Mx_core_x2_x5_x2_XM17 x_core_x2_x5_x2_net8 x_core_x2_x5_net2 x_core_x2_x5_x2_net1 VSS nfet_06v0 L=1.0u W=5.0u
Mx_core_x2_x5_x2_XM18 x_core_x2_x5_x2_net1 x_core_x2_x5_net1 VSS VSS nfet_06v0 L=1.0u W=5.0u
Mx_core_x2_x5_x2_XM19 x_core_x2_x5_x2_net8 x_core_x2_x5_net2 x_core_x2_x5_x2_net20 VSS nfet_06v0 L=1.0u W=5.0u
Mx_core_x2_x5_x2_XM20 x_core_x2_x5_x2_net20 x_core_x2_x5_net1 VSS VSS nfet_06v0 L=1.0u W=5.0u
Mx_core_x2_x5_x2_XM21_f1 x_core_x2_x5_x2_net6 x_core_x2_SZ x_core_x2_x5_x2_net8 VSS nfet_06v0 L=1.0u W=5u
Mx_core_x2_x5_x2_XM21_f2 x_core_x2_x5_x2_net6 x_core_x2_SZ x_core_x2_x5_x2_net8 VSS nfet_06v0 L=1.0u W=5u
Mx_core_x2_x5_x2_XM22_f1 x_core_x2_x5_x2_net3 x_core_x2_SX x_core_x2_x5_x2_net8 VSS nfet_06v0 L=1.0u W=5u
Mx_core_x2_x5_x2_XM22_f2 x_core_x2_x5_x2_net3 x_core_x2_SX x_core_x2_x5_x2_net8 VSS nfet_06v0 L=1.0u W=5u
Mx_core_x2_x5_x2_XM29_f1 x_core_x2_x5_x2_net9 x_core_x2_x5_net3 x_core_x2_x5_x2_net3 VDD pfet_06v0 L=1.0u W=5u
Mx_core_x2_x5_x2_XM29_f2 x_core_x2_x5_x2_net9 x_core_x2_x5_net3 x_core_x2_x5_x2_net3 VDD pfet_06v0 L=1.0u W=5u
Mx_core_x2_x5_x2_XM30_f1 x_core_x2_x5_x2_net12 x_core_x2_x5_net3 x_core_x2_x5_x2_net6 VDD pfet_06v0 L=1.0u W=5.0u
Mx_core_x2_x5_x2_XM30_f2 x_core_x2_x5_x2_net12 x_core_x2_x5_net3 x_core_x2_x5_x2_net6 VDD pfet_06v0 L=1.0u W=5.0u
Mx_core_x2_x5_x2_XM31_f1 x_core_x2_x5_x2_net3 x_core_x2_x5_x2_net9 VDD VDD pfet_06v0 L=1.0u W=5u
Mx_core_x2_x5_x2_XM31_f2 x_core_x2_x5_x2_net3 x_core_x2_x5_x2_net9 VDD VDD pfet_06v0 L=1.0u W=5u
Mx_core_x2_x5_x2_XM31_f3 x_core_x2_x5_x2_net3 x_core_x2_x5_x2_net9 VDD VDD pfet_06v0 L=1.0u W=5u
Mx_core_x2_x5_x2_XM31_f4 x_core_x2_x5_x2_net3 x_core_x2_x5_x2_net9 VDD VDD pfet_06v0 L=1.0u W=5u
Mx_core_x2_x5_x2_XM35_f1 x_core_x2_x5_x2_net6 x_core_x2_x5_x2_net9 VDD VDD pfet_06v0 L=1.0u W=5.0u
Mx_core_x2_x5_x2_XM35_f2 x_core_x2_x5_x2_net6 x_core_x2_x5_x2_net9 VDD VDD pfet_06v0 L=1.0u W=5.0u
Mx_core_x2_x5_x2_XM35_f3 x_core_x2_x5_x2_net6 x_core_x2_x5_x2_net9 VDD VDD pfet_06v0 L=1.0u W=5.0u
Mx_core_x2_x5_x2_XM35_f4 x_core_x2_x5_x2_net6 x_core_x2_x5_x2_net9 VDD VDD pfet_06v0 L=1.0u W=5.0u
Mx_core_x2_x5_x2_XM32 x_core_x2_x5_x2_net10 x_core_x2_x5_x2_net21 x_core_x2_x5_x2_net9 VDD pfet_06v0 L=1.0u W=5u
Mx_core_x2_x5_x2_XM33 x_core_x2_x5_x2_net22 x_core_x2_x5_x2_net21 x_core_x2_x5_x2_net12 VDD pfet_06v0 L=1.0u W=5.0u
Mx_core_x2_x5_x2_XM23_f1 x_core_x2_x5_x2_net10 x_core_x2_x5_net2 x_core_x2_x5_x2_net4 VSS nfet_06v0 L=1.0u W=2.5u
Mx_core_x2_x5_x2_XM23_f2 x_core_x2_x5_x2_net10 x_core_x2_x5_net2 x_core_x2_x5_x2_net4 VSS nfet_06v0 L=1.0u W=2.5u
Mx_core_x2_x5_x2_XM24_f1 x_core_x2_x5_x2_net22 x_core_x2_x5_net2 x_core_x2_x5_x2_net5 VSS nfet_06v0 L=1.0u W=2.5u
Mx_core_x2_x5_x2_XM24_f2 x_core_x2_x5_x2_net22 x_core_x2_x5_net2 x_core_x2_x5_x2_net5 VSS nfet_06v0 L=1.0u W=2.5u
Mx_core_x2_x5_x2_XM25_f1 x_core_x2_x5_x2_net4 x_core_x2_x5_x2_net10 VSS VSS nfet_06v0 L=1.0u W=2.5u
Mx_core_x2_x5_x2_XM25_f2 x_core_x2_x5_x2_net4 x_core_x2_x5_x2_net10 VSS VSS nfet_06v0 L=1.0u W=2.5u
Mx_core_x2_x5_x2_XM25_f3 x_core_x2_x5_x2_net4 x_core_x2_x5_x2_net10 VSS VSS nfet_06v0 L=1.0u W=2.5u
Mx_core_x2_x5_x2_XM25_f4 x_core_x2_x5_x2_net4 x_core_x2_x5_x2_net10 VSS VSS nfet_06v0 L=1.0u W=2.5u
Mx_core_x2_x5_x2_XM26_f1 x_core_x2_x5_x2_net5 x_core_x2_x5_x2_net10 VSS VSS nfet_06v0 L=1.0u W=2.5u
Mx_core_x2_x5_x2_XM26_f2 x_core_x2_x5_x2_net5 x_core_x2_x5_x2_net10 VSS VSS nfet_06v0 L=1.0u W=2.5u
Mx_core_x2_x5_x2_XM26_f3 x_core_x2_x5_x2_net5 x_core_x2_x5_x2_net10 VSS VSS nfet_06v0 L=1.0u W=2.5u
Mx_core_x2_x5_x2_XM26_f4 x_core_x2_x5_x2_net5 x_core_x2_x5_x2_net10 VSS VSS nfet_06v0 L=1.0u W=2.5u
Mx_core_x2_x5_x2_XM27 x_core_x2_x5_x2_net9 x_core_x2_x5_x2_net11 x_core_x2_x5_x2_net10 VSS nfet_06v0 L=1.0u W=2.5u
Mx_core_x2_x5_x2_XM28 x_core_x2_x5_x2_net12 x_core_x2_x5_x2_net11 x_core_x2_x5_x2_net22 VSS nfet_06v0 L=1.0u W=2.5u
Mx_core_x2_x5_x2_XM34 x_core_x2_x5_x2_net13 x_core_x2_x5_x2_net14 VDD VDD pfet_06v0 L=1.0u W=10.0u
Mx_core_x2_x5_x2_XM36 x_core_x2_x5_x2_net14 x_core_x2_x5_net3 x_core_x2_x5_x2_net13 VDD pfet_06v0 L=1.0u W=10.0u
Mx_core_x2_x5_x2_XM37 x_core_x2_x5_x2_net21 x_core_x2_x5_x2_net21 x_core_x2_x5_x2_net14 VDD pfet_06v0 L=1.0u W=10.0u
Mx_core_x2_x5_x2_XM38 x_core_x2_x5_x2_net21 x_core_x2_x5_net2 x_core_x2_x5_x2_net15 VSS nfet_06v0 L=1.0u W=5.0u
Mx_core_x2_x5_x2_XM39 x_core_x2_x5_x2_net15 x_core_x2_x5_net1 VSS VSS nfet_06v0 L=1.0u W=5.0u
Mx_core_x2_x5_x2_XM45 x_core_x2_x5_x2_net16 x_core_x2_x5_net4 VDD VDD pfet_06v0 L=1.0u W=10.0u
Mx_core_x2_x5_x2_XM46 x_core_x2_x5_x2_net11 x_core_x2_x5_net3 x_core_x2_x5_x2_net16 VDD pfet_06v0 L=1.0u W=10.0u
Mx_core_x2_x5_x2_XM40 x_core_x2_x5_x2_net11 x_core_x2_x5_x2_net11 x_core_x2_x5_x2_net18 VSS nfet_06v0 L=1.0u W=5.0u
Mx_core_x2_x5_x2_XM41 x_core_x2_x5_x2_net18 x_core_x2_x5_net2 x_core_x2_x5_x2_net17 VSS nfet_06v0 L=1.0u W=5.0u
Mx_core_x2_x5_x2_XM42 x_core_x2_x5_x2_net17 x_core_x2_x5_x2_net18 VSS VSS nfet_06v0 L=1.0u W=5.0u
Mx_core_x2_x5_x2_XM43_f1 x_core_x2_net2 x_core_x2_x5_x2_net12 VDD VDD pfet_06v0 L=1.0u W=10u
Mx_core_x2_x5_x2_XM43_f2 x_core_x2_net2 x_core_x2_x5_x2_net12 VDD VDD pfet_06v0 L=1.0u W=10u
Mx_core_x2_x5_x2_XM43_f3 x_core_x2_net2 x_core_x2_x5_x2_net12 VDD VDD pfet_06v0 L=1.0u W=10u
Mx_core_x2_x5_x2_XM44_f1 x_core_x2_net2 x_core_x2_x5_x2_net22 VSS VSS nfet_06v0 L=1.0u W=5u
Mx_core_x2_x5_x2_XM44_f2 x_core_x2_net2 x_core_x2_x5_x2_net22 VSS VSS nfet_06v0 L=1.0u W=5u
Mx_core_x2_x5_x2_XM44_f3 x_core_x2_net2 x_core_x2_x5_x2_net22 VSS VSS nfet_06v0 L=1.0u W=5u
Mx_core_x2_x6_x1_XM4 x_core_x2_x6_x1_net3 x_core_x2_x6_net4 VDD VDD pfet_06v0 L=1.0u W=10.0u
Mx_core_x2_x6_x1_XM5 x_core_x2_x6_net2 x_core_x2_x6_net3 x_core_x2_x6_x1_net3 VDD pfet_06v0 L=1.0u W=10.0u
Mx_core_x2_x6_x1_XM6 x_core_x2_x6_net2 x_core_x2_x6_net2 VSS VSS nfet_06v0 L=1.0u W=1.0u
Mx_core_x2_x6_x1_XM7 x_core_x2_x6_x1_net2 x_core_x2_x6_net4 VDD VDD pfet_06v0 L=1.0u W=10.0u
Mx_core_x2_x6_x1_XM8 x_core_x2_x6_net1 x_core_x2_x6_net3 x_core_x2_x6_x1_net2 VDD pfet_06v0 L=1.0u W=10.0u
Mx_core_x2_x6_x1_XM9 x_core_x2_x6_net1 x_core_x2_x6_net2 x_core_x2_x6_x1_net1 VSS nfet_06v0 L=1.0u W=5.0u
Mx_core_x2_x6_x1_XM10 x_core_x2_x6_x1_net1 x_core_x2_x6_net1 VSS VSS nfet_06v0 L=1.0u W=5.0u
Mx_core_x2_x6_x1_XM1 x_core_x2_x6_net3 x_core_x2_x6_net3 VDD VDD pfet_06v0 L=1.0u W=2u
Mx_core_x2_x6_x1_XM2 x_core_x2_x6_x1_net4 x_core_x2_x6_net4 VDD VDD pfet_06v0 L=1.0u W=10.0u
Mx_core_x2_x6_x1_XM3 x_core_x2_x6_net4 x_core_x2_x6_net3 x_core_x2_x6_x1_net4 VDD pfet_06v0 L=1.0u W=10.0u
Mx_core_x2_x6_x1_XM47 x_core_x2_x6_x1_net5 x_core_x2_x6_net3 VSS VSS nfet_06v0 L=1.0u W=1.0u
Mx_core_x2_x6_x1_XM48 x_core_x2_x6_x1_net6 x_core_x2_x6_net3 VSS VSS nfet_06v0 L=1.0u W=1.0u
Mx_core_x2_x6_x1_XM49 x_core_x2_x6_net3 x_core_x2_x6_net3 x_core_x2_x6_x1_net6 VSS nfet_06v0 L=1.0u W=1.0u
Mx_core_x2_x6_x1_XM50 x_core_x2_x6_net4 x_core_x2_x6_net3 x_core_x2_x6_x1_net5 VSS nfet_06v0 L=1.0u W=1.0u
Mx_core_x2_x6_x2_XM11 x_core_x2_x6_x2_net2 x_core_x2_x6_net4 VDD VDD pfet_06v0 L=1.0u W=10.0u
Mx_core_x2_x6_x2_XM12 x_core_x2_x6_x2_net7 x_core_x2_x6_net3 x_core_x2_x6_x2_net2 VDD pfet_06v0 L=1.0u W=10.0u
Mx_core_x2_x6_x2_XM13 x_core_x2_x6_x2_net19 x_core_x2_x6_net4 VDD VDD pfet_06v0 L=1.0u W=10.0u
Mx_core_x2_x6_x2_XM14 x_core_x2_x6_x2_net7 x_core_x2_x6_net3 x_core_x2_x6_x2_net19 VDD pfet_06v0 L=1.0u W=10.0u
Mx_core_x2_x6_x2_XM15_f1 x_core_x2_x6_x2_net5 x_core_x2_SZ x_core_x2_x6_x2_net7 VDD pfet_06v0 L=1.0u W=10.0u
Mx_core_x2_x6_x2_XM15_f2 x_core_x2_x6_x2_net5 x_core_x2_SZ x_core_x2_x6_x2_net7 VDD pfet_06v0 L=1.0u W=10.0u
Mx_core_x2_x6_x2_XM16_f1 x_core_x2_x6_x2_net4 x_core_x2_SY x_core_x2_x6_x2_net7 VDD pfet_06v0 L=1.0u W=10.0u
Mx_core_x2_x6_x2_XM16_f2 x_core_x2_x6_x2_net4 x_core_x2_SY x_core_x2_x6_x2_net7 VDD pfet_06v0 L=1.0u W=10.0u
Mx_core_x2_x6_x2_XM17 x_core_x2_x6_x2_net8 x_core_x2_x6_net2 x_core_x2_x6_x2_net1 VSS nfet_06v0 L=1.0u W=5.0u
Mx_core_x2_x6_x2_XM18 x_core_x2_x6_x2_net1 x_core_x2_x6_net1 VSS VSS nfet_06v0 L=1.0u W=5.0u
Mx_core_x2_x6_x2_XM19 x_core_x2_x6_x2_net8 x_core_x2_x6_net2 x_core_x2_x6_x2_net20 VSS nfet_06v0 L=1.0u W=5.0u
Mx_core_x2_x6_x2_XM20 x_core_x2_x6_x2_net20 x_core_x2_x6_net1 VSS VSS nfet_06v0 L=1.0u W=5.0u
Mx_core_x2_x6_x2_XM21_f1 x_core_x2_x6_x2_net6 x_core_x2_SZ x_core_x2_x6_x2_net8 VSS nfet_06v0 L=1.0u W=5u
Mx_core_x2_x6_x2_XM21_f2 x_core_x2_x6_x2_net6 x_core_x2_SZ x_core_x2_x6_x2_net8 VSS nfet_06v0 L=1.0u W=5u
Mx_core_x2_x6_x2_XM22_f1 x_core_x2_x6_x2_net3 x_core_x2_SY x_core_x2_x6_x2_net8 VSS nfet_06v0 L=1.0u W=5u
Mx_core_x2_x6_x2_XM22_f2 x_core_x2_x6_x2_net3 x_core_x2_SY x_core_x2_x6_x2_net8 VSS nfet_06v0 L=1.0u W=5u
Mx_core_x2_x6_x2_XM29_f1 x_core_x2_x6_x2_net9 x_core_x2_x6_net3 x_core_x2_x6_x2_net3 VDD pfet_06v0 L=1.0u W=5u
Mx_core_x2_x6_x2_XM29_f2 x_core_x2_x6_x2_net9 x_core_x2_x6_net3 x_core_x2_x6_x2_net3 VDD pfet_06v0 L=1.0u W=5u
Mx_core_x2_x6_x2_XM30_f1 x_core_x2_x6_x2_net12 x_core_x2_x6_net3 x_core_x2_x6_x2_net6 VDD pfet_06v0 L=1.0u W=5.0u
Mx_core_x2_x6_x2_XM30_f2 x_core_x2_x6_x2_net12 x_core_x2_x6_net3 x_core_x2_x6_x2_net6 VDD pfet_06v0 L=1.0u W=5.0u
Mx_core_x2_x6_x2_XM31_f1 x_core_x2_x6_x2_net3 x_core_x2_x6_x2_net9 VDD VDD pfet_06v0 L=1.0u W=5u
Mx_core_x2_x6_x2_XM31_f2 x_core_x2_x6_x2_net3 x_core_x2_x6_x2_net9 VDD VDD pfet_06v0 L=1.0u W=5u
Mx_core_x2_x6_x2_XM31_f3 x_core_x2_x6_x2_net3 x_core_x2_x6_x2_net9 VDD VDD pfet_06v0 L=1.0u W=5u
Mx_core_x2_x6_x2_XM31_f4 x_core_x2_x6_x2_net3 x_core_x2_x6_x2_net9 VDD VDD pfet_06v0 L=1.0u W=5u
Mx_core_x2_x6_x2_XM35_f1 x_core_x2_x6_x2_net6 x_core_x2_x6_x2_net9 VDD VDD pfet_06v0 L=1.0u W=5.0u
Mx_core_x2_x6_x2_XM35_f2 x_core_x2_x6_x2_net6 x_core_x2_x6_x2_net9 VDD VDD pfet_06v0 L=1.0u W=5.0u
Mx_core_x2_x6_x2_XM35_f3 x_core_x2_x6_x2_net6 x_core_x2_x6_x2_net9 VDD VDD pfet_06v0 L=1.0u W=5.0u
Mx_core_x2_x6_x2_XM35_f4 x_core_x2_x6_x2_net6 x_core_x2_x6_x2_net9 VDD VDD pfet_06v0 L=1.0u W=5.0u
Mx_core_x2_x6_x2_XM32 x_core_x2_x6_x2_net10 x_core_x2_x6_x2_net21 x_core_x2_x6_x2_net9 VDD pfet_06v0 L=1.0u W=5u
Mx_core_x2_x6_x2_XM33 x_core_x2_x6_x2_net22 x_core_x2_x6_x2_net21 x_core_x2_x6_x2_net12 VDD pfet_06v0 L=1.0u W=5.0u
Mx_core_x2_x6_x2_XM23_f1 x_core_x2_x6_x2_net10 x_core_x2_x6_net2 x_core_x2_x6_x2_net4 VSS nfet_06v0 L=1.0u W=2.5u
Mx_core_x2_x6_x2_XM23_f2 x_core_x2_x6_x2_net10 x_core_x2_x6_net2 x_core_x2_x6_x2_net4 VSS nfet_06v0 L=1.0u W=2.5u
Mx_core_x2_x6_x2_XM24_f1 x_core_x2_x6_x2_net22 x_core_x2_x6_net2 x_core_x2_x6_x2_net5 VSS nfet_06v0 L=1.0u W=2.5u
Mx_core_x2_x6_x2_XM24_f2 x_core_x2_x6_x2_net22 x_core_x2_x6_net2 x_core_x2_x6_x2_net5 VSS nfet_06v0 L=1.0u W=2.5u
Mx_core_x2_x6_x2_XM25_f1 x_core_x2_x6_x2_net4 x_core_x2_x6_x2_net10 VSS VSS nfet_06v0 L=1.0u W=2.5u
Mx_core_x2_x6_x2_XM25_f2 x_core_x2_x6_x2_net4 x_core_x2_x6_x2_net10 VSS VSS nfet_06v0 L=1.0u W=2.5u
Mx_core_x2_x6_x2_XM25_f3 x_core_x2_x6_x2_net4 x_core_x2_x6_x2_net10 VSS VSS nfet_06v0 L=1.0u W=2.5u
Mx_core_x2_x6_x2_XM25_f4 x_core_x2_x6_x2_net4 x_core_x2_x6_x2_net10 VSS VSS nfet_06v0 L=1.0u W=2.5u
Mx_core_x2_x6_x2_XM26_f1 x_core_x2_x6_x2_net5 x_core_x2_x6_x2_net10 VSS VSS nfet_06v0 L=1.0u W=2.5u
Mx_core_x2_x6_x2_XM26_f2 x_core_x2_x6_x2_net5 x_core_x2_x6_x2_net10 VSS VSS nfet_06v0 L=1.0u W=2.5u
Mx_core_x2_x6_x2_XM26_f3 x_core_x2_x6_x2_net5 x_core_x2_x6_x2_net10 VSS VSS nfet_06v0 L=1.0u W=2.5u
Mx_core_x2_x6_x2_XM26_f4 x_core_x2_x6_x2_net5 x_core_x2_x6_x2_net10 VSS VSS nfet_06v0 L=1.0u W=2.5u
Mx_core_x2_x6_x2_XM27 x_core_x2_x6_x2_net9 x_core_x2_x6_x2_net11 x_core_x2_x6_x2_net10 VSS nfet_06v0 L=1.0u W=2.5u
Mx_core_x2_x6_x2_XM28 x_core_x2_x6_x2_net12 x_core_x2_x6_x2_net11 x_core_x2_x6_x2_net22 VSS nfet_06v0 L=1.0u W=2.5u
Mx_core_x2_x6_x2_XM34 x_core_x2_x6_x2_net13 x_core_x2_x6_x2_net14 VDD VDD pfet_06v0 L=1.0u W=10.0u
Mx_core_x2_x6_x2_XM36 x_core_x2_x6_x2_net14 x_core_x2_x6_net3 x_core_x2_x6_x2_net13 VDD pfet_06v0 L=1.0u W=10.0u
Mx_core_x2_x6_x2_XM37 x_core_x2_x6_x2_net21 x_core_x2_x6_x2_net21 x_core_x2_x6_x2_net14 VDD pfet_06v0 L=1.0u W=10.0u
Mx_core_x2_x6_x2_XM38 x_core_x2_x6_x2_net21 x_core_x2_x6_net2 x_core_x2_x6_x2_net15 VSS nfet_06v0 L=1.0u W=5.0u
Mx_core_x2_x6_x2_XM39 x_core_x2_x6_x2_net15 x_core_x2_x6_net1 VSS VSS nfet_06v0 L=1.0u W=5.0u
Mx_core_x2_x6_x2_XM45 x_core_x2_x6_x2_net16 x_core_x2_x6_net4 VDD VDD pfet_06v0 L=1.0u W=10.0u
Mx_core_x2_x6_x2_XM46 x_core_x2_x6_x2_net11 x_core_x2_x6_net3 x_core_x2_x6_x2_net16 VDD pfet_06v0 L=1.0u W=10.0u
Mx_core_x2_x6_x2_XM40 x_core_x2_x6_x2_net11 x_core_x2_x6_x2_net11 x_core_x2_x6_x2_net18 VSS nfet_06v0 L=1.0u W=5.0u
Mx_core_x2_x6_x2_XM41 x_core_x2_x6_x2_net18 x_core_x2_x6_net2 x_core_x2_x6_x2_net17 VSS nfet_06v0 L=1.0u W=5.0u
Mx_core_x2_x6_x2_XM42 x_core_x2_x6_x2_net17 x_core_x2_x6_x2_net18 VSS VSS nfet_06v0 L=1.0u W=5.0u
Mx_core_x2_x6_x2_XM43_f1 x_core_x2_net3 x_core_x2_x6_x2_net12 VDD VDD pfet_06v0 L=1.0u W=10u
Mx_core_x2_x6_x2_XM43_f2 x_core_x2_net3 x_core_x2_x6_x2_net12 VDD VDD pfet_06v0 L=1.0u W=10u
Mx_core_x2_x6_x2_XM43_f3 x_core_x2_net3 x_core_x2_x6_x2_net12 VDD VDD pfet_06v0 L=1.0u W=10u
Mx_core_x2_x6_x2_XM44_f1 x_core_x2_net3 x_core_x2_x6_x2_net22 VSS VSS nfet_06v0 L=1.0u W=5u
Mx_core_x2_x6_x2_XM44_f2 x_core_x2_net3 x_core_x2_x6_x2_net22 VSS VSS nfet_06v0 L=1.0u W=5u
Mx_core_x2_x6_x2_XM44_f3 x_core_x2_net3 x_core_x2_x6_x2_net22 VSS VSS nfet_06v0 L=1.0u W=5u
Mx_core_x2_x7_x2_x2_XM4 x_core_x2_x7_x2_net1 x_core_x2_net1 VDD VDD pfet_06v0 L=1.0u W=3.0u
Mx_core_x2_x7_x2_x2_XM5 VSS x_core_x2_net1 x_core_x2_x7_x2_net1 VSS nfet_06v0 L=1u W=1u
Mx_core_x2_x7_x2_x3_XM4 x_core_Y2 x_core_x2_x7_x2_x3_net1 VDD VDD pfet_06v0 L=1.0u W=3.0u
Mx_core_x2_x7_x2_x3_XM5 VSS x_core_x2_x7_x2_x3_net1 x_core_Y2 VSS nfet_06v0 L=1u W=1u
Mx_core_x2_x7_x2_x3_XM2 VDD x_core_x2_net3 x_core_x2_x7_x2_x3_net1 VDD pfet_06v0 L=1.0u W=3.0u
Mx_core_x2_x7_x2_x3_XM1 VDD x_core_x2_x7_x2_net1 x_core_x2_x7_x2_x3_net1 VDD pfet_06v0 L=1.0u W=3.0u
Mx_core_x2_x7_x2_x3_XM3 VSS x_core_x2_net3 x_core_x2_x7_x2_x3_net2 VSS nfet_06v0 L=1u W=1u
Mx_core_x2_x7_x2_x3_XM6 x_core_x2_x7_x2_x3_net2 x_core_x2_x7_x2_net1 x_core_x2_x7_x2_x3_net1 VSS nfet_06v0 L=1u W=1u
Mx_core_x2_x7_x1_XM4 x_core_x2_x7_x1_net1 x_core_x2_net3 x_core_Z2 VDD pfet_06v0 L=1.0u W=3.0u
Mx_core_x2_x7_x1_XM5 VDD x_core_x2_net2 x_core_x2_x7_x1_net1 VDD pfet_06v0 L=1.0u W=3.0u
Mx_core_x2_x7_x1_XM7 VSS x_core_x2_net3 x_core_Z2 VSS nfet_06v0 L=1u W=1u
Mx_core_x2_x7_x1_XM1 VSS x_core_x2_net2 x_core_Z2 VSS nfet_06v0 L=1u W=1u
Mx_core_x2_x7_x3_x2_XM4 x_core_X2 x_core_x2_x7_x3_x2_net1 VDD VDD pfet_06v0 L=1.0u W=3.0u
Mx_core_x2_x7_x3_x2_XM5 VSS x_core_x2_x7_x3_x2_net1 x_core_X2 VSS nfet_06v0 L=1u W=1u
Mx_core_x2_x7_x3_x2_XM2 VDD x_core_x2_net1 x_core_x2_x7_x3_x2_net1 VDD pfet_06v0 L=1.0u W=3.0u
Mx_core_x2_x7_x3_x2_XM1 VDD x_core_x2_net2 x_core_x2_x7_x3_x2_net1 VDD pfet_06v0 L=1.0u W=3.0u
Mx_core_x2_x7_x3_x2_XM3 VSS x_core_x2_net1 x_core_x2_x7_x3_x2_net2 VSS nfet_06v0 L=1u W=1u
Mx_core_x2_x7_x3_x2_XM6 x_core_x2_x7_x3_x2_net2 x_core_x2_net2 x_core_x2_x7_x3_x2_net1 VSS nfet_06v0 L=1u W=1u
Mx_core_x2_x8_x1_XM4 x_core_x2_x8_x1_net3 x_core_x2_x8_net3 VDD VDD pfet_06v0 L=1.0u W=10.0u
Mx_core_x2_x8_x1_XM5 x_core_x2_x8_net2 x_core_x2_x8_net4 x_core_x2_x8_x1_net3 VDD pfet_06v0 L=1.0u W=10.0u
Mx_core_x2_x8_x1_XM6 x_core_x2_x8_net2 x_core_x2_x8_net2 VSS VSS nfet_06v0 L=1.0u W=1.0u
Mx_core_x2_x8_x1_XM7 x_core_x2_x8_x1_net2 x_core_x2_x8_net3 VDD VDD pfet_06v0 L=1.0u W=10.0u
Mx_core_x2_x8_x1_XM8 x_core_x2_x8_net1 x_core_x2_x8_net4 x_core_x2_x8_x1_net2 VDD pfet_06v0 L=1.0u W=10.0u
Mx_core_x2_x8_x1_XM9 x_core_x2_x8_net1 x_core_x2_x8_net2 x_core_x2_x8_x1_net1 VSS nfet_06v0 L=1.0u W=5.0u
Mx_core_x2_x8_x1_XM10 x_core_x2_x8_x1_net1 x_core_x2_x8_net1 VSS VSS nfet_06v0 L=1.0u W=5.0u
Mx_core_x2_x8_x1_XM1 x_core_x2_x8_net4 x_core_x2_x8_net4 VDD VDD pfet_06v0 L=1.0u W=2u
Mx_core_x2_x8_x1_XM2 x_core_x2_x8_x1_net4 x_core_x2_x8_net3 VDD VDD pfet_06v0 L=1.0u W=10.0u
Mx_core_x2_x8_x1_XM3 x_core_x2_x8_net3 x_core_x2_x8_net4 x_core_x2_x8_x1_net4 VDD pfet_06v0 L=1.0u W=10.0u
Mx_core_x2_x8_x1_XM47 x_core_x2_x8_x1_net5 x_core_x2_x8_net4 VSS VSS nfet_06v0 L=1.0u W=1.0u
Mx_core_x2_x8_x1_XM48 x_core_x2_x8_x1_net6 x_core_x2_x8_net4 VSS VSS nfet_06v0 L=1.0u W=1.0u
Mx_core_x2_x8_x1_XM49 x_core_x2_x8_net4 x_core_x2_x8_net4 x_core_x2_x8_x1_net6 VSS nfet_06v0 L=1.0u W=1.0u
Mx_core_x2_x8_x1_XM50 x_core_x2_x8_net3 x_core_x2_x8_net4 x_core_x2_x8_x1_net5 VSS nfet_06v0 L=1.0u W=1.0u
Mx_core_x2_x8_x2_XM11 x_core_x2_x8_x2_net2 x_core_x2_x8_net3 VDD VDD pfet_06v0 L=1.0u W=10.0u
Mx_core_x2_x8_x2_XM12 x_core_x2_x8_x2_net7 x_core_x2_x8_net4 x_core_x2_x8_x2_net2 VDD pfet_06v0 L=1.0u W=10.0u
Mx_core_x2_x8_x2_XM13 x_core_x2_x8_x2_net18 x_core_x2_x8_net3 VDD VDD pfet_06v0 L=1.0u W=10.0u
Mx_core_x2_x8_x2_XM14 x_core_x2_x8_x2_net7 x_core_x2_x8_net4 x_core_x2_x8_x2_net18 VDD pfet_06v0 L=1.0u W=10.0u
Mx_core_x2_x8_x2_XM15 x_core_x2_x8_x2_net5 S4P_I x_core_x2_x8_x2_net7 VDD pfet_06v0 L=1.0u W=0.55u
Mx_core_x2_x8_x2_XM16 x_core_x2_x8_x2_net4 S4N_I x_core_x2_x8_x2_net7 VDD pfet_06v0 L=1.0u W=0.5u
Mx_core_x2_x8_x2_XM17 x_core_x2_x8_x2_net8 x_core_x2_x8_net2 x_core_x2_x8_x2_net1 VSS nfet_06v0 L=1.0u W=5.0u
Mx_core_x2_x8_x2_XM18 x_core_x2_x8_x2_net1 x_core_x2_x8_net1 VSS VSS nfet_06v0 L=1.0u W=5.0u
Mx_core_x2_x8_x2_XM19 x_core_x2_x8_x2_net8 x_core_x2_x8_net2 x_core_x2_x8_x2_net19 VSS nfet_06v0 L=1.0u W=5.0u
Mx_core_x2_x8_x2_XM20 x_core_x2_x8_x2_net19 x_core_x2_x8_net1 VSS VSS nfet_06v0 L=1.0u W=5.0u
Mx_core_x2_x8_x2_XM21 x_core_x2_x8_x2_net6 S4P_I x_core_x2_x8_x2_net8 VSS nfet_06v0 L=1.0u W=7.5u
Mx_core_x2_x8_x2_XM22 x_core_x2_x8_x2_net3 S4N_I x_core_x2_x8_x2_net8 VSS nfet_06v0 L=1.0u W=8.5u
Mx_core_x2_x8_x2_XM29 x_core_x2_x8_x2_net9 x_core_x2_x8_net4 x_core_x2_x8_x2_net3 VDD pfet_06v0 L=1.0u W=10u
Mx_core_x2_x8_x2_XM30 x_core_x2_x8_x2_G_OUT_P x_core_x2_x8_net4 x_core_x2_x8_x2_net6 VDD pfet_06v0 L=1.0u W=10u
Mx_core_x2_x8_x2_XM31 x_core_x2_x8_x2_net3 x_core_x2_x8_x2_net9 VDD VDD pfet_06v0 L=1.0u W=5u
Mx_core_x2_x8_x2_XM35 x_core_x2_x8_x2_net6 x_core_x2_x8_x2_net9 VDD VDD pfet_06v0 L=1.0u W=5u
Mx_core_x2_x8_x2_XM32 x_core_x2_x8_x2_net10 x_core_x2_x8_x2_net20 x_core_x2_x8_x2_net9 VDD pfet_06v0 L=1.0u W=4.0u
Mx_core_x2_x8_x2_XM33 x_core_x2_x8_x2_net21 x_core_x2_x8_x2_net20 x_core_x2_x8_x2_G_OUT_P VDD pfet_06v0 L=1.0u W=4.0u
Mx_core_x2_x8_x2_XM23 x_core_x2_x8_x2_net10 x_core_x2_x8_net2 x_core_x2_x8_x2_net4 VSS nfet_06v0 L=1.0u W=2.5u
Mx_core_x2_x8_x2_XM24 x_core_x2_x8_x2_net21 x_core_x2_x8_net2 x_core_x2_x8_x2_net5 VSS nfet_06v0 L=1.0u W=2.5u
Mx_core_x2_x8_x2_XM25 x_core_x2_x8_x2_net4 x_core_x2_x8_x2_net10 VSS VSS nfet_06v0 L=1.0u W=2.5u
Mx_core_x2_x8_x2_XM26 x_core_x2_x8_x2_net5 x_core_x2_x8_x2_net10 VSS VSS nfet_06v0 L=1.0u W=2.5u
Mx_core_x2_x8_x2_XM27 x_core_x2_x8_x2_net9 x_core_x2_x8_x2_net11 x_core_x2_x8_x2_net10 VSS nfet_06v0 L=1.0u W=2.0u
Mx_core_x2_x8_x2_XM28 x_core_x2_x8_x2_G_OUT_P x_core_x2_x8_x2_net11 x_core_x2_x8_x2_net21 VSS nfet_06v0 L=1.0u W=2.0u
Mx_core_x2_x8_x2_XM34 x_core_x2_x8_x2_net12 x_core_x2_x8_x2_net13 VDD VDD pfet_06v0 L=1.0u W=10.0u
Mx_core_x2_x8_x2_XM36 x_core_x2_x8_x2_net13 x_core_x2_x8_net4 x_core_x2_x8_x2_net12 VDD pfet_06v0 L=1.0u W=10.0u
Mx_core_x2_x8_x2_XM37 x_core_x2_x8_x2_net20 x_core_x2_x8_x2_net20 x_core_x2_x8_x2_net13 VDD pfet_06v0 L=1.0u W=10.0u
Mx_core_x2_x8_x2_XM38 x_core_x2_x8_x2_net20 x_core_x2_x8_net2 x_core_x2_x8_x2_net14 VSS nfet_06v0 L=1.0u W=5.0u
Mx_core_x2_x8_x2_XM39 x_core_x2_x8_x2_net14 x_core_x2_x8_net1 VSS VSS nfet_06v0 L=1.0u W=5.0u
Mx_core_x2_x8_x2_XM45 x_core_x2_x8_x2_net15 x_core_x2_x8_net3 VDD VDD pfet_06v0 L=1.0u W=10.0u
Mx_core_x2_x8_x2_XM46 x_core_x2_x8_x2_net11 x_core_x2_x8_net4 x_core_x2_x8_x2_net15 VDD pfet_06v0 L=1.0u W=10.0u
Mx_core_x2_x8_x2_XM40 x_core_x2_x8_x2_net11 x_core_x2_x8_x2_net11 x_core_x2_x8_x2_net17 VSS nfet_06v0 L=1.0u W=5.0u
Mx_core_x2_x8_x2_XM41 x_core_x2_x8_x2_net17 x_core_x2_x8_net2 x_core_x2_x8_x2_net16 VSS nfet_06v0 L=1.0u W=5.0u
Mx_core_x2_x8_x2_XM42 x_core_x2_x8_x2_net16 x_core_x2_x8_x2_net17 VSS VSS nfet_06v0 L=1.0u W=5.0u
Mx_core_x2_x8_x2_XM43_m1 x_core_x2_SX x_core_x2_x8_x2_G_OUT_P VDD VDD pfet_06v0 L=1.0u W=1.0u
Mx_core_x2_x8_x2_XM43_m2 x_core_x2_SX x_core_x2_x8_x2_G_OUT_P VDD VDD pfet_06v0 L=1.0u W=1.0u
Mx_core_x2_x8_x2_XM43_m3 x_core_x2_SX x_core_x2_x8_x2_G_OUT_P VDD VDD pfet_06v0 L=1.0u W=1.0u
Mx_core_x2_x8_x2_XM43_m4 x_core_x2_SX x_core_x2_x8_x2_G_OUT_P VDD VDD pfet_06v0 L=1.0u W=1.0u
Mx_core_x2_x8_x2_XM44 x_core_x2_SX x_core_x2_x8_x2_net21 VSS VSS nfet_06v0 L=1.0u W=1.0u
Mx_core_x2_x1_x1_XM4 x_core_x2_x1_x1_net3 x_core_x2_x1_net3 VDD VDD pfet_06v0 L=1.0u W=10.0u
Mx_core_x2_x1_x1_XM5 x_core_x2_x1_net2 x_core_x2_x1_net4 x_core_x2_x1_x1_net3 VDD pfet_06v0 L=1.0u W=10.0u
Mx_core_x2_x1_x1_XM6 x_core_x2_x1_net2 x_core_x2_x1_net2 VSS VSS nfet_06v0 L=1.0u W=1.0u
Mx_core_x2_x1_x1_XM7 x_core_x2_x1_x1_net2 x_core_x2_x1_net3 VDD VDD pfet_06v0 L=1.0u W=10.0u
Mx_core_x2_x1_x1_XM8 x_core_x2_x1_net1 x_core_x2_x1_net4 x_core_x2_x1_x1_net2 VDD pfet_06v0 L=1.0u W=10.0u
Mx_core_x2_x1_x1_XM9 x_core_x2_x1_net1 x_core_x2_x1_net2 x_core_x2_x1_x1_net1 VSS nfet_06v0 L=1.0u W=5.0u
Mx_core_x2_x1_x1_XM10 x_core_x2_x1_x1_net1 x_core_x2_x1_net1 VSS VSS nfet_06v0 L=1.0u W=5.0u
Mx_core_x2_x1_x1_XM1 x_core_x2_x1_net4 x_core_x2_x1_net4 VDD VDD pfet_06v0 L=1.0u W=2u
Mx_core_x2_x1_x1_XM2 x_core_x2_x1_x1_net4 x_core_x2_x1_net3 VDD VDD pfet_06v0 L=1.0u W=10.0u
Mx_core_x2_x1_x1_XM3 x_core_x2_x1_net3 x_core_x2_x1_net4 x_core_x2_x1_x1_net4 VDD pfet_06v0 L=1.0u W=10.0u
Mx_core_x2_x1_x1_XM47 x_core_x2_x1_x1_net5 x_core_x2_x1_net4 VSS VSS nfet_06v0 L=1.0u W=1.0u
Mx_core_x2_x1_x1_XM48 x_core_x2_x1_x1_net6 x_core_x2_x1_net4 VSS VSS nfet_06v0 L=1.0u W=1.0u
Mx_core_x2_x1_x1_XM49 x_core_x2_x1_net4 x_core_x2_x1_net4 x_core_x2_x1_x1_net6 VSS nfet_06v0 L=1.0u W=1.0u
Mx_core_x2_x1_x1_XM50 x_core_x2_x1_net3 x_core_x2_x1_net4 x_core_x2_x1_x1_net5 VSS nfet_06v0 L=1.0u W=1.0u
Mx_core_x2_x1_x2_XM11 x_core_x2_x1_x2_net2 x_core_x2_x1_net3 VDD VDD pfet_06v0 L=1.0u W=10.0u
Mx_core_x2_x1_x2_XM12 x_core_x2_x1_x2_net7 x_core_x2_x1_net4 x_core_x2_x1_x2_net2 VDD pfet_06v0 L=1.0u W=10.0u
Mx_core_x2_x1_x2_XM13 x_core_x2_x1_x2_net18 x_core_x2_x1_net3 VDD VDD pfet_06v0 L=1.0u W=10.0u
Mx_core_x2_x1_x2_XM14 x_core_x2_x1_x2_net7 x_core_x2_x1_net4 x_core_x2_x1_x2_net18 VDD pfet_06v0 L=1.0u W=10.0u
Mx_core_x2_x1_x2_XM15 x_core_x2_x1_x2_net5 S1P_I x_core_x2_x1_x2_net7 VDD pfet_06v0 L=1.0u W=0.55u
Mx_core_x2_x1_x2_XM16 x_core_x2_x1_x2_net4 S1N_I x_core_x2_x1_x2_net7 VDD pfet_06v0 L=1.0u W=0.5u
Mx_core_x2_x1_x2_XM17 x_core_x2_x1_x2_net8 x_core_x2_x1_net2 x_core_x2_x1_x2_net1 VSS nfet_06v0 L=1.0u W=5.0u
Mx_core_x2_x1_x2_XM18 x_core_x2_x1_x2_net1 x_core_x2_x1_net1 VSS VSS nfet_06v0 L=1.0u W=5.0u
Mx_core_x2_x1_x2_XM19 x_core_x2_x1_x2_net8 x_core_x2_x1_net2 x_core_x2_x1_x2_net19 VSS nfet_06v0 L=1.0u W=5.0u
Mx_core_x2_x1_x2_XM20 x_core_x2_x1_x2_net19 x_core_x2_x1_net1 VSS VSS nfet_06v0 L=1.0u W=5.0u
Mx_core_x2_x1_x2_XM21 x_core_x2_x1_x2_net6 S1P_I x_core_x2_x1_x2_net8 VSS nfet_06v0 L=1.0u W=7.5u
Mx_core_x2_x1_x2_XM22 x_core_x2_x1_x2_net3 S1N_I x_core_x2_x1_x2_net8 VSS nfet_06v0 L=1.0u W=8.5u
Mx_core_x2_x1_x2_XM29 x_core_x2_x1_x2_net9 x_core_x2_x1_net4 x_core_x2_x1_x2_net3 VDD pfet_06v0 L=1.0u W=10u
Mx_core_x2_x1_x2_XM30 x_core_x2_x1_x2_G_OUT_P x_core_x2_x1_net4 x_core_x2_x1_x2_net6 VDD pfet_06v0 L=1.0u W=10u
Mx_core_x2_x1_x2_XM31 x_core_x2_x1_x2_net3 x_core_x2_x1_x2_net9 VDD VDD pfet_06v0 L=1.0u W=5u
Mx_core_x2_x1_x2_XM35 x_core_x2_x1_x2_net6 x_core_x2_x1_x2_net9 VDD VDD pfet_06v0 L=1.0u W=5u
Mx_core_x2_x1_x2_XM32 x_core_x2_x1_x2_net10 x_core_x2_x1_x2_net20 x_core_x2_x1_x2_net9 VDD pfet_06v0 L=1.0u W=4.0u
Mx_core_x2_x1_x2_XM33 x_core_x2_x1_x2_net21 x_core_x2_x1_x2_net20 x_core_x2_x1_x2_G_OUT_P VDD pfet_06v0 L=1.0u W=4.0u
Mx_core_x2_x1_x2_XM23 x_core_x2_x1_x2_net10 x_core_x2_x1_net2 x_core_x2_x1_x2_net4 VSS nfet_06v0 L=1.0u W=2.5u
Mx_core_x2_x1_x2_XM24 x_core_x2_x1_x2_net21 x_core_x2_x1_net2 x_core_x2_x1_x2_net5 VSS nfet_06v0 L=1.0u W=2.5u
Mx_core_x2_x1_x2_XM25 x_core_x2_x1_x2_net4 x_core_x2_x1_x2_net10 VSS VSS nfet_06v0 L=1.0u W=2.5u
Mx_core_x2_x1_x2_XM26 x_core_x2_x1_x2_net5 x_core_x2_x1_x2_net10 VSS VSS nfet_06v0 L=1.0u W=2.5u
Mx_core_x2_x1_x2_XM27 x_core_x2_x1_x2_net9 x_core_x2_x1_x2_net11 x_core_x2_x1_x2_net10 VSS nfet_06v0 L=1.0u W=2.0u
Mx_core_x2_x1_x2_XM28 x_core_x2_x1_x2_G_OUT_P x_core_x2_x1_x2_net11 x_core_x2_x1_x2_net21 VSS nfet_06v0 L=1.0u W=2.0u
Mx_core_x2_x1_x2_XM34 x_core_x2_x1_x2_net12 x_core_x2_x1_x2_net13 VDD VDD pfet_06v0 L=1.0u W=10.0u
Mx_core_x2_x1_x2_XM36 x_core_x2_x1_x2_net13 x_core_x2_x1_net4 x_core_x2_x1_x2_net12 VDD pfet_06v0 L=1.0u W=10.0u
Mx_core_x2_x1_x2_XM37 x_core_x2_x1_x2_net20 x_core_x2_x1_x2_net20 x_core_x2_x1_x2_net13 VDD pfet_06v0 L=1.0u W=10.0u
Mx_core_x2_x1_x2_XM38 x_core_x2_x1_x2_net20 x_core_x2_x1_net2 x_core_x2_x1_x2_net14 VSS nfet_06v0 L=1.0u W=5.0u
Mx_core_x2_x1_x2_XM39 x_core_x2_x1_x2_net14 x_core_x2_x1_net1 VSS VSS nfet_06v0 L=1.0u W=5.0u
Mx_core_x2_x1_x2_XM45 x_core_x2_x1_x2_net15 x_core_x2_x1_net3 VDD VDD pfet_06v0 L=1.0u W=10.0u
Mx_core_x2_x1_x2_XM46 x_core_x2_x1_x2_net11 x_core_x2_x1_net4 x_core_x2_x1_x2_net15 VDD pfet_06v0 L=1.0u W=10.0u
Mx_core_x2_x1_x2_XM40 x_core_x2_x1_x2_net11 x_core_x2_x1_x2_net11 x_core_x2_x1_x2_net17 VSS nfet_06v0 L=1.0u W=5.0u
Mx_core_x2_x1_x2_XM41 x_core_x2_x1_x2_net17 x_core_x2_x1_net2 x_core_x2_x1_x2_net16 VSS nfet_06v0 L=1.0u W=5.0u
Mx_core_x2_x1_x2_XM42 x_core_x2_x1_x2_net16 x_core_x2_x1_x2_net17 VSS VSS nfet_06v0 L=1.0u W=5.0u
Mx_core_x2_x1_x2_XM43_m1 x_core_x2_SY x_core_x2_x1_x2_G_OUT_P VDD VDD pfet_06v0 L=1.0u W=1.0u
Mx_core_x2_x1_x2_XM43_m2 x_core_x2_SY x_core_x2_x1_x2_G_OUT_P VDD VDD pfet_06v0 L=1.0u W=1.0u
Mx_core_x2_x1_x2_XM43_m3 x_core_x2_SY x_core_x2_x1_x2_G_OUT_P VDD VDD pfet_06v0 L=1.0u W=1.0u
Mx_core_x2_x1_x2_XM43_m4 x_core_x2_SY x_core_x2_x1_x2_G_OUT_P VDD VDD pfet_06v0 L=1.0u W=1.0u
Mx_core_x2_x1_x2_XM44 x_core_x2_SY x_core_x2_x1_x2_net21 VSS VSS nfet_06v0 L=1.0u W=1.0u
Mx_core_x2_x2_x1_XM4 x_core_x2_x2_x1_net3 x_core_x2_x2_net3 VDD VDD pfet_06v0 L=1.0u W=10.0u
Mx_core_x2_x2_x1_XM5 x_core_x2_x2_net2 x_core_x2_x2_net4 x_core_x2_x2_x1_net3 VDD pfet_06v0 L=1.0u W=10.0u
Mx_core_x2_x2_x1_XM6 x_core_x2_x2_net2 x_core_x2_x2_net2 VSS VSS nfet_06v0 L=1.0u W=1.0u
Mx_core_x2_x2_x1_XM7 x_core_x2_x2_x1_net2 x_core_x2_x2_net3 VDD VDD pfet_06v0 L=1.0u W=10.0u
Mx_core_x2_x2_x1_XM8 x_core_x2_x2_net1 x_core_x2_x2_net4 x_core_x2_x2_x1_net2 VDD pfet_06v0 L=1.0u W=10.0u
Mx_core_x2_x2_x1_XM9 x_core_x2_x2_net1 x_core_x2_x2_net2 x_core_x2_x2_x1_net1 VSS nfet_06v0 L=1.0u W=5.0u
Mx_core_x2_x2_x1_XM10 x_core_x2_x2_x1_net1 x_core_x2_x2_net1 VSS VSS nfet_06v0 L=1.0u W=5.0u
Mx_core_x2_x2_x1_XM1 x_core_x2_x2_net4 x_core_x2_x2_net4 VDD VDD pfet_06v0 L=1.0u W=2u
Mx_core_x2_x2_x1_XM2 x_core_x2_x2_x1_net4 x_core_x2_x2_net3 VDD VDD pfet_06v0 L=1.0u W=10.0u
Mx_core_x2_x2_x1_XM3 x_core_x2_x2_net3 x_core_x2_x2_net4 x_core_x2_x2_x1_net4 VDD pfet_06v0 L=1.0u W=10.0u
Mx_core_x2_x2_x1_XM47 x_core_x2_x2_x1_net5 x_core_x2_x2_net4 VSS VSS nfet_06v0 L=1.0u W=1.0u
Mx_core_x2_x2_x1_XM48 x_core_x2_x2_x1_net6 x_core_x2_x2_net4 VSS VSS nfet_06v0 L=1.0u W=1.0u
Mx_core_x2_x2_x1_XM49 x_core_x2_x2_net4 x_core_x2_x2_net4 x_core_x2_x2_x1_net6 VSS nfet_06v0 L=1.0u W=1.0u
Mx_core_x2_x2_x1_XM50 x_core_x2_x2_net3 x_core_x2_x2_net4 x_core_x2_x2_x1_net5 VSS nfet_06v0 L=1.0u W=1.0u
Mx_core_x2_x2_x2_XM11 x_core_x2_x2_x2_net2 x_core_x2_x2_net3 VDD VDD pfet_06v0 L=1.0u W=10.0u
Mx_core_x2_x2_x2_XM12 x_core_x2_x2_x2_net7 x_core_x2_x2_net4 x_core_x2_x2_x2_net2 VDD pfet_06v0 L=1.0u W=10.0u
Mx_core_x2_x2_x2_XM13 x_core_x2_x2_x2_net18 x_core_x2_x2_net3 VDD VDD pfet_06v0 L=1.0u W=10.0u
Mx_core_x2_x2_x2_XM14 x_core_x2_x2_x2_net7 x_core_x2_x2_net4 x_core_x2_x2_x2_net18 VDD pfet_06v0 L=1.0u W=10.0u
Mx_core_x2_x2_x2_XM15 x_core_x2_x2_x2_net5 S2P_I x_core_x2_x2_x2_net7 VDD pfet_06v0 L=1.0u W=0.55u
Mx_core_x2_x2_x2_XM16 x_core_x2_x2_x2_net4 S2N_I x_core_x2_x2_x2_net7 VDD pfet_06v0 L=1.0u W=0.5u
Mx_core_x2_x2_x2_XM17 x_core_x2_x2_x2_net8 x_core_x2_x2_net2 x_core_x2_x2_x2_net1 VSS nfet_06v0 L=1.0u W=5.0u
Mx_core_x2_x2_x2_XM18 x_core_x2_x2_x2_net1 x_core_x2_x2_net1 VSS VSS nfet_06v0 L=1.0u W=5.0u
Mx_core_x2_x2_x2_XM19 x_core_x2_x2_x2_net8 x_core_x2_x2_net2 x_core_x2_x2_x2_net19 VSS nfet_06v0 L=1.0u W=5.0u
Mx_core_x2_x2_x2_XM20 x_core_x2_x2_x2_net19 x_core_x2_x2_net1 VSS VSS nfet_06v0 L=1.0u W=5.0u
Mx_core_x2_x2_x2_XM21 x_core_x2_x2_x2_net6 S2P_I x_core_x2_x2_x2_net8 VSS nfet_06v0 L=1.0u W=7.5u
Mx_core_x2_x2_x2_XM22 x_core_x2_x2_x2_net3 S2N_I x_core_x2_x2_x2_net8 VSS nfet_06v0 L=1.0u W=8.5u
Mx_core_x2_x2_x2_XM29 x_core_x2_x2_x2_net9 x_core_x2_x2_net4 x_core_x2_x2_x2_net3 VDD pfet_06v0 L=1.0u W=10u
Mx_core_x2_x2_x2_XM30 x_core_x2_x2_x2_G_OUT_P x_core_x2_x2_net4 x_core_x2_x2_x2_net6 VDD pfet_06v0 L=1.0u W=10u
Mx_core_x2_x2_x2_XM31 x_core_x2_x2_x2_net3 x_core_x2_x2_x2_net9 VDD VDD pfet_06v0 L=1.0u W=5u
Mx_core_x2_x2_x2_XM35 x_core_x2_x2_x2_net6 x_core_x2_x2_x2_net9 VDD VDD pfet_06v0 L=1.0u W=5u
Mx_core_x2_x2_x2_XM32 x_core_x2_x2_x2_net10 x_core_x2_x2_x2_net20 x_core_x2_x2_x2_net9 VDD pfet_06v0 L=1.0u W=4.0u
Mx_core_x2_x2_x2_XM33 x_core_x2_x2_x2_net21 x_core_x2_x2_x2_net20 x_core_x2_x2_x2_G_OUT_P VDD pfet_06v0 L=1.0u W=4.0u
Mx_core_x2_x2_x2_XM23 x_core_x2_x2_x2_net10 x_core_x2_x2_net2 x_core_x2_x2_x2_net4 VSS nfet_06v0 L=1.0u W=2.5u
Mx_core_x2_x2_x2_XM24 x_core_x2_x2_x2_net21 x_core_x2_x2_net2 x_core_x2_x2_x2_net5 VSS nfet_06v0 L=1.0u W=2.5u
Mx_core_x2_x2_x2_XM25 x_core_x2_x2_x2_net4 x_core_x2_x2_x2_net10 VSS VSS nfet_06v0 L=1.0u W=2.5u
Mx_core_x2_x2_x2_XM26 x_core_x2_x2_x2_net5 x_core_x2_x2_x2_net10 VSS VSS nfet_06v0 L=1.0u W=2.5u
Mx_core_x2_x2_x2_XM27 x_core_x2_x2_x2_net9 x_core_x2_x2_x2_net11 x_core_x2_x2_x2_net10 VSS nfet_06v0 L=1.0u W=2.0u
Mx_core_x2_x2_x2_XM28 x_core_x2_x2_x2_G_OUT_P x_core_x2_x2_x2_net11 x_core_x2_x2_x2_net21 VSS nfet_06v0 L=1.0u W=2.0u
Mx_core_x2_x2_x2_XM34 x_core_x2_x2_x2_net12 x_core_x2_x2_x2_net13 VDD VDD pfet_06v0 L=1.0u W=10.0u
Mx_core_x2_x2_x2_XM36 x_core_x2_x2_x2_net13 x_core_x2_x2_net4 x_core_x2_x2_x2_net12 VDD pfet_06v0 L=1.0u W=10.0u
Mx_core_x2_x2_x2_XM37 x_core_x2_x2_x2_net20 x_core_x2_x2_x2_net20 x_core_x2_x2_x2_net13 VDD pfet_06v0 L=1.0u W=10.0u
Mx_core_x2_x2_x2_XM38 x_core_x2_x2_x2_net20 x_core_x2_x2_net2 x_core_x2_x2_x2_net14 VSS nfet_06v0 L=1.0u W=5.0u
Mx_core_x2_x2_x2_XM39 x_core_x2_x2_x2_net14 x_core_x2_x2_net1 VSS VSS nfet_06v0 L=1.0u W=5.0u
Mx_core_x2_x2_x2_XM45 x_core_x2_x2_x2_net15 x_core_x2_x2_net3 VDD VDD pfet_06v0 L=1.0u W=10.0u
Mx_core_x2_x2_x2_XM46 x_core_x2_x2_x2_net11 x_core_x2_x2_net4 x_core_x2_x2_x2_net15 VDD pfet_06v0 L=1.0u W=10.0u
Mx_core_x2_x2_x2_XM40 x_core_x2_x2_x2_net11 x_core_x2_x2_x2_net11 x_core_x2_x2_x2_net17 VSS nfet_06v0 L=1.0u W=5.0u
Mx_core_x2_x2_x2_XM41 x_core_x2_x2_x2_net17 x_core_x2_x2_net2 x_core_x2_x2_x2_net16 VSS nfet_06v0 L=1.0u W=5.0u
Mx_core_x2_x2_x2_XM42 x_core_x2_x2_x2_net16 x_core_x2_x2_x2_net17 VSS VSS nfet_06v0 L=1.0u W=5.0u
Mx_core_x2_x2_x2_XM43_m1 x_core_x2_SZ x_core_x2_x2_x2_G_OUT_P VDD VDD pfet_06v0 L=1.0u W=1.0u
Mx_core_x2_x2_x2_XM43_m2 x_core_x2_SZ x_core_x2_x2_x2_G_OUT_P VDD VDD pfet_06v0 L=1.0u W=1.0u
Mx_core_x2_x2_x2_XM43_m3 x_core_x2_SZ x_core_x2_x2_x2_G_OUT_P VDD VDD pfet_06v0 L=1.0u W=1.0u
Mx_core_x2_x2_x2_XM43_m4 x_core_x2_SZ x_core_x2_x2_x2_G_OUT_P VDD VDD pfet_06v0 L=1.0u W=1.0u
Mx_core_x2_x2_x2_XM44 x_core_x2_SZ x_core_x2_x2_x2_net21 VSS VSS nfet_06v0 L=1.0u W=1.0u
Mx_core_x3_x4_x1_XM4 x_core_x3_x4_x1_net3 x_core_x3_x4_net4 VDD VDD pfet_06v0 L=1.0u W=10.0u
Mx_core_x3_x4_x1_XM5 x_core_x3_x4_net2 x_core_x3_x4_net3 x_core_x3_x4_x1_net3 VDD pfet_06v0 L=1.0u W=10.0u
Mx_core_x3_x4_x1_XM6 x_core_x3_x4_net2 x_core_x3_x4_net2 VSS VSS nfet_06v0 L=1.0u W=1.0u
Mx_core_x3_x4_x1_XM7 x_core_x3_x4_x1_net2 x_core_x3_x4_net4 VDD VDD pfet_06v0 L=1.0u W=10.0u
Mx_core_x3_x4_x1_XM8 x_core_x3_x4_net1 x_core_x3_x4_net3 x_core_x3_x4_x1_net2 VDD pfet_06v0 L=1.0u W=10.0u
Mx_core_x3_x4_x1_XM9 x_core_x3_x4_net1 x_core_x3_x4_net2 x_core_x3_x4_x1_net1 VSS nfet_06v0 L=1.0u W=5.0u
Mx_core_x3_x4_x1_XM10 x_core_x3_x4_x1_net1 x_core_x3_x4_net1 VSS VSS nfet_06v0 L=1.0u W=5.0u
Mx_core_x3_x4_x1_XM1 x_core_x3_x4_net3 x_core_x3_x4_net3 VDD VDD pfet_06v0 L=1.0u W=2u
Mx_core_x3_x4_x1_XM2 x_core_x3_x4_x1_net4 x_core_x3_x4_net4 VDD VDD pfet_06v0 L=1.0u W=10.0u
Mx_core_x3_x4_x1_XM3 x_core_x3_x4_net4 x_core_x3_x4_net3 x_core_x3_x4_x1_net4 VDD pfet_06v0 L=1.0u W=10.0u
Mx_core_x3_x4_x1_XM47 x_core_x3_x4_x1_net5 x_core_x3_x4_net3 VSS VSS nfet_06v0 L=1.0u W=1.0u
Mx_core_x3_x4_x1_XM48 x_core_x3_x4_x1_net6 x_core_x3_x4_net3 VSS VSS nfet_06v0 L=1.0u W=1.0u
Mx_core_x3_x4_x1_XM49 x_core_x3_x4_net3 x_core_x3_x4_net3 x_core_x3_x4_x1_net6 VSS nfet_06v0 L=1.0u W=1.0u
Mx_core_x3_x4_x1_XM50 x_core_x3_x4_net4 x_core_x3_x4_net3 x_core_x3_x4_x1_net5 VSS nfet_06v0 L=1.0u W=1.0u
Mx_core_x3_x4_x2_XM11 x_core_x3_x4_x2_net2 x_core_x3_x4_net4 VDD VDD pfet_06v0 L=1.0u W=10.0u
Mx_core_x3_x4_x2_XM12 x_core_x3_x4_x2_net7 x_core_x3_x4_net3 x_core_x3_x4_x2_net2 VDD pfet_06v0 L=1.0u W=10.0u
Mx_core_x3_x4_x2_XM13 x_core_x3_x4_x2_net19 x_core_x3_x4_net4 VDD VDD pfet_06v0 L=1.0u W=10.0u
Mx_core_x3_x4_x2_XM14 x_core_x3_x4_x2_net7 x_core_x3_x4_net3 x_core_x3_x4_x2_net19 VDD pfet_06v0 L=1.0u W=10.0u
Mx_core_x3_x4_x2_XM15_f1 x_core_x3_x4_x2_net5 x_core_x3_SY x_core_x3_x4_x2_net7 VDD pfet_06v0 L=1.0u W=10.0u
Mx_core_x3_x4_x2_XM15_f2 x_core_x3_x4_x2_net5 x_core_x3_SY x_core_x3_x4_x2_net7 VDD pfet_06v0 L=1.0u W=10.0u
Mx_core_x3_x4_x2_XM16_f1 x_core_x3_x4_x2_net4 x_core_x3_SX x_core_x3_x4_x2_net7 VDD pfet_06v0 L=1.0u W=10.0u
Mx_core_x3_x4_x2_XM16_f2 x_core_x3_x4_x2_net4 x_core_x3_SX x_core_x3_x4_x2_net7 VDD pfet_06v0 L=1.0u W=10.0u
Mx_core_x3_x4_x2_XM17 x_core_x3_x4_x2_net8 x_core_x3_x4_net2 x_core_x3_x4_x2_net1 VSS nfet_06v0 L=1.0u W=5.0u
Mx_core_x3_x4_x2_XM18 x_core_x3_x4_x2_net1 x_core_x3_x4_net1 VSS VSS nfet_06v0 L=1.0u W=5.0u
Mx_core_x3_x4_x2_XM19 x_core_x3_x4_x2_net8 x_core_x3_x4_net2 x_core_x3_x4_x2_net20 VSS nfet_06v0 L=1.0u W=5.0u
Mx_core_x3_x4_x2_XM20 x_core_x3_x4_x2_net20 x_core_x3_x4_net1 VSS VSS nfet_06v0 L=1.0u W=5.0u
Mx_core_x3_x4_x2_XM21_f1 x_core_x3_x4_x2_net6 x_core_x3_SY x_core_x3_x4_x2_net8 VSS nfet_06v0 L=1.0u W=5u
Mx_core_x3_x4_x2_XM21_f2 x_core_x3_x4_x2_net6 x_core_x3_SY x_core_x3_x4_x2_net8 VSS nfet_06v0 L=1.0u W=5u
Mx_core_x3_x4_x2_XM22_f1 x_core_x3_x4_x2_net3 x_core_x3_SX x_core_x3_x4_x2_net8 VSS nfet_06v0 L=1.0u W=5u
Mx_core_x3_x4_x2_XM22_f2 x_core_x3_x4_x2_net3 x_core_x3_SX x_core_x3_x4_x2_net8 VSS nfet_06v0 L=1.0u W=5u
Mx_core_x3_x4_x2_XM29_f1 x_core_x3_x4_x2_net9 x_core_x3_x4_net3 x_core_x3_x4_x2_net3 VDD pfet_06v0 L=1.0u W=5u
Mx_core_x3_x4_x2_XM29_f2 x_core_x3_x4_x2_net9 x_core_x3_x4_net3 x_core_x3_x4_x2_net3 VDD pfet_06v0 L=1.0u W=5u
Mx_core_x3_x4_x2_XM30_f1 x_core_x3_x4_x2_net12 x_core_x3_x4_net3 x_core_x3_x4_x2_net6 VDD pfet_06v0 L=1.0u W=5.0u
Mx_core_x3_x4_x2_XM30_f2 x_core_x3_x4_x2_net12 x_core_x3_x4_net3 x_core_x3_x4_x2_net6 VDD pfet_06v0 L=1.0u W=5.0u
Mx_core_x3_x4_x2_XM31_f1 x_core_x3_x4_x2_net3 x_core_x3_x4_x2_net9 VDD VDD pfet_06v0 L=1.0u W=5u
Mx_core_x3_x4_x2_XM31_f2 x_core_x3_x4_x2_net3 x_core_x3_x4_x2_net9 VDD VDD pfet_06v0 L=1.0u W=5u
Mx_core_x3_x4_x2_XM31_f3 x_core_x3_x4_x2_net3 x_core_x3_x4_x2_net9 VDD VDD pfet_06v0 L=1.0u W=5u
Mx_core_x3_x4_x2_XM31_f4 x_core_x3_x4_x2_net3 x_core_x3_x4_x2_net9 VDD VDD pfet_06v0 L=1.0u W=5u
Mx_core_x3_x4_x2_XM35_f1 x_core_x3_x4_x2_net6 x_core_x3_x4_x2_net9 VDD VDD pfet_06v0 L=1.0u W=5.0u
Mx_core_x3_x4_x2_XM35_f2 x_core_x3_x4_x2_net6 x_core_x3_x4_x2_net9 VDD VDD pfet_06v0 L=1.0u W=5.0u
Mx_core_x3_x4_x2_XM35_f3 x_core_x3_x4_x2_net6 x_core_x3_x4_x2_net9 VDD VDD pfet_06v0 L=1.0u W=5.0u
Mx_core_x3_x4_x2_XM35_f4 x_core_x3_x4_x2_net6 x_core_x3_x4_x2_net9 VDD VDD pfet_06v0 L=1.0u W=5.0u
Mx_core_x3_x4_x2_XM32 x_core_x3_x4_x2_net10 x_core_x3_x4_x2_net21 x_core_x3_x4_x2_net9 VDD pfet_06v0 L=1.0u W=5u
Mx_core_x3_x4_x2_XM33 x_core_x3_x4_x2_net22 x_core_x3_x4_x2_net21 x_core_x3_x4_x2_net12 VDD pfet_06v0 L=1.0u W=5.0u
Mx_core_x3_x4_x2_XM23_f1 x_core_x3_x4_x2_net10 x_core_x3_x4_net2 x_core_x3_x4_x2_net4 VSS nfet_06v0 L=1.0u W=2.5u
Mx_core_x3_x4_x2_XM23_f2 x_core_x3_x4_x2_net10 x_core_x3_x4_net2 x_core_x3_x4_x2_net4 VSS nfet_06v0 L=1.0u W=2.5u
Mx_core_x3_x4_x2_XM24_f1 x_core_x3_x4_x2_net22 x_core_x3_x4_net2 x_core_x3_x4_x2_net5 VSS nfet_06v0 L=1.0u W=2.5u
Mx_core_x3_x4_x2_XM24_f2 x_core_x3_x4_x2_net22 x_core_x3_x4_net2 x_core_x3_x4_x2_net5 VSS nfet_06v0 L=1.0u W=2.5u
Mx_core_x3_x4_x2_XM25_f1 x_core_x3_x4_x2_net4 x_core_x3_x4_x2_net10 VSS VSS nfet_06v0 L=1.0u W=2.5u
Mx_core_x3_x4_x2_XM25_f2 x_core_x3_x4_x2_net4 x_core_x3_x4_x2_net10 VSS VSS nfet_06v0 L=1.0u W=2.5u
Mx_core_x3_x4_x2_XM25_f3 x_core_x3_x4_x2_net4 x_core_x3_x4_x2_net10 VSS VSS nfet_06v0 L=1.0u W=2.5u
Mx_core_x3_x4_x2_XM25_f4 x_core_x3_x4_x2_net4 x_core_x3_x4_x2_net10 VSS VSS nfet_06v0 L=1.0u W=2.5u
Mx_core_x3_x4_x2_XM26_f1 x_core_x3_x4_x2_net5 x_core_x3_x4_x2_net10 VSS VSS nfet_06v0 L=1.0u W=2.5u
Mx_core_x3_x4_x2_XM26_f2 x_core_x3_x4_x2_net5 x_core_x3_x4_x2_net10 VSS VSS nfet_06v0 L=1.0u W=2.5u
Mx_core_x3_x4_x2_XM26_f3 x_core_x3_x4_x2_net5 x_core_x3_x4_x2_net10 VSS VSS nfet_06v0 L=1.0u W=2.5u
Mx_core_x3_x4_x2_XM26_f4 x_core_x3_x4_x2_net5 x_core_x3_x4_x2_net10 VSS VSS nfet_06v0 L=1.0u W=2.5u
Mx_core_x3_x4_x2_XM27 x_core_x3_x4_x2_net9 x_core_x3_x4_x2_net11 x_core_x3_x4_x2_net10 VSS nfet_06v0 L=1.0u W=2.5u
Mx_core_x3_x4_x2_XM28 x_core_x3_x4_x2_net12 x_core_x3_x4_x2_net11 x_core_x3_x4_x2_net22 VSS nfet_06v0 L=1.0u W=2.5u
Mx_core_x3_x4_x2_XM34 x_core_x3_x4_x2_net13 x_core_x3_x4_x2_net14 VDD VDD pfet_06v0 L=1.0u W=10.0u
Mx_core_x3_x4_x2_XM36 x_core_x3_x4_x2_net14 x_core_x3_x4_net3 x_core_x3_x4_x2_net13 VDD pfet_06v0 L=1.0u W=10.0u
Mx_core_x3_x4_x2_XM37 x_core_x3_x4_x2_net21 x_core_x3_x4_x2_net21 x_core_x3_x4_x2_net14 VDD pfet_06v0 L=1.0u W=10.0u
Mx_core_x3_x4_x2_XM38 x_core_x3_x4_x2_net21 x_core_x3_x4_net2 x_core_x3_x4_x2_net15 VSS nfet_06v0 L=1.0u W=5.0u
Mx_core_x3_x4_x2_XM39 x_core_x3_x4_x2_net15 x_core_x3_x4_net1 VSS VSS nfet_06v0 L=1.0u W=5.0u
Mx_core_x3_x4_x2_XM45 x_core_x3_x4_x2_net16 x_core_x3_x4_net4 VDD VDD pfet_06v0 L=1.0u W=10.0u
Mx_core_x3_x4_x2_XM46 x_core_x3_x4_x2_net11 x_core_x3_x4_net3 x_core_x3_x4_x2_net16 VDD pfet_06v0 L=1.0u W=10.0u
Mx_core_x3_x4_x2_XM40 x_core_x3_x4_x2_net11 x_core_x3_x4_x2_net11 x_core_x3_x4_x2_net18 VSS nfet_06v0 L=1.0u W=5.0u
Mx_core_x3_x4_x2_XM41 x_core_x3_x4_x2_net18 x_core_x3_x4_net2 x_core_x3_x4_x2_net17 VSS nfet_06v0 L=1.0u W=5.0u
Mx_core_x3_x4_x2_XM42 x_core_x3_x4_x2_net17 x_core_x3_x4_x2_net18 VSS VSS nfet_06v0 L=1.0u W=5.0u
Mx_core_x3_x4_x2_XM43_f1 x_core_x3_net1 x_core_x3_x4_x2_net12 VDD VDD pfet_06v0 L=1.0u W=10u
Mx_core_x3_x4_x2_XM43_f2 x_core_x3_net1 x_core_x3_x4_x2_net12 VDD VDD pfet_06v0 L=1.0u W=10u
Mx_core_x3_x4_x2_XM43_f3 x_core_x3_net1 x_core_x3_x4_x2_net12 VDD VDD pfet_06v0 L=1.0u W=10u
Mx_core_x3_x4_x2_XM44_f1 x_core_x3_net1 x_core_x3_x4_x2_net22 VSS VSS nfet_06v0 L=1.0u W=5u
Mx_core_x3_x4_x2_XM44_f2 x_core_x3_net1 x_core_x3_x4_x2_net22 VSS VSS nfet_06v0 L=1.0u W=5u
Mx_core_x3_x4_x2_XM44_f3 x_core_x3_net1 x_core_x3_x4_x2_net22 VSS VSS nfet_06v0 L=1.0u W=5u
Mx_core_x3_x5_x1_XM4 x_core_x3_x5_x1_net3 x_core_x3_x5_net4 VDD VDD pfet_06v0 L=1.0u W=10.0u
Mx_core_x3_x5_x1_XM5 x_core_x3_x5_net2 x_core_x3_x5_net3 x_core_x3_x5_x1_net3 VDD pfet_06v0 L=1.0u W=10.0u
Mx_core_x3_x5_x1_XM6 x_core_x3_x5_net2 x_core_x3_x5_net2 VSS VSS nfet_06v0 L=1.0u W=1.0u
Mx_core_x3_x5_x1_XM7 x_core_x3_x5_x1_net2 x_core_x3_x5_net4 VDD VDD pfet_06v0 L=1.0u W=10.0u
Mx_core_x3_x5_x1_XM8 x_core_x3_x5_net1 x_core_x3_x5_net3 x_core_x3_x5_x1_net2 VDD pfet_06v0 L=1.0u W=10.0u
Mx_core_x3_x5_x1_XM9 x_core_x3_x5_net1 x_core_x3_x5_net2 x_core_x3_x5_x1_net1 VSS nfet_06v0 L=1.0u W=5.0u
Mx_core_x3_x5_x1_XM10 x_core_x3_x5_x1_net1 x_core_x3_x5_net1 VSS VSS nfet_06v0 L=1.0u W=5.0u
Mx_core_x3_x5_x1_XM1 x_core_x3_x5_net3 x_core_x3_x5_net3 VDD VDD pfet_06v0 L=1.0u W=2u
Mx_core_x3_x5_x1_XM2 x_core_x3_x5_x1_net4 x_core_x3_x5_net4 VDD VDD pfet_06v0 L=1.0u W=10.0u
Mx_core_x3_x5_x1_XM3 x_core_x3_x5_net4 x_core_x3_x5_net3 x_core_x3_x5_x1_net4 VDD pfet_06v0 L=1.0u W=10.0u
Mx_core_x3_x5_x1_XM47 x_core_x3_x5_x1_net5 x_core_x3_x5_net3 VSS VSS nfet_06v0 L=1.0u W=1.0u
Mx_core_x3_x5_x1_XM48 x_core_x3_x5_x1_net6 x_core_x3_x5_net3 VSS VSS nfet_06v0 L=1.0u W=1.0u
Mx_core_x3_x5_x1_XM49 x_core_x3_x5_net3 x_core_x3_x5_net3 x_core_x3_x5_x1_net6 VSS nfet_06v0 L=1.0u W=1.0u
Mx_core_x3_x5_x1_XM50 x_core_x3_x5_net4 x_core_x3_x5_net3 x_core_x3_x5_x1_net5 VSS nfet_06v0 L=1.0u W=1.0u
Mx_core_x3_x5_x2_XM11 x_core_x3_x5_x2_net2 x_core_x3_x5_net4 VDD VDD pfet_06v0 L=1.0u W=10.0u
Mx_core_x3_x5_x2_XM12 x_core_x3_x5_x2_net7 x_core_x3_x5_net3 x_core_x3_x5_x2_net2 VDD pfet_06v0 L=1.0u W=10.0u
Mx_core_x3_x5_x2_XM13 x_core_x3_x5_x2_net19 x_core_x3_x5_net4 VDD VDD pfet_06v0 L=1.0u W=10.0u
Mx_core_x3_x5_x2_XM14 x_core_x3_x5_x2_net7 x_core_x3_x5_net3 x_core_x3_x5_x2_net19 VDD pfet_06v0 L=1.0u W=10.0u
Mx_core_x3_x5_x2_XM15_f1 x_core_x3_x5_x2_net5 x_core_x3_SZ x_core_x3_x5_x2_net7 VDD pfet_06v0 L=1.0u W=10.0u
Mx_core_x3_x5_x2_XM15_f2 x_core_x3_x5_x2_net5 x_core_x3_SZ x_core_x3_x5_x2_net7 VDD pfet_06v0 L=1.0u W=10.0u
Mx_core_x3_x5_x2_XM16_f1 x_core_x3_x5_x2_net4 x_core_x3_SX x_core_x3_x5_x2_net7 VDD pfet_06v0 L=1.0u W=10.0u
Mx_core_x3_x5_x2_XM16_f2 x_core_x3_x5_x2_net4 x_core_x3_SX x_core_x3_x5_x2_net7 VDD pfet_06v0 L=1.0u W=10.0u
Mx_core_x3_x5_x2_XM17 x_core_x3_x5_x2_net8 x_core_x3_x5_net2 x_core_x3_x5_x2_net1 VSS nfet_06v0 L=1.0u W=5.0u
Mx_core_x3_x5_x2_XM18 x_core_x3_x5_x2_net1 x_core_x3_x5_net1 VSS VSS nfet_06v0 L=1.0u W=5.0u
Mx_core_x3_x5_x2_XM19 x_core_x3_x5_x2_net8 x_core_x3_x5_net2 x_core_x3_x5_x2_net20 VSS nfet_06v0 L=1.0u W=5.0u
Mx_core_x3_x5_x2_XM20 x_core_x3_x5_x2_net20 x_core_x3_x5_net1 VSS VSS nfet_06v0 L=1.0u W=5.0u
Mx_core_x3_x5_x2_XM21_f1 x_core_x3_x5_x2_net6 x_core_x3_SZ x_core_x3_x5_x2_net8 VSS nfet_06v0 L=1.0u W=5u
Mx_core_x3_x5_x2_XM21_f2 x_core_x3_x5_x2_net6 x_core_x3_SZ x_core_x3_x5_x2_net8 VSS nfet_06v0 L=1.0u W=5u
Mx_core_x3_x5_x2_XM22_f1 x_core_x3_x5_x2_net3 x_core_x3_SX x_core_x3_x5_x2_net8 VSS nfet_06v0 L=1.0u W=5u
Mx_core_x3_x5_x2_XM22_f2 x_core_x3_x5_x2_net3 x_core_x3_SX x_core_x3_x5_x2_net8 VSS nfet_06v0 L=1.0u W=5u
Mx_core_x3_x5_x2_XM29_f1 x_core_x3_x5_x2_net9 x_core_x3_x5_net3 x_core_x3_x5_x2_net3 VDD pfet_06v0 L=1.0u W=5u
Mx_core_x3_x5_x2_XM29_f2 x_core_x3_x5_x2_net9 x_core_x3_x5_net3 x_core_x3_x5_x2_net3 VDD pfet_06v0 L=1.0u W=5u
Mx_core_x3_x5_x2_XM30_f1 x_core_x3_x5_x2_net12 x_core_x3_x5_net3 x_core_x3_x5_x2_net6 VDD pfet_06v0 L=1.0u W=5.0u
Mx_core_x3_x5_x2_XM30_f2 x_core_x3_x5_x2_net12 x_core_x3_x5_net3 x_core_x3_x5_x2_net6 VDD pfet_06v0 L=1.0u W=5.0u
Mx_core_x3_x5_x2_XM31_f1 x_core_x3_x5_x2_net3 x_core_x3_x5_x2_net9 VDD VDD pfet_06v0 L=1.0u W=5u
Mx_core_x3_x5_x2_XM31_f2 x_core_x3_x5_x2_net3 x_core_x3_x5_x2_net9 VDD VDD pfet_06v0 L=1.0u W=5u
Mx_core_x3_x5_x2_XM31_f3 x_core_x3_x5_x2_net3 x_core_x3_x5_x2_net9 VDD VDD pfet_06v0 L=1.0u W=5u
Mx_core_x3_x5_x2_XM31_f4 x_core_x3_x5_x2_net3 x_core_x3_x5_x2_net9 VDD VDD pfet_06v0 L=1.0u W=5u
Mx_core_x3_x5_x2_XM35_f1 x_core_x3_x5_x2_net6 x_core_x3_x5_x2_net9 VDD VDD pfet_06v0 L=1.0u W=5.0u
Mx_core_x3_x5_x2_XM35_f2 x_core_x3_x5_x2_net6 x_core_x3_x5_x2_net9 VDD VDD pfet_06v0 L=1.0u W=5.0u
Mx_core_x3_x5_x2_XM35_f3 x_core_x3_x5_x2_net6 x_core_x3_x5_x2_net9 VDD VDD pfet_06v0 L=1.0u W=5.0u
Mx_core_x3_x5_x2_XM35_f4 x_core_x3_x5_x2_net6 x_core_x3_x5_x2_net9 VDD VDD pfet_06v0 L=1.0u W=5.0u
Mx_core_x3_x5_x2_XM32 x_core_x3_x5_x2_net10 x_core_x3_x5_x2_net21 x_core_x3_x5_x2_net9 VDD pfet_06v0 L=1.0u W=5u
Mx_core_x3_x5_x2_XM33 x_core_x3_x5_x2_net22 x_core_x3_x5_x2_net21 x_core_x3_x5_x2_net12 VDD pfet_06v0 L=1.0u W=5.0u
Mx_core_x3_x5_x2_XM23_f1 x_core_x3_x5_x2_net10 x_core_x3_x5_net2 x_core_x3_x5_x2_net4 VSS nfet_06v0 L=1.0u W=2.5u
Mx_core_x3_x5_x2_XM23_f2 x_core_x3_x5_x2_net10 x_core_x3_x5_net2 x_core_x3_x5_x2_net4 VSS nfet_06v0 L=1.0u W=2.5u
Mx_core_x3_x5_x2_XM24_f1 x_core_x3_x5_x2_net22 x_core_x3_x5_net2 x_core_x3_x5_x2_net5 VSS nfet_06v0 L=1.0u W=2.5u
Mx_core_x3_x5_x2_XM24_f2 x_core_x3_x5_x2_net22 x_core_x3_x5_net2 x_core_x3_x5_x2_net5 VSS nfet_06v0 L=1.0u W=2.5u
Mx_core_x3_x5_x2_XM25_f1 x_core_x3_x5_x2_net4 x_core_x3_x5_x2_net10 VSS VSS nfet_06v0 L=1.0u W=2.5u
Mx_core_x3_x5_x2_XM25_f2 x_core_x3_x5_x2_net4 x_core_x3_x5_x2_net10 VSS VSS nfet_06v0 L=1.0u W=2.5u
Mx_core_x3_x5_x2_XM25_f3 x_core_x3_x5_x2_net4 x_core_x3_x5_x2_net10 VSS VSS nfet_06v0 L=1.0u W=2.5u
Mx_core_x3_x5_x2_XM25_f4 x_core_x3_x5_x2_net4 x_core_x3_x5_x2_net10 VSS VSS nfet_06v0 L=1.0u W=2.5u
Mx_core_x3_x5_x2_XM26_f1 x_core_x3_x5_x2_net5 x_core_x3_x5_x2_net10 VSS VSS nfet_06v0 L=1.0u W=2.5u
Mx_core_x3_x5_x2_XM26_f2 x_core_x3_x5_x2_net5 x_core_x3_x5_x2_net10 VSS VSS nfet_06v0 L=1.0u W=2.5u
Mx_core_x3_x5_x2_XM26_f3 x_core_x3_x5_x2_net5 x_core_x3_x5_x2_net10 VSS VSS nfet_06v0 L=1.0u W=2.5u
Mx_core_x3_x5_x2_XM26_f4 x_core_x3_x5_x2_net5 x_core_x3_x5_x2_net10 VSS VSS nfet_06v0 L=1.0u W=2.5u
Mx_core_x3_x5_x2_XM27 x_core_x3_x5_x2_net9 x_core_x3_x5_x2_net11 x_core_x3_x5_x2_net10 VSS nfet_06v0 L=1.0u W=2.5u
Mx_core_x3_x5_x2_XM28 x_core_x3_x5_x2_net12 x_core_x3_x5_x2_net11 x_core_x3_x5_x2_net22 VSS nfet_06v0 L=1.0u W=2.5u
Mx_core_x3_x5_x2_XM34 x_core_x3_x5_x2_net13 x_core_x3_x5_x2_net14 VDD VDD pfet_06v0 L=1.0u W=10.0u
Mx_core_x3_x5_x2_XM36 x_core_x3_x5_x2_net14 x_core_x3_x5_net3 x_core_x3_x5_x2_net13 VDD pfet_06v0 L=1.0u W=10.0u
Mx_core_x3_x5_x2_XM37 x_core_x3_x5_x2_net21 x_core_x3_x5_x2_net21 x_core_x3_x5_x2_net14 VDD pfet_06v0 L=1.0u W=10.0u
Mx_core_x3_x5_x2_XM38 x_core_x3_x5_x2_net21 x_core_x3_x5_net2 x_core_x3_x5_x2_net15 VSS nfet_06v0 L=1.0u W=5.0u
Mx_core_x3_x5_x2_XM39 x_core_x3_x5_x2_net15 x_core_x3_x5_net1 VSS VSS nfet_06v0 L=1.0u W=5.0u
Mx_core_x3_x5_x2_XM45 x_core_x3_x5_x2_net16 x_core_x3_x5_net4 VDD VDD pfet_06v0 L=1.0u W=10.0u
Mx_core_x3_x5_x2_XM46 x_core_x3_x5_x2_net11 x_core_x3_x5_net3 x_core_x3_x5_x2_net16 VDD pfet_06v0 L=1.0u W=10.0u
Mx_core_x3_x5_x2_XM40 x_core_x3_x5_x2_net11 x_core_x3_x5_x2_net11 x_core_x3_x5_x2_net18 VSS nfet_06v0 L=1.0u W=5.0u
Mx_core_x3_x5_x2_XM41 x_core_x3_x5_x2_net18 x_core_x3_x5_net2 x_core_x3_x5_x2_net17 VSS nfet_06v0 L=1.0u W=5.0u
Mx_core_x3_x5_x2_XM42 x_core_x3_x5_x2_net17 x_core_x3_x5_x2_net18 VSS VSS nfet_06v0 L=1.0u W=5.0u
Mx_core_x3_x5_x2_XM43_f1 x_core_x3_net2 x_core_x3_x5_x2_net12 VDD VDD pfet_06v0 L=1.0u W=10u
Mx_core_x3_x5_x2_XM43_f2 x_core_x3_net2 x_core_x3_x5_x2_net12 VDD VDD pfet_06v0 L=1.0u W=10u
Mx_core_x3_x5_x2_XM43_f3 x_core_x3_net2 x_core_x3_x5_x2_net12 VDD VDD pfet_06v0 L=1.0u W=10u
Mx_core_x3_x5_x2_XM44_f1 x_core_x3_net2 x_core_x3_x5_x2_net22 VSS VSS nfet_06v0 L=1.0u W=5u
Mx_core_x3_x5_x2_XM44_f2 x_core_x3_net2 x_core_x3_x5_x2_net22 VSS VSS nfet_06v0 L=1.0u W=5u
Mx_core_x3_x5_x2_XM44_f3 x_core_x3_net2 x_core_x3_x5_x2_net22 VSS VSS nfet_06v0 L=1.0u W=5u
Mx_core_x3_x6_x1_XM4 x_core_x3_x6_x1_net3 x_core_x3_x6_net4 VDD VDD pfet_06v0 L=1.0u W=10.0u
Mx_core_x3_x6_x1_XM5 x_core_x3_x6_net2 x_core_x3_x6_net3 x_core_x3_x6_x1_net3 VDD pfet_06v0 L=1.0u W=10.0u
Mx_core_x3_x6_x1_XM6 x_core_x3_x6_net2 x_core_x3_x6_net2 VSS VSS nfet_06v0 L=1.0u W=1.0u
Mx_core_x3_x6_x1_XM7 x_core_x3_x6_x1_net2 x_core_x3_x6_net4 VDD VDD pfet_06v0 L=1.0u W=10.0u
Mx_core_x3_x6_x1_XM8 x_core_x3_x6_net1 x_core_x3_x6_net3 x_core_x3_x6_x1_net2 VDD pfet_06v0 L=1.0u W=10.0u
Mx_core_x3_x6_x1_XM9 x_core_x3_x6_net1 x_core_x3_x6_net2 x_core_x3_x6_x1_net1 VSS nfet_06v0 L=1.0u W=5.0u
Mx_core_x3_x6_x1_XM10 x_core_x3_x6_x1_net1 x_core_x3_x6_net1 VSS VSS nfet_06v0 L=1.0u W=5.0u
Mx_core_x3_x6_x1_XM1 x_core_x3_x6_net3 x_core_x3_x6_net3 VDD VDD pfet_06v0 L=1.0u W=2u
Mx_core_x3_x6_x1_XM2 x_core_x3_x6_x1_net4 x_core_x3_x6_net4 VDD VDD pfet_06v0 L=1.0u W=10.0u
Mx_core_x3_x6_x1_XM3 x_core_x3_x6_net4 x_core_x3_x6_net3 x_core_x3_x6_x1_net4 VDD pfet_06v0 L=1.0u W=10.0u
Mx_core_x3_x6_x1_XM47 x_core_x3_x6_x1_net5 x_core_x3_x6_net3 VSS VSS nfet_06v0 L=1.0u W=1.0u
Mx_core_x3_x6_x1_XM48 x_core_x3_x6_x1_net6 x_core_x3_x6_net3 VSS VSS nfet_06v0 L=1.0u W=1.0u
Mx_core_x3_x6_x1_XM49 x_core_x3_x6_net3 x_core_x3_x6_net3 x_core_x3_x6_x1_net6 VSS nfet_06v0 L=1.0u W=1.0u
Mx_core_x3_x6_x1_XM50 x_core_x3_x6_net4 x_core_x3_x6_net3 x_core_x3_x6_x1_net5 VSS nfet_06v0 L=1.0u W=1.0u
Mx_core_x3_x6_x2_XM11 x_core_x3_x6_x2_net2 x_core_x3_x6_net4 VDD VDD pfet_06v0 L=1.0u W=10.0u
Mx_core_x3_x6_x2_XM12 x_core_x3_x6_x2_net7 x_core_x3_x6_net3 x_core_x3_x6_x2_net2 VDD pfet_06v0 L=1.0u W=10.0u
Mx_core_x3_x6_x2_XM13 x_core_x3_x6_x2_net19 x_core_x3_x6_net4 VDD VDD pfet_06v0 L=1.0u W=10.0u
Mx_core_x3_x6_x2_XM14 x_core_x3_x6_x2_net7 x_core_x3_x6_net3 x_core_x3_x6_x2_net19 VDD pfet_06v0 L=1.0u W=10.0u
Mx_core_x3_x6_x2_XM15_f1 x_core_x3_x6_x2_net5 x_core_x3_SZ x_core_x3_x6_x2_net7 VDD pfet_06v0 L=1.0u W=10.0u
Mx_core_x3_x6_x2_XM15_f2 x_core_x3_x6_x2_net5 x_core_x3_SZ x_core_x3_x6_x2_net7 VDD pfet_06v0 L=1.0u W=10.0u
Mx_core_x3_x6_x2_XM16_f1 x_core_x3_x6_x2_net4 x_core_x3_SY x_core_x3_x6_x2_net7 VDD pfet_06v0 L=1.0u W=10.0u
Mx_core_x3_x6_x2_XM16_f2 x_core_x3_x6_x2_net4 x_core_x3_SY x_core_x3_x6_x2_net7 VDD pfet_06v0 L=1.0u W=10.0u
Mx_core_x3_x6_x2_XM17 x_core_x3_x6_x2_net8 x_core_x3_x6_net2 x_core_x3_x6_x2_net1 VSS nfet_06v0 L=1.0u W=5.0u
Mx_core_x3_x6_x2_XM18 x_core_x3_x6_x2_net1 x_core_x3_x6_net1 VSS VSS nfet_06v0 L=1.0u W=5.0u
Mx_core_x3_x6_x2_XM19 x_core_x3_x6_x2_net8 x_core_x3_x6_net2 x_core_x3_x6_x2_net20 VSS nfet_06v0 L=1.0u W=5.0u
Mx_core_x3_x6_x2_XM20 x_core_x3_x6_x2_net20 x_core_x3_x6_net1 VSS VSS nfet_06v0 L=1.0u W=5.0u
Mx_core_x3_x6_x2_XM21_f1 x_core_x3_x6_x2_net6 x_core_x3_SZ x_core_x3_x6_x2_net8 VSS nfet_06v0 L=1.0u W=5u
Mx_core_x3_x6_x2_XM21_f2 x_core_x3_x6_x2_net6 x_core_x3_SZ x_core_x3_x6_x2_net8 VSS nfet_06v0 L=1.0u W=5u
Mx_core_x3_x6_x2_XM22_f1 x_core_x3_x6_x2_net3 x_core_x3_SY x_core_x3_x6_x2_net8 VSS nfet_06v0 L=1.0u W=5u
Mx_core_x3_x6_x2_XM22_f2 x_core_x3_x6_x2_net3 x_core_x3_SY x_core_x3_x6_x2_net8 VSS nfet_06v0 L=1.0u W=5u
Mx_core_x3_x6_x2_XM29_f1 x_core_x3_x6_x2_net9 x_core_x3_x6_net3 x_core_x3_x6_x2_net3 VDD pfet_06v0 L=1.0u W=5u
Mx_core_x3_x6_x2_XM29_f2 x_core_x3_x6_x2_net9 x_core_x3_x6_net3 x_core_x3_x6_x2_net3 VDD pfet_06v0 L=1.0u W=5u
Mx_core_x3_x6_x2_XM30_f1 x_core_x3_x6_x2_net12 x_core_x3_x6_net3 x_core_x3_x6_x2_net6 VDD pfet_06v0 L=1.0u W=5.0u
Mx_core_x3_x6_x2_XM30_f2 x_core_x3_x6_x2_net12 x_core_x3_x6_net3 x_core_x3_x6_x2_net6 VDD pfet_06v0 L=1.0u W=5.0u
Mx_core_x3_x6_x2_XM31_f1 x_core_x3_x6_x2_net3 x_core_x3_x6_x2_net9 VDD VDD pfet_06v0 L=1.0u W=5u
Mx_core_x3_x6_x2_XM31_f2 x_core_x3_x6_x2_net3 x_core_x3_x6_x2_net9 VDD VDD pfet_06v0 L=1.0u W=5u
Mx_core_x3_x6_x2_XM31_f3 x_core_x3_x6_x2_net3 x_core_x3_x6_x2_net9 VDD VDD pfet_06v0 L=1.0u W=5u
Mx_core_x3_x6_x2_XM31_f4 x_core_x3_x6_x2_net3 x_core_x3_x6_x2_net9 VDD VDD pfet_06v0 L=1.0u W=5u
Mx_core_x3_x6_x2_XM35_f1 x_core_x3_x6_x2_net6 x_core_x3_x6_x2_net9 VDD VDD pfet_06v0 L=1.0u W=5.0u
Mx_core_x3_x6_x2_XM35_f2 x_core_x3_x6_x2_net6 x_core_x3_x6_x2_net9 VDD VDD pfet_06v0 L=1.0u W=5.0u
Mx_core_x3_x6_x2_XM35_f3 x_core_x3_x6_x2_net6 x_core_x3_x6_x2_net9 VDD VDD pfet_06v0 L=1.0u W=5.0u
Mx_core_x3_x6_x2_XM35_f4 x_core_x3_x6_x2_net6 x_core_x3_x6_x2_net9 VDD VDD pfet_06v0 L=1.0u W=5.0u
Mx_core_x3_x6_x2_XM32 x_core_x3_x6_x2_net10 x_core_x3_x6_x2_net21 x_core_x3_x6_x2_net9 VDD pfet_06v0 L=1.0u W=5u
Mx_core_x3_x6_x2_XM33 x_core_x3_x6_x2_net22 x_core_x3_x6_x2_net21 x_core_x3_x6_x2_net12 VDD pfet_06v0 L=1.0u W=5.0u
Mx_core_x3_x6_x2_XM23_f1 x_core_x3_x6_x2_net10 x_core_x3_x6_net2 x_core_x3_x6_x2_net4 VSS nfet_06v0 L=1.0u W=2.5u
Mx_core_x3_x6_x2_XM23_f2 x_core_x3_x6_x2_net10 x_core_x3_x6_net2 x_core_x3_x6_x2_net4 VSS nfet_06v0 L=1.0u W=2.5u
Mx_core_x3_x6_x2_XM24_f1 x_core_x3_x6_x2_net22 x_core_x3_x6_net2 x_core_x3_x6_x2_net5 VSS nfet_06v0 L=1.0u W=2.5u
Mx_core_x3_x6_x2_XM24_f2 x_core_x3_x6_x2_net22 x_core_x3_x6_net2 x_core_x3_x6_x2_net5 VSS nfet_06v0 L=1.0u W=2.5u
Mx_core_x3_x6_x2_XM25_f1 x_core_x3_x6_x2_net4 x_core_x3_x6_x2_net10 VSS VSS nfet_06v0 L=1.0u W=2.5u
Mx_core_x3_x6_x2_XM25_f2 x_core_x3_x6_x2_net4 x_core_x3_x6_x2_net10 VSS VSS nfet_06v0 L=1.0u W=2.5u
Mx_core_x3_x6_x2_XM25_f3 x_core_x3_x6_x2_net4 x_core_x3_x6_x2_net10 VSS VSS nfet_06v0 L=1.0u W=2.5u
Mx_core_x3_x6_x2_XM25_f4 x_core_x3_x6_x2_net4 x_core_x3_x6_x2_net10 VSS VSS nfet_06v0 L=1.0u W=2.5u
Mx_core_x3_x6_x2_XM26_f1 x_core_x3_x6_x2_net5 x_core_x3_x6_x2_net10 VSS VSS nfet_06v0 L=1.0u W=2.5u
Mx_core_x3_x6_x2_XM26_f2 x_core_x3_x6_x2_net5 x_core_x3_x6_x2_net10 VSS VSS nfet_06v0 L=1.0u W=2.5u
Mx_core_x3_x6_x2_XM26_f3 x_core_x3_x6_x2_net5 x_core_x3_x6_x2_net10 VSS VSS nfet_06v0 L=1.0u W=2.5u
Mx_core_x3_x6_x2_XM26_f4 x_core_x3_x6_x2_net5 x_core_x3_x6_x2_net10 VSS VSS nfet_06v0 L=1.0u W=2.5u
Mx_core_x3_x6_x2_XM27 x_core_x3_x6_x2_net9 x_core_x3_x6_x2_net11 x_core_x3_x6_x2_net10 VSS nfet_06v0 L=1.0u W=2.5u
Mx_core_x3_x6_x2_XM28 x_core_x3_x6_x2_net12 x_core_x3_x6_x2_net11 x_core_x3_x6_x2_net22 VSS nfet_06v0 L=1.0u W=2.5u
Mx_core_x3_x6_x2_XM34 x_core_x3_x6_x2_net13 x_core_x3_x6_x2_net14 VDD VDD pfet_06v0 L=1.0u W=10.0u
Mx_core_x3_x6_x2_XM36 x_core_x3_x6_x2_net14 x_core_x3_x6_net3 x_core_x3_x6_x2_net13 VDD pfet_06v0 L=1.0u W=10.0u
Mx_core_x3_x6_x2_XM37 x_core_x3_x6_x2_net21 x_core_x3_x6_x2_net21 x_core_x3_x6_x2_net14 VDD pfet_06v0 L=1.0u W=10.0u
Mx_core_x3_x6_x2_XM38 x_core_x3_x6_x2_net21 x_core_x3_x6_net2 x_core_x3_x6_x2_net15 VSS nfet_06v0 L=1.0u W=5.0u
Mx_core_x3_x6_x2_XM39 x_core_x3_x6_x2_net15 x_core_x3_x6_net1 VSS VSS nfet_06v0 L=1.0u W=5.0u
Mx_core_x3_x6_x2_XM45 x_core_x3_x6_x2_net16 x_core_x3_x6_net4 VDD VDD pfet_06v0 L=1.0u W=10.0u
Mx_core_x3_x6_x2_XM46 x_core_x3_x6_x2_net11 x_core_x3_x6_net3 x_core_x3_x6_x2_net16 VDD pfet_06v0 L=1.0u W=10.0u
Mx_core_x3_x6_x2_XM40 x_core_x3_x6_x2_net11 x_core_x3_x6_x2_net11 x_core_x3_x6_x2_net18 VSS nfet_06v0 L=1.0u W=5.0u
Mx_core_x3_x6_x2_XM41 x_core_x3_x6_x2_net18 x_core_x3_x6_net2 x_core_x3_x6_x2_net17 VSS nfet_06v0 L=1.0u W=5.0u
Mx_core_x3_x6_x2_XM42 x_core_x3_x6_x2_net17 x_core_x3_x6_x2_net18 VSS VSS nfet_06v0 L=1.0u W=5.0u
Mx_core_x3_x6_x2_XM43_f1 x_core_x3_net3 x_core_x3_x6_x2_net12 VDD VDD pfet_06v0 L=1.0u W=10u
Mx_core_x3_x6_x2_XM43_f2 x_core_x3_net3 x_core_x3_x6_x2_net12 VDD VDD pfet_06v0 L=1.0u W=10u
Mx_core_x3_x6_x2_XM43_f3 x_core_x3_net3 x_core_x3_x6_x2_net12 VDD VDD pfet_06v0 L=1.0u W=10u
Mx_core_x3_x6_x2_XM44_f1 x_core_x3_net3 x_core_x3_x6_x2_net22 VSS VSS nfet_06v0 L=1.0u W=5u
Mx_core_x3_x6_x2_XM44_f2 x_core_x3_net3 x_core_x3_x6_x2_net22 VSS VSS nfet_06v0 L=1.0u W=5u
Mx_core_x3_x6_x2_XM44_f3 x_core_x3_net3 x_core_x3_x6_x2_net22 VSS VSS nfet_06v0 L=1.0u W=5u
Mx_core_x3_x7_x2_x2_XM4 x_core_x3_x7_x2_net1 x_core_x3_net1 VDD VDD pfet_06v0 L=1.0u W=3.0u
Mx_core_x3_x7_x2_x2_XM5 VSS x_core_x3_net1 x_core_x3_x7_x2_net1 VSS nfet_06v0 L=1u W=1u
Mx_core_x3_x7_x2_x3_XM4 x_core_Y3 x_core_x3_x7_x2_x3_net1 VDD VDD pfet_06v0 L=1.0u W=3.0u
Mx_core_x3_x7_x2_x3_XM5 VSS x_core_x3_x7_x2_x3_net1 x_core_Y3 VSS nfet_06v0 L=1u W=1u
Mx_core_x3_x7_x2_x3_XM2 VDD x_core_x3_net3 x_core_x3_x7_x2_x3_net1 VDD pfet_06v0 L=1.0u W=3.0u
Mx_core_x3_x7_x2_x3_XM1 VDD x_core_x3_x7_x2_net1 x_core_x3_x7_x2_x3_net1 VDD pfet_06v0 L=1.0u W=3.0u
Mx_core_x3_x7_x2_x3_XM3 VSS x_core_x3_net3 x_core_x3_x7_x2_x3_net2 VSS nfet_06v0 L=1u W=1u
Mx_core_x3_x7_x2_x3_XM6 x_core_x3_x7_x2_x3_net2 x_core_x3_x7_x2_net1 x_core_x3_x7_x2_x3_net1 VSS nfet_06v0 L=1u W=1u
Mx_core_x3_x7_x1_XM4 x_core_x3_x7_x1_net1 x_core_x3_net3 x_core_Z3 VDD pfet_06v0 L=1.0u W=3.0u
Mx_core_x3_x7_x1_XM5 VDD x_core_x3_net2 x_core_x3_x7_x1_net1 VDD pfet_06v0 L=1.0u W=3.0u
Mx_core_x3_x7_x1_XM7 VSS x_core_x3_net3 x_core_Z3 VSS nfet_06v0 L=1u W=1u
Mx_core_x3_x7_x1_XM1 VSS x_core_x3_net2 x_core_Z3 VSS nfet_06v0 L=1u W=1u
Mx_core_x3_x7_x3_x2_XM4 x_core_X3 x_core_x3_x7_x3_x2_net1 VDD VDD pfet_06v0 L=1.0u W=3.0u
Mx_core_x3_x7_x3_x2_XM5 VSS x_core_x3_x7_x3_x2_net1 x_core_X3 VSS nfet_06v0 L=1u W=1u
Mx_core_x3_x7_x3_x2_XM2 VDD x_core_x3_net1 x_core_x3_x7_x3_x2_net1 VDD pfet_06v0 L=1.0u W=3.0u
Mx_core_x3_x7_x3_x2_XM1 VDD x_core_x3_net2 x_core_x3_x7_x3_x2_net1 VDD pfet_06v0 L=1.0u W=3.0u
Mx_core_x3_x7_x3_x2_XM3 VSS x_core_x3_net1 x_core_x3_x7_x3_x2_net2 VSS nfet_06v0 L=1u W=1u
Mx_core_x3_x7_x3_x2_XM6 x_core_x3_x7_x3_x2_net2 x_core_x3_net2 x_core_x3_x7_x3_x2_net1 VSS nfet_06v0 L=1u W=1u
Mx_core_x3_x8_x1_XM4 x_core_x3_x8_x1_net3 x_core_x3_x8_net3 VDD VDD pfet_06v0 L=1.0u W=10.0u
Mx_core_x3_x8_x1_XM5 x_core_x3_x8_net2 x_core_x3_x8_net4 x_core_x3_x8_x1_net3 VDD pfet_06v0 L=1.0u W=10.0u
Mx_core_x3_x8_x1_XM6 x_core_x3_x8_net2 x_core_x3_x8_net2 VSS VSS nfet_06v0 L=1.0u W=1.0u
Mx_core_x3_x8_x1_XM7 x_core_x3_x8_x1_net2 x_core_x3_x8_net3 VDD VDD pfet_06v0 L=1.0u W=10.0u
Mx_core_x3_x8_x1_XM8 x_core_x3_x8_net1 x_core_x3_x8_net4 x_core_x3_x8_x1_net2 VDD pfet_06v0 L=1.0u W=10.0u
Mx_core_x3_x8_x1_XM9 x_core_x3_x8_net1 x_core_x3_x8_net2 x_core_x3_x8_x1_net1 VSS nfet_06v0 L=1.0u W=5.0u
Mx_core_x3_x8_x1_XM10 x_core_x3_x8_x1_net1 x_core_x3_x8_net1 VSS VSS nfet_06v0 L=1.0u W=5.0u
Mx_core_x3_x8_x1_XM1 x_core_x3_x8_net4 x_core_x3_x8_net4 VDD VDD pfet_06v0 L=1.0u W=2u
Mx_core_x3_x8_x1_XM2 x_core_x3_x8_x1_net4 x_core_x3_x8_net3 VDD VDD pfet_06v0 L=1.0u W=10.0u
Mx_core_x3_x8_x1_XM3 x_core_x3_x8_net3 x_core_x3_x8_net4 x_core_x3_x8_x1_net4 VDD pfet_06v0 L=1.0u W=10.0u
Mx_core_x3_x8_x1_XM47 x_core_x3_x8_x1_net5 x_core_x3_x8_net4 VSS VSS nfet_06v0 L=1.0u W=1.0u
Mx_core_x3_x8_x1_XM48 x_core_x3_x8_x1_net6 x_core_x3_x8_net4 VSS VSS nfet_06v0 L=1.0u W=1.0u
Mx_core_x3_x8_x1_XM49 x_core_x3_x8_net4 x_core_x3_x8_net4 x_core_x3_x8_x1_net6 VSS nfet_06v0 L=1.0u W=1.0u
Mx_core_x3_x8_x1_XM50 x_core_x3_x8_net3 x_core_x3_x8_net4 x_core_x3_x8_x1_net5 VSS nfet_06v0 L=1.0u W=1.0u
Mx_core_x3_x8_x2_XM11 x_core_x3_x8_x2_net2 x_core_x3_x8_net3 VDD VDD pfet_06v0 L=1.0u W=10.0u
Mx_core_x3_x8_x2_XM12 x_core_x3_x8_x2_net7 x_core_x3_x8_net4 x_core_x3_x8_x2_net2 VDD pfet_06v0 L=1.0u W=10.0u
Mx_core_x3_x8_x2_XM13 x_core_x3_x8_x2_net18 x_core_x3_x8_net3 VDD VDD pfet_06v0 L=1.0u W=10.0u
Mx_core_x3_x8_x2_XM14 x_core_x3_x8_x2_net7 x_core_x3_x8_net4 x_core_x3_x8_x2_net18 VDD pfet_06v0 L=1.0u W=10.0u
Mx_core_x3_x8_x2_XM15 x_core_x3_x8_x2_net5 S3P_I x_core_x3_x8_x2_net7 VDD pfet_06v0 L=1.0u W=0.55u
Mx_core_x3_x8_x2_XM16 x_core_x3_x8_x2_net4 S3N_I x_core_x3_x8_x2_net7 VDD pfet_06v0 L=1.0u W=0.5u
Mx_core_x3_x8_x2_XM17 x_core_x3_x8_x2_net8 x_core_x3_x8_net2 x_core_x3_x8_x2_net1 VSS nfet_06v0 L=1.0u W=5.0u
Mx_core_x3_x8_x2_XM18 x_core_x3_x8_x2_net1 x_core_x3_x8_net1 VSS VSS nfet_06v0 L=1.0u W=5.0u
Mx_core_x3_x8_x2_XM19 x_core_x3_x8_x2_net8 x_core_x3_x8_net2 x_core_x3_x8_x2_net19 VSS nfet_06v0 L=1.0u W=5.0u
Mx_core_x3_x8_x2_XM20 x_core_x3_x8_x2_net19 x_core_x3_x8_net1 VSS VSS nfet_06v0 L=1.0u W=5.0u
Mx_core_x3_x8_x2_XM21 x_core_x3_x8_x2_net6 S3P_I x_core_x3_x8_x2_net8 VSS nfet_06v0 L=1.0u W=7.5u
Mx_core_x3_x8_x2_XM22 x_core_x3_x8_x2_net3 S3N_I x_core_x3_x8_x2_net8 VSS nfet_06v0 L=1.0u W=8.5u
Mx_core_x3_x8_x2_XM29 x_core_x3_x8_x2_net9 x_core_x3_x8_net4 x_core_x3_x8_x2_net3 VDD pfet_06v0 L=1.0u W=10u
Mx_core_x3_x8_x2_XM30 x_core_x3_x8_x2_G_OUT_P x_core_x3_x8_net4 x_core_x3_x8_x2_net6 VDD pfet_06v0 L=1.0u W=10u
Mx_core_x3_x8_x2_XM31 x_core_x3_x8_x2_net3 x_core_x3_x8_x2_net9 VDD VDD pfet_06v0 L=1.0u W=5u
Mx_core_x3_x8_x2_XM35 x_core_x3_x8_x2_net6 x_core_x3_x8_x2_net9 VDD VDD pfet_06v0 L=1.0u W=5u
Mx_core_x3_x8_x2_XM32 x_core_x3_x8_x2_net10 x_core_x3_x8_x2_net20 x_core_x3_x8_x2_net9 VDD pfet_06v0 L=1.0u W=4.0u
Mx_core_x3_x8_x2_XM33 x_core_x3_x8_x2_net21 x_core_x3_x8_x2_net20 x_core_x3_x8_x2_G_OUT_P VDD pfet_06v0 L=1.0u W=4.0u
Mx_core_x3_x8_x2_XM23 x_core_x3_x8_x2_net10 x_core_x3_x8_net2 x_core_x3_x8_x2_net4 VSS nfet_06v0 L=1.0u W=2.5u
Mx_core_x3_x8_x2_XM24 x_core_x3_x8_x2_net21 x_core_x3_x8_net2 x_core_x3_x8_x2_net5 VSS nfet_06v0 L=1.0u W=2.5u
Mx_core_x3_x8_x2_XM25 x_core_x3_x8_x2_net4 x_core_x3_x8_x2_net10 VSS VSS nfet_06v0 L=1.0u W=2.5u
Mx_core_x3_x8_x2_XM26 x_core_x3_x8_x2_net5 x_core_x3_x8_x2_net10 VSS VSS nfet_06v0 L=1.0u W=2.5u
Mx_core_x3_x8_x2_XM27 x_core_x3_x8_x2_net9 x_core_x3_x8_x2_net11 x_core_x3_x8_x2_net10 VSS nfet_06v0 L=1.0u W=2.0u
Mx_core_x3_x8_x2_XM28 x_core_x3_x8_x2_G_OUT_P x_core_x3_x8_x2_net11 x_core_x3_x8_x2_net21 VSS nfet_06v0 L=1.0u W=2.0u
Mx_core_x3_x8_x2_XM34 x_core_x3_x8_x2_net12 x_core_x3_x8_x2_net13 VDD VDD pfet_06v0 L=1.0u W=10.0u
Mx_core_x3_x8_x2_XM36 x_core_x3_x8_x2_net13 x_core_x3_x8_net4 x_core_x3_x8_x2_net12 VDD pfet_06v0 L=1.0u W=10.0u
Mx_core_x3_x8_x2_XM37 x_core_x3_x8_x2_net20 x_core_x3_x8_x2_net20 x_core_x3_x8_x2_net13 VDD pfet_06v0 L=1.0u W=10.0u
Mx_core_x3_x8_x2_XM38 x_core_x3_x8_x2_net20 x_core_x3_x8_net2 x_core_x3_x8_x2_net14 VSS nfet_06v0 L=1.0u W=5.0u
Mx_core_x3_x8_x2_XM39 x_core_x3_x8_x2_net14 x_core_x3_x8_net1 VSS VSS nfet_06v0 L=1.0u W=5.0u
Mx_core_x3_x8_x2_XM45 x_core_x3_x8_x2_net15 x_core_x3_x8_net3 VDD VDD pfet_06v0 L=1.0u W=10.0u
Mx_core_x3_x8_x2_XM46 x_core_x3_x8_x2_net11 x_core_x3_x8_net4 x_core_x3_x8_x2_net15 VDD pfet_06v0 L=1.0u W=10.0u
Mx_core_x3_x8_x2_XM40 x_core_x3_x8_x2_net11 x_core_x3_x8_x2_net11 x_core_x3_x8_x2_net17 VSS nfet_06v0 L=1.0u W=5.0u
Mx_core_x3_x8_x2_XM41 x_core_x3_x8_x2_net17 x_core_x3_x8_net2 x_core_x3_x8_x2_net16 VSS nfet_06v0 L=1.0u W=5.0u
Mx_core_x3_x8_x2_XM42 x_core_x3_x8_x2_net16 x_core_x3_x8_x2_net17 VSS VSS nfet_06v0 L=1.0u W=5.0u
Mx_core_x3_x8_x2_XM43_m1 x_core_x3_SX x_core_x3_x8_x2_G_OUT_P VDD VDD pfet_06v0 L=1.0u W=1.0u
Mx_core_x3_x8_x2_XM43_m2 x_core_x3_SX x_core_x3_x8_x2_G_OUT_P VDD VDD pfet_06v0 L=1.0u W=1.0u
Mx_core_x3_x8_x2_XM43_m3 x_core_x3_SX x_core_x3_x8_x2_G_OUT_P VDD VDD pfet_06v0 L=1.0u W=1.0u
Mx_core_x3_x8_x2_XM43_m4 x_core_x3_SX x_core_x3_x8_x2_G_OUT_P VDD VDD pfet_06v0 L=1.0u W=1.0u
Mx_core_x3_x8_x2_XM44 x_core_x3_SX x_core_x3_x8_x2_net21 VSS VSS nfet_06v0 L=1.0u W=1.0u
Mx_core_x3_x1_x1_XM4 x_core_x3_x1_x1_net3 x_core_x3_x1_net3 VDD VDD pfet_06v0 L=1.0u W=10.0u
Mx_core_x3_x1_x1_XM5 x_core_x3_x1_net2 x_core_x3_x1_net4 x_core_x3_x1_x1_net3 VDD pfet_06v0 L=1.0u W=10.0u
Mx_core_x3_x1_x1_XM6 x_core_x3_x1_net2 x_core_x3_x1_net2 VSS VSS nfet_06v0 L=1.0u W=1.0u
Mx_core_x3_x1_x1_XM7 x_core_x3_x1_x1_net2 x_core_x3_x1_net3 VDD VDD pfet_06v0 L=1.0u W=10.0u
Mx_core_x3_x1_x1_XM8 x_core_x3_x1_net1 x_core_x3_x1_net4 x_core_x3_x1_x1_net2 VDD pfet_06v0 L=1.0u W=10.0u
Mx_core_x3_x1_x1_XM9 x_core_x3_x1_net1 x_core_x3_x1_net2 x_core_x3_x1_x1_net1 VSS nfet_06v0 L=1.0u W=5.0u
Mx_core_x3_x1_x1_XM10 x_core_x3_x1_x1_net1 x_core_x3_x1_net1 VSS VSS nfet_06v0 L=1.0u W=5.0u
Mx_core_x3_x1_x1_XM1 x_core_x3_x1_net4 x_core_x3_x1_net4 VDD VDD pfet_06v0 L=1.0u W=2u
Mx_core_x3_x1_x1_XM2 x_core_x3_x1_x1_net4 x_core_x3_x1_net3 VDD VDD pfet_06v0 L=1.0u W=10.0u
Mx_core_x3_x1_x1_XM3 x_core_x3_x1_net3 x_core_x3_x1_net4 x_core_x3_x1_x1_net4 VDD pfet_06v0 L=1.0u W=10.0u
Mx_core_x3_x1_x1_XM47 x_core_x3_x1_x1_net5 x_core_x3_x1_net4 VSS VSS nfet_06v0 L=1.0u W=1.0u
Mx_core_x3_x1_x1_XM48 x_core_x3_x1_x1_net6 x_core_x3_x1_net4 VSS VSS nfet_06v0 L=1.0u W=1.0u
Mx_core_x3_x1_x1_XM49 x_core_x3_x1_net4 x_core_x3_x1_net4 x_core_x3_x1_x1_net6 VSS nfet_06v0 L=1.0u W=1.0u
Mx_core_x3_x1_x1_XM50 x_core_x3_x1_net3 x_core_x3_x1_net4 x_core_x3_x1_x1_net5 VSS nfet_06v0 L=1.0u W=1.0u
Mx_core_x3_x1_x2_XM11 x_core_x3_x1_x2_net2 x_core_x3_x1_net3 VDD VDD pfet_06v0 L=1.0u W=10.0u
Mx_core_x3_x1_x2_XM12 x_core_x3_x1_x2_net7 x_core_x3_x1_net4 x_core_x3_x1_x2_net2 VDD pfet_06v0 L=1.0u W=10.0u
Mx_core_x3_x1_x2_XM13 x_core_x3_x1_x2_net18 x_core_x3_x1_net3 VDD VDD pfet_06v0 L=1.0u W=10.0u
Mx_core_x3_x1_x2_XM14 x_core_x3_x1_x2_net7 x_core_x3_x1_net4 x_core_x3_x1_x2_net18 VDD pfet_06v0 L=1.0u W=10.0u
Mx_core_x3_x1_x2_XM15 x_core_x3_x1_x2_net5 S4P_I x_core_x3_x1_x2_net7 VDD pfet_06v0 L=1.0u W=0.55u
Mx_core_x3_x1_x2_XM16 x_core_x3_x1_x2_net4 S4N_I x_core_x3_x1_x2_net7 VDD pfet_06v0 L=1.0u W=0.5u
Mx_core_x3_x1_x2_XM17 x_core_x3_x1_x2_net8 x_core_x3_x1_net2 x_core_x3_x1_x2_net1 VSS nfet_06v0 L=1.0u W=5.0u
Mx_core_x3_x1_x2_XM18 x_core_x3_x1_x2_net1 x_core_x3_x1_net1 VSS VSS nfet_06v0 L=1.0u W=5.0u
Mx_core_x3_x1_x2_XM19 x_core_x3_x1_x2_net8 x_core_x3_x1_net2 x_core_x3_x1_x2_net19 VSS nfet_06v0 L=1.0u W=5.0u
Mx_core_x3_x1_x2_XM20 x_core_x3_x1_x2_net19 x_core_x3_x1_net1 VSS VSS nfet_06v0 L=1.0u W=5.0u
Mx_core_x3_x1_x2_XM21 x_core_x3_x1_x2_net6 S4P_I x_core_x3_x1_x2_net8 VSS nfet_06v0 L=1.0u W=7.5u
Mx_core_x3_x1_x2_XM22 x_core_x3_x1_x2_net3 S4N_I x_core_x3_x1_x2_net8 VSS nfet_06v0 L=1.0u W=8.5u
Mx_core_x3_x1_x2_XM29 x_core_x3_x1_x2_net9 x_core_x3_x1_net4 x_core_x3_x1_x2_net3 VDD pfet_06v0 L=1.0u W=10u
Mx_core_x3_x1_x2_XM30 x_core_x3_x1_x2_G_OUT_P x_core_x3_x1_net4 x_core_x3_x1_x2_net6 VDD pfet_06v0 L=1.0u W=10u
Mx_core_x3_x1_x2_XM31 x_core_x3_x1_x2_net3 x_core_x3_x1_x2_net9 VDD VDD pfet_06v0 L=1.0u W=5u
Mx_core_x3_x1_x2_XM35 x_core_x3_x1_x2_net6 x_core_x3_x1_x2_net9 VDD VDD pfet_06v0 L=1.0u W=5u
Mx_core_x3_x1_x2_XM32 x_core_x3_x1_x2_net10 x_core_x3_x1_x2_net20 x_core_x3_x1_x2_net9 VDD pfet_06v0 L=1.0u W=4.0u
Mx_core_x3_x1_x2_XM33 x_core_x3_x1_x2_net21 x_core_x3_x1_x2_net20 x_core_x3_x1_x2_G_OUT_P VDD pfet_06v0 L=1.0u W=4.0u
Mx_core_x3_x1_x2_XM23 x_core_x3_x1_x2_net10 x_core_x3_x1_net2 x_core_x3_x1_x2_net4 VSS nfet_06v0 L=1.0u W=2.5u
Mx_core_x3_x1_x2_XM24 x_core_x3_x1_x2_net21 x_core_x3_x1_net2 x_core_x3_x1_x2_net5 VSS nfet_06v0 L=1.0u W=2.5u
Mx_core_x3_x1_x2_XM25 x_core_x3_x1_x2_net4 x_core_x3_x1_x2_net10 VSS VSS nfet_06v0 L=1.0u W=2.5u
Mx_core_x3_x1_x2_XM26 x_core_x3_x1_x2_net5 x_core_x3_x1_x2_net10 VSS VSS nfet_06v0 L=1.0u W=2.5u
Mx_core_x3_x1_x2_XM27 x_core_x3_x1_x2_net9 x_core_x3_x1_x2_net11 x_core_x3_x1_x2_net10 VSS nfet_06v0 L=1.0u W=2.0u
Mx_core_x3_x1_x2_XM28 x_core_x3_x1_x2_G_OUT_P x_core_x3_x1_x2_net11 x_core_x3_x1_x2_net21 VSS nfet_06v0 L=1.0u W=2.0u
Mx_core_x3_x1_x2_XM34 x_core_x3_x1_x2_net12 x_core_x3_x1_x2_net13 VDD VDD pfet_06v0 L=1.0u W=10.0u
Mx_core_x3_x1_x2_XM36 x_core_x3_x1_x2_net13 x_core_x3_x1_net4 x_core_x3_x1_x2_net12 VDD pfet_06v0 L=1.0u W=10.0u
Mx_core_x3_x1_x2_XM37 x_core_x3_x1_x2_net20 x_core_x3_x1_x2_net20 x_core_x3_x1_x2_net13 VDD pfet_06v0 L=1.0u W=10.0u
Mx_core_x3_x1_x2_XM38 x_core_x3_x1_x2_net20 x_core_x3_x1_net2 x_core_x3_x1_x2_net14 VSS nfet_06v0 L=1.0u W=5.0u
Mx_core_x3_x1_x2_XM39 x_core_x3_x1_x2_net14 x_core_x3_x1_net1 VSS VSS nfet_06v0 L=1.0u W=5.0u
Mx_core_x3_x1_x2_XM45 x_core_x3_x1_x2_net15 x_core_x3_x1_net3 VDD VDD pfet_06v0 L=1.0u W=10.0u
Mx_core_x3_x1_x2_XM46 x_core_x3_x1_x2_net11 x_core_x3_x1_net4 x_core_x3_x1_x2_net15 VDD pfet_06v0 L=1.0u W=10.0u
Mx_core_x3_x1_x2_XM40 x_core_x3_x1_x2_net11 x_core_x3_x1_x2_net11 x_core_x3_x1_x2_net17 VSS nfet_06v0 L=1.0u W=5.0u
Mx_core_x3_x1_x2_XM41 x_core_x3_x1_x2_net17 x_core_x3_x1_net2 x_core_x3_x1_x2_net16 VSS nfet_06v0 L=1.0u W=5.0u
Mx_core_x3_x1_x2_XM42 x_core_x3_x1_x2_net16 x_core_x3_x1_x2_net17 VSS VSS nfet_06v0 L=1.0u W=5.0u
Mx_core_x3_x1_x2_XM43_m1 x_core_x3_SY x_core_x3_x1_x2_G_OUT_P VDD VDD pfet_06v0 L=1.0u W=1.0u
Mx_core_x3_x1_x2_XM43_m2 x_core_x3_SY x_core_x3_x1_x2_G_OUT_P VDD VDD pfet_06v0 L=1.0u W=1.0u
Mx_core_x3_x1_x2_XM43_m3 x_core_x3_SY x_core_x3_x1_x2_G_OUT_P VDD VDD pfet_06v0 L=1.0u W=1.0u
Mx_core_x3_x1_x2_XM43_m4 x_core_x3_SY x_core_x3_x1_x2_G_OUT_P VDD VDD pfet_06v0 L=1.0u W=1.0u
Mx_core_x3_x1_x2_XM44 x_core_x3_SY x_core_x3_x1_x2_net21 VSS VSS nfet_06v0 L=1.0u W=1.0u
Mx_core_x3_x2_x1_XM4 x_core_x3_x2_x1_net3 x_core_x3_x2_net3 VDD VDD pfet_06v0 L=1.0u W=10.0u
Mx_core_x3_x2_x1_XM5 x_core_x3_x2_net2 x_core_x3_x2_net4 x_core_x3_x2_x1_net3 VDD pfet_06v0 L=1.0u W=10.0u
Mx_core_x3_x2_x1_XM6 x_core_x3_x2_net2 x_core_x3_x2_net2 VSS VSS nfet_06v0 L=1.0u W=1.0u
Mx_core_x3_x2_x1_XM7 x_core_x3_x2_x1_net2 x_core_x3_x2_net3 VDD VDD pfet_06v0 L=1.0u W=10.0u
Mx_core_x3_x2_x1_XM8 x_core_x3_x2_net1 x_core_x3_x2_net4 x_core_x3_x2_x1_net2 VDD pfet_06v0 L=1.0u W=10.0u
Mx_core_x3_x2_x1_XM9 x_core_x3_x2_net1 x_core_x3_x2_net2 x_core_x3_x2_x1_net1 VSS nfet_06v0 L=1.0u W=5.0u
Mx_core_x3_x2_x1_XM10 x_core_x3_x2_x1_net1 x_core_x3_x2_net1 VSS VSS nfet_06v0 L=1.0u W=5.0u
Mx_core_x3_x2_x1_XM1 x_core_x3_x2_net4 x_core_x3_x2_net4 VDD VDD pfet_06v0 L=1.0u W=2u
Mx_core_x3_x2_x1_XM2 x_core_x3_x2_x1_net4 x_core_x3_x2_net3 VDD VDD pfet_06v0 L=1.0u W=10.0u
Mx_core_x3_x2_x1_XM3 x_core_x3_x2_net3 x_core_x3_x2_net4 x_core_x3_x2_x1_net4 VDD pfet_06v0 L=1.0u W=10.0u
Mx_core_x3_x2_x1_XM47 x_core_x3_x2_x1_net5 x_core_x3_x2_net4 VSS VSS nfet_06v0 L=1.0u W=1.0u
Mx_core_x3_x2_x1_XM48 x_core_x3_x2_x1_net6 x_core_x3_x2_net4 VSS VSS nfet_06v0 L=1.0u W=1.0u
Mx_core_x3_x2_x1_XM49 x_core_x3_x2_net4 x_core_x3_x2_net4 x_core_x3_x2_x1_net6 VSS nfet_06v0 L=1.0u W=1.0u
Mx_core_x3_x2_x1_XM50 x_core_x3_x2_net3 x_core_x3_x2_net4 x_core_x3_x2_x1_net5 VSS nfet_06v0 L=1.0u W=1.0u
Mx_core_x3_x2_x2_XM11 x_core_x3_x2_x2_net2 x_core_x3_x2_net3 VDD VDD pfet_06v0 L=1.0u W=10.0u
Mx_core_x3_x2_x2_XM12 x_core_x3_x2_x2_net7 x_core_x3_x2_net4 x_core_x3_x2_x2_net2 VDD pfet_06v0 L=1.0u W=10.0u
Mx_core_x3_x2_x2_XM13 x_core_x3_x2_x2_net18 x_core_x3_x2_net3 VDD VDD pfet_06v0 L=1.0u W=10.0u
Mx_core_x3_x2_x2_XM14 x_core_x3_x2_x2_net7 x_core_x3_x2_net4 x_core_x3_x2_x2_net18 VDD pfet_06v0 L=1.0u W=10.0u
Mx_core_x3_x2_x2_XM15 x_core_x3_x2_x2_net5 S1P_I x_core_x3_x2_x2_net7 VDD pfet_06v0 L=1.0u W=0.55u
Mx_core_x3_x2_x2_XM16 x_core_x3_x2_x2_net4 S1N_I x_core_x3_x2_x2_net7 VDD pfet_06v0 L=1.0u W=0.5u
Mx_core_x3_x2_x2_XM17 x_core_x3_x2_x2_net8 x_core_x3_x2_net2 x_core_x3_x2_x2_net1 VSS nfet_06v0 L=1.0u W=5.0u
Mx_core_x3_x2_x2_XM18 x_core_x3_x2_x2_net1 x_core_x3_x2_net1 VSS VSS nfet_06v0 L=1.0u W=5.0u
Mx_core_x3_x2_x2_XM19 x_core_x3_x2_x2_net8 x_core_x3_x2_net2 x_core_x3_x2_x2_net19 VSS nfet_06v0 L=1.0u W=5.0u
Mx_core_x3_x2_x2_XM20 x_core_x3_x2_x2_net19 x_core_x3_x2_net1 VSS VSS nfet_06v0 L=1.0u W=5.0u
Mx_core_x3_x2_x2_XM21 x_core_x3_x2_x2_net6 S1P_I x_core_x3_x2_x2_net8 VSS nfet_06v0 L=1.0u W=7.5u
Mx_core_x3_x2_x2_XM22 x_core_x3_x2_x2_net3 S1N_I x_core_x3_x2_x2_net8 VSS nfet_06v0 L=1.0u W=8.5u
Mx_core_x3_x2_x2_XM29 x_core_x3_x2_x2_net9 x_core_x3_x2_net4 x_core_x3_x2_x2_net3 VDD pfet_06v0 L=1.0u W=10u
Mx_core_x3_x2_x2_XM30 x_core_x3_x2_x2_G_OUT_P x_core_x3_x2_net4 x_core_x3_x2_x2_net6 VDD pfet_06v0 L=1.0u W=10u
Mx_core_x3_x2_x2_XM31 x_core_x3_x2_x2_net3 x_core_x3_x2_x2_net9 VDD VDD pfet_06v0 L=1.0u W=5u
Mx_core_x3_x2_x2_XM35 x_core_x3_x2_x2_net6 x_core_x3_x2_x2_net9 VDD VDD pfet_06v0 L=1.0u W=5u
Mx_core_x3_x2_x2_XM32 x_core_x3_x2_x2_net10 x_core_x3_x2_x2_net20 x_core_x3_x2_x2_net9 VDD pfet_06v0 L=1.0u W=4.0u
Mx_core_x3_x2_x2_XM33 x_core_x3_x2_x2_net21 x_core_x3_x2_x2_net20 x_core_x3_x2_x2_G_OUT_P VDD pfet_06v0 L=1.0u W=4.0u
Mx_core_x3_x2_x2_XM23 x_core_x3_x2_x2_net10 x_core_x3_x2_net2 x_core_x3_x2_x2_net4 VSS nfet_06v0 L=1.0u W=2.5u
Mx_core_x3_x2_x2_XM24 x_core_x3_x2_x2_net21 x_core_x3_x2_net2 x_core_x3_x2_x2_net5 VSS nfet_06v0 L=1.0u W=2.5u
Mx_core_x3_x2_x2_XM25 x_core_x3_x2_x2_net4 x_core_x3_x2_x2_net10 VSS VSS nfet_06v0 L=1.0u W=2.5u
Mx_core_x3_x2_x2_XM26 x_core_x3_x2_x2_net5 x_core_x3_x2_x2_net10 VSS VSS nfet_06v0 L=1.0u W=2.5u
Mx_core_x3_x2_x2_XM27 x_core_x3_x2_x2_net9 x_core_x3_x2_x2_net11 x_core_x3_x2_x2_net10 VSS nfet_06v0 L=1.0u W=2.0u
Mx_core_x3_x2_x2_XM28 x_core_x3_x2_x2_G_OUT_P x_core_x3_x2_x2_net11 x_core_x3_x2_x2_net21 VSS nfet_06v0 L=1.0u W=2.0u
Mx_core_x3_x2_x2_XM34 x_core_x3_x2_x2_net12 x_core_x3_x2_x2_net13 VDD VDD pfet_06v0 L=1.0u W=10.0u
Mx_core_x3_x2_x2_XM36 x_core_x3_x2_x2_net13 x_core_x3_x2_net4 x_core_x3_x2_x2_net12 VDD pfet_06v0 L=1.0u W=10.0u
Mx_core_x3_x2_x2_XM37 x_core_x3_x2_x2_net20 x_core_x3_x2_x2_net20 x_core_x3_x2_x2_net13 VDD pfet_06v0 L=1.0u W=10.0u
Mx_core_x3_x2_x2_XM38 x_core_x3_x2_x2_net20 x_core_x3_x2_net2 x_core_x3_x2_x2_net14 VSS nfet_06v0 L=1.0u W=5.0u
Mx_core_x3_x2_x2_XM39 x_core_x3_x2_x2_net14 x_core_x3_x2_net1 VSS VSS nfet_06v0 L=1.0u W=5.0u
Mx_core_x3_x2_x2_XM45 x_core_x3_x2_x2_net15 x_core_x3_x2_net3 VDD VDD pfet_06v0 L=1.0u W=10.0u
Mx_core_x3_x2_x2_XM46 x_core_x3_x2_x2_net11 x_core_x3_x2_net4 x_core_x3_x2_x2_net15 VDD pfet_06v0 L=1.0u W=10.0u
Mx_core_x3_x2_x2_XM40 x_core_x3_x2_x2_net11 x_core_x3_x2_x2_net11 x_core_x3_x2_x2_net17 VSS nfet_06v0 L=1.0u W=5.0u
Mx_core_x3_x2_x2_XM41 x_core_x3_x2_x2_net17 x_core_x3_x2_net2 x_core_x3_x2_x2_net16 VSS nfet_06v0 L=1.0u W=5.0u
Mx_core_x3_x2_x2_XM42 x_core_x3_x2_x2_net16 x_core_x3_x2_x2_net17 VSS VSS nfet_06v0 L=1.0u W=5.0u
Mx_core_x3_x2_x2_XM43_m1 x_core_x3_SZ x_core_x3_x2_x2_G_OUT_P VDD VDD pfet_06v0 L=1.0u W=1.0u
Mx_core_x3_x2_x2_XM43_m2 x_core_x3_SZ x_core_x3_x2_x2_G_OUT_P VDD VDD pfet_06v0 L=1.0u W=1.0u
Mx_core_x3_x2_x2_XM43_m3 x_core_x3_SZ x_core_x3_x2_x2_G_OUT_P VDD VDD pfet_06v0 L=1.0u W=1.0u
Mx_core_x3_x2_x2_XM43_m4 x_core_x3_SZ x_core_x3_x2_x2_G_OUT_P VDD VDD pfet_06v0 L=1.0u W=1.0u
Mx_core_x3_x2_x2_XM44 x_core_x3_SZ x_core_x3_x2_x2_net21 VSS VSS nfet_06v0 L=1.0u W=1.0u
Mx_core_x4_x4_x1_XM4 x_core_x4_x4_x1_net3 x_core_x4_x4_net4 VDD VDD pfet_06v0 L=1.0u W=10.0u
Mx_core_x4_x4_x1_XM5 x_core_x4_x4_net2 x_core_x4_x4_net3 x_core_x4_x4_x1_net3 VDD pfet_06v0 L=1.0u W=10.0u
Mx_core_x4_x4_x1_XM6 x_core_x4_x4_net2 x_core_x4_x4_net2 VSS VSS nfet_06v0 L=1.0u W=1.0u
Mx_core_x4_x4_x1_XM7 x_core_x4_x4_x1_net2 x_core_x4_x4_net4 VDD VDD pfet_06v0 L=1.0u W=10.0u
Mx_core_x4_x4_x1_XM8 x_core_x4_x4_net1 x_core_x4_x4_net3 x_core_x4_x4_x1_net2 VDD pfet_06v0 L=1.0u W=10.0u
Mx_core_x4_x4_x1_XM9 x_core_x4_x4_net1 x_core_x4_x4_net2 x_core_x4_x4_x1_net1 VSS nfet_06v0 L=1.0u W=5.0u
Mx_core_x4_x4_x1_XM10 x_core_x4_x4_x1_net1 x_core_x4_x4_net1 VSS VSS nfet_06v0 L=1.0u W=5.0u
Mx_core_x4_x4_x1_XM1 x_core_x4_x4_net3 x_core_x4_x4_net3 VDD VDD pfet_06v0 L=1.0u W=2u
Mx_core_x4_x4_x1_XM2 x_core_x4_x4_x1_net4 x_core_x4_x4_net4 VDD VDD pfet_06v0 L=1.0u W=10.0u
Mx_core_x4_x4_x1_XM3 x_core_x4_x4_net4 x_core_x4_x4_net3 x_core_x4_x4_x1_net4 VDD pfet_06v0 L=1.0u W=10.0u
Mx_core_x4_x4_x1_XM47 x_core_x4_x4_x1_net5 x_core_x4_x4_net3 VSS VSS nfet_06v0 L=1.0u W=1.0u
Mx_core_x4_x4_x1_XM48 x_core_x4_x4_x1_net6 x_core_x4_x4_net3 VSS VSS nfet_06v0 L=1.0u W=1.0u
Mx_core_x4_x4_x1_XM49 x_core_x4_x4_net3 x_core_x4_x4_net3 x_core_x4_x4_x1_net6 VSS nfet_06v0 L=1.0u W=1.0u
Mx_core_x4_x4_x1_XM50 x_core_x4_x4_net4 x_core_x4_x4_net3 x_core_x4_x4_x1_net5 VSS nfet_06v0 L=1.0u W=1.0u
Mx_core_x4_x4_x2_XM11 x_core_x4_x4_x2_net2 x_core_x4_x4_net4 VDD VDD pfet_06v0 L=1.0u W=10.0u
Mx_core_x4_x4_x2_XM12 x_core_x4_x4_x2_net7 x_core_x4_x4_net3 x_core_x4_x4_x2_net2 VDD pfet_06v0 L=1.0u W=10.0u
Mx_core_x4_x4_x2_XM13 x_core_x4_x4_x2_net19 x_core_x4_x4_net4 VDD VDD pfet_06v0 L=1.0u W=10.0u
Mx_core_x4_x4_x2_XM14 x_core_x4_x4_x2_net7 x_core_x4_x4_net3 x_core_x4_x4_x2_net19 VDD pfet_06v0 L=1.0u W=10.0u
Mx_core_x4_x4_x2_XM15_f1 x_core_x4_x4_x2_net5 x_core_x4_SY x_core_x4_x4_x2_net7 VDD pfet_06v0 L=1.0u W=10.0u
Mx_core_x4_x4_x2_XM15_f2 x_core_x4_x4_x2_net5 x_core_x4_SY x_core_x4_x4_x2_net7 VDD pfet_06v0 L=1.0u W=10.0u
Mx_core_x4_x4_x2_XM16_f1 x_core_x4_x4_x2_net4 x_core_x4_SX x_core_x4_x4_x2_net7 VDD pfet_06v0 L=1.0u W=10.0u
Mx_core_x4_x4_x2_XM16_f2 x_core_x4_x4_x2_net4 x_core_x4_SX x_core_x4_x4_x2_net7 VDD pfet_06v0 L=1.0u W=10.0u
Mx_core_x4_x4_x2_XM17 x_core_x4_x4_x2_net8 x_core_x4_x4_net2 x_core_x4_x4_x2_net1 VSS nfet_06v0 L=1.0u W=5.0u
Mx_core_x4_x4_x2_XM18 x_core_x4_x4_x2_net1 x_core_x4_x4_net1 VSS VSS nfet_06v0 L=1.0u W=5.0u
Mx_core_x4_x4_x2_XM19 x_core_x4_x4_x2_net8 x_core_x4_x4_net2 x_core_x4_x4_x2_net20 VSS nfet_06v0 L=1.0u W=5.0u
Mx_core_x4_x4_x2_XM20 x_core_x4_x4_x2_net20 x_core_x4_x4_net1 VSS VSS nfet_06v0 L=1.0u W=5.0u
Mx_core_x4_x4_x2_XM21_f1 x_core_x4_x4_x2_net6 x_core_x4_SY x_core_x4_x4_x2_net8 VSS nfet_06v0 L=1.0u W=5u
Mx_core_x4_x4_x2_XM21_f2 x_core_x4_x4_x2_net6 x_core_x4_SY x_core_x4_x4_x2_net8 VSS nfet_06v0 L=1.0u W=5u
Mx_core_x4_x4_x2_XM22_f1 x_core_x4_x4_x2_net3 x_core_x4_SX x_core_x4_x4_x2_net8 VSS nfet_06v0 L=1.0u W=5u
Mx_core_x4_x4_x2_XM22_f2 x_core_x4_x4_x2_net3 x_core_x4_SX x_core_x4_x4_x2_net8 VSS nfet_06v0 L=1.0u W=5u
Mx_core_x4_x4_x2_XM29_f1 x_core_x4_x4_x2_net9 x_core_x4_x4_net3 x_core_x4_x4_x2_net3 VDD pfet_06v0 L=1.0u W=5u
Mx_core_x4_x4_x2_XM29_f2 x_core_x4_x4_x2_net9 x_core_x4_x4_net3 x_core_x4_x4_x2_net3 VDD pfet_06v0 L=1.0u W=5u
Mx_core_x4_x4_x2_XM30_f1 x_core_x4_x4_x2_net12 x_core_x4_x4_net3 x_core_x4_x4_x2_net6 VDD pfet_06v0 L=1.0u W=5.0u
Mx_core_x4_x4_x2_XM30_f2 x_core_x4_x4_x2_net12 x_core_x4_x4_net3 x_core_x4_x4_x2_net6 VDD pfet_06v0 L=1.0u W=5.0u
Mx_core_x4_x4_x2_XM31_f1 x_core_x4_x4_x2_net3 x_core_x4_x4_x2_net9 VDD VDD pfet_06v0 L=1.0u W=5u
Mx_core_x4_x4_x2_XM31_f2 x_core_x4_x4_x2_net3 x_core_x4_x4_x2_net9 VDD VDD pfet_06v0 L=1.0u W=5u
Mx_core_x4_x4_x2_XM31_f3 x_core_x4_x4_x2_net3 x_core_x4_x4_x2_net9 VDD VDD pfet_06v0 L=1.0u W=5u
Mx_core_x4_x4_x2_XM31_f4 x_core_x4_x4_x2_net3 x_core_x4_x4_x2_net9 VDD VDD pfet_06v0 L=1.0u W=5u
Mx_core_x4_x4_x2_XM35_f1 x_core_x4_x4_x2_net6 x_core_x4_x4_x2_net9 VDD VDD pfet_06v0 L=1.0u W=5.0u
Mx_core_x4_x4_x2_XM35_f2 x_core_x4_x4_x2_net6 x_core_x4_x4_x2_net9 VDD VDD pfet_06v0 L=1.0u W=5.0u
Mx_core_x4_x4_x2_XM35_f3 x_core_x4_x4_x2_net6 x_core_x4_x4_x2_net9 VDD VDD pfet_06v0 L=1.0u W=5.0u
Mx_core_x4_x4_x2_XM35_f4 x_core_x4_x4_x2_net6 x_core_x4_x4_x2_net9 VDD VDD pfet_06v0 L=1.0u W=5.0u
Mx_core_x4_x4_x2_XM32 x_core_x4_x4_x2_net10 x_core_x4_x4_x2_net21 x_core_x4_x4_x2_net9 VDD pfet_06v0 L=1.0u W=5u
Mx_core_x4_x4_x2_XM33 x_core_x4_x4_x2_net22 x_core_x4_x4_x2_net21 x_core_x4_x4_x2_net12 VDD pfet_06v0 L=1.0u W=5.0u
Mx_core_x4_x4_x2_XM23_f1 x_core_x4_x4_x2_net10 x_core_x4_x4_net2 x_core_x4_x4_x2_net4 VSS nfet_06v0 L=1.0u W=2.5u
Mx_core_x4_x4_x2_XM23_f2 x_core_x4_x4_x2_net10 x_core_x4_x4_net2 x_core_x4_x4_x2_net4 VSS nfet_06v0 L=1.0u W=2.5u
Mx_core_x4_x4_x2_XM24_f1 x_core_x4_x4_x2_net22 x_core_x4_x4_net2 x_core_x4_x4_x2_net5 VSS nfet_06v0 L=1.0u W=2.5u
Mx_core_x4_x4_x2_XM24_f2 x_core_x4_x4_x2_net22 x_core_x4_x4_net2 x_core_x4_x4_x2_net5 VSS nfet_06v0 L=1.0u W=2.5u
Mx_core_x4_x4_x2_XM25_f1 x_core_x4_x4_x2_net4 x_core_x4_x4_x2_net10 VSS VSS nfet_06v0 L=1.0u W=2.5u
Mx_core_x4_x4_x2_XM25_f2 x_core_x4_x4_x2_net4 x_core_x4_x4_x2_net10 VSS VSS nfet_06v0 L=1.0u W=2.5u
Mx_core_x4_x4_x2_XM25_f3 x_core_x4_x4_x2_net4 x_core_x4_x4_x2_net10 VSS VSS nfet_06v0 L=1.0u W=2.5u
Mx_core_x4_x4_x2_XM25_f4 x_core_x4_x4_x2_net4 x_core_x4_x4_x2_net10 VSS VSS nfet_06v0 L=1.0u W=2.5u
Mx_core_x4_x4_x2_XM26_f1 x_core_x4_x4_x2_net5 x_core_x4_x4_x2_net10 VSS VSS nfet_06v0 L=1.0u W=2.5u
Mx_core_x4_x4_x2_XM26_f2 x_core_x4_x4_x2_net5 x_core_x4_x4_x2_net10 VSS VSS nfet_06v0 L=1.0u W=2.5u
Mx_core_x4_x4_x2_XM26_f3 x_core_x4_x4_x2_net5 x_core_x4_x4_x2_net10 VSS VSS nfet_06v0 L=1.0u W=2.5u
Mx_core_x4_x4_x2_XM26_f4 x_core_x4_x4_x2_net5 x_core_x4_x4_x2_net10 VSS VSS nfet_06v0 L=1.0u W=2.5u
Mx_core_x4_x4_x2_XM27 x_core_x4_x4_x2_net9 x_core_x4_x4_x2_net11 x_core_x4_x4_x2_net10 VSS nfet_06v0 L=1.0u W=2.5u
Mx_core_x4_x4_x2_XM28 x_core_x4_x4_x2_net12 x_core_x4_x4_x2_net11 x_core_x4_x4_x2_net22 VSS nfet_06v0 L=1.0u W=2.5u
Mx_core_x4_x4_x2_XM34 x_core_x4_x4_x2_net13 x_core_x4_x4_x2_net14 VDD VDD pfet_06v0 L=1.0u W=10.0u
Mx_core_x4_x4_x2_XM36 x_core_x4_x4_x2_net14 x_core_x4_x4_net3 x_core_x4_x4_x2_net13 VDD pfet_06v0 L=1.0u W=10.0u
Mx_core_x4_x4_x2_XM37 x_core_x4_x4_x2_net21 x_core_x4_x4_x2_net21 x_core_x4_x4_x2_net14 VDD pfet_06v0 L=1.0u W=10.0u
Mx_core_x4_x4_x2_XM38 x_core_x4_x4_x2_net21 x_core_x4_x4_net2 x_core_x4_x4_x2_net15 VSS nfet_06v0 L=1.0u W=5.0u
Mx_core_x4_x4_x2_XM39 x_core_x4_x4_x2_net15 x_core_x4_x4_net1 VSS VSS nfet_06v0 L=1.0u W=5.0u
Mx_core_x4_x4_x2_XM45 x_core_x4_x4_x2_net16 x_core_x4_x4_net4 VDD VDD pfet_06v0 L=1.0u W=10.0u
Mx_core_x4_x4_x2_XM46 x_core_x4_x4_x2_net11 x_core_x4_x4_net3 x_core_x4_x4_x2_net16 VDD pfet_06v0 L=1.0u W=10.0u
Mx_core_x4_x4_x2_XM40 x_core_x4_x4_x2_net11 x_core_x4_x4_x2_net11 x_core_x4_x4_x2_net18 VSS nfet_06v0 L=1.0u W=5.0u
Mx_core_x4_x4_x2_XM41 x_core_x4_x4_x2_net18 x_core_x4_x4_net2 x_core_x4_x4_x2_net17 VSS nfet_06v0 L=1.0u W=5.0u
Mx_core_x4_x4_x2_XM42 x_core_x4_x4_x2_net17 x_core_x4_x4_x2_net18 VSS VSS nfet_06v0 L=1.0u W=5.0u
Mx_core_x4_x4_x2_XM43_f1 x_core_x4_net1 x_core_x4_x4_x2_net12 VDD VDD pfet_06v0 L=1.0u W=10u
Mx_core_x4_x4_x2_XM43_f2 x_core_x4_net1 x_core_x4_x4_x2_net12 VDD VDD pfet_06v0 L=1.0u W=10u
Mx_core_x4_x4_x2_XM43_f3 x_core_x4_net1 x_core_x4_x4_x2_net12 VDD VDD pfet_06v0 L=1.0u W=10u
Mx_core_x4_x4_x2_XM44_f1 x_core_x4_net1 x_core_x4_x4_x2_net22 VSS VSS nfet_06v0 L=1.0u W=5u
Mx_core_x4_x4_x2_XM44_f2 x_core_x4_net1 x_core_x4_x4_x2_net22 VSS VSS nfet_06v0 L=1.0u W=5u
Mx_core_x4_x4_x2_XM44_f3 x_core_x4_net1 x_core_x4_x4_x2_net22 VSS VSS nfet_06v0 L=1.0u W=5u
Mx_core_x4_x5_x1_XM4 x_core_x4_x5_x1_net3 x_core_x4_x5_net4 VDD VDD pfet_06v0 L=1.0u W=10.0u
Mx_core_x4_x5_x1_XM5 x_core_x4_x5_net2 x_core_x4_x5_net3 x_core_x4_x5_x1_net3 VDD pfet_06v0 L=1.0u W=10.0u
Mx_core_x4_x5_x1_XM6 x_core_x4_x5_net2 x_core_x4_x5_net2 VSS VSS nfet_06v0 L=1.0u W=1.0u
Mx_core_x4_x5_x1_XM7 x_core_x4_x5_x1_net2 x_core_x4_x5_net4 VDD VDD pfet_06v0 L=1.0u W=10.0u
Mx_core_x4_x5_x1_XM8 x_core_x4_x5_net1 x_core_x4_x5_net3 x_core_x4_x5_x1_net2 VDD pfet_06v0 L=1.0u W=10.0u
Mx_core_x4_x5_x1_XM9 x_core_x4_x5_net1 x_core_x4_x5_net2 x_core_x4_x5_x1_net1 VSS nfet_06v0 L=1.0u W=5.0u
Mx_core_x4_x5_x1_XM10 x_core_x4_x5_x1_net1 x_core_x4_x5_net1 VSS VSS nfet_06v0 L=1.0u W=5.0u
Mx_core_x4_x5_x1_XM1 x_core_x4_x5_net3 x_core_x4_x5_net3 VDD VDD pfet_06v0 L=1.0u W=2u
Mx_core_x4_x5_x1_XM2 x_core_x4_x5_x1_net4 x_core_x4_x5_net4 VDD VDD pfet_06v0 L=1.0u W=10.0u
Mx_core_x4_x5_x1_XM3 x_core_x4_x5_net4 x_core_x4_x5_net3 x_core_x4_x5_x1_net4 VDD pfet_06v0 L=1.0u W=10.0u
Mx_core_x4_x5_x1_XM47 x_core_x4_x5_x1_net5 x_core_x4_x5_net3 VSS VSS nfet_06v0 L=1.0u W=1.0u
Mx_core_x4_x5_x1_XM48 x_core_x4_x5_x1_net6 x_core_x4_x5_net3 VSS VSS nfet_06v0 L=1.0u W=1.0u
Mx_core_x4_x5_x1_XM49 x_core_x4_x5_net3 x_core_x4_x5_net3 x_core_x4_x5_x1_net6 VSS nfet_06v0 L=1.0u W=1.0u
Mx_core_x4_x5_x1_XM50 x_core_x4_x5_net4 x_core_x4_x5_net3 x_core_x4_x5_x1_net5 VSS nfet_06v0 L=1.0u W=1.0u
Mx_core_x4_x5_x2_XM11 x_core_x4_x5_x2_net2 x_core_x4_x5_net4 VDD VDD pfet_06v0 L=1.0u W=10.0u
Mx_core_x4_x5_x2_XM12 x_core_x4_x5_x2_net7 x_core_x4_x5_net3 x_core_x4_x5_x2_net2 VDD pfet_06v0 L=1.0u W=10.0u
Mx_core_x4_x5_x2_XM13 x_core_x4_x5_x2_net19 x_core_x4_x5_net4 VDD VDD pfet_06v0 L=1.0u W=10.0u
Mx_core_x4_x5_x2_XM14 x_core_x4_x5_x2_net7 x_core_x4_x5_net3 x_core_x4_x5_x2_net19 VDD pfet_06v0 L=1.0u W=10.0u
Mx_core_x4_x5_x2_XM15_f1 x_core_x4_x5_x2_net5 x_core_x4_SZ x_core_x4_x5_x2_net7 VDD pfet_06v0 L=1.0u W=10.0u
Mx_core_x4_x5_x2_XM15_f2 x_core_x4_x5_x2_net5 x_core_x4_SZ x_core_x4_x5_x2_net7 VDD pfet_06v0 L=1.0u W=10.0u
Mx_core_x4_x5_x2_XM16_f1 x_core_x4_x5_x2_net4 x_core_x4_SX x_core_x4_x5_x2_net7 VDD pfet_06v0 L=1.0u W=10.0u
Mx_core_x4_x5_x2_XM16_f2 x_core_x4_x5_x2_net4 x_core_x4_SX x_core_x4_x5_x2_net7 VDD pfet_06v0 L=1.0u W=10.0u
Mx_core_x4_x5_x2_XM17 x_core_x4_x5_x2_net8 x_core_x4_x5_net2 x_core_x4_x5_x2_net1 VSS nfet_06v0 L=1.0u W=5.0u
Mx_core_x4_x5_x2_XM18 x_core_x4_x5_x2_net1 x_core_x4_x5_net1 VSS VSS nfet_06v0 L=1.0u W=5.0u
Mx_core_x4_x5_x2_XM19 x_core_x4_x5_x2_net8 x_core_x4_x5_net2 x_core_x4_x5_x2_net20 VSS nfet_06v0 L=1.0u W=5.0u
Mx_core_x4_x5_x2_XM20 x_core_x4_x5_x2_net20 x_core_x4_x5_net1 VSS VSS nfet_06v0 L=1.0u W=5.0u
Mx_core_x4_x5_x2_XM21_f1 x_core_x4_x5_x2_net6 x_core_x4_SZ x_core_x4_x5_x2_net8 VSS nfet_06v0 L=1.0u W=5u
Mx_core_x4_x5_x2_XM21_f2 x_core_x4_x5_x2_net6 x_core_x4_SZ x_core_x4_x5_x2_net8 VSS nfet_06v0 L=1.0u W=5u
Mx_core_x4_x5_x2_XM22_f1 x_core_x4_x5_x2_net3 x_core_x4_SX x_core_x4_x5_x2_net8 VSS nfet_06v0 L=1.0u W=5u
Mx_core_x4_x5_x2_XM22_f2 x_core_x4_x5_x2_net3 x_core_x4_SX x_core_x4_x5_x2_net8 VSS nfet_06v0 L=1.0u W=5u
Mx_core_x4_x5_x2_XM29_f1 x_core_x4_x5_x2_net9 x_core_x4_x5_net3 x_core_x4_x5_x2_net3 VDD pfet_06v0 L=1.0u W=5u
Mx_core_x4_x5_x2_XM29_f2 x_core_x4_x5_x2_net9 x_core_x4_x5_net3 x_core_x4_x5_x2_net3 VDD pfet_06v0 L=1.0u W=5u
Mx_core_x4_x5_x2_XM30_f1 x_core_x4_x5_x2_net12 x_core_x4_x5_net3 x_core_x4_x5_x2_net6 VDD pfet_06v0 L=1.0u W=5.0u
Mx_core_x4_x5_x2_XM30_f2 x_core_x4_x5_x2_net12 x_core_x4_x5_net3 x_core_x4_x5_x2_net6 VDD pfet_06v0 L=1.0u W=5.0u
Mx_core_x4_x5_x2_XM31_f1 x_core_x4_x5_x2_net3 x_core_x4_x5_x2_net9 VDD VDD pfet_06v0 L=1.0u W=5u
Mx_core_x4_x5_x2_XM31_f2 x_core_x4_x5_x2_net3 x_core_x4_x5_x2_net9 VDD VDD pfet_06v0 L=1.0u W=5u
Mx_core_x4_x5_x2_XM31_f3 x_core_x4_x5_x2_net3 x_core_x4_x5_x2_net9 VDD VDD pfet_06v0 L=1.0u W=5u
Mx_core_x4_x5_x2_XM31_f4 x_core_x4_x5_x2_net3 x_core_x4_x5_x2_net9 VDD VDD pfet_06v0 L=1.0u W=5u
Mx_core_x4_x5_x2_XM35_f1 x_core_x4_x5_x2_net6 x_core_x4_x5_x2_net9 VDD VDD pfet_06v0 L=1.0u W=5.0u
Mx_core_x4_x5_x2_XM35_f2 x_core_x4_x5_x2_net6 x_core_x4_x5_x2_net9 VDD VDD pfet_06v0 L=1.0u W=5.0u
Mx_core_x4_x5_x2_XM35_f3 x_core_x4_x5_x2_net6 x_core_x4_x5_x2_net9 VDD VDD pfet_06v0 L=1.0u W=5.0u
Mx_core_x4_x5_x2_XM35_f4 x_core_x4_x5_x2_net6 x_core_x4_x5_x2_net9 VDD VDD pfet_06v0 L=1.0u W=5.0u
Mx_core_x4_x5_x2_XM32 x_core_x4_x5_x2_net10 x_core_x4_x5_x2_net21 x_core_x4_x5_x2_net9 VDD pfet_06v0 L=1.0u W=5u
Mx_core_x4_x5_x2_XM33 x_core_x4_x5_x2_net22 x_core_x4_x5_x2_net21 x_core_x4_x5_x2_net12 VDD pfet_06v0 L=1.0u W=5.0u
Mx_core_x4_x5_x2_XM23_f1 x_core_x4_x5_x2_net10 x_core_x4_x5_net2 x_core_x4_x5_x2_net4 VSS nfet_06v0 L=1.0u W=2.5u
Mx_core_x4_x5_x2_XM23_f2 x_core_x4_x5_x2_net10 x_core_x4_x5_net2 x_core_x4_x5_x2_net4 VSS nfet_06v0 L=1.0u W=2.5u
Mx_core_x4_x5_x2_XM24_f1 x_core_x4_x5_x2_net22 x_core_x4_x5_net2 x_core_x4_x5_x2_net5 VSS nfet_06v0 L=1.0u W=2.5u
Mx_core_x4_x5_x2_XM24_f2 x_core_x4_x5_x2_net22 x_core_x4_x5_net2 x_core_x4_x5_x2_net5 VSS nfet_06v0 L=1.0u W=2.5u
Mx_core_x4_x5_x2_XM25_f1 x_core_x4_x5_x2_net4 x_core_x4_x5_x2_net10 VSS VSS nfet_06v0 L=1.0u W=2.5u
Mx_core_x4_x5_x2_XM25_f2 x_core_x4_x5_x2_net4 x_core_x4_x5_x2_net10 VSS VSS nfet_06v0 L=1.0u W=2.5u
Mx_core_x4_x5_x2_XM25_f3 x_core_x4_x5_x2_net4 x_core_x4_x5_x2_net10 VSS VSS nfet_06v0 L=1.0u W=2.5u
Mx_core_x4_x5_x2_XM25_f4 x_core_x4_x5_x2_net4 x_core_x4_x5_x2_net10 VSS VSS nfet_06v0 L=1.0u W=2.5u
Mx_core_x4_x5_x2_XM26_f1 x_core_x4_x5_x2_net5 x_core_x4_x5_x2_net10 VSS VSS nfet_06v0 L=1.0u W=2.5u
Mx_core_x4_x5_x2_XM26_f2 x_core_x4_x5_x2_net5 x_core_x4_x5_x2_net10 VSS VSS nfet_06v0 L=1.0u W=2.5u
Mx_core_x4_x5_x2_XM26_f3 x_core_x4_x5_x2_net5 x_core_x4_x5_x2_net10 VSS VSS nfet_06v0 L=1.0u W=2.5u
Mx_core_x4_x5_x2_XM26_f4 x_core_x4_x5_x2_net5 x_core_x4_x5_x2_net10 VSS VSS nfet_06v0 L=1.0u W=2.5u
Mx_core_x4_x5_x2_XM27 x_core_x4_x5_x2_net9 x_core_x4_x5_x2_net11 x_core_x4_x5_x2_net10 VSS nfet_06v0 L=1.0u W=2.5u
Mx_core_x4_x5_x2_XM28 x_core_x4_x5_x2_net12 x_core_x4_x5_x2_net11 x_core_x4_x5_x2_net22 VSS nfet_06v0 L=1.0u W=2.5u
Mx_core_x4_x5_x2_XM34 x_core_x4_x5_x2_net13 x_core_x4_x5_x2_net14 VDD VDD pfet_06v0 L=1.0u W=10.0u
Mx_core_x4_x5_x2_XM36 x_core_x4_x5_x2_net14 x_core_x4_x5_net3 x_core_x4_x5_x2_net13 VDD pfet_06v0 L=1.0u W=10.0u
Mx_core_x4_x5_x2_XM37 x_core_x4_x5_x2_net21 x_core_x4_x5_x2_net21 x_core_x4_x5_x2_net14 VDD pfet_06v0 L=1.0u W=10.0u
Mx_core_x4_x5_x2_XM38 x_core_x4_x5_x2_net21 x_core_x4_x5_net2 x_core_x4_x5_x2_net15 VSS nfet_06v0 L=1.0u W=5.0u
Mx_core_x4_x5_x2_XM39 x_core_x4_x5_x2_net15 x_core_x4_x5_net1 VSS VSS nfet_06v0 L=1.0u W=5.0u
Mx_core_x4_x5_x2_XM45 x_core_x4_x5_x2_net16 x_core_x4_x5_net4 VDD VDD pfet_06v0 L=1.0u W=10.0u
Mx_core_x4_x5_x2_XM46 x_core_x4_x5_x2_net11 x_core_x4_x5_net3 x_core_x4_x5_x2_net16 VDD pfet_06v0 L=1.0u W=10.0u
Mx_core_x4_x5_x2_XM40 x_core_x4_x5_x2_net11 x_core_x4_x5_x2_net11 x_core_x4_x5_x2_net18 VSS nfet_06v0 L=1.0u W=5.0u
Mx_core_x4_x5_x2_XM41 x_core_x4_x5_x2_net18 x_core_x4_x5_net2 x_core_x4_x5_x2_net17 VSS nfet_06v0 L=1.0u W=5.0u
Mx_core_x4_x5_x2_XM42 x_core_x4_x5_x2_net17 x_core_x4_x5_x2_net18 VSS VSS nfet_06v0 L=1.0u W=5.0u
Mx_core_x4_x5_x2_XM43_f1 x_core_x4_net2 x_core_x4_x5_x2_net12 VDD VDD pfet_06v0 L=1.0u W=10u
Mx_core_x4_x5_x2_XM43_f2 x_core_x4_net2 x_core_x4_x5_x2_net12 VDD VDD pfet_06v0 L=1.0u W=10u
Mx_core_x4_x5_x2_XM43_f3 x_core_x4_net2 x_core_x4_x5_x2_net12 VDD VDD pfet_06v0 L=1.0u W=10u
Mx_core_x4_x5_x2_XM44_f1 x_core_x4_net2 x_core_x4_x5_x2_net22 VSS VSS nfet_06v0 L=1.0u W=5u
Mx_core_x4_x5_x2_XM44_f2 x_core_x4_net2 x_core_x4_x5_x2_net22 VSS VSS nfet_06v0 L=1.0u W=5u
Mx_core_x4_x5_x2_XM44_f3 x_core_x4_net2 x_core_x4_x5_x2_net22 VSS VSS nfet_06v0 L=1.0u W=5u
Mx_core_x4_x6_x1_XM4 x_core_x4_x6_x1_net3 x_core_x4_x6_net4 VDD VDD pfet_06v0 L=1.0u W=10.0u
Mx_core_x4_x6_x1_XM5 x_core_x4_x6_net2 x_core_x4_x6_net3 x_core_x4_x6_x1_net3 VDD pfet_06v0 L=1.0u W=10.0u
Mx_core_x4_x6_x1_XM6 x_core_x4_x6_net2 x_core_x4_x6_net2 VSS VSS nfet_06v0 L=1.0u W=1.0u
Mx_core_x4_x6_x1_XM7 x_core_x4_x6_x1_net2 x_core_x4_x6_net4 VDD VDD pfet_06v0 L=1.0u W=10.0u
Mx_core_x4_x6_x1_XM8 x_core_x4_x6_net1 x_core_x4_x6_net3 x_core_x4_x6_x1_net2 VDD pfet_06v0 L=1.0u W=10.0u
Mx_core_x4_x6_x1_XM9 x_core_x4_x6_net1 x_core_x4_x6_net2 x_core_x4_x6_x1_net1 VSS nfet_06v0 L=1.0u W=5.0u
Mx_core_x4_x6_x1_XM10 x_core_x4_x6_x1_net1 x_core_x4_x6_net1 VSS VSS nfet_06v0 L=1.0u W=5.0u
Mx_core_x4_x6_x1_XM1 x_core_x4_x6_net3 x_core_x4_x6_net3 VDD VDD pfet_06v0 L=1.0u W=2u
Mx_core_x4_x6_x1_XM2 x_core_x4_x6_x1_net4 x_core_x4_x6_net4 VDD VDD pfet_06v0 L=1.0u W=10.0u
Mx_core_x4_x6_x1_XM3 x_core_x4_x6_net4 x_core_x4_x6_net3 x_core_x4_x6_x1_net4 VDD pfet_06v0 L=1.0u W=10.0u
Mx_core_x4_x6_x1_XM47 x_core_x4_x6_x1_net5 x_core_x4_x6_net3 VSS VSS nfet_06v0 L=1.0u W=1.0u
Mx_core_x4_x6_x1_XM48 x_core_x4_x6_x1_net6 x_core_x4_x6_net3 VSS VSS nfet_06v0 L=1.0u W=1.0u
Mx_core_x4_x6_x1_XM49 x_core_x4_x6_net3 x_core_x4_x6_net3 x_core_x4_x6_x1_net6 VSS nfet_06v0 L=1.0u W=1.0u
Mx_core_x4_x6_x1_XM50 x_core_x4_x6_net4 x_core_x4_x6_net3 x_core_x4_x6_x1_net5 VSS nfet_06v0 L=1.0u W=1.0u
Mx_core_x4_x6_x2_XM11 x_core_x4_x6_x2_net2 x_core_x4_x6_net4 VDD VDD pfet_06v0 L=1.0u W=10.0u
Mx_core_x4_x6_x2_XM12 x_core_x4_x6_x2_net7 x_core_x4_x6_net3 x_core_x4_x6_x2_net2 VDD pfet_06v0 L=1.0u W=10.0u
Mx_core_x4_x6_x2_XM13 x_core_x4_x6_x2_net19 x_core_x4_x6_net4 VDD VDD pfet_06v0 L=1.0u W=10.0u
Mx_core_x4_x6_x2_XM14 x_core_x4_x6_x2_net7 x_core_x4_x6_net3 x_core_x4_x6_x2_net19 VDD pfet_06v0 L=1.0u W=10.0u
Mx_core_x4_x6_x2_XM15_f1 x_core_x4_x6_x2_net5 x_core_x4_SZ x_core_x4_x6_x2_net7 VDD pfet_06v0 L=1.0u W=10.0u
Mx_core_x4_x6_x2_XM15_f2 x_core_x4_x6_x2_net5 x_core_x4_SZ x_core_x4_x6_x2_net7 VDD pfet_06v0 L=1.0u W=10.0u
Mx_core_x4_x6_x2_XM16_f1 x_core_x4_x6_x2_net4 x_core_x4_SY x_core_x4_x6_x2_net7 VDD pfet_06v0 L=1.0u W=10.0u
Mx_core_x4_x6_x2_XM16_f2 x_core_x4_x6_x2_net4 x_core_x4_SY x_core_x4_x6_x2_net7 VDD pfet_06v0 L=1.0u W=10.0u
Mx_core_x4_x6_x2_XM17 x_core_x4_x6_x2_net8 x_core_x4_x6_net2 x_core_x4_x6_x2_net1 VSS nfet_06v0 L=1.0u W=5.0u
Mx_core_x4_x6_x2_XM18 x_core_x4_x6_x2_net1 x_core_x4_x6_net1 VSS VSS nfet_06v0 L=1.0u W=5.0u
Mx_core_x4_x6_x2_XM19 x_core_x4_x6_x2_net8 x_core_x4_x6_net2 x_core_x4_x6_x2_net20 VSS nfet_06v0 L=1.0u W=5.0u
Mx_core_x4_x6_x2_XM20 x_core_x4_x6_x2_net20 x_core_x4_x6_net1 VSS VSS nfet_06v0 L=1.0u W=5.0u
Mx_core_x4_x6_x2_XM21_f1 x_core_x4_x6_x2_net6 x_core_x4_SZ x_core_x4_x6_x2_net8 VSS nfet_06v0 L=1.0u W=5u
Mx_core_x4_x6_x2_XM21_f2 x_core_x4_x6_x2_net6 x_core_x4_SZ x_core_x4_x6_x2_net8 VSS nfet_06v0 L=1.0u W=5u
Mx_core_x4_x6_x2_XM22_f1 x_core_x4_x6_x2_net3 x_core_x4_SY x_core_x4_x6_x2_net8 VSS nfet_06v0 L=1.0u W=5u
Mx_core_x4_x6_x2_XM22_f2 x_core_x4_x6_x2_net3 x_core_x4_SY x_core_x4_x6_x2_net8 VSS nfet_06v0 L=1.0u W=5u
Mx_core_x4_x6_x2_XM29_f1 x_core_x4_x6_x2_net9 x_core_x4_x6_net3 x_core_x4_x6_x2_net3 VDD pfet_06v0 L=1.0u W=5u
Mx_core_x4_x6_x2_XM29_f2 x_core_x4_x6_x2_net9 x_core_x4_x6_net3 x_core_x4_x6_x2_net3 VDD pfet_06v0 L=1.0u W=5u
Mx_core_x4_x6_x2_XM30_f1 x_core_x4_x6_x2_net12 x_core_x4_x6_net3 x_core_x4_x6_x2_net6 VDD pfet_06v0 L=1.0u W=5.0u
Mx_core_x4_x6_x2_XM30_f2 x_core_x4_x6_x2_net12 x_core_x4_x6_net3 x_core_x4_x6_x2_net6 VDD pfet_06v0 L=1.0u W=5.0u
Mx_core_x4_x6_x2_XM31_f1 x_core_x4_x6_x2_net3 x_core_x4_x6_x2_net9 VDD VDD pfet_06v0 L=1.0u W=5u
Mx_core_x4_x6_x2_XM31_f2 x_core_x4_x6_x2_net3 x_core_x4_x6_x2_net9 VDD VDD pfet_06v0 L=1.0u W=5u
Mx_core_x4_x6_x2_XM31_f3 x_core_x4_x6_x2_net3 x_core_x4_x6_x2_net9 VDD VDD pfet_06v0 L=1.0u W=5u
Mx_core_x4_x6_x2_XM31_f4 x_core_x4_x6_x2_net3 x_core_x4_x6_x2_net9 VDD VDD pfet_06v0 L=1.0u W=5u
Mx_core_x4_x6_x2_XM35_f1 x_core_x4_x6_x2_net6 x_core_x4_x6_x2_net9 VDD VDD pfet_06v0 L=1.0u W=5.0u
Mx_core_x4_x6_x2_XM35_f2 x_core_x4_x6_x2_net6 x_core_x4_x6_x2_net9 VDD VDD pfet_06v0 L=1.0u W=5.0u
Mx_core_x4_x6_x2_XM35_f3 x_core_x4_x6_x2_net6 x_core_x4_x6_x2_net9 VDD VDD pfet_06v0 L=1.0u W=5.0u
Mx_core_x4_x6_x2_XM35_f4 x_core_x4_x6_x2_net6 x_core_x4_x6_x2_net9 VDD VDD pfet_06v0 L=1.0u W=5.0u
Mx_core_x4_x6_x2_XM32 x_core_x4_x6_x2_net10 x_core_x4_x6_x2_net21 x_core_x4_x6_x2_net9 VDD pfet_06v0 L=1.0u W=5u
Mx_core_x4_x6_x2_XM33 x_core_x4_x6_x2_net22 x_core_x4_x6_x2_net21 x_core_x4_x6_x2_net12 VDD pfet_06v0 L=1.0u W=5.0u
Mx_core_x4_x6_x2_XM23_f1 x_core_x4_x6_x2_net10 x_core_x4_x6_net2 x_core_x4_x6_x2_net4 VSS nfet_06v0 L=1.0u W=2.5u
Mx_core_x4_x6_x2_XM23_f2 x_core_x4_x6_x2_net10 x_core_x4_x6_net2 x_core_x4_x6_x2_net4 VSS nfet_06v0 L=1.0u W=2.5u
Mx_core_x4_x6_x2_XM24_f1 x_core_x4_x6_x2_net22 x_core_x4_x6_net2 x_core_x4_x6_x2_net5 VSS nfet_06v0 L=1.0u W=2.5u
Mx_core_x4_x6_x2_XM24_f2 x_core_x4_x6_x2_net22 x_core_x4_x6_net2 x_core_x4_x6_x2_net5 VSS nfet_06v0 L=1.0u W=2.5u
Mx_core_x4_x6_x2_XM25_f1 x_core_x4_x6_x2_net4 x_core_x4_x6_x2_net10 VSS VSS nfet_06v0 L=1.0u W=2.5u
Mx_core_x4_x6_x2_XM25_f2 x_core_x4_x6_x2_net4 x_core_x4_x6_x2_net10 VSS VSS nfet_06v0 L=1.0u W=2.5u
Mx_core_x4_x6_x2_XM25_f3 x_core_x4_x6_x2_net4 x_core_x4_x6_x2_net10 VSS VSS nfet_06v0 L=1.0u W=2.5u
Mx_core_x4_x6_x2_XM25_f4 x_core_x4_x6_x2_net4 x_core_x4_x6_x2_net10 VSS VSS nfet_06v0 L=1.0u W=2.5u
Mx_core_x4_x6_x2_XM26_f1 x_core_x4_x6_x2_net5 x_core_x4_x6_x2_net10 VSS VSS nfet_06v0 L=1.0u W=2.5u
Mx_core_x4_x6_x2_XM26_f2 x_core_x4_x6_x2_net5 x_core_x4_x6_x2_net10 VSS VSS nfet_06v0 L=1.0u W=2.5u
Mx_core_x4_x6_x2_XM26_f3 x_core_x4_x6_x2_net5 x_core_x4_x6_x2_net10 VSS VSS nfet_06v0 L=1.0u W=2.5u
Mx_core_x4_x6_x2_XM26_f4 x_core_x4_x6_x2_net5 x_core_x4_x6_x2_net10 VSS VSS nfet_06v0 L=1.0u W=2.5u
Mx_core_x4_x6_x2_XM27 x_core_x4_x6_x2_net9 x_core_x4_x6_x2_net11 x_core_x4_x6_x2_net10 VSS nfet_06v0 L=1.0u W=2.5u
Mx_core_x4_x6_x2_XM28 x_core_x4_x6_x2_net12 x_core_x4_x6_x2_net11 x_core_x4_x6_x2_net22 VSS nfet_06v0 L=1.0u W=2.5u
Mx_core_x4_x6_x2_XM34 x_core_x4_x6_x2_net13 x_core_x4_x6_x2_net14 VDD VDD pfet_06v0 L=1.0u W=10.0u
Mx_core_x4_x6_x2_XM36 x_core_x4_x6_x2_net14 x_core_x4_x6_net3 x_core_x4_x6_x2_net13 VDD pfet_06v0 L=1.0u W=10.0u
Mx_core_x4_x6_x2_XM37 x_core_x4_x6_x2_net21 x_core_x4_x6_x2_net21 x_core_x4_x6_x2_net14 VDD pfet_06v0 L=1.0u W=10.0u
Mx_core_x4_x6_x2_XM38 x_core_x4_x6_x2_net21 x_core_x4_x6_net2 x_core_x4_x6_x2_net15 VSS nfet_06v0 L=1.0u W=5.0u
Mx_core_x4_x6_x2_XM39 x_core_x4_x6_x2_net15 x_core_x4_x6_net1 VSS VSS nfet_06v0 L=1.0u W=5.0u
Mx_core_x4_x6_x2_XM45 x_core_x4_x6_x2_net16 x_core_x4_x6_net4 VDD VDD pfet_06v0 L=1.0u W=10.0u
Mx_core_x4_x6_x2_XM46 x_core_x4_x6_x2_net11 x_core_x4_x6_net3 x_core_x4_x6_x2_net16 VDD pfet_06v0 L=1.0u W=10.0u
Mx_core_x4_x6_x2_XM40 x_core_x4_x6_x2_net11 x_core_x4_x6_x2_net11 x_core_x4_x6_x2_net18 VSS nfet_06v0 L=1.0u W=5.0u
Mx_core_x4_x6_x2_XM41 x_core_x4_x6_x2_net18 x_core_x4_x6_net2 x_core_x4_x6_x2_net17 VSS nfet_06v0 L=1.0u W=5.0u
Mx_core_x4_x6_x2_XM42 x_core_x4_x6_x2_net17 x_core_x4_x6_x2_net18 VSS VSS nfet_06v0 L=1.0u W=5.0u
Mx_core_x4_x6_x2_XM43_f1 x_core_x4_net3 x_core_x4_x6_x2_net12 VDD VDD pfet_06v0 L=1.0u W=10u
Mx_core_x4_x6_x2_XM43_f2 x_core_x4_net3 x_core_x4_x6_x2_net12 VDD VDD pfet_06v0 L=1.0u W=10u
Mx_core_x4_x6_x2_XM43_f3 x_core_x4_net3 x_core_x4_x6_x2_net12 VDD VDD pfet_06v0 L=1.0u W=10u
Mx_core_x4_x6_x2_XM44_f1 x_core_x4_net3 x_core_x4_x6_x2_net22 VSS VSS nfet_06v0 L=1.0u W=5u
Mx_core_x4_x6_x2_XM44_f2 x_core_x4_net3 x_core_x4_x6_x2_net22 VSS VSS nfet_06v0 L=1.0u W=5u
Mx_core_x4_x6_x2_XM44_f3 x_core_x4_net3 x_core_x4_x6_x2_net22 VSS VSS nfet_06v0 L=1.0u W=5u
Mx_core_x4_x7_x2_x2_XM4 x_core_x4_x7_x2_net1 x_core_x4_net1 VDD VDD pfet_06v0 L=1.0u W=3.0u
Mx_core_x4_x7_x2_x2_XM5 VSS x_core_x4_net1 x_core_x4_x7_x2_net1 VSS nfet_06v0 L=1u W=1u
Mx_core_x4_x7_x2_x3_XM4 x_core_Y4 x_core_x4_x7_x2_x3_net1 VDD VDD pfet_06v0 L=1.0u W=3.0u
Mx_core_x4_x7_x2_x3_XM5 VSS x_core_x4_x7_x2_x3_net1 x_core_Y4 VSS nfet_06v0 L=1u W=1u
Mx_core_x4_x7_x2_x3_XM2 VDD x_core_x4_net3 x_core_x4_x7_x2_x3_net1 VDD pfet_06v0 L=1.0u W=3.0u
Mx_core_x4_x7_x2_x3_XM1 VDD x_core_x4_x7_x2_net1 x_core_x4_x7_x2_x3_net1 VDD pfet_06v0 L=1.0u W=3.0u
Mx_core_x4_x7_x2_x3_XM3 VSS x_core_x4_net3 x_core_x4_x7_x2_x3_net2 VSS nfet_06v0 L=1u W=1u
Mx_core_x4_x7_x2_x3_XM6 x_core_x4_x7_x2_x3_net2 x_core_x4_x7_x2_net1 x_core_x4_x7_x2_x3_net1 VSS nfet_06v0 L=1u W=1u
Mx_core_x4_x7_x1_XM4 x_core_x4_x7_x1_net1 x_core_x4_net3 x_core_Z4 VDD pfet_06v0 L=1.0u W=3.0u
Mx_core_x4_x7_x1_XM5 VDD x_core_x4_net2 x_core_x4_x7_x1_net1 VDD pfet_06v0 L=1.0u W=3.0u
Mx_core_x4_x7_x1_XM7 VSS x_core_x4_net3 x_core_Z4 VSS nfet_06v0 L=1u W=1u
Mx_core_x4_x7_x1_XM1 VSS x_core_x4_net2 x_core_Z4 VSS nfet_06v0 L=1u W=1u
Mx_core_x4_x7_x3_x2_XM4 x_core_X4 x_core_x4_x7_x3_x2_net1 VDD VDD pfet_06v0 L=1.0u W=3.0u
Mx_core_x4_x7_x3_x2_XM5 VSS x_core_x4_x7_x3_x2_net1 x_core_X4 VSS nfet_06v0 L=1u W=1u
Mx_core_x4_x7_x3_x2_XM2 VDD x_core_x4_net1 x_core_x4_x7_x3_x2_net1 VDD pfet_06v0 L=1.0u W=3.0u
Mx_core_x4_x7_x3_x2_XM1 VDD x_core_x4_net2 x_core_x4_x7_x3_x2_net1 VDD pfet_06v0 L=1.0u W=3.0u
Mx_core_x4_x7_x3_x2_XM3 VSS x_core_x4_net1 x_core_x4_x7_x3_x2_net2 VSS nfet_06v0 L=1u W=1u
Mx_core_x4_x7_x3_x2_XM6 x_core_x4_x7_x3_x2_net2 x_core_x4_net2 x_core_x4_x7_x3_x2_net1 VSS nfet_06v0 L=1u W=1u
Mx_core_x4_x8_x1_XM4 x_core_x4_x8_x1_net3 x_core_x4_x8_net3 VDD VDD pfet_06v0 L=1.0u W=10.0u
Mx_core_x4_x8_x1_XM5 x_core_x4_x8_net2 x_core_x4_x8_net4 x_core_x4_x8_x1_net3 VDD pfet_06v0 L=1.0u W=10.0u
Mx_core_x4_x8_x1_XM6 x_core_x4_x8_net2 x_core_x4_x8_net2 VSS VSS nfet_06v0 L=1.0u W=1.0u
Mx_core_x4_x8_x1_XM7 x_core_x4_x8_x1_net2 x_core_x4_x8_net3 VDD VDD pfet_06v0 L=1.0u W=10.0u
Mx_core_x4_x8_x1_XM8 x_core_x4_x8_net1 x_core_x4_x8_net4 x_core_x4_x8_x1_net2 VDD pfet_06v0 L=1.0u W=10.0u
Mx_core_x4_x8_x1_XM9 x_core_x4_x8_net1 x_core_x4_x8_net2 x_core_x4_x8_x1_net1 VSS nfet_06v0 L=1.0u W=5.0u
Mx_core_x4_x8_x1_XM10 x_core_x4_x8_x1_net1 x_core_x4_x8_net1 VSS VSS nfet_06v0 L=1.0u W=5.0u
Mx_core_x4_x8_x1_XM1 x_core_x4_x8_net4 x_core_x4_x8_net4 VDD VDD pfet_06v0 L=1.0u W=2u
Mx_core_x4_x8_x1_XM2 x_core_x4_x8_x1_net4 x_core_x4_x8_net3 VDD VDD pfet_06v0 L=1.0u W=10.0u
Mx_core_x4_x8_x1_XM3 x_core_x4_x8_net3 x_core_x4_x8_net4 x_core_x4_x8_x1_net4 VDD pfet_06v0 L=1.0u W=10.0u
Mx_core_x4_x8_x1_XM47 x_core_x4_x8_x1_net5 x_core_x4_x8_net4 VSS VSS nfet_06v0 L=1.0u W=1.0u
Mx_core_x4_x8_x1_XM48 x_core_x4_x8_x1_net6 x_core_x4_x8_net4 VSS VSS nfet_06v0 L=1.0u W=1.0u
Mx_core_x4_x8_x1_XM49 x_core_x4_x8_net4 x_core_x4_x8_net4 x_core_x4_x8_x1_net6 VSS nfet_06v0 L=1.0u W=1.0u
Mx_core_x4_x8_x1_XM50 x_core_x4_x8_net3 x_core_x4_x8_net4 x_core_x4_x8_x1_net5 VSS nfet_06v0 L=1.0u W=1.0u
Mx_core_x4_x8_x2_XM11 x_core_x4_x8_x2_net2 x_core_x4_x8_net3 VDD VDD pfet_06v0 L=1.0u W=10.0u
Mx_core_x4_x8_x2_XM12 x_core_x4_x8_x2_net7 x_core_x4_x8_net4 x_core_x4_x8_x2_net2 VDD pfet_06v0 L=1.0u W=10.0u
Mx_core_x4_x8_x2_XM13 x_core_x4_x8_x2_net18 x_core_x4_x8_net3 VDD VDD pfet_06v0 L=1.0u W=10.0u
Mx_core_x4_x8_x2_XM14 x_core_x4_x8_x2_net7 x_core_x4_x8_net4 x_core_x4_x8_x2_net18 VDD pfet_06v0 L=1.0u W=10.0u
Mx_core_x4_x8_x2_XM15 x_core_x4_x8_x2_net5 S2P_I x_core_x4_x8_x2_net7 VDD pfet_06v0 L=1.0u W=0.55u
Mx_core_x4_x8_x2_XM16 x_core_x4_x8_x2_net4 S2N_I x_core_x4_x8_x2_net7 VDD pfet_06v0 L=1.0u W=0.5u
Mx_core_x4_x8_x2_XM17 x_core_x4_x8_x2_net8 x_core_x4_x8_net2 x_core_x4_x8_x2_net1 VSS nfet_06v0 L=1.0u W=5.0u
Mx_core_x4_x8_x2_XM18 x_core_x4_x8_x2_net1 x_core_x4_x8_net1 VSS VSS nfet_06v0 L=1.0u W=5.0u
Mx_core_x4_x8_x2_XM19 x_core_x4_x8_x2_net8 x_core_x4_x8_net2 x_core_x4_x8_x2_net19 VSS nfet_06v0 L=1.0u W=5.0u
Mx_core_x4_x8_x2_XM20 x_core_x4_x8_x2_net19 x_core_x4_x8_net1 VSS VSS nfet_06v0 L=1.0u W=5.0u
Mx_core_x4_x8_x2_XM21 x_core_x4_x8_x2_net6 S2P_I x_core_x4_x8_x2_net8 VSS nfet_06v0 L=1.0u W=7.5u
Mx_core_x4_x8_x2_XM22 x_core_x4_x8_x2_net3 S2N_I x_core_x4_x8_x2_net8 VSS nfet_06v0 L=1.0u W=8.5u
Mx_core_x4_x8_x2_XM29 x_core_x4_x8_x2_net9 x_core_x4_x8_net4 x_core_x4_x8_x2_net3 VDD pfet_06v0 L=1.0u W=10u
Mx_core_x4_x8_x2_XM30 x_core_x4_x8_x2_G_OUT_P x_core_x4_x8_net4 x_core_x4_x8_x2_net6 VDD pfet_06v0 L=1.0u W=10u
Mx_core_x4_x8_x2_XM31 x_core_x4_x8_x2_net3 x_core_x4_x8_x2_net9 VDD VDD pfet_06v0 L=1.0u W=5u
Mx_core_x4_x8_x2_XM35 x_core_x4_x8_x2_net6 x_core_x4_x8_x2_net9 VDD VDD pfet_06v0 L=1.0u W=5u
Mx_core_x4_x8_x2_XM32 x_core_x4_x8_x2_net10 x_core_x4_x8_x2_net20 x_core_x4_x8_x2_net9 VDD pfet_06v0 L=1.0u W=4.0u
Mx_core_x4_x8_x2_XM33 x_core_x4_x8_x2_net21 x_core_x4_x8_x2_net20 x_core_x4_x8_x2_G_OUT_P VDD pfet_06v0 L=1.0u W=4.0u
Mx_core_x4_x8_x2_XM23 x_core_x4_x8_x2_net10 x_core_x4_x8_net2 x_core_x4_x8_x2_net4 VSS nfet_06v0 L=1.0u W=2.5u
Mx_core_x4_x8_x2_XM24 x_core_x4_x8_x2_net21 x_core_x4_x8_net2 x_core_x4_x8_x2_net5 VSS nfet_06v0 L=1.0u W=2.5u
Mx_core_x4_x8_x2_XM25 x_core_x4_x8_x2_net4 x_core_x4_x8_x2_net10 VSS VSS nfet_06v0 L=1.0u W=2.5u
Mx_core_x4_x8_x2_XM26 x_core_x4_x8_x2_net5 x_core_x4_x8_x2_net10 VSS VSS nfet_06v0 L=1.0u W=2.5u
Mx_core_x4_x8_x2_XM27 x_core_x4_x8_x2_net9 x_core_x4_x8_x2_net11 x_core_x4_x8_x2_net10 VSS nfet_06v0 L=1.0u W=2.0u
Mx_core_x4_x8_x2_XM28 x_core_x4_x8_x2_G_OUT_P x_core_x4_x8_x2_net11 x_core_x4_x8_x2_net21 VSS nfet_06v0 L=1.0u W=2.0u
Mx_core_x4_x8_x2_XM34 x_core_x4_x8_x2_net12 x_core_x4_x8_x2_net13 VDD VDD pfet_06v0 L=1.0u W=10.0u
Mx_core_x4_x8_x2_XM36 x_core_x4_x8_x2_net13 x_core_x4_x8_net4 x_core_x4_x8_x2_net12 VDD pfet_06v0 L=1.0u W=10.0u
Mx_core_x4_x8_x2_XM37 x_core_x4_x8_x2_net20 x_core_x4_x8_x2_net20 x_core_x4_x8_x2_net13 VDD pfet_06v0 L=1.0u W=10.0u
Mx_core_x4_x8_x2_XM38 x_core_x4_x8_x2_net20 x_core_x4_x8_net2 x_core_x4_x8_x2_net14 VSS nfet_06v0 L=1.0u W=5.0u
Mx_core_x4_x8_x2_XM39 x_core_x4_x8_x2_net14 x_core_x4_x8_net1 VSS VSS nfet_06v0 L=1.0u W=5.0u
Mx_core_x4_x8_x2_XM45 x_core_x4_x8_x2_net15 x_core_x4_x8_net3 VDD VDD pfet_06v0 L=1.0u W=10.0u
Mx_core_x4_x8_x2_XM46 x_core_x4_x8_x2_net11 x_core_x4_x8_net4 x_core_x4_x8_x2_net15 VDD pfet_06v0 L=1.0u W=10.0u
Mx_core_x4_x8_x2_XM40 x_core_x4_x8_x2_net11 x_core_x4_x8_x2_net11 x_core_x4_x8_x2_net17 VSS nfet_06v0 L=1.0u W=5.0u
Mx_core_x4_x8_x2_XM41 x_core_x4_x8_x2_net17 x_core_x4_x8_net2 x_core_x4_x8_x2_net16 VSS nfet_06v0 L=1.0u W=5.0u
Mx_core_x4_x8_x2_XM42 x_core_x4_x8_x2_net16 x_core_x4_x8_x2_net17 VSS VSS nfet_06v0 L=1.0u W=5.0u
Mx_core_x4_x8_x2_XM43_m1 x_core_x4_SX x_core_x4_x8_x2_G_OUT_P VDD VDD pfet_06v0 L=1.0u W=1.0u
Mx_core_x4_x8_x2_XM43_m2 x_core_x4_SX x_core_x4_x8_x2_G_OUT_P VDD VDD pfet_06v0 L=1.0u W=1.0u
Mx_core_x4_x8_x2_XM43_m3 x_core_x4_SX x_core_x4_x8_x2_G_OUT_P VDD VDD pfet_06v0 L=1.0u W=1.0u
Mx_core_x4_x8_x2_XM43_m4 x_core_x4_SX x_core_x4_x8_x2_G_OUT_P VDD VDD pfet_06v0 L=1.0u W=1.0u
Mx_core_x4_x8_x2_XM44 x_core_x4_SX x_core_x4_x8_x2_net21 VSS VSS nfet_06v0 L=1.0u W=1.0u
Mx_core_x4_x1_x1_XM4 x_core_x4_x1_x1_net3 x_core_x4_x1_net3 VDD VDD pfet_06v0 L=1.0u W=10.0u
Mx_core_x4_x1_x1_XM5 x_core_x4_x1_net2 x_core_x4_x1_net4 x_core_x4_x1_x1_net3 VDD pfet_06v0 L=1.0u W=10.0u
Mx_core_x4_x1_x1_XM6 x_core_x4_x1_net2 x_core_x4_x1_net2 VSS VSS nfet_06v0 L=1.0u W=1.0u
Mx_core_x4_x1_x1_XM7 x_core_x4_x1_x1_net2 x_core_x4_x1_net3 VDD VDD pfet_06v0 L=1.0u W=10.0u
Mx_core_x4_x1_x1_XM8 x_core_x4_x1_net1 x_core_x4_x1_net4 x_core_x4_x1_x1_net2 VDD pfet_06v0 L=1.0u W=10.0u
Mx_core_x4_x1_x1_XM9 x_core_x4_x1_net1 x_core_x4_x1_net2 x_core_x4_x1_x1_net1 VSS nfet_06v0 L=1.0u W=5.0u
Mx_core_x4_x1_x1_XM10 x_core_x4_x1_x1_net1 x_core_x4_x1_net1 VSS VSS nfet_06v0 L=1.0u W=5.0u
Mx_core_x4_x1_x1_XM1 x_core_x4_x1_net4 x_core_x4_x1_net4 VDD VDD pfet_06v0 L=1.0u W=2u
Mx_core_x4_x1_x1_XM2 x_core_x4_x1_x1_net4 x_core_x4_x1_net3 VDD VDD pfet_06v0 L=1.0u W=10.0u
Mx_core_x4_x1_x1_XM3 x_core_x4_x1_net3 x_core_x4_x1_net4 x_core_x4_x1_x1_net4 VDD pfet_06v0 L=1.0u W=10.0u
Mx_core_x4_x1_x1_XM47 x_core_x4_x1_x1_net5 x_core_x4_x1_net4 VSS VSS nfet_06v0 L=1.0u W=1.0u
Mx_core_x4_x1_x1_XM48 x_core_x4_x1_x1_net6 x_core_x4_x1_net4 VSS VSS nfet_06v0 L=1.0u W=1.0u
Mx_core_x4_x1_x1_XM49 x_core_x4_x1_net4 x_core_x4_x1_net4 x_core_x4_x1_x1_net6 VSS nfet_06v0 L=1.0u W=1.0u
Mx_core_x4_x1_x1_XM50 x_core_x4_x1_net3 x_core_x4_x1_net4 x_core_x4_x1_x1_net5 VSS nfet_06v0 L=1.0u W=1.0u
Mx_core_x4_x1_x2_XM11 x_core_x4_x1_x2_net2 x_core_x4_x1_net3 VDD VDD pfet_06v0 L=1.0u W=10.0u
Mx_core_x4_x1_x2_XM12 x_core_x4_x1_x2_net7 x_core_x4_x1_net4 x_core_x4_x1_x2_net2 VDD pfet_06v0 L=1.0u W=10.0u
Mx_core_x4_x1_x2_XM13 x_core_x4_x1_x2_net18 x_core_x4_x1_net3 VDD VDD pfet_06v0 L=1.0u W=10.0u
Mx_core_x4_x1_x2_XM14 x_core_x4_x1_x2_net7 x_core_x4_x1_net4 x_core_x4_x1_x2_net18 VDD pfet_06v0 L=1.0u W=10.0u
Mx_core_x4_x1_x2_XM15 x_core_x4_x1_x2_net5 S3P_I x_core_x4_x1_x2_net7 VDD pfet_06v0 L=1.0u W=0.55u
Mx_core_x4_x1_x2_XM16 x_core_x4_x1_x2_net4 S3N_I x_core_x4_x1_x2_net7 VDD pfet_06v0 L=1.0u W=0.5u
Mx_core_x4_x1_x2_XM17 x_core_x4_x1_x2_net8 x_core_x4_x1_net2 x_core_x4_x1_x2_net1 VSS nfet_06v0 L=1.0u W=5.0u
Mx_core_x4_x1_x2_XM18 x_core_x4_x1_x2_net1 x_core_x4_x1_net1 VSS VSS nfet_06v0 L=1.0u W=5.0u
Mx_core_x4_x1_x2_XM19 x_core_x4_x1_x2_net8 x_core_x4_x1_net2 x_core_x4_x1_x2_net19 VSS nfet_06v0 L=1.0u W=5.0u
Mx_core_x4_x1_x2_XM20 x_core_x4_x1_x2_net19 x_core_x4_x1_net1 VSS VSS nfet_06v0 L=1.0u W=5.0u
Mx_core_x4_x1_x2_XM21 x_core_x4_x1_x2_net6 S3P_I x_core_x4_x1_x2_net8 VSS nfet_06v0 L=1.0u W=7.5u
Mx_core_x4_x1_x2_XM22 x_core_x4_x1_x2_net3 S3N_I x_core_x4_x1_x2_net8 VSS nfet_06v0 L=1.0u W=8.5u
Mx_core_x4_x1_x2_XM29 x_core_x4_x1_x2_net9 x_core_x4_x1_net4 x_core_x4_x1_x2_net3 VDD pfet_06v0 L=1.0u W=10u
Mx_core_x4_x1_x2_XM30 x_core_x4_x1_x2_G_OUT_P x_core_x4_x1_net4 x_core_x4_x1_x2_net6 VDD pfet_06v0 L=1.0u W=10u
Mx_core_x4_x1_x2_XM31 x_core_x4_x1_x2_net3 x_core_x4_x1_x2_net9 VDD VDD pfet_06v0 L=1.0u W=5u
Mx_core_x4_x1_x2_XM35 x_core_x4_x1_x2_net6 x_core_x4_x1_x2_net9 VDD VDD pfet_06v0 L=1.0u W=5u
Mx_core_x4_x1_x2_XM32 x_core_x4_x1_x2_net10 x_core_x4_x1_x2_net20 x_core_x4_x1_x2_net9 VDD pfet_06v0 L=1.0u W=4.0u
Mx_core_x4_x1_x2_XM33 x_core_x4_x1_x2_net21 x_core_x4_x1_x2_net20 x_core_x4_x1_x2_G_OUT_P VDD pfet_06v0 L=1.0u W=4.0u
Mx_core_x4_x1_x2_XM23 x_core_x4_x1_x2_net10 x_core_x4_x1_net2 x_core_x4_x1_x2_net4 VSS nfet_06v0 L=1.0u W=2.5u
Mx_core_x4_x1_x2_XM24 x_core_x4_x1_x2_net21 x_core_x4_x1_net2 x_core_x4_x1_x2_net5 VSS nfet_06v0 L=1.0u W=2.5u
Mx_core_x4_x1_x2_XM25 x_core_x4_x1_x2_net4 x_core_x4_x1_x2_net10 VSS VSS nfet_06v0 L=1.0u W=2.5u
Mx_core_x4_x1_x2_XM26 x_core_x4_x1_x2_net5 x_core_x4_x1_x2_net10 VSS VSS nfet_06v0 L=1.0u W=2.5u
Mx_core_x4_x1_x2_XM27 x_core_x4_x1_x2_net9 x_core_x4_x1_x2_net11 x_core_x4_x1_x2_net10 VSS nfet_06v0 L=1.0u W=2.0u
Mx_core_x4_x1_x2_XM28 x_core_x4_x1_x2_G_OUT_P x_core_x4_x1_x2_net11 x_core_x4_x1_x2_net21 VSS nfet_06v0 L=1.0u W=2.0u
Mx_core_x4_x1_x2_XM34 x_core_x4_x1_x2_net12 x_core_x4_x1_x2_net13 VDD VDD pfet_06v0 L=1.0u W=10.0u
Mx_core_x4_x1_x2_XM36 x_core_x4_x1_x2_net13 x_core_x4_x1_net4 x_core_x4_x1_x2_net12 VDD pfet_06v0 L=1.0u W=10.0u
Mx_core_x4_x1_x2_XM37 x_core_x4_x1_x2_net20 x_core_x4_x1_x2_net20 x_core_x4_x1_x2_net13 VDD pfet_06v0 L=1.0u W=10.0u
Mx_core_x4_x1_x2_XM38 x_core_x4_x1_x2_net20 x_core_x4_x1_net2 x_core_x4_x1_x2_net14 VSS nfet_06v0 L=1.0u W=5.0u
Mx_core_x4_x1_x2_XM39 x_core_x4_x1_x2_net14 x_core_x4_x1_net1 VSS VSS nfet_06v0 L=1.0u W=5.0u
Mx_core_x4_x1_x2_XM45 x_core_x4_x1_x2_net15 x_core_x4_x1_net3 VDD VDD pfet_06v0 L=1.0u W=10.0u
Mx_core_x4_x1_x2_XM46 x_core_x4_x1_x2_net11 x_core_x4_x1_net4 x_core_x4_x1_x2_net15 VDD pfet_06v0 L=1.0u W=10.0u
Mx_core_x4_x1_x2_XM40 x_core_x4_x1_x2_net11 x_core_x4_x1_x2_net11 x_core_x4_x1_x2_net17 VSS nfet_06v0 L=1.0u W=5.0u
Mx_core_x4_x1_x2_XM41 x_core_x4_x1_x2_net17 x_core_x4_x1_net2 x_core_x4_x1_x2_net16 VSS nfet_06v0 L=1.0u W=5.0u
Mx_core_x4_x1_x2_XM42 x_core_x4_x1_x2_net16 x_core_x4_x1_x2_net17 VSS VSS nfet_06v0 L=1.0u W=5.0u
Mx_core_x4_x1_x2_XM43_m1 x_core_x4_SY x_core_x4_x1_x2_G_OUT_P VDD VDD pfet_06v0 L=1.0u W=1.0u
Mx_core_x4_x1_x2_XM43_m2 x_core_x4_SY x_core_x4_x1_x2_G_OUT_P VDD VDD pfet_06v0 L=1.0u W=1.0u
Mx_core_x4_x1_x2_XM43_m3 x_core_x4_SY x_core_x4_x1_x2_G_OUT_P VDD VDD pfet_06v0 L=1.0u W=1.0u
Mx_core_x4_x1_x2_XM43_m4 x_core_x4_SY x_core_x4_x1_x2_G_OUT_P VDD VDD pfet_06v0 L=1.0u W=1.0u
Mx_core_x4_x1_x2_XM44 x_core_x4_SY x_core_x4_x1_x2_net21 VSS VSS nfet_06v0 L=1.0u W=1.0u
Mx_core_x4_x2_x1_XM4 x_core_x4_x2_x1_net3 x_core_x4_x2_net3 VDD VDD pfet_06v0 L=1.0u W=10.0u
Mx_core_x4_x2_x1_XM5 x_core_x4_x2_net2 x_core_x4_x2_net4 x_core_x4_x2_x1_net3 VDD pfet_06v0 L=1.0u W=10.0u
Mx_core_x4_x2_x1_XM6 x_core_x4_x2_net2 x_core_x4_x2_net2 VSS VSS nfet_06v0 L=1.0u W=1.0u
Mx_core_x4_x2_x1_XM7 x_core_x4_x2_x1_net2 x_core_x4_x2_net3 VDD VDD pfet_06v0 L=1.0u W=10.0u
Mx_core_x4_x2_x1_XM8 x_core_x4_x2_net1 x_core_x4_x2_net4 x_core_x4_x2_x1_net2 VDD pfet_06v0 L=1.0u W=10.0u
Mx_core_x4_x2_x1_XM9 x_core_x4_x2_net1 x_core_x4_x2_net2 x_core_x4_x2_x1_net1 VSS nfet_06v0 L=1.0u W=5.0u
Mx_core_x4_x2_x1_XM10 x_core_x4_x2_x1_net1 x_core_x4_x2_net1 VSS VSS nfet_06v0 L=1.0u W=5.0u
Mx_core_x4_x2_x1_XM1 x_core_x4_x2_net4 x_core_x4_x2_net4 VDD VDD pfet_06v0 L=1.0u W=2u
Mx_core_x4_x2_x1_XM2 x_core_x4_x2_x1_net4 x_core_x4_x2_net3 VDD VDD pfet_06v0 L=1.0u W=10.0u
Mx_core_x4_x2_x1_XM3 x_core_x4_x2_net3 x_core_x4_x2_net4 x_core_x4_x2_x1_net4 VDD pfet_06v0 L=1.0u W=10.0u
Mx_core_x4_x2_x1_XM47 x_core_x4_x2_x1_net5 x_core_x4_x2_net4 VSS VSS nfet_06v0 L=1.0u W=1.0u
Mx_core_x4_x2_x1_XM48 x_core_x4_x2_x1_net6 x_core_x4_x2_net4 VSS VSS nfet_06v0 L=1.0u W=1.0u
Mx_core_x4_x2_x1_XM49 x_core_x4_x2_net4 x_core_x4_x2_net4 x_core_x4_x2_x1_net6 VSS nfet_06v0 L=1.0u W=1.0u
Mx_core_x4_x2_x1_XM50 x_core_x4_x2_net3 x_core_x4_x2_net4 x_core_x4_x2_x1_net5 VSS nfet_06v0 L=1.0u W=1.0u
Mx_core_x4_x2_x2_XM11 x_core_x4_x2_x2_net2 x_core_x4_x2_net3 VDD VDD pfet_06v0 L=1.0u W=10.0u
Mx_core_x4_x2_x2_XM12 x_core_x4_x2_x2_net7 x_core_x4_x2_net4 x_core_x4_x2_x2_net2 VDD pfet_06v0 L=1.0u W=10.0u
Mx_core_x4_x2_x2_XM13 x_core_x4_x2_x2_net18 x_core_x4_x2_net3 VDD VDD pfet_06v0 L=1.0u W=10.0u
Mx_core_x4_x2_x2_XM14 x_core_x4_x2_x2_net7 x_core_x4_x2_net4 x_core_x4_x2_x2_net18 VDD pfet_06v0 L=1.0u W=10.0u
Mx_core_x4_x2_x2_XM15 x_core_x4_x2_x2_net5 S4P_I x_core_x4_x2_x2_net7 VDD pfet_06v0 L=1.0u W=0.55u
Mx_core_x4_x2_x2_XM16 x_core_x4_x2_x2_net4 S4N_I x_core_x4_x2_x2_net7 VDD pfet_06v0 L=1.0u W=0.5u
Mx_core_x4_x2_x2_XM17 x_core_x4_x2_x2_net8 x_core_x4_x2_net2 x_core_x4_x2_x2_net1 VSS nfet_06v0 L=1.0u W=5.0u
Mx_core_x4_x2_x2_XM18 x_core_x4_x2_x2_net1 x_core_x4_x2_net1 VSS VSS nfet_06v0 L=1.0u W=5.0u
Mx_core_x4_x2_x2_XM19 x_core_x4_x2_x2_net8 x_core_x4_x2_net2 x_core_x4_x2_x2_net19 VSS nfet_06v0 L=1.0u W=5.0u
Mx_core_x4_x2_x2_XM20 x_core_x4_x2_x2_net19 x_core_x4_x2_net1 VSS VSS nfet_06v0 L=1.0u W=5.0u
Mx_core_x4_x2_x2_XM21 x_core_x4_x2_x2_net6 S4P_I x_core_x4_x2_x2_net8 VSS nfet_06v0 L=1.0u W=7.5u
Mx_core_x4_x2_x2_XM22 x_core_x4_x2_x2_net3 S4N_I x_core_x4_x2_x2_net8 VSS nfet_06v0 L=1.0u W=8.5u
Mx_core_x4_x2_x2_XM29 x_core_x4_x2_x2_net9 x_core_x4_x2_net4 x_core_x4_x2_x2_net3 VDD pfet_06v0 L=1.0u W=10u
Mx_core_x4_x2_x2_XM30 x_core_x4_x2_x2_G_OUT_P x_core_x4_x2_net4 x_core_x4_x2_x2_net6 VDD pfet_06v0 L=1.0u W=10u
Mx_core_x4_x2_x2_XM31 x_core_x4_x2_x2_net3 x_core_x4_x2_x2_net9 VDD VDD pfet_06v0 L=1.0u W=5u
Mx_core_x4_x2_x2_XM35 x_core_x4_x2_x2_net6 x_core_x4_x2_x2_net9 VDD VDD pfet_06v0 L=1.0u W=5u
Mx_core_x4_x2_x2_XM32 x_core_x4_x2_x2_net10 x_core_x4_x2_x2_net20 x_core_x4_x2_x2_net9 VDD pfet_06v0 L=1.0u W=4.0u
Mx_core_x4_x2_x2_XM33 x_core_x4_x2_x2_net21 x_core_x4_x2_x2_net20 x_core_x4_x2_x2_G_OUT_P VDD pfet_06v0 L=1.0u W=4.0u
Mx_core_x4_x2_x2_XM23 x_core_x4_x2_x2_net10 x_core_x4_x2_net2 x_core_x4_x2_x2_net4 VSS nfet_06v0 L=1.0u W=2.5u
Mx_core_x4_x2_x2_XM24 x_core_x4_x2_x2_net21 x_core_x4_x2_net2 x_core_x4_x2_x2_net5 VSS nfet_06v0 L=1.0u W=2.5u
Mx_core_x4_x2_x2_XM25 x_core_x4_x2_x2_net4 x_core_x4_x2_x2_net10 VSS VSS nfet_06v0 L=1.0u W=2.5u
Mx_core_x4_x2_x2_XM26 x_core_x4_x2_x2_net5 x_core_x4_x2_x2_net10 VSS VSS nfet_06v0 L=1.0u W=2.5u
Mx_core_x4_x2_x2_XM27 x_core_x4_x2_x2_net9 x_core_x4_x2_x2_net11 x_core_x4_x2_x2_net10 VSS nfet_06v0 L=1.0u W=2.0u
Mx_core_x4_x2_x2_XM28 x_core_x4_x2_x2_G_OUT_P x_core_x4_x2_x2_net11 x_core_x4_x2_x2_net21 VSS nfet_06v0 L=1.0u W=2.0u
Mx_core_x4_x2_x2_XM34 x_core_x4_x2_x2_net12 x_core_x4_x2_x2_net13 VDD VDD pfet_06v0 L=1.0u W=10.0u
Mx_core_x4_x2_x2_XM36 x_core_x4_x2_x2_net13 x_core_x4_x2_net4 x_core_x4_x2_x2_net12 VDD pfet_06v0 L=1.0u W=10.0u
Mx_core_x4_x2_x2_XM37 x_core_x4_x2_x2_net20 x_core_x4_x2_x2_net20 x_core_x4_x2_x2_net13 VDD pfet_06v0 L=1.0u W=10.0u
Mx_core_x4_x2_x2_XM38 x_core_x4_x2_x2_net20 x_core_x4_x2_net2 x_core_x4_x2_x2_net14 VSS nfet_06v0 L=1.0u W=5.0u
Mx_core_x4_x2_x2_XM39 x_core_x4_x2_x2_net14 x_core_x4_x2_net1 VSS VSS nfet_06v0 L=1.0u W=5.0u
Mx_core_x4_x2_x2_XM45 x_core_x4_x2_x2_net15 x_core_x4_x2_net3 VDD VDD pfet_06v0 L=1.0u W=10.0u
Mx_core_x4_x2_x2_XM46 x_core_x4_x2_x2_net11 x_core_x4_x2_net4 x_core_x4_x2_x2_net15 VDD pfet_06v0 L=1.0u W=10.0u
Mx_core_x4_x2_x2_XM40 x_core_x4_x2_x2_net11 x_core_x4_x2_x2_net11 x_core_x4_x2_x2_net17 VSS nfet_06v0 L=1.0u W=5.0u
Mx_core_x4_x2_x2_XM41 x_core_x4_x2_x2_net17 x_core_x4_x2_net2 x_core_x4_x2_x2_net16 VSS nfet_06v0 L=1.0u W=5.0u
Mx_core_x4_x2_x2_XM42 x_core_x4_x2_x2_net16 x_core_x4_x2_x2_net17 VSS VSS nfet_06v0 L=1.0u W=5.0u
Mx_core_x4_x2_x2_XM43_m1 x_core_x4_SZ x_core_x4_x2_x2_G_OUT_P VDD VDD pfet_06v0 L=1.0u W=1.0u
Mx_core_x4_x2_x2_XM43_m2 x_core_x4_SZ x_core_x4_x2_x2_G_OUT_P VDD VDD pfet_06v0 L=1.0u W=1.0u
Mx_core_x4_x2_x2_XM43_m3 x_core_x4_SZ x_core_x4_x2_x2_G_OUT_P VDD VDD pfet_06v0 L=1.0u W=1.0u
Mx_core_x4_x2_x2_XM43_m4 x_core_x4_SZ x_core_x4_x2_x2_G_OUT_P VDD VDD pfet_06v0 L=1.0u W=1.0u
Mx_core_x4_x2_x2_XM44 x_core_x4_SZ x_core_x4_x2_x2_net21 VSS VSS nfet_06v0 L=1.0u W=1.0u
Mdecn0 VSS VDD VSS VSS nfet_06v0 L=2.0u W=1.0u
Mdecn1 VSS VDD VSS VSS nfet_06v0 L=2.0u W=1.0u
Mdecn2 VSS VDD VSS VSS nfet_06v0 L=2.0u W=1.0u
Mdecn3 VSS VDD VSS VSS nfet_06v0 L=2.0u W=1.0u
Mdecn4 VSS VDD VSS VSS nfet_06v0 L=2.0u W=1.0u
Mdecn5 VSS VDD VSS VSS nfet_06v0 L=2.0u W=1.0u
Mdecn6 VSS VDD VSS VSS nfet_06v0 L=2.0u W=1.0u
Mdecn7 VSS VDD VSS VSS nfet_06v0 L=2.0u W=1.0u
Mdecn8 VSS VDD VSS VSS nfet_06v0 L=2.0u W=1.0u
Mdecn9 VSS VDD VSS VSS nfet_06v0 L=2.0u W=1.0u
Mdecn10 VSS VDD VSS VSS nfet_06v0 L=2.0u W=1.0u
Mdecn11 VSS VDD VSS VSS nfet_06v0 L=2.0u W=1.0u
Mdecn12 VSS VDD VSS VSS nfet_06v0 L=2.0u W=1.0u
Mdecp13 VDD VSS VDD VDD pfet_06v0 L=2.0u W=1.0u
Mdecp14 VDD VSS VDD VDD pfet_06v0 L=2.0u W=1.0u
Mdecp15 VDD VSS VDD VDD pfet_06v0 L=2.0u W=1.0u
Mdecp16 VDD VSS VDD VDD pfet_06v0 L=2.0u W=1.0u
Mdecp17 VDD VSS VDD VDD pfet_06v0 L=2.0u W=1.0u
Mdecp18 VDD VSS VDD VDD pfet_06v0 L=2.0u W=1.0u
Mdecp19 VDD VSS VDD VDD pfet_06v0 L=2.0u W=1.0u
Mdecp20 VDD VSS VDD VDD pfet_06v0 L=2.0u W=1.0u
Mdecp21 VDD VSS VDD VDD pfet_06v0 L=2.0u W=1.0u
Mdecp22 VDD VSS VDD VDD pfet_06v0 L=2.0u W=1.0u
Mdecp23 VDD VSS VDD VDD pfet_06v0 L=2.0u W=1.0u
Mdecp24 VDD VSS VDD VDD pfet_06v0 L=2.0u W=1.0u
Mdecn25 VSS VDD VSS VSS nfet_06v0 L=2.0u W=18.0u
Mdecn26 VSS VDD VSS VSS nfet_06v0 L=2.0u W=18.0u
Mdecn27 VSS VDD VSS VSS nfet_06v0 L=2.0u W=18.0u
Mdecp28 VDD VSS VDD VDD pfet_06v0 L=2.0u W=18.0u
Mdecp29 VDD VSS VDD VDD pfet_06v0 L=2.0u W=18.0u
Mdecn30 VSS VDD VSS VSS nfet_06v0 L=2.0u W=18.0u
Mdecn31 VSS VDD VSS VSS nfet_06v0 L=2.0u W=18.0u
Mdecn32 VSS VDD VSS VSS nfet_06v0 L=2.0u W=18.0u
Mdecp33 VDD VSS VDD VDD pfet_06v0 L=2.0u W=18.0u
Mdecp34 VDD VSS VDD VDD pfet_06v0 L=2.0u W=18.0u
Mdecn35 VSS VDD VSS VSS nfet_06v0 L=2.0u W=18.0u
Mdecn36 VSS VDD VSS VSS nfet_06v0 L=2.0u W=18.0u
Mdecn37 VSS VDD VSS VSS nfet_06v0 L=2.0u W=18.0u
Mdecp38 VDD VSS VDD VDD pfet_06v0 L=2.0u W=18.0u
Mdecp39 VDD VSS VDD VDD pfet_06v0 L=2.0u W=18.0u
Mdecn40 VSS VDD VSS VSS nfet_06v0 L=2.0u W=18.0u
Mdecn41 VSS VDD VSS VSS nfet_06v0 L=2.0u W=18.0u
Mdecp42 VDD VSS VDD VDD pfet_06v0 L=2.0u W=18.0u
Mdecp43 VDD VSS VDD VDD pfet_06v0 L=2.0u W=18.0u
Mdecn44 VSS VDD VSS VSS nfet_06v0 L=2.0u W=18.0u
Mdecn45 VSS VDD VSS VSS nfet_06v0 L=2.0u W=18.0u
Mdecp46 VDD VSS VDD VDD pfet_06v0 L=2.0u W=18.0u
Mdecp47 VDD VSS VDD VDD pfet_06v0 L=2.0u W=18.0u
Mdecn48 VSS VDD VSS VSS nfet_06v0 L=2.0u W=18.0u
Mdecn49 VSS VDD VSS VSS nfet_06v0 L=2.0u W=18.0u
Mdecp50 VDD VSS VDD VDD pfet_06v0 L=2.0u W=18.0u
Mdecp51 VDD VSS VDD VDD pfet_06v0 L=2.0u W=18.0u
Mdecn52 VSS VDD VSS VSS nfet_06v0 L=2.0u W=18.0u
Mdecn53 VSS VDD VSS VSS nfet_06v0 L=2.0u W=18.0u
Mdecp54 VDD VSS VDD VDD pfet_06v0 L=2.0u W=18.0u
Mdecp55 VDD VSS VDD VDD pfet_06v0 L=2.0u W=18.0u
Mdecn56 VSS VDD VSS VSS nfet_06v0 L=2.0u W=18.0u
Mdecn57 VSS VDD VSS VSS nfet_06v0 L=2.0u W=18.0u
Mdecp58 VDD VSS VDD VDD pfet_06v0 L=2.0u W=18.0u
Mdecp59 VDD VSS VDD VDD pfet_06v0 L=2.0u W=18.0u
Mdecn60 VSS VDD VSS VSS nfet_06v0 L=2.0u W=18.0u
Mdecn61 VSS VDD VSS VSS nfet_06v0 L=2.0u W=18.0u
Mdecp62 VDD VSS VDD VDD pfet_06v0 L=2.0u W=18.0u
Mdecp63 VDD VSS VDD VDD pfet_06v0 L=2.0u W=18.0u
Mdecn64 VSS VDD VSS VSS nfet_06v0 L=2.0u W=18.0u
Mdecn65 VSS VDD VSS VSS nfet_06v0 L=2.0u W=18.0u
Mdecp66 VDD VSS VDD VDD pfet_06v0 L=2.0u W=18.0u
Mdecp67 VDD VSS VDD VDD pfet_06v0 L=2.0u W=18.0u
Mdecn68 VSS VDD VSS VSS nfet_06v0 L=2.0u W=18.0u
Mdecn69 VSS VDD VSS VSS nfet_06v0 L=2.0u W=18.0u
Mdecp70 VDD VSS VDD VDD pfet_06v0 L=2.0u W=18.0u
Mdecp71 VDD VSS VDD VDD pfet_06v0 L=2.0u W=18.0u
Mdecn72 VSS VDD VSS VSS nfet_06v0 L=2.0u W=18.0u
Mdecn73 VSS VDD VSS VSS nfet_06v0 L=2.0u W=18.0u
Mdecp74 VDD VSS VDD VDD pfet_06v0 L=2.0u W=18.0u
Mdecp75 VDD VSS VDD VDD pfet_06v0 L=2.0u W=18.0u
Mdecn76 VSS VDD VSS VSS nfet_06v0 L=2.0u W=9.75u
Mdecn77 VSS VDD VSS VSS nfet_06v0 L=2.0u W=9.75u
Mdecp78 VDD VSS VDD VDD pfet_06v0 L=2.0u W=9.75u
Mdecp79 VDD VSS VDD VDD pfet_06v0 L=2.0u W=9.75u
Mdecn80 VSS VDD VSS VSS nfet_06v0 L=2.0u W=9.75u
Mdecn81 VSS VDD VSS VSS nfet_06v0 L=2.0u W=9.75u
Mdecp82 VDD VSS VDD VDD pfet_06v0 L=2.0u W=9.75u
Mdecp83 VDD VSS VDD VDD pfet_06v0 L=2.0u W=9.75u
Mdecn84 VSS VDD VSS VSS nfet_06v0 L=2.0u W=9.75u
Mdecn85 VSS VDD VSS VSS nfet_06v0 L=2.0u W=9.75u
Mdecp86 VDD VSS VDD VDD pfet_06v0 L=2.0u W=9.75u
Mdecp87 VDD VSS VDD VDD pfet_06v0 L=2.0u W=9.75u
Mdecn88 VSS VDD VSS VSS nfet_06v0 L=2.0u W=9.75u
Mdecn89 VSS VDD VSS VSS nfet_06v0 L=2.0u W=9.75u
Mdecp90 VDD VSS VDD VDD pfet_06v0 L=2.0u W=9.75u
Mdecp91 VDD VSS VDD VDD pfet_06v0 L=2.0u W=9.75u
Mdecn92 VSS VDD VSS VSS nfet_06v0 L=2.0u W=9.75u
Mdecn93 VSS VDD VSS VSS nfet_06v0 L=2.0u W=9.75u
Mdecp94 VDD VSS VDD VDD pfet_06v0 L=2.0u W=9.75u
Mdecp95 VDD VSS VDD VDD pfet_06v0 L=2.0u W=9.75u
Mdecn96 VSS VDD VSS VSS nfet_06v0 L=2.0u W=9.75u
Mdecn97 VSS VDD VSS VSS nfet_06v0 L=2.0u W=9.75u
Mdecp98 VDD VSS VDD VDD pfet_06v0 L=2.0u W=9.75u
Mdecp99 VDD VSS VDD VDD pfet_06v0 L=2.0u W=9.75u
Mdecn100 VSS VDD VSS VSS nfet_06v0 L=2.0u W=9.75u
Mdecn101 VSS VDD VSS VSS nfet_06v0 L=2.0u W=9.75u
Mdecp102 VDD VSS VDD VDD pfet_06v0 L=2.0u W=9.75u
Mdecp103 VDD VSS VDD VDD pfet_06v0 L=2.0u W=9.75u
Mdecn104 VSS VDD VSS VSS nfet_06v0 L=2.0u W=9.75u
Mdecn105 VSS VDD VSS VSS nfet_06v0 L=2.0u W=9.75u
Mdecp106 VDD VSS VDD VDD pfet_06v0 L=2.0u W=9.75u
Mdecp107 VDD VSS VDD VDD pfet_06v0 L=2.0u W=9.75u
Mdecn108 VSS VDD VSS VSS nfet_06v0 L=2.0u W=9.75u
Mdecn109 VSS VDD VSS VSS nfet_06v0 L=2.0u W=9.75u
Mdecp110 VDD VSS VDD VDD pfet_06v0 L=2.0u W=9.75u
Mdecp111 VDD VSS VDD VDD pfet_06v0 L=2.0u W=9.75u
Mdecn112 VSS VDD VSS VSS nfet_06v0 L=2.0u W=9.75u
Mdecn113 VSS VDD VSS VSS nfet_06v0 L=2.0u W=9.75u
Mdecp114 VDD VSS VDD VDD pfet_06v0 L=2.0u W=9.75u
Mdecp115 VDD VSS VDD VDD pfet_06v0 L=2.0u W=9.75u
Mdecn116 VSS VDD VSS VSS nfet_06v0 L=2.0u W=9.75u
Mdecn117 VSS VDD VSS VSS nfet_06v0 L=2.0u W=9.75u
Mdecp118 VDD VSS VDD VDD pfet_06v0 L=2.0u W=9.75u
Mdecp119 VDD VSS VDD VDD pfet_06v0 L=2.0u W=9.75u
Mdecn120 VSS VDD VSS VSS nfet_06v0 L=2.0u W=9.75u
Mdecn121 VSS VDD VSS VSS nfet_06v0 L=2.0u W=9.75u
Mdecp122 VDD VSS VDD VDD pfet_06v0 L=2.0u W=9.75u
Mdecp123 VDD VSS VDD VDD pfet_06v0 L=2.0u W=9.75u
Mdecn124 VSS VDD VSS VSS nfet_06v0 L=2.0u W=18.0u
Mdecp125 VDD VSS VDD VDD pfet_06v0 L=2.0u W=18.0u
Mdecn126 VSS VDD VSS VSS nfet_06v0 L=2.0u W=18.0u
Mdecp127 VDD VSS VDD VDD pfet_06v0 L=2.0u W=18.0u
Mdecn128 VSS VDD VSS VSS nfet_06v0 L=2.0u W=18.0u
Mdecp129 VDD VSS VDD VDD pfet_06v0 L=2.0u W=18.0u
Mdecn130 VSS VDD VSS VSS nfet_06v0 L=2.0u W=9.75u
Mdecp131 VDD VSS VDD VDD pfet_06v0 L=2.0u W=9.75u
Mdecn132 VSS VDD VSS VSS nfet_06v0 L=2.0u W=9.75u
Mdecp133 VDD VSS VDD VDD pfet_06v0 L=2.0u W=9.75u
Mdecn134 VSS VDD VSS VSS nfet_06v0 L=2.0u W=9.75u
Mdecp135 VDD VSS VDD VDD pfet_06v0 L=2.0u W=9.75u
Mdecn136 VSS VDD VSS VSS nfet_06v0 L=2.0u W=9.75u
Mdecp137 VDD VSS VDD VDD pfet_06v0 L=2.0u W=9.75u
Mdecn138 VSS VDD VSS VSS nfet_06v0 L=2.0u W=1.0u
Mdecn139 VSS VDD VSS VSS nfet_06v0 L=2.0u W=1.0u
Mdecp140 VDD VSS VDD VDD pfet_06v0 L=2.0u W=1.0u
Mdecp141 VDD VSS VDD VDD pfet_06v0 L=2.0u W=1.0u
Mdecn142 VSS VDD VSS VSS nfet_06v0 L=2.0u W=1.0u
Mdecn143 VSS VDD VSS VSS nfet_06v0 L=2.0u W=1.0u
Mdecp144 VDD VSS VDD VDD pfet_06v0 L=2.0u W=1.0u
Mdecp145 VDD VSS VDD VDD pfet_06v0 L=2.0u W=1.0u
Mdecn146 VSS VDD VSS VSS nfet_06v0 L=2.0u W=1.0u
Mdecn147 VSS VDD VSS VSS nfet_06v0 L=2.0u W=1.0u
Mdecp148 VDD VSS VDD VDD pfet_06v0 L=2.0u W=1.0u
Mdecp149 VDD VSS VDD VDD pfet_06v0 L=2.0u W=1.0u
Mdecn150 VSS VDD VSS VSS nfet_06v0 L=2.0u W=1.0u
Mdecp151 VDD VSS VDD VDD pfet_06v0 L=2.0u W=1.0u
Mdecn152 VSS VDD VSS VSS nfet_06v0 L=2.0u W=1.0u
Mdecp153 VDD VSS VDD VDD pfet_06v0 L=2.0u W=1.0u
Mdecn154 VSS VDD VSS VSS nfet_06v0 L=2.0u W=1.0u
Mdecp155 VDD VSS VDD VDD pfet_06v0 L=2.0u W=1.0u
* diodes: the line as it is. KLayout's deck reads them with 'A=' and 'P=', which is what the simulator calls
*   area and pj; written as numbers and not as xschem's expression, because the reader does not evaluate.
D1_Xx_esd_S1P S1P_I VDD diode_pd2nw_06v0 A=100p P=40u
D2_Xx_esd_S1P S1P_I VDD diode_pd2nw_06v0 A=100p P=40u
D3_Xx_esd_S1P S1P_I VDD diode_pd2nw_06v0 A=100p P=40u
D4_Xx_esd_S1P S1P_I VDD diode_pd2nw_06v0 A=100p P=40u
D5_Xx_esd_S1P VSS S1P_I diode_nd2ps_06v0 A=100p P=40u
D6_Xx_esd_S1P VSS S1P_I diode_nd2ps_06v0 A=100p P=40u
D7_Xx_esd_S1P VSS S1P_I diode_nd2ps_06v0 A=100p P=40u
D8_Xx_esd_S1P VSS S1P_I diode_nd2ps_06v0 A=100p P=40u
D1_Xx_esd_S1N S1N_I VDD diode_pd2nw_06v0 A=100p P=40u
D2_Xx_esd_S1N S1N_I VDD diode_pd2nw_06v0 A=100p P=40u
D3_Xx_esd_S1N S1N_I VDD diode_pd2nw_06v0 A=100p P=40u
D4_Xx_esd_S1N S1N_I VDD diode_pd2nw_06v0 A=100p P=40u
D5_Xx_esd_S1N VSS S1N_I diode_nd2ps_06v0 A=100p P=40u
D6_Xx_esd_S1N VSS S1N_I diode_nd2ps_06v0 A=100p P=40u
D7_Xx_esd_S1N VSS S1N_I diode_nd2ps_06v0 A=100p P=40u
D8_Xx_esd_S1N VSS S1N_I diode_nd2ps_06v0 A=100p P=40u
D1_Xx_esd_S2P S2P_I VDD diode_pd2nw_06v0 A=100p P=40u
D2_Xx_esd_S2P S2P_I VDD diode_pd2nw_06v0 A=100p P=40u
D3_Xx_esd_S2P S2P_I VDD diode_pd2nw_06v0 A=100p P=40u
D4_Xx_esd_S2P S2P_I VDD diode_pd2nw_06v0 A=100p P=40u
D5_Xx_esd_S2P VSS S2P_I diode_nd2ps_06v0 A=100p P=40u
D6_Xx_esd_S2P VSS S2P_I diode_nd2ps_06v0 A=100p P=40u
D7_Xx_esd_S2P VSS S2P_I diode_nd2ps_06v0 A=100p P=40u
D8_Xx_esd_S2P VSS S2P_I diode_nd2ps_06v0 A=100p P=40u
D1_Xx_esd_S2N S2N_I VDD diode_pd2nw_06v0 A=100p P=40u
D2_Xx_esd_S2N S2N_I VDD diode_pd2nw_06v0 A=100p P=40u
D3_Xx_esd_S2N S2N_I VDD diode_pd2nw_06v0 A=100p P=40u
D4_Xx_esd_S2N S2N_I VDD diode_pd2nw_06v0 A=100p P=40u
D5_Xx_esd_S2N VSS S2N_I diode_nd2ps_06v0 A=100p P=40u
D6_Xx_esd_S2N VSS S2N_I diode_nd2ps_06v0 A=100p P=40u
D7_Xx_esd_S2N VSS S2N_I diode_nd2ps_06v0 A=100p P=40u
D8_Xx_esd_S2N VSS S2N_I diode_nd2ps_06v0 A=100p P=40u
D1_Xx_esd_S3P S3P_I VDD diode_pd2nw_06v0 A=100p P=40u
D2_Xx_esd_S3P S3P_I VDD diode_pd2nw_06v0 A=100p P=40u
D3_Xx_esd_S3P S3P_I VDD diode_pd2nw_06v0 A=100p P=40u
D4_Xx_esd_S3P S3P_I VDD diode_pd2nw_06v0 A=100p P=40u
D5_Xx_esd_S3P VSS S3P_I diode_nd2ps_06v0 A=100p P=40u
D6_Xx_esd_S3P VSS S3P_I diode_nd2ps_06v0 A=100p P=40u
D7_Xx_esd_S3P VSS S3P_I diode_nd2ps_06v0 A=100p P=40u
D8_Xx_esd_S3P VSS S3P_I diode_nd2ps_06v0 A=100p P=40u
D1_Xx_esd_S3N S3N_I VDD diode_pd2nw_06v0 A=100p P=40u
D2_Xx_esd_S3N S3N_I VDD diode_pd2nw_06v0 A=100p P=40u
D3_Xx_esd_S3N S3N_I VDD diode_pd2nw_06v0 A=100p P=40u
D4_Xx_esd_S3N S3N_I VDD diode_pd2nw_06v0 A=100p P=40u
D5_Xx_esd_S3N VSS S3N_I diode_nd2ps_06v0 A=100p P=40u
D6_Xx_esd_S3N VSS S3N_I diode_nd2ps_06v0 A=100p P=40u
D7_Xx_esd_S3N VSS S3N_I diode_nd2ps_06v0 A=100p P=40u
D8_Xx_esd_S3N VSS S3N_I diode_nd2ps_06v0 A=100p P=40u
D1_Xx_esd_S4P S4P_I VDD diode_pd2nw_06v0 A=100p P=40u
D2_Xx_esd_S4P S4P_I VDD diode_pd2nw_06v0 A=100p P=40u
D3_Xx_esd_S4P S4P_I VDD diode_pd2nw_06v0 A=100p P=40u
D4_Xx_esd_S4P S4P_I VDD diode_pd2nw_06v0 A=100p P=40u
D5_Xx_esd_S4P VSS S4P_I diode_nd2ps_06v0 A=100p P=40u
D6_Xx_esd_S4P VSS S4P_I diode_nd2ps_06v0 A=100p P=40u
D7_Xx_esd_S4P VSS S4P_I diode_nd2ps_06v0 A=100p P=40u
D8_Xx_esd_S4P VSS S4P_I diode_nd2ps_06v0 A=100p P=40u
D1_Xx_esd_S4N S4N_I VDD diode_pd2nw_06v0 A=100p P=40u
D2_Xx_esd_S4N S4N_I VDD diode_pd2nw_06v0 A=100p P=40u
D3_Xx_esd_S4N S4N_I VDD diode_pd2nw_06v0 A=100p P=40u
D4_Xx_esd_S4N S4N_I VDD diode_pd2nw_06v0 A=100p P=40u
D5_Xx_esd_S4N VSS S4N_I diode_nd2ps_06v0 A=100p P=40u
D6_Xx_esd_S4N VSS S4N_I diode_nd2ps_06v0 A=100p P=40u
D7_Xx_esd_S4N VSS S4N_I diode_nd2ps_06v0 A=100p P=40u
D8_Xx_esd_S4N VSS S4N_I diode_nd2ps_06v0 A=100p P=40u
D1_Xx_esd_X X_I VDD diode_pd2nw_06v0 A=100p P=40u
D2_Xx_esd_X X_I VDD diode_pd2nw_06v0 A=100p P=40u
D3_Xx_esd_X X_I VDD diode_pd2nw_06v0 A=100p P=40u
D4_Xx_esd_X X_I VDD diode_pd2nw_06v0 A=100p P=40u
D5_Xx_esd_X VSS X_I diode_nd2ps_06v0 A=100p P=40u
D6_Xx_esd_X VSS X_I diode_nd2ps_06v0 A=100p P=40u
D7_Xx_esd_X VSS X_I diode_nd2ps_06v0 A=100p P=40u
D8_Xx_esd_X VSS X_I diode_nd2ps_06v0 A=100p P=40u
D1_Xx_esd_Y Y_I VDD diode_pd2nw_06v0 A=100p P=40u
D2_Xx_esd_Y Y_I VDD diode_pd2nw_06v0 A=100p P=40u
D3_Xx_esd_Y Y_I VDD diode_pd2nw_06v0 A=100p P=40u
D4_Xx_esd_Y Y_I VDD diode_pd2nw_06v0 A=100p P=40u
D5_Xx_esd_Y VSS Y_I diode_nd2ps_06v0 A=100p P=40u
D6_Xx_esd_Y VSS Y_I diode_nd2ps_06v0 A=100p P=40u
D7_Xx_esd_Y VSS Y_I diode_nd2ps_06v0 A=100p P=40u
D8_Xx_esd_Y VSS Y_I diode_nd2ps_06v0 A=100p P=40u
D1_Xx_esd_Z Z_I VDD diode_pd2nw_06v0 A=100p P=40u
D2_Xx_esd_Z Z_I VDD diode_pd2nw_06v0 A=100p P=40u
D3_Xx_esd_Z Z_I VDD diode_pd2nw_06v0 A=100p P=40u
D4_Xx_esd_Z Z_I VDD diode_pd2nw_06v0 A=100p P=40u
D5_Xx_esd_Z VSS Z_I diode_nd2ps_06v0 A=100p P=40u
D6_Xx_esd_Z VSS Z_I diode_nd2ps_06v0 A=100p P=40u
D7_Xx_esd_Z VSS Z_I diode_nd2ps_06v0 A=100p P=40u
D8_Xx_esd_Z VSS Z_I diode_nd2ps_06v0 A=100p P=40u
* condensadores: elemento 'C' con W/L en METROS, no 'X' con c_width/c_length.
*   El deck de KLayout los lee con un delegate (custom_classes.lvs, SubcircuitModelsReader#element)
*   que SOLO actua si el elemento empieza por 'C', y de ahi saca A=W*L*1e12 y P=2*(W+L)*1e6.
*   Escrito como 'X...' se leeria como llamada a subcircuito y no emparejaria con nada.
Cx_core_x1_x4_x2_XC2 x_core_x1_net1 x_core_x1_x4_x2_net5 4e-13 cap_mim_2f0fF
Cx_core_x1_x4_x2_XC3 x_core_x1_x4_x2_net6 x_core_x1_net1 4e-13 cap_mim_2f0fF
Cx_core_x1_x5_x2_XC2 x_core_x1_net2 x_core_x1_x5_x2_net5 4e-13 cap_mim_2f0fF
Cx_core_x1_x5_x2_XC3 x_core_x1_x5_x2_net6 x_core_x1_net2 4e-13 cap_mim_2f0fF
Cx_core_x1_x6_x2_XC2 x_core_x1_net3 x_core_x1_x6_x2_net5 4e-13 cap_mim_2f0fF
Cx_core_x1_x6_x2_XC3 x_core_x1_x6_x2_net6 x_core_x1_net3 4e-13 cap_mim_2f0fF
Cx_core_x1_x8_x2_XC3 x_core_x1_x8_x2_net6 x_core_x1_SX 4e-13 cap_mim_2f0fF
Cx_core_x1_x8_x2_XC1 x_core_x1_SX x_core_x1_x8_x2_net5 4e-13 cap_mim_2f0fF
Cx_core_x1_x1_x2_XC3 x_core_x1_x1_x2_net6 x_core_x1_SY 4e-13 cap_mim_2f0fF
Cx_core_x1_x1_x2_XC1 x_core_x1_SY x_core_x1_x1_x2_net5 4e-13 cap_mim_2f0fF
Cx_core_x1_x2_x2_XC3 x_core_x1_x2_x2_net6 x_core_x1_SZ 4e-13 cap_mim_2f0fF
Cx_core_x1_x2_x2_XC1 x_core_x1_SZ x_core_x1_x2_x2_net5 4e-13 cap_mim_2f0fF
Cx_core_x2_x4_x2_XC2 x_core_x2_net1 x_core_x2_x4_x2_net5 4e-13 cap_mim_2f0fF
Cx_core_x2_x4_x2_XC3 x_core_x2_x4_x2_net6 x_core_x2_net1 4e-13 cap_mim_2f0fF
Cx_core_x2_x5_x2_XC2 x_core_x2_net2 x_core_x2_x5_x2_net5 4e-13 cap_mim_2f0fF
Cx_core_x2_x5_x2_XC3 x_core_x2_x5_x2_net6 x_core_x2_net2 4e-13 cap_mim_2f0fF
Cx_core_x2_x6_x2_XC2 x_core_x2_net3 x_core_x2_x6_x2_net5 4e-13 cap_mim_2f0fF
Cx_core_x2_x6_x2_XC3 x_core_x2_x6_x2_net6 x_core_x2_net3 4e-13 cap_mim_2f0fF
Cx_core_x2_x8_x2_XC3 x_core_x2_x8_x2_net6 x_core_x2_SX 4e-13 cap_mim_2f0fF
Cx_core_x2_x8_x2_XC1 x_core_x2_SX x_core_x2_x8_x2_net5 4e-13 cap_mim_2f0fF
Cx_core_x2_x1_x2_XC3 x_core_x2_x1_x2_net6 x_core_x2_SY 4e-13 cap_mim_2f0fF
Cx_core_x2_x1_x2_XC1 x_core_x2_SY x_core_x2_x1_x2_net5 4e-13 cap_mim_2f0fF
Cx_core_x2_x2_x2_XC3 x_core_x2_x2_x2_net6 x_core_x2_SZ 4e-13 cap_mim_2f0fF
Cx_core_x2_x2_x2_XC1 x_core_x2_SZ x_core_x2_x2_x2_net5 4e-13 cap_mim_2f0fF
Cx_core_x3_x4_x2_XC2 x_core_x3_net1 x_core_x3_x4_x2_net5 4e-13 cap_mim_2f0fF
Cx_core_x3_x4_x2_XC3 x_core_x3_x4_x2_net6 x_core_x3_net1 4e-13 cap_mim_2f0fF
Cx_core_x3_x5_x2_XC2 x_core_x3_net2 x_core_x3_x5_x2_net5 4e-13 cap_mim_2f0fF
Cx_core_x3_x5_x2_XC3 x_core_x3_x5_x2_net6 x_core_x3_net2 4e-13 cap_mim_2f0fF
Cx_core_x3_x6_x2_XC2 x_core_x3_net3 x_core_x3_x6_x2_net5 4e-13 cap_mim_2f0fF
Cx_core_x3_x6_x2_XC3 x_core_x3_x6_x2_net6 x_core_x3_net3 4e-13 cap_mim_2f0fF
Cx_core_x3_x8_x2_XC3 x_core_x3_x8_x2_net6 x_core_x3_SX 4e-13 cap_mim_2f0fF
Cx_core_x3_x8_x2_XC1 x_core_x3_SX x_core_x3_x8_x2_net5 4e-13 cap_mim_2f0fF
Cx_core_x3_x1_x2_XC3 x_core_x3_x1_x2_net6 x_core_x3_SY 4e-13 cap_mim_2f0fF
Cx_core_x3_x1_x2_XC1 x_core_x3_SY x_core_x3_x1_x2_net5 4e-13 cap_mim_2f0fF
Cx_core_x3_x2_x2_XC3 x_core_x3_x2_x2_net6 x_core_x3_SZ 4e-13 cap_mim_2f0fF
Cx_core_x3_x2_x2_XC1 x_core_x3_SZ x_core_x3_x2_x2_net5 4e-13 cap_mim_2f0fF
Cx_core_x4_x4_x2_XC2 x_core_x4_net1 x_core_x4_x4_x2_net5 4e-13 cap_mim_2f0fF
Cx_core_x4_x4_x2_XC3 x_core_x4_x4_x2_net6 x_core_x4_net1 4e-13 cap_mim_2f0fF
Cx_core_x4_x5_x2_XC2 x_core_x4_net2 x_core_x4_x5_x2_net5 4e-13 cap_mim_2f0fF
Cx_core_x4_x5_x2_XC3 x_core_x4_x5_x2_net6 x_core_x4_net2 4e-13 cap_mim_2f0fF
Cx_core_x4_x6_x2_XC2 x_core_x4_net3 x_core_x4_x6_x2_net5 4e-13 cap_mim_2f0fF
Cx_core_x4_x6_x2_XC3 x_core_x4_x6_x2_net6 x_core_x4_net3 4e-13 cap_mim_2f0fF
Cx_core_x4_x8_x2_XC3 x_core_x4_x8_x2_net6 x_core_x4_SX 4e-13 cap_mim_2f0fF
Cx_core_x4_x8_x2_XC1 x_core_x4_SX x_core_x4_x8_x2_net5 4e-13 cap_mim_2f0fF
Cx_core_x4_x1_x2_XC3 x_core_x4_x1_x2_net6 x_core_x4_SY 4e-13 cap_mim_2f0fF
Cx_core_x4_x1_x2_XC1 x_core_x4_SY x_core_x4_x1_x2_net5 4e-13 cap_mim_2f0fF
Cx_core_x4_x2_x2_XC3 x_core_x4_x2_x2_net6 x_core_x4_SZ 4e-13 cap_mim_2f0fF
Cx_core_x4_x2_x2_XC1 x_core_x4_SZ x_core_x4_x2_x2_net5 4e-13 cap_mim_2f0fF
* resistencias: elemento 'R' con W/L/S en METROS, no 'X' con r_width/r_length.
*   Mismo motivo que los condensadores: el delegate del deck (custom_classes.lvs,
*   SubcircuitModelsReader#element) solo entra por la primera letra, y para 'R' de tres
*   nodos monta un DeviceClassResistorWithBulk con los terminales A, B, W.
*   El deck hace W=W*PAR*1e6 y L=L*S*1e6, o sea que la 'S' MULTIPLICA el largo.
*   Aun asi la serie se escribe TRAMO A TRAMO, no con un 'S=5': el layout dibuja
*   `s` cuerpos de poly encadenados por metal1 y las dos herramientas los extraen
*   como `s` dispositivos. Juntarlos en uno exige la reduccion en serie, y netgen no
*   la aplica aqui porque lee la resistencia de tres nodos como si tuviera dos y le
*   pone de modelo el nodo de sustrato: la clase le sale 'VSS' y su setup no la
*   reconoce. Escribiendo los tramos, las dos partes cuentan lo mismo y no hace falta.
RFB_x_core_x1_x8_x2_1 x_core_x1_x8_x2_G_OUT_P RFB_x_core_x1_x8_x2$1 VSS ppolyf_u_1k W=1e-06 L=7.645e-05 R=76450
RFB_x_core_x1_x8_x2_2 RFB_x_core_x1_x8_x2$1 RFB_x_core_x1_x8_x2$2 VSS ppolyf_u_1k W=1e-06 L=7.645e-05 R=76450
RFB_x_core_x1_x8_x2_3 RFB_x_core_x1_x8_x2$2 RFB_x_core_x1_x8_x2$3 VSS ppolyf_u_1k W=1e-06 L=7.645e-05 R=76450
RFB_x_core_x1_x8_x2_4 RFB_x_core_x1_x8_x2$3 RFB_x_core_x1_x8_x2$4 VSS ppolyf_u_1k W=1e-06 L=7.645e-05 R=76450
RFB_x_core_x1_x8_x2_5 RFB_x_core_x1_x8_x2$4 x_core_x1_SX VSS ppolyf_u_1k W=1e-06 L=7.645e-05 R=76450
RFB_x_core_x1_x1_x2_1 x_core_x1_x1_x2_G_OUT_P RFB_x_core_x1_x1_x2$1 VSS ppolyf_u_1k W=1e-06 L=7.645e-05 R=76450
RFB_x_core_x1_x1_x2_2 RFB_x_core_x1_x1_x2$1 RFB_x_core_x1_x1_x2$2 VSS ppolyf_u_1k W=1e-06 L=7.645e-05 R=76450
RFB_x_core_x1_x1_x2_3 RFB_x_core_x1_x1_x2$2 RFB_x_core_x1_x1_x2$3 VSS ppolyf_u_1k W=1e-06 L=7.645e-05 R=76450
RFB_x_core_x1_x1_x2_4 RFB_x_core_x1_x1_x2$3 RFB_x_core_x1_x1_x2$4 VSS ppolyf_u_1k W=1e-06 L=7.645e-05 R=76450
RFB_x_core_x1_x1_x2_5 RFB_x_core_x1_x1_x2$4 x_core_x1_SY VSS ppolyf_u_1k W=1e-06 L=7.645e-05 R=76450
RFB_x_core_x1_x2_x2_1 x_core_x1_x2_x2_G_OUT_P RFB_x_core_x1_x2_x2$1 VSS ppolyf_u_1k W=1e-06 L=7.645e-05 R=76450
RFB_x_core_x1_x2_x2_2 RFB_x_core_x1_x2_x2$1 RFB_x_core_x1_x2_x2$2 VSS ppolyf_u_1k W=1e-06 L=7.645e-05 R=76450
RFB_x_core_x1_x2_x2_3 RFB_x_core_x1_x2_x2$2 RFB_x_core_x1_x2_x2$3 VSS ppolyf_u_1k W=1e-06 L=7.645e-05 R=76450
RFB_x_core_x1_x2_x2_4 RFB_x_core_x1_x2_x2$3 RFB_x_core_x1_x2_x2$4 VSS ppolyf_u_1k W=1e-06 L=7.645e-05 R=76450
RFB_x_core_x1_x2_x2_5 RFB_x_core_x1_x2_x2$4 x_core_x1_SZ VSS ppolyf_u_1k W=1e-06 L=7.645e-05 R=76450
RFB_x_core_x2_x8_x2_1 x_core_x2_x8_x2_G_OUT_P RFB_x_core_x2_x8_x2$1 VSS ppolyf_u_1k W=1e-06 L=7.645e-05 R=76450
RFB_x_core_x2_x8_x2_2 RFB_x_core_x2_x8_x2$1 RFB_x_core_x2_x8_x2$2 VSS ppolyf_u_1k W=1e-06 L=7.645e-05 R=76450
RFB_x_core_x2_x8_x2_3 RFB_x_core_x2_x8_x2$2 RFB_x_core_x2_x8_x2$3 VSS ppolyf_u_1k W=1e-06 L=7.645e-05 R=76450
RFB_x_core_x2_x8_x2_4 RFB_x_core_x2_x8_x2$3 RFB_x_core_x2_x8_x2$4 VSS ppolyf_u_1k W=1e-06 L=7.645e-05 R=76450
RFB_x_core_x2_x8_x2_5 RFB_x_core_x2_x8_x2$4 x_core_x2_SX VSS ppolyf_u_1k W=1e-06 L=7.645e-05 R=76450
RFB_x_core_x2_x1_x2_1 x_core_x2_x1_x2_G_OUT_P RFB_x_core_x2_x1_x2$1 VSS ppolyf_u_1k W=1e-06 L=7.645e-05 R=76450
RFB_x_core_x2_x1_x2_2 RFB_x_core_x2_x1_x2$1 RFB_x_core_x2_x1_x2$2 VSS ppolyf_u_1k W=1e-06 L=7.645e-05 R=76450
RFB_x_core_x2_x1_x2_3 RFB_x_core_x2_x1_x2$2 RFB_x_core_x2_x1_x2$3 VSS ppolyf_u_1k W=1e-06 L=7.645e-05 R=76450
RFB_x_core_x2_x1_x2_4 RFB_x_core_x2_x1_x2$3 RFB_x_core_x2_x1_x2$4 VSS ppolyf_u_1k W=1e-06 L=7.645e-05 R=76450
RFB_x_core_x2_x1_x2_5 RFB_x_core_x2_x1_x2$4 x_core_x2_SY VSS ppolyf_u_1k W=1e-06 L=7.645e-05 R=76450
RFB_x_core_x2_x2_x2_1 x_core_x2_x2_x2_G_OUT_P RFB_x_core_x2_x2_x2$1 VSS ppolyf_u_1k W=1e-06 L=7.645e-05 R=76450
RFB_x_core_x2_x2_x2_2 RFB_x_core_x2_x2_x2$1 RFB_x_core_x2_x2_x2$2 VSS ppolyf_u_1k W=1e-06 L=7.645e-05 R=76450
RFB_x_core_x2_x2_x2_3 RFB_x_core_x2_x2_x2$2 RFB_x_core_x2_x2_x2$3 VSS ppolyf_u_1k W=1e-06 L=7.645e-05 R=76450
RFB_x_core_x2_x2_x2_4 RFB_x_core_x2_x2_x2$3 RFB_x_core_x2_x2_x2$4 VSS ppolyf_u_1k W=1e-06 L=7.645e-05 R=76450
RFB_x_core_x2_x2_x2_5 RFB_x_core_x2_x2_x2$4 x_core_x2_SZ VSS ppolyf_u_1k W=1e-06 L=7.645e-05 R=76450
RFB_x_core_x3_x8_x2_1 x_core_x3_x8_x2_G_OUT_P RFB_x_core_x3_x8_x2$1 VSS ppolyf_u_1k W=1e-06 L=7.645e-05 R=76450
RFB_x_core_x3_x8_x2_2 RFB_x_core_x3_x8_x2$1 RFB_x_core_x3_x8_x2$2 VSS ppolyf_u_1k W=1e-06 L=7.645e-05 R=76450
RFB_x_core_x3_x8_x2_3 RFB_x_core_x3_x8_x2$2 RFB_x_core_x3_x8_x2$3 VSS ppolyf_u_1k W=1e-06 L=7.645e-05 R=76450
RFB_x_core_x3_x8_x2_4 RFB_x_core_x3_x8_x2$3 RFB_x_core_x3_x8_x2$4 VSS ppolyf_u_1k W=1e-06 L=7.645e-05 R=76450
RFB_x_core_x3_x8_x2_5 RFB_x_core_x3_x8_x2$4 x_core_x3_SX VSS ppolyf_u_1k W=1e-06 L=7.645e-05 R=76450
RFB_x_core_x3_x1_x2_1 x_core_x3_x1_x2_G_OUT_P RFB_x_core_x3_x1_x2$1 VSS ppolyf_u_1k W=1e-06 L=7.645e-05 R=76450
RFB_x_core_x3_x1_x2_2 RFB_x_core_x3_x1_x2$1 RFB_x_core_x3_x1_x2$2 VSS ppolyf_u_1k W=1e-06 L=7.645e-05 R=76450
RFB_x_core_x3_x1_x2_3 RFB_x_core_x3_x1_x2$2 RFB_x_core_x3_x1_x2$3 VSS ppolyf_u_1k W=1e-06 L=7.645e-05 R=76450
RFB_x_core_x3_x1_x2_4 RFB_x_core_x3_x1_x2$3 RFB_x_core_x3_x1_x2$4 VSS ppolyf_u_1k W=1e-06 L=7.645e-05 R=76450
RFB_x_core_x3_x1_x2_5 RFB_x_core_x3_x1_x2$4 x_core_x3_SY VSS ppolyf_u_1k W=1e-06 L=7.645e-05 R=76450
RFB_x_core_x3_x2_x2_1 x_core_x3_x2_x2_G_OUT_P RFB_x_core_x3_x2_x2$1 VSS ppolyf_u_1k W=1e-06 L=7.645e-05 R=76450
RFB_x_core_x3_x2_x2_2 RFB_x_core_x3_x2_x2$1 RFB_x_core_x3_x2_x2$2 VSS ppolyf_u_1k W=1e-06 L=7.645e-05 R=76450
RFB_x_core_x3_x2_x2_3 RFB_x_core_x3_x2_x2$2 RFB_x_core_x3_x2_x2$3 VSS ppolyf_u_1k W=1e-06 L=7.645e-05 R=76450
RFB_x_core_x3_x2_x2_4 RFB_x_core_x3_x2_x2$3 RFB_x_core_x3_x2_x2$4 VSS ppolyf_u_1k W=1e-06 L=7.645e-05 R=76450
RFB_x_core_x3_x2_x2_5 RFB_x_core_x3_x2_x2$4 x_core_x3_SZ VSS ppolyf_u_1k W=1e-06 L=7.645e-05 R=76450
RFB_x_core_x4_x8_x2_1 x_core_x4_x8_x2_G_OUT_P RFB_x_core_x4_x8_x2$1 VSS ppolyf_u_1k W=1e-06 L=7.645e-05 R=76450
RFB_x_core_x4_x8_x2_2 RFB_x_core_x4_x8_x2$1 RFB_x_core_x4_x8_x2$2 VSS ppolyf_u_1k W=1e-06 L=7.645e-05 R=76450
RFB_x_core_x4_x8_x2_3 RFB_x_core_x4_x8_x2$2 RFB_x_core_x4_x8_x2$3 VSS ppolyf_u_1k W=1e-06 L=7.645e-05 R=76450
RFB_x_core_x4_x8_x2_4 RFB_x_core_x4_x8_x2$3 RFB_x_core_x4_x8_x2$4 VSS ppolyf_u_1k W=1e-06 L=7.645e-05 R=76450
RFB_x_core_x4_x8_x2_5 RFB_x_core_x4_x8_x2$4 x_core_x4_SX VSS ppolyf_u_1k W=1e-06 L=7.645e-05 R=76450
RFB_x_core_x4_x1_x2_1 x_core_x4_x1_x2_G_OUT_P RFB_x_core_x4_x1_x2$1 VSS ppolyf_u_1k W=1e-06 L=7.645e-05 R=76450
RFB_x_core_x4_x1_x2_2 RFB_x_core_x4_x1_x2$1 RFB_x_core_x4_x1_x2$2 VSS ppolyf_u_1k W=1e-06 L=7.645e-05 R=76450
RFB_x_core_x4_x1_x2_3 RFB_x_core_x4_x1_x2$2 RFB_x_core_x4_x1_x2$3 VSS ppolyf_u_1k W=1e-06 L=7.645e-05 R=76450
RFB_x_core_x4_x1_x2_4 RFB_x_core_x4_x1_x2$3 RFB_x_core_x4_x1_x2$4 VSS ppolyf_u_1k W=1e-06 L=7.645e-05 R=76450
RFB_x_core_x4_x1_x2_5 RFB_x_core_x4_x1_x2$4 x_core_x4_SY VSS ppolyf_u_1k W=1e-06 L=7.645e-05 R=76450
RFB_x_core_x4_x2_x2_1 x_core_x4_x2_x2_G_OUT_P RFB_x_core_x4_x2_x2$1 VSS ppolyf_u_1k W=1e-06 L=7.645e-05 R=76450
RFB_x_core_x4_x2_x2_2 RFB_x_core_x4_x2_x2$1 RFB_x_core_x4_x2_x2$2 VSS ppolyf_u_1k W=1e-06 L=7.645e-05 R=76450
RFB_x_core_x4_x2_x2_3 RFB_x_core_x4_x2_x2$2 RFB_x_core_x4_x2_x2$3 VSS ppolyf_u_1k W=1e-06 L=7.645e-05 R=76450
RFB_x_core_x4_x2_x2_4 RFB_x_core_x4_x2_x2$3 RFB_x_core_x4_x2_x2$4 VSS ppolyf_u_1k W=1e-06 L=7.645e-05 R=76450
RFB_x_core_x4_x2_x2_5 RFB_x_core_x4_x2_x2$4 x_core_x4_SZ VSS ppolyf_u_1k W=1e-06 L=7.645e-05 R=76450
RR1_Xx_esd_S1P_1 S1P_I S1P VDD ppolyf_u W=4e-05 L=1e-05 R=250
RR1_Xx_esd_S1N_1 S1N_I S1N VDD ppolyf_u W=4e-05 L=1e-05 R=250
RR1_Xx_esd_S2P_1 S2P_I S2P VDD ppolyf_u W=4e-05 L=1e-05 R=250
RR1_Xx_esd_S2N_1 S2N_I S2N VDD ppolyf_u W=4e-05 L=1e-05 R=250
RR1_Xx_esd_S3P_1 S3P_I S3P VDD ppolyf_u W=4e-05 L=1e-05 R=250
RR1_Xx_esd_S3N_1 S3N_I S3N VDD ppolyf_u W=4e-05 L=1e-05 R=250
RR1_Xx_esd_S4P_1 S4P_I S4P VDD ppolyf_u W=4e-05 L=1e-05 R=250
RR1_Xx_esd_S4N_1 S4N_I S4N VDD ppolyf_u W=4e-05 L=1e-05 R=250
RR1_Xx_esd_X_1 X_I X VDD ppolyf_u W=4e-05 L=1e-05 R=250
RR1_Xx_esd_Y_1 Y_I Y VDD ppolyf_u W=4e-05 L=1e-05 R=250
RR1_Xx_esd_Z_1 Z_I Z VDD ppolyf_u W=4e-05 L=1e-05 R=250
.ends
