* fuente: /foss/designs/a_zonetic2026/XSCHEM/OPAM/simulation/COMP.sch/COMP.spice
* leida via enlace: /foss/designs/a_zonetic2026/spice_blocks/COMP.spice
* fecha de la fuente: 2026-08-07 09:54   sha1: 4d36464aab
* generado por flatten_spice.py — NO editar a mano
* netlist plana generada por flatten_spice.py (top: COMP)
* 50 MOSFETs; nets fusionadas por V=0: ninguna
* nombres: los del esquematico; solo llevan la ruta de instancias (Mx1_M4) los -2 que chocaban
* m -> fingers: XM15: m=2 nf=1 -> nf=2; XM16: m=2 nf=1 -> nf=2; XM21: m=2 nf=1 -> nf=2; XM22: m=2 nf=1 -> nf=2; XM29: m=2 nf=1 -> nf=2; XM30: m=2 nf=1 -> nf=2; XM31: m=4 nf=1 -> nf=4; XM35: m=4 nf=1 -> nf=4; XM23: m=2 nf=1 -> nf=2; XM24: m=2 nf=1 -> nf=2; XM25: m=4 nf=1 -> nf=4; XM26: m=4 nf=1 -> nf=4; XM43: m=3 nf=1 -> nf=3; XM44: m=3 nf=1 -> nf=3
* para LVS: cada dedo, un transistor en paralelo
.subckt COMP VDD INN OUT INP VSS
XM4 x1_net3 net4 VDD VDD pfet_06v0 L=1.0u W=10.0u
XM5 net2 net3 x1_net3 VDD pfet_06v0 L=1.0u W=10.0u
XM6 net2 net2 VSS VSS nfet_06v0 L=1.0u W=1.0u
XM7 x1_net2 net4 VDD VDD pfet_06v0 L=1.0u W=10.0u
XM8 net1 net3 x1_net2 VDD pfet_06v0 L=1.0u W=10.0u
XM9 net1 net2 x1_net1 VSS nfet_06v0 L=1.0u W=5.0u
XM10 x1_net1 net1 VSS VSS nfet_06v0 L=1.0u W=5.0u
XM1 net3 net3 VDD VDD pfet_06v0 L=1.0u W=2u
XM2 x1_net4 net4 VDD VDD pfet_06v0 L=1.0u W=10.0u
XM3 net4 net3 x1_net4 VDD pfet_06v0 L=1.0u W=10.0u
XM47 x1_net5 net3 VSS VSS nfet_06v0 L=1.0u W=1.0u
XM48 x1_net6 net3 VSS VSS nfet_06v0 L=1.0u W=1.0u
XM49 net3 net3 x1_net6 VSS nfet_06v0 L=1.0u W=1.0u
XM50 net4 net3 x1_net5 VSS nfet_06v0 L=1.0u W=1.0u
XM11 x2_net2 net4 VDD VDD pfet_06v0 L=1.0u W=10.0u
XM12 x2_net7 net3 x2_net2 VDD pfet_06v0 L=1.0u W=10.0u
XM13 x2_net19 net4 VDD VDD pfet_06v0 L=1.0u W=10.0u
XM14 x2_net7 net3 x2_net19 VDD pfet_06v0 L=1.0u W=10.0u
XM15_f1 x2_net5 INP x2_net7 VDD pfet_06v0 L=1.0u W=10.0u
XM15_f2 x2_net5 INP x2_net7 VDD pfet_06v0 L=1.0u W=10.0u
XM16_f1 x2_net4 INN x2_net7 VDD pfet_06v0 L=1.0u W=10.0u
XM16_f2 x2_net4 INN x2_net7 VDD pfet_06v0 L=1.0u W=10.0u
XM17 x2_net8 net2 x2_net1 VSS nfet_06v0 L=1.0u W=5.0u
XM18 x2_net1 net1 VSS VSS nfet_06v0 L=1.0u W=5.0u
XM19 x2_net8 net2 x2_net20 VSS nfet_06v0 L=1.0u W=5.0u
XM20 x2_net20 net1 VSS VSS nfet_06v0 L=1.0u W=5.0u
XM21_f1 x2_net6 INP x2_net8 VSS nfet_06v0 L=1.0u W=5u
XM21_f2 x2_net6 INP x2_net8 VSS nfet_06v0 L=1.0u W=5u
XM22_f1 x2_net3 INN x2_net8 VSS nfet_06v0 L=1.0u W=5u
XM22_f2 x2_net3 INN x2_net8 VSS nfet_06v0 L=1.0u W=5u
XM29_f1 x2_net9 net3 x2_net3 VDD pfet_06v0 L=1.0u W=5u
XM29_f2 x2_net9 net3 x2_net3 VDD pfet_06v0 L=1.0u W=5u
XM30_f1 x2_net12 net3 x2_net6 VDD pfet_06v0 L=1.0u W=5.0u
XM30_f2 x2_net12 net3 x2_net6 VDD pfet_06v0 L=1.0u W=5.0u
XM31_f1 x2_net3 x2_net9 VDD VDD pfet_06v0 L=1.0u W=5u
XM31_f2 x2_net3 x2_net9 VDD VDD pfet_06v0 L=1.0u W=5u
XM31_f3 x2_net3 x2_net9 VDD VDD pfet_06v0 L=1.0u W=5u
XM31_f4 x2_net3 x2_net9 VDD VDD pfet_06v0 L=1.0u W=5u
XM35_f1 x2_net6 x2_net9 VDD VDD pfet_06v0 L=1.0u W=5.0u
XM35_f2 x2_net6 x2_net9 VDD VDD pfet_06v0 L=1.0u W=5.0u
XM35_f3 x2_net6 x2_net9 VDD VDD pfet_06v0 L=1.0u W=5.0u
XM35_f4 x2_net6 x2_net9 VDD VDD pfet_06v0 L=1.0u W=5.0u
XM32 x2_net10 x2_net21 x2_net9 VDD pfet_06v0 L=1.0u W=5u
XM33 x2_net22 x2_net21 x2_net12 VDD pfet_06v0 L=1.0u W=5.0u
XM23_f1 x2_net10 net2 x2_net4 VSS nfet_06v0 L=1.0u W=2.5u
XM23_f2 x2_net10 net2 x2_net4 VSS nfet_06v0 L=1.0u W=2.5u
XM24_f1 x2_net22 net2 x2_net5 VSS nfet_06v0 L=1.0u W=2.5u
XM24_f2 x2_net22 net2 x2_net5 VSS nfet_06v0 L=1.0u W=2.5u
XM25_f1 x2_net4 x2_net10 VSS VSS nfet_06v0 L=1.0u W=2.5u
XM25_f2 x2_net4 x2_net10 VSS VSS nfet_06v0 L=1.0u W=2.5u
XM25_f3 x2_net4 x2_net10 VSS VSS nfet_06v0 L=1.0u W=2.5u
XM25_f4 x2_net4 x2_net10 VSS VSS nfet_06v0 L=1.0u W=2.5u
XM26_f1 x2_net5 x2_net10 VSS VSS nfet_06v0 L=1.0u W=2.5u
XM26_f2 x2_net5 x2_net10 VSS VSS nfet_06v0 L=1.0u W=2.5u
XM26_f3 x2_net5 x2_net10 VSS VSS nfet_06v0 L=1.0u W=2.5u
XM26_f4 x2_net5 x2_net10 VSS VSS nfet_06v0 L=1.0u W=2.5u
XM27 x2_net9 x2_net11 x2_net10 VSS nfet_06v0 L=1.0u W=2.5u
XM28 x2_net12 x2_net11 x2_net22 VSS nfet_06v0 L=1.0u W=2.5u
XM34 x2_net13 x2_net14 VDD VDD pfet_06v0 L=1.0u W=10.0u
XM36 x2_net14 net3 x2_net13 VDD pfet_06v0 L=1.0u W=10.0u
XM37 x2_net21 x2_net21 x2_net14 VDD pfet_06v0 L=1.0u W=10.0u
XM38 x2_net21 net2 x2_net15 VSS nfet_06v0 L=1.0u W=5.0u
XM39 x2_net15 net1 VSS VSS nfet_06v0 L=1.0u W=5.0u
XM45 x2_net16 net4 VDD VDD pfet_06v0 L=1.0u W=10.0u
XM46 x2_net11 net3 x2_net16 VDD pfet_06v0 L=1.0u W=10.0u
XM40 x2_net11 x2_net11 x2_net18 VSS nfet_06v0 L=1.0u W=5.0u
XM41 x2_net18 net2 x2_net17 VSS nfet_06v0 L=1.0u W=5.0u
XM42 x2_net17 x2_net18 VSS VSS nfet_06v0 L=1.0u W=5.0u
XM43_f1 OUT x2_net12 VDD VDD pfet_06v0 L=1.0u W=10u
XM43_f2 OUT x2_net12 VDD VDD pfet_06v0 L=1.0u W=10u
XM43_f3 OUT x2_net12 VDD VDD pfet_06v0 L=1.0u W=10u
XM44_f1 OUT x2_net22 VSS VSS nfet_06v0 L=1.0u W=5u
XM44_f2 OUT x2_net22 VSS VSS nfet_06v0 L=1.0u W=5u
XM44_f3 OUT x2_net22 VSS VSS nfet_06v0 L=1.0u W=5u
* condensadores: elemento 'C' con W/L en METROS, no 'X' con c_width/c_length.
*   El deck de KLayout los lee con un delegate (custom_classes.lvs, SubcircuitModelsReader#element)
*   que SOLO actua si el elemento empieza por 'C', y de ahi saca A=W*L*1e12 y P=2*(W+L)*1e6.
*   Escrito como 'X...' se leeria como llamada a subcircuito y no emparejaria con nada.
XC2 OUT x2_net5 cap_mim_2f0_m4m5_noshield W=2e-05 L=1e-05
XC3 x2_net6 OUT cap_mim_2f0_m4m5_noshield W=2e-05 L=1e-05
.ends
