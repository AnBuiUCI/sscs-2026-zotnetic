* NGSPICE file created from GRADIENT_NAV.ext - technology: gf180mcuD

.subckt GRADIENT_NAV S2N S2P VDD VSS X XP S1N S1P S3N S3P S4N S4P XN Y YN YP Z ZN
+ ZP
X0 a_4026_74376# a_4114_74260# S2P S2P pfet_06v0 ad=1.32p pd=6.88u as=1.32p ps=6.88u w=3u l=1u
X1 a_46046_60452# a_54516_57052# cap_mim_2f0_m4m5_noshield c_width=20u c_length=10u
X2 a_2418_22332# a_2218_22216# a_2118_22332# S2P nfet_06v0 ad=2.2p pd=10.88u as=1.25p ps=5.5u w=5u l=1u
X3 a_20158_65848# a_11346_65848# S2P S2P nfet_06v0 ad=1.3p pd=5.52u as=2.2p ps=10.88u w=5u l=1u
X4 a_29886_42976# a_29886_42976# a_31510_42976# S2P pfet_06v0 ad=4.4p pd=20.88u as=4.4p ps=20.88u w=10u l=1u
X5 a_27228_22332# a_23050_22216# a_25214_25732# S2P nfet_06v0 ad=1.1p pd=5.88u as=1.1p ps=5.88u w=2.5u l=1u
X6 a_40322_16940# a_25998_13540# a_41442_13656# S2P nfet_06v0 ad=2.2p pd=10.88u as=1.25p ps=5.5u w=5u l=1u
X7 a_54466_8260# a_43622_8144# S2P S2P pfet_06v0 ad=2.5p pd=10.5u as=4.4p ps=20.88u w=10u l=1u
X8 a_68150_17056# a_50118_16940# S2P S2P pfet_06v0 ad=2.5p pd=10.5u as=4.4p ps=20.88u w=10u l=1u
X9 a_25998_48260# a_26338_51660# a_26238_51776# S2P pfet_06v0 ad=4.4p pd=20.88u as=2.5p ps=10.5u w=10u l=1u
X10 a_3270_8260# a_1958_8144# S2P S2P pfet_06v0 ad=2.5p pd=10.5u as=4.4p ps=20.88u w=10u l=1u
X11 a_54516_39692# a_48482_43092# S2P S2P pfet_06v0 ad=0.308p pd=2.28u as=0.308p ps=2.28u w=0.7u l=20u
X12 a_5194_43092# a_4714_39576# a_2458_43092# S2P pfet_06v0 ad=4.4p pd=20.88u as=4.4p ps=20.88u w=10u l=1u
X13 a_50056_56936# a_50056_56936# a_52464_57052# S2P nfet_06v0 ad=2.2p pd=10.88u as=2.2p ps=10.88u w=5u l=1u
X14 a_27228_57052# a_29886_60336# a_27650_60452# S2P pfet_06v0 ad=2.2p pd=10.88u as=2.2p ps=10.88u w=5u l=1u
X15 S2P a_24886_74260# a_28314_74376# S2P nfet_06v0 ad=0.44p pd=2.88u as=0.25p ps=1.5u w=1u l=1u
X16 a_26038_16940# a_26338_16940# a_29274_17056# S2P pfet_06v0 ad=4.4p pd=20.88u as=2.5p ps=10.5u w=10u l=1u
X17 S2P a_34314_48376# a_32610_51776# S2P nfet_06v0 ad=0.65p pd=3.02u as=0.65p ps=3.02u w=2.5u l=1u
X18 a_27650_25732# a_29224_22216# a_27228_22332# S2P nfet_06v0 ad=1.1p pd=5.88u as=1.1p ps=5.88u w=2.5u l=1u
X19 a_56690_17056# a_58394_13656# S2P S2P nfet_06v0 ad=0.65p pd=3.02u as=0.65p ps=3.02u w=2.5u l=1u
X20 S2P a_2330_75936# a_1830_74376# S2P nfet_06v0 ad=0.44p pd=2.88u as=0.44p ps=2.88u w=1u l=1u
X21 a_8010_48376# a_7810_48260# a_6246_48376# S2P nfet_06v0 ad=1.3p pd=5.52u as=2.2p ps=10.88u w=5u l=1u
X22 a_6606_34416# a_7810_30900# a_8530_34416# S2P pfet_06v0 ad=4.4p pd=20.88u as=2.6p ps=10.52u w=10u l=1u
X23 a_2118_4860# a_1918_4744# S2P S2P nfet_06v0 ad=1.25p pd=5.5u as=2.2p ps=10.88u w=5u l=1u
X24 a_1918_56936# a_2218_56936# a_14316_57052# S2P nfet_06v0 ad=2.2p pd=10.88u as=1.25p ps=5.5u w=5u l=1u
X25 a_33202_65848# a_34842_69248# S2P S2P pfet_06v0 ad=1.3p pd=5.52u as=2.2p ps=10.88u w=5u l=1u
X26 a_64402_69132# a_64402_69132# a_66026_69132# S2P pfet_06v0 ad=4.4p pd=20.88u as=4.4p ps=20.88u w=10u l=1u
X27 a_54466_60452# a_43622_60336# S2P S2P pfet_06v0 ad=2.5p pd=10.5u as=4.4p ps=20.88u w=10u l=1u
X28 w_64222_7494# a_64528_7674# a_64528_7674# w_64222_7494# pfet_06v0 ad=0.52p pd=2.52u as=0.52p ps=2.52u w=2u l=1u
X29 w_64222_24966# a_64528_25146# a_64528_25146# w_64222_24966# pfet_06v0 ad=0.52p pd=2.52u as=0.52p ps=2.52u w=2u l=1u
X30 a_31058_31016# a_26730_30900# S2P S2P nfet_06v0 ad=1.25p pd=5.5u as=2.2p ps=10.88u w=5u l=1u
X31 S2P a_27382_74260# a_27294_74376# S2P nfet_06v0 ad=0.44p pd=2.88u as=0.44p ps=2.88u w=1u l=1u
X32 a_64528_7674# a_69626_5570# a_69538_5686# S2P nfet_06v0 ad=0.6448p pd=3u as=1.0912p ps=5.84u w=2.48u l=1u
X33 S2P a_59506_65848# a_68318_65848# S2P nfet_06v0 ad=1.3p pd=5.52u as=1.3p ps=5.52u w=5u l=1u
X34 a_32652_22332# a_31632_22332# S2P S2P nfet_06v0 ad=1.25p pd=5.5u as=2.2p ps=10.88u w=5u l=1u
X35 a_45846_22332# S4P a_44082_22332# S2P nfet_06v0 ad=2.2p pd=10.88u as=2.2p ps=10.88u w=5u l=1u
X36 a_10234_31016# a_1918_30900# a_9646_34416# S2P nfet_06v0 ad=0.65p pd=3.02u as=1.1p ps=5.88u w=2.5u l=1u
X37 a_6818_8260# a_2258_8144# a_4182_4860# S2P pfet_06v0 ad=2.2p pd=10.88u as=2.2p ps=10.88u w=5u l=1u
X38 a_35958_51776# a_39778_48260# a_35426_48376# S2P nfet_06v0 ad=1.1p pd=5.88u as=1.1p ps=5.88u w=2.5u l=1u
X39 a_2218_56936# a_2218_56936# S2P S2P nfet_06v0 ad=0.44p pd=2.88u as=0.44p ps=2.88u w=1u l=1u
X40 a_8530_17056# a_7810_13540# a_6606_17056# S2P pfet_06v0 ad=2.6p pd=10.52u as=4.4p ps=20.88u w=10u l=1u
X41 a_67394_40518# a_64528_42506# a_68794_40518# S2P nfet_06v0 ad=0.88p pd=4.88u as=0.5p ps=2.5u w=2u l=1u
X42 a_54766_69248# a_55970_65732# a_56690_69248# S2P pfet_06v0 ad=4.4p pd=20.88u as=2.6p ps=10.52u w=10u l=1u
X43 a_9646_51776# a_8922_48260# a_6606_51776# S2P pfet_06v0 ad=2.6p pd=10.52u as=4.4p ps=20.88u w=10u l=1u
X44 a_56690_69248# a_68318_65848# cap_mim_2f0_m4m5_noshield c_width=20u c_length=10u
X45 a_46858_25732# a_47328_22332# S2P S2P nfet_06v0 ad=1.1p pd=5.88u as=1.1p ps=5.88u w=2.5u l=1u
X46 a_54406_65848# a_50078_65732# a_55138_65848# S2P nfet_06v0 ad=2.2p pd=10.88u as=1.25p ps=5.5u w=5u l=1u
X47 S2P a_14134_74260# a_17562_74376# S2P nfet_06v0 ad=0.44p pd=2.88u as=0.25p ps=1.5u w=1u l=1u
X48 a_44238_65848# a_35426_65848# S2P S2P nfet_06v0 ad=1.3p pd=5.52u as=2.2p ps=10.88u w=5u l=1u
X49 a_30888_57052# a_22750_56936# S2P S2P nfet_06v0 ad=1.25p pd=5.5u as=2.2p ps=10.88u w=5u l=1u
X50 a_8530_69248# a_1918_65732# a_11346_65848# S2P nfet_06v0 ad=1.1p pd=5.88u as=0.65p ps=3.02u w=2.5u l=1u
X51 a_12670_74260# a_59506_48376# S2P S2P nfet_06v0 ad=2.2p pd=10.88u as=1.3p ps=5.52u w=5u l=1u
X52 a_27228_4860# a_29886_8144# a_27650_8260# S2P pfet_06v0 ad=2.2p pd=10.88u as=2.2p ps=10.88u w=5u l=1u
X53 a_5194_25732# a_5664_22332# S2P S2P nfet_06v0 ad=1.1p pd=5.88u as=1.1p ps=5.88u w=2.5u l=1u
X54 a_4382_60452# S3P a_2458_60452# S2P pfet_06v0 ad=4.4p pd=20.88u as=4.4p ps=20.88u w=10u l=1u
X55 a_64528_25146# a_64526_23042# a_64438_23158# S2P nfet_06v0 ad=0.6448p pd=3u as=1.0912p ps=5.84u w=2.48u l=1u
X56 a_44238_13656# a_35958_17056# S2P S2P pfet_06v0 ad=4.4p pd=20.88u as=2.6p ps=10.52u w=10u l=1u
X57 a_5664_4860# a_9054_8144# a_6006_8260# S2P pfet_06v0 ad=2.2p pd=10.88u as=2.2p ps=10.88u w=5u l=1u
X58 a_43922_25616# a_43922_25616# S2P S2P pfet_06v0 ad=0.88p pd=4.88u as=0.88p ps=4.88u w=2u l=1u
X59 a_36180_57052# a_23090_60336# S2P S2P nfet_06v0 ad=0.25p pd=1.5u as=0.44p ps=2.88u w=1u l=1u
X60 a_1918_22216# a_2258_25616# a_15026_25732# S2P pfet_06v0 ad=4.4p pd=20.88u as=2.5p ps=10.5u w=10u l=1u
X61 a_18066_17056# a_17866_16940# S2P S2P pfet_06v0 ad=2.5p pd=10.5u as=4.4p ps=20.88u w=10u l=1u
X62 a_44814_57052# a_43582_56936# S2P S2P nfet_06v0 ad=1.25p pd=5.5u as=2.2p ps=10.88u w=5u l=1u
X63 a_25998_65732# a_26338_69132# a_26238_69248# S2P pfet_06v0 ad=4.4p pd=20.88u as=2.5p ps=10.5u w=10u l=1u
X64 a_1958_16940# a_2258_16940# a_3882_13656# S2P nfet_06v0 ad=0.44p pd=2.88u as=0.25p ps=1.5u w=1u l=1u
X65 a_54406_13656# a_55970_13540# a_56170_13656# S2P nfet_06v0 ad=2.2p pd=10.88u as=1.3p ps=5.52u w=5u l=1u
X66 a_67394_5686# a_64528_7674# a_68794_5686# S2P nfet_06v0 ad=0.88p pd=4.88u as=0.5p ps=2.5u w=2u l=1u
X67 a_50056_4744# a_50056_4744# a_52464_4860# S2P nfet_06v0 ad=2.2p pd=10.88u as=2.2p ps=10.88u w=5u l=1u
X68 a_22750_4744# a_23090_8144# a_35858_8260# S2P pfet_06v0 ad=4.4p pd=20.88u as=2.5p ps=10.5u w=10u l=1u
X69 a_37212_4860# a_23090_8144# S2P S2P nfet_06v0 ad=0.25p pd=1.5u as=0.44p ps=2.88u w=1u l=1u
X70 a_9646_17056# a_1918_13540# a_10234_13656# S2P nfet_06v0 ad=1.1p pd=5.88u as=0.65p ps=3.02u w=2.5u l=1u
X71 a_29224_39576# a_23090_42976# a_33634_43092# S2P pfet_06v0 ad=4.4p pd=20.88u as=2.5p ps=10.5u w=10u l=1u
X72 a_4914_39692# a_6006_43092# S2P S2P pfet_06v0 ad=2.2p pd=10.88u as=2.2p ps=10.88u w=5u l=1u
X73 a_46858_60452# S2N a_44122_60452# S2P pfet_06v0 ad=4.4p pd=20.88u as=4.4p ps=20.88u w=10u l=1u
X74 S2P a_34842_17056# a_33202_13656# S2P pfet_06v0 ad=2.2p pd=10.88u as=1.3p ps=5.52u w=5u l=1u
X75 a_6818_43092# a_8392_39576# a_6396_39692# S2P nfet_06v0 ad=1.1p pd=5.88u as=1.1p ps=5.88u w=2.5u l=1u
X76 a_43782_57052# a_43582_56936# S2P S2P nfet_06v0 ad=1.25p pd=5.5u as=2.2p ps=10.88u w=5u l=1u
X77 a_16242_69132# a_1918_65732# a_17362_65848# S2P nfet_06v0 ad=2.2p pd=10.88u as=1.25p ps=5.5u w=5u l=1u
X78 a_46578_4860# S3N a_44082_4860# S2P nfet_06v0 ad=2.2p pd=10.88u as=2.2p ps=10.88u w=5u l=1u
X79 a_58922_17056# a_63858_13540# a_58394_13656# S2P nfet_06v0 ad=1.1p pd=5.88u as=1.1p ps=5.88u w=2.5u l=1u
X80 a_50118_34300# a_50418_34300# a_52042_31016# S2P nfet_06v0 ad=0.44p pd=2.88u as=0.25p ps=1.5u w=1u l=1u
X81 a_25746_39692# a_26838_43092# S2P S2P pfet_06v0 ad=2.2p pd=10.88u as=2.2p ps=10.88u w=5u l=1u
X82 a_9122_48376# a_8922_48260# a_6246_48376# S2P nfet_06v0 ad=1.3p pd=5.52u as=2.2p ps=10.88u w=5u l=1u
X83 a_2118_57052# a_1918_56936# S2P S2P nfet_06v0 ad=1.25p pd=5.5u as=2.2p ps=10.88u w=5u l=1u
X84 a_26496_22332# a_29886_25616# a_26838_25732# S2P pfet_06v0 ad=2.2p pd=10.88u as=2.2p ps=10.88u w=5u l=1u
X85 a_51430_17056# a_50118_16940# S2P S2P pfet_06v0 ad=2.5p pd=10.5u as=4.4p ps=20.88u w=10u l=1u
X86 a_68318_31016# a_59506_31016# S2P S2P nfet_06v0 ad=1.3p pd=5.52u as=2.2p ps=10.88u w=5u l=1u
X87 a_26338_16940# a_26338_16940# a_28994_13656# S2P nfet_06v0 ad=0.44p pd=2.88u as=0.25p ps=1.5u w=1u l=1u
X88 a_32610_34416# a_25998_30900# a_35426_31016# S2P nfet_06v0 ad=1.1p pd=5.88u as=0.65p ps=3.02u w=2.5u l=1u
X89 a_32610_69248# a_34314_65848# S2P S2P nfet_06v0 ad=0.65p pd=3.02u as=0.65p ps=3.02u w=2.5u l=1u
X90 a_32610_17056# a_34314_13656# S2P S2P nfet_06v0 ad=0.65p pd=3.02u as=1.1p ps=5.88u w=2.5u l=1u
X91 a_2650_48260# a_1918_48260# a_2850_48376# S2P nfet_06v0 ad=2.2p pd=10.88u as=1.25p ps=5.5u w=5u l=1u
X92 a_39778_48260# a_26338_51660# a_44070_51776# S2P pfet_06v0 ad=4.4p pd=20.88u as=2.5p ps=10.5u w=10u l=1u
X93 a_23290_60452# a_23090_60336# a_24102_60452# S2P pfet_06v0 ad=4.4p pd=20.88u as=2.5p ps=10.5u w=10u l=1u
X94 a_30686_17056# a_33002_13540# a_33726_17056# S2P pfet_06v0 ad=4.4p pd=20.88u as=2.6p ps=10.52u w=10u l=1u
X95 a_8392_22216# a_2258_25616# a_12802_25732# S2P pfet_06v0 ad=4.4p pd=20.88u as=2.5p ps=10.5u w=10u l=1u
X96 a_55578_60452# a_43622_60336# S2P S2P pfet_06v0 ad=2.5p pd=10.5u as=4.4p ps=20.88u w=10u l=1u
X97 a_22990_60452# a_22790_60336# S2P S2P pfet_06v0 ad=2.5p pd=10.5u as=4.4p ps=20.88u w=10u l=1u
X98 a_57282_31016# a_57082_30900# a_54406_31016# S2P nfet_06v0 ad=1.3p pd=5.52u as=2.2p ps=10.88u w=5u l=1u
X99 a_9646_69248# a_8922_65732# a_6606_69248# S2P pfet_06v0 ad=2.6p pd=10.52u as=4.4p ps=20.88u w=10u l=1u
X100 a_33202_48376# a_26338_51660# a_34842_51776# S2P pfet_06v0 ad=2.2p pd=10.88u as=1.3p ps=5.52u w=5u l=1u
X101 a_2258_60336# a_2258_60336# a_16380_57052# S2P nfet_06v0 ad=0.44p pd=2.88u as=0.25p ps=1.5u w=1u l=1u
X102 a_33634_8260# a_22790_8144# S2P S2P pfet_06v0 ad=2.5p pd=10.5u as=4.4p ps=20.88u w=10u l=1u
X103 a_47328_22332# a_50718_25616# a_47670_25732# S2P pfet_06v0 ad=2.2p pd=10.88u as=2.2p ps=10.88u w=5u l=1u
X104 a_69196_7790# a_68484_7790# S2P S2P nfet_05v0 ad=0.5808p pd=3.52u as=0.5808p ps=3.52u w=1.32u l=0.6u
X105 a_45846_39692# a_47670_43092# S2P S2P pfet_06v0 ad=2.2p pd=10.88u as=2.2p ps=10.88u w=5u l=1u
X106 a_11346_31016# a_16242_34300# a_11878_34416# S2P pfet_06v0 ad=2.2p pd=10.88u as=2.2p ps=10.88u w=5u l=1u
X107 a_6606_51776# a_2258_51660# a_6306_51776# S2P pfet_06v0 ad=4.4p pd=20.88u as=2.5p ps=10.5u w=10u l=1u
X108 a_22790_8144# a_23090_8144# a_36180_4860# S2P nfet_06v0 ad=0.44p pd=2.88u as=0.25p ps=1.5u w=1u l=1u
X109 a_11346_31016# a_1918_30900# a_8530_34416# S2P nfet_06v0 ad=0.65p pd=3.02u as=1.1p ps=5.88u w=2.5u l=1u
X110 a_5194_51776# a_1958_51660# S2P S2P pfet_06v0 ad=2.5p pd=10.5u as=4.4p ps=20.88u w=10u l=1u
X111 a_67286_31016# a_66266_31016# S2P S2P nfet_06v0 ad=1.25p pd=5.5u as=2.2p ps=10.88u w=5u l=1u
X112 a_2418_57052# a_2218_56936# a_3150_57052# S2P nfet_06v0 ad=2.2p pd=10.88u as=1.25p ps=5.5u w=5u l=1u
X113 a_27350_51776# a_26038_51660# S2P S2P pfet_06v0 ad=2.5p pd=10.5u as=4.4p ps=20.88u w=10u l=1u
X114 a_6246_31016# a_1918_30900# a_5946_31016# S2P nfet_06v0 ad=2.2p pd=10.88u as=1.25p ps=5.5u w=5u l=1u
X115 S2P a_10234_65848# a_9646_69248# S2P nfet_06v0 ad=0.65p pd=3.02u as=0.65p ps=3.02u w=2.5u l=1u
X116 a_63858_30900# a_50418_34300# a_68150_34416# S2P pfet_06v0 ad=4.4p pd=20.88u as=2.5p ps=10.5u w=10u l=1u
X117 S2P a_11346_48376# a_20158_48376# S2P nfet_06v0 ad=1.3p pd=5.52u as=1.3p ps=5.52u w=5u l=1u
X118 a_46046_8260# S3P a_44122_8260# S2P pfet_06v0 ad=4.4p pd=20.88u as=4.4p ps=20.88u w=10u l=1u
X119 a_43782_4860# a_43582_4744# S2P S2P nfet_06v0 ad=1.25p pd=5.5u as=2.2p ps=10.88u w=5u l=1u
X120 a_23250_57052# a_23050_56936# a_23982_57052# S2P nfet_06v0 ad=2.2p pd=10.88u as=1.25p ps=5.5u w=5u l=1u
X121 a_26038_51660# a_26338_51660# a_27962_48376# S2P nfet_06v0 ad=0.44p pd=2.88u as=0.25p ps=1.5u w=1u l=1u
X122 a_64528_25146# a_65638_23042# a_65550_23158# S2P nfet_06v0 ad=0.6448p pd=3u as=1.0912p ps=5.84u w=2.48u l=1u
X123 a_65550_5686# a_65638_5570# a_64528_7674# S2P nfet_06v0 ad=1.0912p pd=5.84u as=0.6448p ps=3u w=2.48u l=1u
X124 a_54106_31016# a_50810_30900# S2P S2P nfet_06v0 ad=1.25p pd=5.5u as=2.2p ps=10.88u w=5u l=1u
X125 a_43622_25616# a_43922_25616# a_58614_25732# S2P pfet_06v0 ad=4.4p pd=20.88u as=2.5p ps=10.5u w=10u l=1u
X126 a_12802_43092# a_1958_42976# S2P S2P pfet_06v0 ad=2.5p pd=10.5u as=4.4p ps=20.88u w=10u l=1u
X127 a_4382_8260# a_12852_4860# cap_mim_2f0_m4m5_noshield c_width=20u c_length=10u
X128 a_50718_60336# a_43882_56936# a_51720_57052# S2P nfet_06v0 ad=2.2p pd=10.88u as=1.25p ps=5.5u w=5u l=1u
X129 a_9646_51776# a_10234_48376# S2P S2P nfet_06v0 ad=0.65p pd=3.02u as=0.65p ps=3.02u w=2.5u l=1u
X130 a_16242_16940# a_16242_16940# a_17866_16940# S2P pfet_06v0 ad=4.4p pd=20.88u as=4.4p ps=20.88u w=10u l=1u
X131 a_54406_13656# a_57082_13540# a_57282_13656# S2P nfet_06v0 ad=2.2p pd=10.88u as=1.3p ps=5.52u w=5u l=1u
X132 a_10878_60452# a_10678_60336# S2P S2P pfet_06v0 ad=2.5p pd=10.5u as=4.4p ps=20.88u w=10u l=1u
X133 a_29886_25616# a_23050_22216# a_30888_22332# S2P nfet_06v0 ad=2.2p pd=10.88u as=1.25p ps=5.5u w=5u l=1u
X134 a_32610_51776# a_31890_48260# a_30686_51776# S2P pfet_06v0 ad=2.6p pd=10.52u as=4.4p ps=20.88u w=10u l=1u
X135 a_10056_39692# a_1918_39576# S2P S2P nfet_06v0 ad=1.25p pd=5.5u as=2.2p ps=10.88u w=5u l=1u
X136 a_48482_8260# a_43922_8144# a_45846_4860# S2P pfet_06v0 ad=2.2p pd=10.88u as=2.2p ps=10.88u w=5u l=1u
X137 S2P a_10234_31016# a_9646_34416# S2P nfet_06v0 ad=1.1p pd=5.88u as=0.65p ps=3.02u w=2.5u l=1u
X138 a_69418_57016# a_64938_58576# a_68486_56900# S2P nfet_06v0 ad=0.25p pd=1.5u as=0.44p ps=2.88u w=1u l=1u
X139 a_50810_65732# a_50078_65732# a_51010_65848# S2P nfet_06v0 ad=2.2p pd=10.88u as=1.25p ps=5.5u w=5u l=1u
X140 a_14046_74376# a_14134_74260# S2P S2P pfet_06v0 ad=1.32p pd=6.88u as=1.32p ps=6.88u w=3u l=1u
X141 a_12670_74260# a_60038_51776# S2P S2P pfet_06v0 ad=2.6p pd=10.52u as=4.4p ps=20.88u w=10u l=1u
X142 a_58922_17056# a_50418_16940# a_57282_13656# S2P pfet_06v0 ad=1.3p pd=5.52u as=2.2p ps=10.88u w=5u l=1u
X143 a_53074_31016# a_50418_34300# S2P S2P nfet_06v0 ad=0.25p pd=1.5u as=0.44p ps=2.88u w=1u l=1u
X144 a_23050_39576# a_23090_42976# a_34746_43092# S2P pfet_06v0 ad=4.4p pd=20.88u as=2.5p ps=10.5u w=10u l=1u
X145 a_60038_51776# a_50418_51660# a_56170_48376# S2P pfet_06v0 ad=1.3p pd=5.52u as=2.2p ps=10.88u w=5u l=1u
X146 a_48060_4860# a_43882_4744# a_46046_8260# S2P nfet_06v0 ad=1.1p pd=5.88u as=1.1p ps=5.88u w=2.5u l=1u
X147 a_44122_25732# a_43922_25616# a_44934_25732# S2P pfet_06v0 ad=4.4p pd=20.88u as=2.5p ps=10.5u w=10u l=1u
X148 S2P a_23422_74260# a_26550_74376# S2P nfet_06v0 ad=0.44p pd=2.88u as=0.25p ps=1.5u w=1u l=1u
X149 a_39778_65732# a_26338_69132# a_44070_69248# S2P pfet_06v0 ad=4.4p pd=20.88u as=2.5p ps=10.5u w=10u l=1u
X150 a_14316_4860# a_1918_4744# S2P S2P nfet_06v0 ad=1.25p pd=5.5u as=2.2p ps=10.88u w=5u l=1u
X151 a_23050_39576# a_23050_39576# S2P S2P nfet_06v0 ad=0.44p pd=2.88u as=0.44p ps=2.88u w=1u l=1u
X152 a_29224_22216# a_29224_22216# a_31632_22332# S2P nfet_06v0 ad=2.2p pd=10.88u as=2.2p ps=10.88u w=5u l=1u
X153 a_44082_22332# a_43882_22216# a_44814_22332# S2P nfet_06v0 ad=2.2p pd=10.88u as=1.25p ps=5.5u w=5u l=1u
X154 a_33202_65848# a_26338_69132# a_34842_69248# S2P pfet_06v0 ad=2.2p pd=10.88u as=1.3p ps=5.52u w=5u l=1u
X155 a_32090_65848# a_31890_65732# a_30326_65848# S2P nfet_06v0 ad=1.3p pd=5.52u as=2.2p ps=10.88u w=5u l=1u
X156 a_58614_43092# a_43622_42976# S2P S2P pfet_06v0 ad=2.5p pd=10.5u as=4.4p ps=20.88u w=10u l=1u
X157 a_2158_25732# a_1958_25616# S2P S2P pfet_06v0 ad=2.5p pd=10.5u as=4.4p ps=20.88u w=10u l=1u
X158 a_12852_57052# a_6396_57052# S2P S2P nfet_06v0 ad=0.44p pd=2.88u as=0.44p ps=2.88u w=1u l=1u
X159 a_6606_69248# a_2258_69132# a_6306_69248# S2P pfet_06v0 ad=4.4p pd=20.88u as=2.5p ps=10.5u w=10u l=1u
X160 a_29224_4744# a_29224_4744# a_31632_4860# S2P nfet_06v0 ad=2.2p pd=10.88u as=2.2p ps=10.88u w=5u l=1u
X161 a_26730_30900# a_26338_34300# a_27350_34416# S2P pfet_06v0 ad=4.4p pd=20.88u as=2.5p ps=10.5u w=10u l=1u
X162 a_30026_48376# a_26730_48260# S2P S2P nfet_06v0 ad=1.25p pd=5.5u as=2.2p ps=10.88u w=5u l=1u
X163 a_5194_69248# a_1958_69132# S2P S2P pfet_06v0 ad=2.5p pd=10.5u as=4.4p ps=20.88u w=10u l=1u
X164 a_50418_16940# a_50418_16940# S2P S2P pfet_06v0 ad=0.88p pd=4.88u as=0.88p ps=4.88u w=2u l=1u
X165 S2P a_58394_48376# a_57806_51776# S2P nfet_06v0 ad=1.1p pd=5.88u as=0.65p ps=3.02u w=2.5u l=1u
X166 a_48060_22332# a_43882_22216# a_46046_25732# S2P nfet_06v0 ad=1.1p pd=5.88u as=1.1p ps=5.88u w=2.5u l=1u
X167 S2P a_34314_31016# a_33726_34416# S2P nfet_06v0 ad=0.65p pd=3.02u as=0.65p ps=3.02u w=2.5u l=1u
X168 a_34842_69248# a_39778_65732# a_34314_65848# S2P nfet_06v0 ad=1.1p pd=5.88u as=1.1p ps=5.88u w=2.5u l=1u
X169 a_67772_25262# a_64528_25146# w_64222_24966# w_64222_24966# pfet_05v0 ad=0.8052p pd=4.54u as=0.8052p ps=4.54u w=1.83u l=0.5u
X170 a_4182_57052# S3P a_2418_57052# S2P nfet_06v0 ad=2.2p pd=10.88u as=2.2p ps=10.88u w=5u l=1u
X171 a_5194_8260# S1N a_2458_8260# S2P pfet_06v0 ad=4.4p pd=20.88u as=4.4p ps=20.88u w=10u l=1u
X172 S2P a_10234_48376# a_8530_51776# S2P nfet_06v0 ad=1.1p pd=5.88u as=0.65p ps=3.02u w=2.5u l=1u
X173 a_42186_65848# a_25998_65732# a_43206_65848# S2P nfet_06v0 ad=2.2p pd=10.88u as=1.25p ps=5.5u w=5u l=1u
X174 a_2258_69132# a_2258_69132# a_4914_65848# S2P nfet_06v0 ad=0.44p pd=2.88u as=0.25p ps=1.5u w=1u l=1u
X175 a_46578_39692# S1N a_44082_39692# S2P nfet_06v0 ad=2.2p pd=10.88u as=2.2p ps=10.88u w=5u l=1u
X176 a_27350_69248# a_26038_69132# S2P S2P pfet_06v0 ad=2.5p pd=10.5u as=4.4p ps=20.88u w=10u l=1u
X177 a_58394_31016# a_50078_30900# a_57806_34416# S2P nfet_06v0 ad=0.65p pd=3.02u as=1.1p ps=5.88u w=2.5u l=1u
X178 a_69538_23158# a_69626_23042# a_64528_25146# S2P nfet_06v0 ad=1.0912p pd=5.84u as=0.6448p ps=3u w=2.48u l=1u
X179 a_44082_22332# a_43882_22216# a_43782_22332# S2P nfet_06v0 ad=2.2p pd=10.88u as=1.25p ps=5.5u w=5u l=1u
X180 a_57012_39692# a_43922_42976# S2P S2P nfet_06v0 ad=0.25p pd=1.5u as=0.44p ps=2.88u w=1u l=1u
X181 a_6978_31016# a_2650_30900# S2P S2P nfet_06v0 ad=1.25p pd=5.5u as=2.2p ps=10.88u w=5u l=1u
X182 a_33684_4860# a_25014_4860# cap_mim_2f0_m4m5_noshield c_width=20u c_length=10u
X183 w_64222_7494# a_64528_7674# a_64528_7674# w_64222_7494# pfet_06v0 ad=0.52p pd=2.52u as=0.52p ps=2.52u w=2u l=1u
X184 a_17866_34300# a_2258_34300# a_18066_34416# S2P pfet_06v0 ad=4.4p pd=20.88u as=2.5p ps=10.5u w=10u l=1u
X185 a_6606_51776# a_2258_51660# a_7418_51776# S2P pfet_06v0 ad=4.4p pd=20.88u as=2.5p ps=10.5u w=10u l=1u
X186 a_33684_39692# a_25014_39692# cap_mim_2f0_m4m5_noshield c_width=20u c_length=10u
X187 a_40322_16940# a_40322_16940# a_41946_16940# S2P pfet_06v0 ad=4.4p pd=20.88u as=4.4p ps=20.88u w=10u l=1u
X188 a_9122_13656# a_10762_17056# S2P S2P pfet_06v0 ad=1.3p pd=5.52u as=2.2p ps=10.88u w=5u l=1u
X189 a_9646_34416# a_10234_31016# S2P S2P nfet_06v0 ad=0.65p pd=3.02u as=1.1p ps=5.88u w=2.5u l=1u
X190 a_25746_4860# a_25546_4744# a_23250_4860# S2P nfet_06v0 ad=2.2p pd=10.88u as=2.2p ps=10.88u w=5u l=1u
X191 a_28994_48376# a_26338_51660# S2P S2P nfet_06v0 ad=0.25p pd=1.5u as=0.44p ps=2.88u w=1u l=1u
X192 a_47670_60452# a_43922_60336# a_46578_57052# S2P pfet_06v0 ad=2.2p pd=10.88u as=2.2p ps=10.88u w=5u l=1u
X193 a_6396_39692# a_9054_42976# a_6818_43092# S2P pfet_06v0 ad=2.2p pd=10.88u as=2.2p ps=10.88u w=5u l=1u
X194 a_39778_65732# a_39778_65732# a_42186_65848# S2P nfet_06v0 ad=2.2p pd=10.88u as=2.2p ps=10.88u w=5u l=1u
X195 a_26338_51660# a_26338_51660# S2P S2P pfet_06v0 ad=0.88p pd=4.88u as=0.88p ps=4.88u w=2u l=1u
X196 a_20158_31016# a_11878_34416# S2P S2P pfet_06v0 ad=4.4p pd=20.88u as=2.6p ps=10.52u w=10u l=1u
X197 a_20158_48376# a_11878_51776# S2P S2P pfet_06v0 ad=2.6p pd=10.52u as=4.4p ps=20.88u w=10u l=1u
X198 S2P a_35426_13656# a_44238_13656# S2P nfet_06v0 ad=1.3p pd=5.52u as=1.3p ps=5.52u w=5u l=1u
X199 a_2218_4744# a_2218_4744# S2P S2P nfet_06v0 ad=0.44p pd=2.88u as=0.44p ps=2.88u w=1u l=1u
X200 a_57282_31016# a_58922_34416# S2P S2P pfet_06v0 ad=1.3p pd=5.52u as=1.3p ps=5.52u w=5u l=1u
X201 a_57282_48376# a_58922_51776# S2P S2P pfet_06v0 ad=1.3p pd=5.52u as=2.2p ps=10.88u w=5u l=1u
X202 w_64222_42326# a_64528_42506# a_64528_42506# w_64222_42326# pfet_06v0 ad=0.88p pd=4.88u as=0.52p ps=2.52u w=2u l=1u
X203 a_6006_60452# a_2258_60336# a_4914_57052# S2P pfet_06v0 ad=2.2p pd=10.88u as=2.2p ps=10.88u w=5u l=1u
X204 a_55980_39692# a_43582_39576# S2P S2P nfet_06v0 ad=1.25p pd=5.5u as=2.2p ps=10.88u w=5u l=1u
X205 a_32610_69248# a_31890_65732# a_30686_69248# S2P pfet_06v0 ad=2.6p pd=10.52u as=4.4p ps=20.88u w=10u l=1u
X206 a_12802_8260# a_1958_8144# S2P S2P pfet_06v0 ad=2.5p pd=10.5u as=4.4p ps=20.88u w=10u l=1u
X207 a_10762_34416# a_2258_34300# a_9122_31016# S2P pfet_06v0 ad=1.3p pd=5.52u as=2.2p ps=10.88u w=5u l=1u
X208 a_26238_17056# a_26038_16940# S2P S2P pfet_06v0 ad=2.5p pd=10.5u as=4.4p ps=20.88u w=10u l=1u
X209 a_52042_65848# a_50418_69132# S2P S2P nfet_06v0 ad=0.25p pd=1.5u as=0.44p ps=2.88u w=1u l=1u
X210 a_43582_39576# a_43922_42976# a_56690_43092# S2P pfet_06v0 ad=4.4p pd=20.88u as=2.5p ps=10.5u w=10u l=1u
X211 a_30326_13656# a_25998_13540# a_31058_13656# S2P nfet_06v0 ad=2.2p pd=10.88u as=1.25p ps=5.5u w=5u l=1u
X212 a_13914_43092# a_1958_42976# S2P S2P pfet_06v0 ad=2.5p pd=10.5u as=4.4p ps=20.88u w=10u l=1u
X213 S2P a_10762_51776# a_8010_48376# S2P pfet_06v0 ad=2.2p pd=10.88u as=1.3p ps=5.52u w=5u l=1u
X214 a_20158_65848# a_11346_65848# S2P S2P nfet_06v0 ad=2.2p pd=10.88u as=1.3p ps=5.52u w=5u l=1u
X215 a_68318_65848# a_60038_69248# S2P S2P pfet_06v0 ad=2.6p pd=10.52u as=4.4p ps=20.88u w=10u l=1u
X216 S2P a_64938_58576# a_68486_56900# S2P pfet_06v0 ad=1.32p pd=6.88u as=1.32p ps=6.88u w=3u l=1u
X217 a_26838_60452# a_23090_60336# a_25746_57052# S2P pfet_06v0 ad=2.2p pd=10.88u as=2.2p ps=10.88u w=5u l=1u
X218 a_57806_51776# a_58394_48376# S2P S2P nfet_06v0 ad=0.65p pd=3.02u as=1.1p ps=5.88u w=2.5u l=1u
X219 a_33726_17056# a_34314_13656# S2P S2P nfet_06v0 ad=0.65p pd=3.02u as=0.65p ps=3.02u w=2.5u l=1u
X220 a_60038_69248# a_50418_69132# a_56170_65848# S2P pfet_06v0 ad=1.3p pd=5.52u as=2.2p ps=10.88u w=5u l=1u
X221 a_56170_31016# a_55970_30900# a_54406_31016# S2P nfet_06v0 ad=1.3p pd=5.52u as=2.2p ps=10.88u w=5u l=1u
X222 a_8530_51776# a_10234_48376# S2P S2P nfet_06v0 ad=0.65p pd=3.02u as=1.1p ps=5.88u w=2.5u l=1u
X223 a_43882_4744# a_43922_8144# a_55578_8260# S2P pfet_06v0 ad=4.4p pd=20.88u as=2.5p ps=10.5u w=10u l=1u
X224 a_48060_22332# a_50718_25616# a_48482_25732# S2P pfet_06v0 ad=2.2p pd=10.88u as=2.2p ps=10.88u w=5u l=1u
X225 a_57806_17056# a_50078_13540# a_58394_13656# S2P nfet_06v0 ad=1.1p pd=5.88u as=0.65p ps=3.02u w=2.5u l=1u
X226 a_35148_39692# a_22750_39576# S2P S2P nfet_06v0 ad=1.25p pd=5.5u as=2.2p ps=10.88u w=5u l=1u
X227 a_25998_13540# a_25998_13540# S2P S2P nfet_06v0 ad=0.44p pd=2.88u as=0.44p ps=2.88u w=1u l=1u
X228 S2P a_3382_74260# a_5878_74260# S2P pfet_06v0 ad=1.32p pd=6.88u as=1.32p ps=6.88u w=3u l=1u
X229 S2P a_10234_31016# a_8530_34416# S2P nfet_06v0 ad=0.65p pd=3.02u as=0.65p ps=3.02u w=2.5u l=1u
X230 a_23090_42976# a_23090_42976# a_37212_39692# S2P nfet_06v0 ad=0.44p pd=2.88u as=0.25p ps=1.5u w=1u l=1u
X231 S2P a_10762_34416# a_9122_31016# S2P pfet_06v0 ad=2.2p pd=10.88u as=1.3p ps=5.52u w=5u l=1u
X232 a_26838_43092# a_29224_39576# a_26496_39692# S2P nfet_06v0 ad=1.1p pd=5.88u as=1.1p ps=5.88u w=2.5u l=1u
X233 a_22950_4860# a_22750_4744# S2P S2P nfet_06v0 ad=1.25p pd=5.5u as=2.2p ps=10.88u w=5u l=1u
X234 a_17362_13656# a_2650_13540# S2P S2P nfet_06v0 ad=1.25p pd=5.5u as=2.2p ps=10.88u w=5u l=1u
X235 a_47328_4860# a_50718_8144# a_47670_8260# S2P pfet_06v0 ad=2.2p pd=10.88u as=2.2p ps=10.88u w=5u l=1u
X236 a_22750_39576# a_23090_42976# a_35858_43092# S2P pfet_06v0 ad=4.4p pd=20.88u as=2.5p ps=10.5u w=10u l=1u
X237 a_31510_60336# a_23090_60336# a_31710_60452# S2P pfet_06v0 ad=4.4p pd=20.88u as=2.5p ps=10.5u w=10u l=1u
X238 a_5664_57052# a_9054_60336# a_6006_60452# S2P pfet_06v0 ad=2.2p pd=10.88u as=2.2p ps=10.88u w=5u l=1u
X239 a_1958_8144# a_2258_8144# a_16950_8260# S2P pfet_06v0 ad=4.4p pd=20.88u as=2.5p ps=10.5u w=10u l=1u
X240 S2P a_34842_34416# a_32090_31016# S2P pfet_06v0 ad=2.2p pd=10.88u as=1.3p ps=5.52u w=5u l=1u
X241 S2P a_34842_51776# a_32090_48376# S2P pfet_06v0 ad=1.3p pd=5.52u as=1.3p ps=5.52u w=5u l=1u
X242 a_22950_22332# a_22750_22216# S2P S2P nfet_06v0 ad=1.25p pd=5.5u as=2.2p ps=10.88u w=5u l=1u
X243 a_5946_65848# a_2650_65732# S2P S2P nfet_06v0 ad=1.25p pd=5.5u as=2.2p ps=10.88u w=5u l=1u
X244 a_58394_13656# a_64402_16940# a_58922_17056# S2P pfet_06v0 ad=2.2p pd=10.88u as=2.2p ps=10.88u w=5u l=1u
X245 a_26930_13656# a_26730_13540# S2P S2P nfet_06v0 ad=1.25p pd=5.5u as=2.2p ps=10.88u w=5u l=1u
X246 a_30326_48376# a_25998_48260# a_30026_48376# S2P nfet_06v0 ad=2.2p pd=10.88u as=1.25p ps=5.5u w=5u l=1u
X247 a_50078_48260# a_50418_51660# a_50318_51776# S2P pfet_06v0 ad=4.4p pd=20.88u as=2.5p ps=10.5u w=10u l=1u
X248 a_22790_42976# a_23090_42976# a_36180_39692# S2P nfet_06v0 ad=0.44p pd=2.88u as=0.25p ps=1.5u w=1u l=1u
X249 a_63858_30900# a_63858_30900# a_66266_31016# S2P nfet_06v0 ad=2.2p pd=10.88u as=2.2p ps=10.88u w=5u l=1u
X250 a_33684_57052# a_25014_57052# cap_mim_2f0_m4m5_noshield c_width=20u c_length=10u
X251 a_27650_8260# a_23090_8144# a_25014_4860# S2P pfet_06v0 ad=2.2p pd=10.88u as=2.2p ps=10.88u w=5u l=1u
X252 a_57012_4860# a_43922_8144# S2P S2P nfet_06v0 ad=0.25p pd=1.5u as=0.44p ps=2.88u w=1u l=1u
X253 a_6606_69248# a_2258_69132# a_7418_69248# S2P pfet_06v0 ad=4.4p pd=20.88u as=2.5p ps=10.5u w=10u l=1u
X254 a_9122_13656# a_10762_17056# S2P S2P pfet_06v0 ad=1.3p pd=5.52u as=1.3p ps=5.52u w=5u l=1u
X255 a_50118_16940# a_50418_16940# a_53354_17056# S2P pfet_06v0 ad=4.4p pd=20.88u as=2.5p ps=10.5u w=10u l=1u
X256 S2P a_34314_13656# a_32610_17056# S2P nfet_06v0 ad=1.1p pd=5.88u as=0.65p ps=3.02u w=2.5u l=1u
X257 S2P a_58394_48376# a_56690_51776# S2P nfet_06v0 ad=0.65p pd=3.02u as=0.65p ps=3.02u w=2.5u l=1u
X258 a_52464_39692# a_43882_39576# a_53484_39692# S2P nfet_06v0 ad=2.2p pd=10.88u as=1.25p ps=5.5u w=5u l=1u
X259 a_8010_31016# a_10762_34416# S2P S2P pfet_06v0 ad=1.3p pd=5.52u as=1.3p ps=5.52u w=5u l=1u
X260 a_8010_48376# a_10762_51776# S2P S2P pfet_06v0 ad=1.3p pd=5.52u as=2.2p ps=10.88u w=5u l=1u
X261 a_1958_25616# a_2258_25616# a_16950_25732# S2P pfet_06v0 ad=4.4p pd=20.88u as=2.5p ps=10.5u w=10u l=1u
X262 a_19990_17056# a_1958_16940# S2P S2P pfet_06v0 ad=2.5p pd=10.5u as=4.4p ps=20.88u w=10u l=1u
X263 a_6606_17056# a_8922_13540# a_9646_17056# S2P pfet_06v0 ad=4.4p pd=20.88u as=2.6p ps=10.52u w=10u l=1u
X264 a_26338_69132# a_26338_69132# S2P S2P pfet_06v0 ad=0.88p pd=4.88u as=0.88p ps=4.88u w=2u l=1u
X265 a_8392_4744# a_8392_4744# a_10800_4860# S2P nfet_06v0 ad=2.2p pd=10.88u as=2.2p ps=10.88u w=5u l=1u
X266 a_20158_65848# a_11878_69248# S2P S2P pfet_06v0 ad=2.6p pd=10.52u as=4.4p ps=20.88u w=10u l=1u
X267 a_57282_65848# a_58922_69248# S2P S2P pfet_06v0 ad=1.3p pd=5.52u as=2.2p ps=10.88u w=5u l=1u
X268 a_57806_17056# a_58394_13656# S2P S2P nfet_06v0 ad=0.65p pd=3.02u as=0.65p ps=3.02u w=2.5u l=1u
X269 a_44238_31016# a_35426_31016# S2P S2P nfet_06v0 ad=2.2p pd=10.88u as=1.3p ps=5.52u w=5u l=1u
X270 a_8530_17056# a_10234_13656# S2P S2P nfet_06v0 ad=0.65p pd=3.02u as=0.65p ps=3.02u w=2.5u l=1u
X271 a_1958_42976# a_2258_42976# a_15348_39692# S2P nfet_06v0 ad=0.44p pd=2.88u as=0.25p ps=1.5u w=1u l=1u
X272 a_68150_51776# a_50118_51660# S2P S2P pfet_06v0 ad=2.5p pd=10.5u as=4.4p ps=20.88u w=10u l=1u
X273 a_50078_13540# a_50078_13540# S2P S2P nfet_06v0 ad=0.44p pd=2.88u as=0.44p ps=2.88u w=1u l=1u
X274 a_19126_13656# a_18106_13656# S2P S2P nfet_06v0 ad=1.25p pd=5.5u as=2.2p ps=10.88u w=5u l=1u
X275 a_2458_8260# a_2258_8144# a_2158_8260# S2P pfet_06v0 ad=4.4p pd=20.88u as=2.5p ps=10.5u w=10u l=1u
X276 a_58614_8260# a_43622_8144# S2P S2P pfet_06v0 ad=2.5p pd=10.5u as=4.4p ps=20.88u w=10u l=1u
X277 S2P a_10762_69248# a_8010_65848# S2P pfet_06v0 ad=2.2p pd=10.88u as=1.3p ps=5.52u w=5u l=1u
X278 a_26038_51660# a_26338_51660# a_29274_51776# S2P pfet_06v0 ad=4.4p pd=20.88u as=2.5p ps=10.5u w=10u l=1u
X279 a_44122_25732# a_43922_25616# a_43822_25732# S2P pfet_06v0 ad=4.4p pd=20.88u as=2.5p ps=10.5u w=10u l=1u
X280 a_2418_39692# a_2218_39576# a_2118_39692# S2P nfet_06v0 ad=2.2p pd=10.88u as=1.25p ps=5.5u w=5u l=1u
X281 a_67394_5686# a_64528_7674# a_64528_7674# S2P nfet_06v0 ad=0.88p pd=4.88u as=0.52p ps=2.52u w=2u l=1u
X282 a_2650_13540# a_2258_16940# a_3270_17056# S2P pfet_06v0 ad=4.4p pd=20.88u as=2.5p ps=10.5u w=10u l=1u
X283 a_27228_39692# a_23050_39576# a_25214_43092# S2P nfet_06v0 ad=1.1p pd=5.88u as=1.1p ps=5.88u w=2.5u l=1u
X284 a_2850_31016# a_2650_30900# S2P S2P nfet_06v0 ad=1.25p pd=5.5u as=2.2p ps=10.88u w=5u l=1u
X285 a_64438_39310# a_64526_39194# a_64528_42506# S2P nfet_06v0 ad=1.0912p pd=5.84u as=0.6448p ps=3u w=2.48u l=1u
X286 w_64222_42326# a_64528_42506# a_64528_42506# w_64222_42326# pfet_06v0 ad=0.52p pd=2.52u as=0.52p ps=2.52u w=2u l=1u
X287 a_15026_43092# a_1958_42976# S2P S2P pfet_06v0 ad=2.5p pd=10.5u as=4.4p ps=20.88u w=10u l=1u
X288 a_27650_43092# a_29224_39576# a_27228_39692# S2P nfet_06v0 ad=1.1p pd=5.88u as=1.1p ps=5.88u w=2.5u l=1u
X289 a_43882_22216# a_43882_22216# S2P S2P nfet_06v0 ad=0.44p pd=2.88u as=0.44p ps=2.88u w=1u l=1u
X290 a_25214_25732# S2P a_23290_25732# S2P pfet_06v0 ad=4.4p pd=20.88u as=4.4p ps=20.88u w=10u l=1u
X291 a_59506_65848# a_50078_65732# a_56690_69248# S2P nfet_06v0 ad=0.65p pd=3.02u as=1.1p ps=5.88u w=2.5u l=1u
X292 a_52342_25616# a_43922_25616# a_52542_25732# S2P pfet_06v0 ad=4.4p pd=20.88u as=2.5p ps=10.5u w=10u l=1u
X293 a_67654_57016# a_65902_57016# a_66722_56900# S2P nfet_06v0 ad=0.25p pd=1.5u as=0.44p ps=2.88u w=1u l=1u
X294 S2P a_58394_13656# a_56690_17056# S2P nfet_06v0 ad=1.1p pd=5.88u as=0.65p ps=3.02u w=2.5u l=1u
X295 a_33684_22332# a_27650_25732# S2P S2P pfet_06v0 ad=0.308p pd=2.28u as=0.308p ps=2.28u w=0.7u l=20u
X296 S2P a_34842_69248# a_32090_65848# S2P pfet_06v0 ad=1.3p pd=5.52u as=1.3p ps=5.52u w=5u l=1u
X297 a_8530_51776# a_7810_48260# a_6606_51776# S2P pfet_06v0 ad=2.6p pd=10.52u as=4.4p ps=20.88u w=10u l=1u
X298 a_10800_57052# a_2218_56936# a_11820_57052# S2P nfet_06v0 ad=2.2p pd=10.88u as=1.25p ps=5.5u w=5u l=1u
X299 a_65522_65848# a_50810_65732# S2P S2P nfet_06v0 ad=1.25p pd=5.5u as=2.2p ps=10.88u w=5u l=1u
X300 a_2230_76052# a_1918_74260# a_1830_74376# S2P pfet_06v0 ad=0.75p pd=3.5u as=1.32p ps=6.88u w=3u l=1u
X301 a_42146_17056# a_41946_16940# S2P S2P pfet_06v0 ad=2.5p pd=10.5u as=4.4p ps=20.88u w=10u l=1u
X302 a_50078_65732# a_50418_69132# a_50318_69248# S2P pfet_06v0 ad=4.4p pd=20.88u as=2.5p ps=10.5u w=10u l=1u
X303 a_1918_65732# a_1918_65732# S2P S2P nfet_06v0 ad=0.44p pd=2.88u as=0.44p ps=2.88u w=1u l=1u
X304 a_20158_13656# a_8010_13656# cap_mim_2f0_m4m5_noshield c_width=20u c_length=10u
X305 a_31058_48376# a_26730_48260# S2P S2P nfet_06v0 ad=1.25p pd=5.5u as=2.2p ps=10.88u w=5u l=1u
X306 a_24798_74376# a_24886_74260# S2P S2P pfet_06v0 ad=1.32p pd=6.88u as=1.32p ps=6.88u w=3u l=1u
X307 a_33202_13656# a_33002_13540# a_30326_13656# S2P nfet_06v0 ad=1.3p pd=5.52u as=2.2p ps=10.88u w=5u l=1u
X308 a_43822_43092# a_43622_42976# S2P S2P pfet_06v0 ad=2.5p pd=10.5u as=4.4p ps=20.88u w=10u l=1u
X309 a_32652_39692# a_31632_39692# S2P S2P nfet_06v0 ad=1.25p pd=5.5u as=2.2p ps=10.88u w=5u l=1u
X310 a_45846_39692# S1P a_44082_39692# S2P nfet_06v0 ad=2.2p pd=10.88u as=2.2p ps=10.88u w=5u l=1u
X311 a_10234_48376# a_1918_48260# a_9646_51776# S2P nfet_06v0 ad=0.65p pd=3.02u as=1.1p ps=5.88u w=2.5u l=1u
X312 a_6306_17056# a_1958_16940# S2P S2P pfet_06v0 ad=2.5p pd=10.5u as=4.4p ps=20.88u w=10u l=1u
X313 a_8010_65848# a_10762_69248# S2P S2P pfet_06v0 ad=1.3p pd=5.52u as=2.2p ps=10.88u w=5u l=1u
X314 a_44238_48376# a_35958_51776# S2P S2P pfet_06v0 ad=4.4p pd=20.88u as=2.6p ps=10.52u w=10u l=1u
X315 a_54406_13656# a_50078_13540# a_54106_13656# S2P nfet_06v0 ad=2.2p pd=10.88u as=1.25p ps=5.5u w=5u l=1u
X316 a_43206_13656# a_42186_13656# S2P S2P nfet_06v0 ad=1.25p pd=5.5u as=2.2p ps=10.88u w=5u l=1u
X317 a_23050_4744# a_23090_8144# a_34746_8260# S2P pfet_06v0 ad=4.4p pd=20.88u as=2.5p ps=10.5u w=10u l=1u
X318 a_46858_43092# a_47328_39692# S2P S2P nfet_06v0 ad=1.1p pd=5.88u as=1.1p ps=5.88u w=2.5u l=1u
X319 S2P a_58922_17056# a_57282_13656# S2P pfet_06v0 ad=2.2p pd=10.88u as=1.3p ps=5.52u w=5u l=1u
X320 a_18066_51776# a_17866_51660# S2P S2P pfet_06v0 ad=2.5p pd=10.5u as=4.4p ps=20.88u w=10u l=1u
X321 a_40322_69132# a_25998_65732# a_41442_65848# S2P nfet_06v0 ad=2.2p pd=10.88u as=1.25p ps=5.5u w=5u l=1u
X322 a_68150_69248# a_50118_69132# S2P S2P pfet_06v0 ad=2.5p pd=10.5u as=4.4p ps=20.88u w=10u l=1u
X323 a_54766_17056# a_50418_16940# a_54466_17056# S2P pfet_06v0 ad=4.4p pd=20.88u as=2.5p ps=10.5u w=10u l=1u
X324 a_15698_13540# a_2258_16940# a_19990_17056# S2P pfet_06v0 ad=4.4p pd=20.88u as=2.5p ps=10.5u w=10u l=1u
X325 a_5194_43092# a_5664_39692# S2P S2P nfet_06v0 ad=1.1p pd=5.88u as=1.1p ps=5.88u w=2.5u l=1u
X326 a_27650_60452# a_23090_60336# a_25014_57052# S2P pfet_06v0 ad=2.2p pd=10.88u as=2.2p ps=10.88u w=5u l=1u
X327 a_12670_74260# a_56170_48376# cap_mim_2f0_m4m5_noshield c_width=20u c_length=10u
X328 a_64528_42506# a_64528_42506# w_64222_42326# w_64222_42326# pfet_06v0 ad=0.52p pd=2.52u as=0.88p ps=4.88u w=2u l=1u
X329 S2P a_4114_74260# a_4026_74376# S2P nfet_06v0 ad=0.44p pd=2.88u as=0.44p ps=2.88u w=1u l=1u
X330 a_52542_43092# a_52342_42976# S2P S2P pfet_06v0 ad=2.5p pd=10.5u as=4.4p ps=20.88u w=10u l=1u
X331 a_9122_13656# a_2258_16940# a_10762_17056# S2P pfet_06v0 ad=2.2p pd=10.88u as=1.3p ps=5.52u w=5u l=1u
X332 a_2218_56936# a_2258_60336# a_13914_60452# S2P pfet_06v0 ad=4.4p pd=20.88u as=2.5p ps=10.5u w=10u l=1u
X333 a_26038_69132# a_26338_69132# a_29274_69248# S2P pfet_06v0 ad=4.4p pd=20.88u as=2.5p ps=10.5u w=10u l=1u
X334 a_64438_21950# a_64526_21834# a_64528_25146# S2P nfet_06v0 ad=1.0912p pd=5.84u as=0.6448p ps=3u w=2.48u l=1u
X335 a_50418_16940# a_50418_16940# a_53074_13656# S2P nfet_06v0 ad=0.44p pd=2.88u as=0.25p ps=1.5u w=1u l=1u
X336 S2P a_13082_75936# a_16630_74260# S2P pfet_06v0 ad=1.32p pd=6.88u as=1.32p ps=6.88u w=3u l=1u
X337 a_56690_69248# a_58394_65848# S2P S2P nfet_06v0 ad=0.65p pd=3.02u as=0.65p ps=3.02u w=2.5u l=1u
X338 a_56690_17056# a_58394_13656# S2P S2P nfet_06v0 ad=0.65p pd=3.02u as=1.1p ps=5.88u w=2.5u l=1u
X339 a_68318_31016# a_56170_31016# cap_mim_2f0_m4m5_noshield c_width=20u c_length=10u
X340 a_68398_57016# a_68486_56900# S2P S2P pfet_06v0 ad=1.32p pd=6.88u as=1.32p ps=6.88u w=3u l=1u
X341 a_67852_39310# a_65888_39194# a_67552_39310# S2P nfet_06v0 ad=0.175p pd=1.2u as=0.175p ps=1.2u w=0.7u l=1u
X342 a_10762_17056# a_15698_13540# a_10234_13656# S2P nfet_06v0 ad=1.1p pd=5.88u as=1.1p ps=5.88u w=2.5u l=1u
X343 a_68318_31016# a_60038_34416# S2P S2P pfet_06v0 ad=4.4p pd=20.88u as=2.6p ps=10.52u w=10u l=1u
X344 a_27294_74376# a_27382_74260# S2P S2P pfet_06v0 ad=1.32p pd=6.88u as=1.32p ps=6.88u w=3u l=1u
X345 a_23090_42976# a_23090_42976# S2P S2P pfet_06v0 ad=0.88p pd=4.88u as=0.88p ps=4.88u w=2u l=1u
X346 S2P a_34842_51776# a_33202_48376# S2P pfet_06v0 ad=2.2p pd=10.88u as=1.3p ps=5.52u w=5u l=1u
X347 a_35426_31016# a_40322_34300# a_35958_34416# S2P pfet_06v0 ad=2.2p pd=10.88u as=2.2p ps=10.88u w=5u l=1u
X348 S2P a_64938_58576# a_64438_57016# S2P nfet_06v0 ad=0.44p pd=2.88u as=0.44p ps=2.88u w=1u l=1u
X349 a_56170_13656# a_58922_17056# S2P S2P pfet_06v0 ad=1.3p pd=5.52u as=1.3p ps=5.52u w=5u l=1u
X350 a_31710_25732# a_31510_25616# S2P S2P pfet_06v0 ad=2.5p pd=10.5u as=4.4p ps=20.88u w=10u l=1u
X351 a_12852_39692# a_4182_39692# cap_mim_2f0_m4m5_noshield c_width=20u c_length=10u
X352 a_43922_25616# a_43922_25616# a_58044_22332# S2P nfet_06v0 ad=0.44p pd=2.88u as=0.25p ps=1.5u w=1u l=1u
X353 a_30386_34416# a_26038_34300# S2P S2P pfet_06v0 ad=2.5p pd=10.5u as=4.4p ps=20.88u w=10u l=1u
X354 S2P a_35958_34416# a_44238_31016# S2P pfet_06v0 ad=2.6p pd=10.52u as=2.6p ps=10.52u w=10u l=1u
X355 a_51430_51776# a_50118_51660# S2P S2P pfet_06v0 ad=2.5p pd=10.5u as=4.4p ps=20.88u w=10u l=1u
X356 a_2158_34416# a_1958_34300# S2P S2P pfet_06v0 ad=2.5p pd=10.5u as=4.4p ps=20.88u w=10u l=1u
X357 a_11878_17056# a_15698_13540# a_11346_13656# S2P nfet_06v0 ad=1.1p pd=5.88u as=1.1p ps=5.88u w=2.5u l=1u
X358 a_8530_69248# a_7810_65732# a_6606_69248# S2P pfet_06v0 ad=2.6p pd=10.52u as=4.4p ps=20.88u w=10u l=1u
X359 a_30686_51776# a_33002_48260# a_33726_51776# S2P pfet_06v0 ad=4.4p pd=20.88u as=2.6p ps=10.52u w=10u l=1u
X360 a_2258_42976# a_2258_42976# S2P S2P pfet_06v0 ad=0.88p pd=4.88u as=0.88p ps=4.88u w=2u l=1u
X361 a_6246_13656# a_1918_13540# a_6978_13656# S2P nfet_06v0 ad=2.2p pd=10.88u as=1.25p ps=5.5u w=5u l=1u
X362 a_50118_51660# a_50418_51660# a_52042_48376# S2P nfet_06v0 ad=0.44p pd=2.88u as=0.25p ps=1.5u w=1u l=1u
X363 a_30326_31016# a_33002_30900# a_33202_31016# S2P nfet_06v0 ad=2.2p pd=10.88u as=1.3p ps=5.52u w=5u l=1u
X364 a_23290_43092# a_23090_42976# a_22990_43092# S2P pfet_06v0 ad=4.4p pd=20.88u as=2.5p ps=10.5u w=10u l=1u
X365 a_12670_74260# a_59506_48376# S2P S2P nfet_06v0 ad=1.3p pd=5.52u as=2.2p ps=10.88u w=5u l=1u
X366 a_44934_8260# a_43622_8144# S2P S2P pfet_06v0 ad=2.5p pd=10.5u as=4.4p ps=20.88u w=10u l=1u
X367 a_32610_51776# a_25998_48260# a_35426_48376# S2P nfet_06v0 ad=1.1p pd=5.88u as=0.65p ps=3.02u w=2.5u l=1u
X368 a_64402_34300# a_50078_30900# a_65522_31016# S2P nfet_06v0 ad=2.2p pd=10.88u as=1.25p ps=5.5u w=5u l=1u
X369 a_44238_65848# a_35958_69248# S2P S2P pfet_06v0 ad=4.4p pd=20.88u as=2.6p ps=10.52u w=10u l=1u
X370 a_55138_13656# a_50810_13540# S2P S2P nfet_06v0 ad=1.25p pd=5.5u as=2.2p ps=10.88u w=5u l=1u
X371 a_64438_5686# a_64526_5570# a_64528_7674# S2P nfet_06v0 ad=1.0912p pd=5.84u as=0.6448p ps=3u w=2.48u l=1u
X372 a_57282_48376# a_57082_48260# a_54406_48376# S2P nfet_06v0 ad=1.3p pd=5.52u as=2.2p ps=10.88u w=5u l=1u
X373 a_34314_13656# a_25998_13540# a_33726_17056# S2P nfet_06v0 ad=0.65p pd=3.02u as=1.1p ps=5.88u w=2.5u l=1u
X374 a_35958_17056# a_26338_16940# a_32090_13656# S2P pfet_06v0 ad=1.3p pd=5.52u as=2.2p ps=10.88u w=5u l=1u
X375 a_44934_43092# a_43622_42976# S2P S2P pfet_06v0 ad=2.5p pd=10.5u as=4.4p ps=20.88u w=10u l=1u
X376 a_67852_21950# a_65888_21834# a_67552_21950# S2P nfet_06v0 ad=0.175p pd=1.2u as=0.175p ps=1.2u w=0.7u l=1u
X377 a_18066_69248# a_17866_69132# S2P S2P pfet_06v0 ad=2.5p pd=10.5u as=4.4p ps=20.88u w=10u l=1u
X378 a_64438_4478# a_65888_4362# S2P S2P nfet_06v0 ad=0.5456p pd=3.36u as=0.5456p ps=3.36u w=1.24u l=1u
X379 a_48482_25732# a_43922_25616# a_45846_22332# S2P pfet_06v0 ad=2.2p pd=10.88u as=2.2p ps=10.88u w=5u l=1u
X380 a_54766_34416# a_57082_30900# a_57806_34416# S2P pfet_06v0 ad=4.4p pd=20.88u as=2.6p ps=10.52u w=10u l=1u
X381 a_11346_48376# a_1918_48260# a_8530_51776# S2P nfet_06v0 ad=0.65p pd=3.02u as=1.1p ps=5.88u w=2.5u l=1u
X382 a_43622_60336# a_43922_60336# a_57012_57052# S2P nfet_06v0 ad=0.44p pd=2.88u as=0.25p ps=1.5u w=1u l=1u
X383 a_7418_17056# a_1958_16940# S2P S2P pfet_06v0 ad=2.5p pd=10.5u as=4.4p ps=20.88u w=10u l=1u
X384 a_54406_65848# a_55970_65732# a_56170_65848# S2P nfet_06v0 ad=2.2p pd=10.88u as=1.3p ps=5.52u w=5u l=1u
X385 a_1958_69132# a_2258_69132# a_3882_65848# S2P nfet_06v0 ad=0.44p pd=2.88u as=0.25p ps=1.5u w=1u l=1u
X386 a_5046_74376# a_3294_74376# a_4114_74260# S2P nfet_06v0 ad=0.25p pd=1.5u as=0.44p ps=2.88u w=1u l=1u
X387 a_67286_48376# a_66266_48376# S2P S2P nfet_06v0 ad=1.25p pd=5.5u as=2.2p ps=10.88u w=5u l=1u
X388 a_27228_4860# a_23050_4744# a_25214_8260# S2P nfet_06v0 ad=1.1p pd=5.88u as=1.1p ps=5.88u w=2.5u l=1u
X389 a_60038_34416# a_63858_30900# a_59506_31016# S2P nfet_06v0 ad=1.1p pd=5.88u as=1.1p ps=5.88u w=2.5u l=1u
X390 a_6818_25732# a_2258_25616# a_4182_22332# S2P pfet_06v0 ad=2.2p pd=10.88u as=2.2p ps=10.88u w=5u l=1u
X391 a_9646_69248# a_1918_65732# a_10234_65848# S2P nfet_06v0 ad=1.1p pd=5.88u as=0.65p ps=3.02u w=2.5u l=1u
X392 a_66226_34416# a_66026_34300# S2P S2P pfet_06v0 ad=2.5p pd=10.5u as=4.4p ps=20.88u w=10u l=1u
X393 a_6246_48376# a_1918_48260# a_5946_48376# S2P nfet_06v0 ad=2.2p pd=10.88u as=1.25p ps=5.5u w=5u l=1u
X394 a_68152_4478# a_65888_4362# a_67852_4478# S2P nfet_06v0 ad=0.175p pd=1.2u as=0.175p ps=1.2u w=0.7u l=1u
X395 a_33726_34416# a_33002_30900# a_30686_34416# S2P pfet_06v0 ad=2.6p pd=10.52u as=4.4p ps=20.88u w=10u l=1u
X396 a_16242_51660# a_16242_51660# a_17866_51660# S2P pfet_06v0 ad=4.4p pd=20.88u as=4.4p ps=20.88u w=10u l=1u
X397 a_54766_17056# a_50418_16940# a_55578_17056# S2P pfet_06v0 ad=4.4p pd=20.88u as=2.5p ps=10.5u w=10u l=1u
X398 a_43922_60336# a_43922_60336# S2P S2P pfet_06v0 ad=0.88p pd=4.88u as=0.88p ps=4.88u w=2u l=1u
X399 a_50718_42976# a_50718_42976# a_52342_42976# S2P pfet_06v0 ad=4.4p pd=20.88u as=4.4p ps=20.88u w=10u l=1u
X400 a_43582_56936# a_43882_56936# a_55980_57052# S2P nfet_06v0 ad=2.2p pd=10.88u as=1.25p ps=5.5u w=5u l=1u
X401 S2P a_34842_69248# a_33202_65848# S2P pfet_06v0 ad=2.2p pd=10.88u as=1.3p ps=5.52u w=5u l=1u
X402 S2P a_34842_17056# a_33202_13656# S2P pfet_06v0 ad=1.3p pd=5.52u as=1.3p ps=5.52u w=5u l=1u
X403 a_24102_25732# a_22790_25616# S2P S2P pfet_06v0 ad=2.5p pd=10.5u as=4.4p ps=20.88u w=10u l=1u
X404 a_50810_30900# a_50418_34300# a_51430_34416# S2P pfet_06v0 ad=4.4p pd=20.88u as=2.5p ps=10.5u w=10u l=1u
X405 a_1918_56936# a_2258_60336# a_15026_60452# S2P pfet_06v0 ad=4.4p pd=20.88u as=2.5p ps=10.5u w=10u l=1u
X406 a_54106_48376# a_50810_48260# S2P S2P nfet_06v0 ad=1.25p pd=5.5u as=2.2p ps=10.88u w=5u l=1u
X407 S2P a_58394_31016# a_57806_34416# S2P nfet_06v0 ad=0.65p pd=3.02u as=0.65p ps=3.02u w=2.5u l=1u
X408 a_58922_69248# a_63858_65732# a_58394_65848# S2P nfet_06v0 ad=1.1p pd=5.88u as=1.1p ps=5.88u w=2.5u l=1u
X409 S2P a_14046_74376# a_14866_74260# S2P pfet_06v0 ad=1.32p pd=6.88u as=1.32p ps=6.88u w=3u l=1u
X410 a_43582_4744# a_43922_8144# a_56690_8260# S2P pfet_06v0 ad=4.4p pd=20.88u as=2.5p ps=10.5u w=10u l=1u
X411 a_64528_25146# a_64528_25146# w_64222_24966# w_64222_24966# pfet_06v0 ad=0.52p pd=2.52u as=0.52p ps=2.52u w=2u l=1u
X412 a_37212_22332# a_23090_25616# S2P S2P nfet_06v0 ad=0.25p pd=1.5u as=0.44p ps=2.88u w=1u l=1u
X413 a_58922_51776# a_50418_51660# a_57282_48376# S2P pfet_06v0 ad=1.3p pd=5.52u as=2.2p ps=10.88u w=5u l=1u
X414 a_23250_4860# a_23050_4744# a_23982_4860# S2P nfet_06v0 ad=2.2p pd=10.88u as=1.25p ps=5.5u w=5u l=1u
X415 a_12852_57052# a_4182_57052# cap_mim_2f0_m4m5_noshield c_width=20u c_length=10u
X416 S2P a_58922_34416# a_56170_31016# S2P pfet_06v0 ad=1.3p pd=5.52u as=1.3p ps=5.52u w=5u l=1u
X417 a_66634_57016# a_66722_56900# S2P S2P pfet_06v0 ad=1.32p pd=6.88u as=1.32p ps=6.88u w=3u l=1u
X418 a_51430_69248# a_50118_69132# S2P S2P pfet_06v0 ad=2.5p pd=10.5u as=4.4p ps=20.88u w=10u l=1u
X419 a_4914_4860# S1N a_2418_4860# S2P nfet_06v0 ad=2.2p pd=10.88u as=2.2p ps=10.88u w=5u l=1u
X420 a_26338_69132# a_26338_69132# a_28994_65848# S2P nfet_06v0 ad=0.44p pd=2.88u as=0.25p ps=1.5u w=1u l=1u
X421 a_54516_22332# a_48060_22332# S2P S2P nfet_06v0 ad=0.44p pd=2.88u as=0.44p ps=2.88u w=1u l=1u
X422 a_29886_42976# a_23050_39576# a_30888_39692# S2P nfet_06v0 ad=2.2p pd=10.88u as=1.25p ps=5.5u w=5u l=1u
X423 a_25214_60452# a_33684_57052# cap_mim_2f0_m4m5_noshield c_width=20u c_length=10u
X424 a_22790_42976# a_23090_42976# a_37782_43092# S2P pfet_06v0 ad=4.4p pd=20.88u as=2.5p ps=10.5u w=10u l=1u
X425 a_32610_69248# a_34314_65848# S2P S2P nfet_06v0 ad=0.65p pd=3.02u as=1.1p ps=5.88u w=2.5u l=1u
X426 a_30686_69248# a_33002_65732# a_33726_69248# S2P pfet_06v0 ad=4.4p pd=20.88u as=2.6p ps=10.52u w=10u l=1u
X427 a_41946_34300# a_26338_34300# a_42146_34416# S2P pfet_06v0 ad=4.4p pd=20.88u as=2.5p ps=10.5u w=10u l=1u
X428 a_8010_31016# a_2258_34300# a_11878_34416# S2P pfet_06v0 ad=2.2p pd=10.88u as=1.3p ps=5.52u w=5u l=1u
X429 S2P a_10234_48376# a_9646_51776# S2P nfet_06v0 ad=1.1p pd=5.88u as=0.65p ps=3.02u w=2.5u l=1u
X430 a_64528_42506# a_64528_42506# a_67394_40518# S2P nfet_06v0 ad=0.52p pd=2.52u as=0.88p ps=4.88u w=2u l=1u
X431 a_44238_48376# a_32090_48376# cap_mim_2f0_m4m5_noshield c_width=20u c_length=10u
X432 S2P a_66722_56900# a_66634_57016# S2P nfet_06v0 ad=0.44p pd=2.88u as=0.44p ps=2.88u w=1u l=1u
X433 a_22750_56936# a_23050_56936# a_35148_57052# S2P nfet_06v0 ad=2.2p pd=10.88u as=1.25p ps=5.5u w=5u l=1u
X434 a_53074_48376# a_50418_51660# S2P S2P nfet_06v0 ad=0.25p pd=1.5u as=0.44p ps=2.88u w=1u l=1u
X435 a_29886_25616# a_29886_25616# a_31510_25616# S2P pfet_06v0 ad=4.4p pd=20.88u as=4.4p ps=20.88u w=10u l=1u
X436 a_26496_4860# a_23050_4744# a_26026_8260# S2P nfet_06v0 ad=1.1p pd=5.88u as=1.1p ps=5.88u w=2.5u l=1u
X437 a_43922_8144# a_43922_8144# a_58044_4860# S2P nfet_06v0 ad=0.44p pd=2.88u as=0.25p ps=1.5u w=1u l=1u
X438 a_31498_34416# a_26038_34300# S2P S2P pfet_06v0 ad=2.5p pd=10.5u as=4.4p ps=20.88u w=10u l=1u
X439 a_2458_43092# a_2258_42976# a_3270_43092# S2P pfet_06v0 ad=4.4p pd=20.88u as=2.5p ps=10.5u w=10u l=1u
X440 a_50418_51660# a_50418_51660# S2P S2P pfet_06v0 ad=0.88p pd=4.88u as=0.88p ps=4.88u w=2u l=1u
X441 a_44238_31016# a_32090_31016# cap_mim_2f0_m4m5_noshield c_width=20u c_length=10u
X442 a_5194_8260# a_5664_4860# S2P S2P nfet_06v0 ad=1.1p pd=5.88u as=1.1p ps=5.88u w=2.5u l=1u
X443 a_5194_25732# S1N a_2458_25732# S2P pfet_06v0 ad=4.4p pd=20.88u as=4.4p ps=20.88u w=10u l=1u
X444 a_53484_22332# a_52464_22332# S2P S2P nfet_06v0 ad=1.25p pd=5.5u as=2.2p ps=10.88u w=5u l=1u
X445 a_29224_39576# a_29224_39576# a_31632_39692# S2P nfet_06v0 ad=2.2p pd=10.88u as=2.2p ps=10.88u w=5u l=1u
X446 a_44082_39692# a_43882_39576# a_44814_39692# S2P nfet_06v0 ad=2.2p pd=10.88u as=1.25p ps=5.5u w=5u l=1u
X447 a_26496_57052# a_29886_60336# a_26838_60452# S2P pfet_06v0 ad=2.2p pd=10.88u as=2.2p ps=10.88u w=5u l=1u
X448 a_9054_8144# a_2218_4744# a_10056_4860# S2P nfet_06v0 ad=2.2p pd=10.88u as=1.25p ps=5.5u w=5u l=1u
X449 a_50318_17056# a_50118_16940# S2P S2P pfet_06v0 ad=2.5p pd=10.5u as=4.4p ps=20.88u w=10u l=1u
X450 a_56690_17056# a_50078_13540# a_59506_13656# S2P nfet_06v0 ad=1.1p pd=5.88u as=0.65p ps=3.02u w=2.5u l=1u
X451 a_33726_34416# a_25998_30900# a_34314_31016# S2P nfet_06v0 ad=1.1p pd=5.88u as=0.65p ps=3.02u w=2.5u l=1u
X452 a_8392_56936# a_2258_60336# a_12802_60452# S2P pfet_06v0 ad=4.4p pd=20.88u as=2.5p ps=10.5u w=10u l=1u
X453 a_26730_30900# a_25998_30900# a_26930_31016# S2P nfet_06v0 ad=2.2p pd=10.88u as=1.25p ps=5.5u w=5u l=1u
X454 a_6246_31016# a_7810_30900# a_8010_31016# S2P nfet_06v0 ad=2.2p pd=10.88u as=1.3p ps=5.52u w=5u l=1u
X455 a_40322_51660# a_40322_51660# a_41946_51660# S2P pfet_06v0 ad=4.4p pd=20.88u as=4.4p ps=20.88u w=10u l=1u
X456 a_9122_48376# a_10762_51776# S2P S2P pfet_06v0 ad=1.3p pd=5.52u as=2.2p ps=10.88u w=5u l=1u
X457 a_58044_57052# a_43922_60336# S2P S2P nfet_06v0 ad=0.25p pd=1.5u as=0.44p ps=2.88u w=1u l=1u
X458 a_48060_39692# a_43882_39576# a_46046_43092# S2P nfet_06v0 ad=1.1p pd=5.88u as=1.1p ps=5.88u w=2.5u l=1u
X459 S2P a_34314_48376# a_33726_51776# S2P nfet_06v0 ad=0.65p pd=3.02u as=0.65p ps=3.02u w=2.5u l=1u
X460 a_47328_57052# a_50718_60336# a_47670_60452# S2P pfet_06v0 ad=2.2p pd=10.88u as=2.2p ps=10.88u w=5u l=1u
X461 a_15348_22332# a_2258_25616# S2P S2P nfet_06v0 ad=0.25p pd=1.5u as=0.44p ps=2.88u w=1u l=1u
X462 a_12852_57052# a_6818_60452# S2P S2P pfet_06v0 ad=0.308p pd=2.28u as=0.308p ps=2.28u w=0.7u l=20u
X463 a_58394_48376# a_50078_48260# a_57806_51776# S2P nfet_06v0 ad=0.65p pd=3.02u as=1.1p ps=5.88u w=2.5u l=1u
X464 a_4182_4860# S1P a_2418_4860# S2P nfet_06v0 ad=2.2p pd=10.88u as=2.2p ps=10.88u w=5u l=1u
X465 a_53484_4860# a_52464_4860# S2P S2P nfet_06v0 ad=1.25p pd=5.5u as=2.2p ps=10.88u w=5u l=1u
X466 a_44082_39692# a_43882_39576# a_43782_39692# S2P nfet_06v0 ad=2.2p pd=10.88u as=1.25p ps=5.5u w=5u l=1u
X467 a_35426_13656# a_25998_13540# a_32610_17056# S2P nfet_06v0 ad=0.65p pd=3.02u as=1.1p ps=5.88u w=2.5u l=1u
X468 a_6978_48376# a_2650_48260# S2P S2P nfet_06v0 ad=1.25p pd=5.5u as=2.2p ps=10.88u w=5u l=1u
X469 a_46046_43092# S1P a_44122_43092# S2P pfet_06v0 ad=4.4p pd=20.88u as=4.4p ps=20.88u w=10u l=1u
X470 a_16242_69132# a_16242_69132# a_17866_69132# S2P pfet_06v0 ad=4.4p pd=20.88u as=4.4p ps=20.88u w=10u l=1u
X471 a_9646_51776# a_10234_48376# S2P S2P nfet_06v0 ad=0.65p pd=3.02u as=1.1p ps=5.88u w=2.5u l=1u
X472 a_50056_4744# a_43922_8144# a_54466_8260# S2P pfet_06v0 ad=4.4p pd=20.88u as=2.5p ps=10.5u w=10u l=1u
X473 S2P a_10762_17056# a_8010_13656# S2P pfet_06v0 ad=1.3p pd=5.52u as=1.3p ps=5.52u w=5u l=1u
X474 a_54406_65848# a_57082_65732# a_57282_65848# S2P nfet_06v0 ad=2.2p pd=10.88u as=1.3p ps=5.52u w=5u l=1u
X475 a_2458_8260# a_2258_8144# a_3270_8260# S2P pfet_06v0 ad=4.4p pd=20.88u as=2.5p ps=10.5u w=10u l=1u
X476 a_41442_13656# a_26730_13540# S2P S2P nfet_06v0 ad=1.25p pd=5.5u as=2.2p ps=10.88u w=5u l=1u
X477 a_26238_51776# a_26038_51660# S2P S2P pfet_06v0 ad=2.5p pd=10.5u as=4.4p ps=20.88u w=10u l=1u
X478 a_6396_4860# a_9054_8144# a_6818_8260# S2P pfet_06v0 ad=2.2p pd=10.88u as=2.2p ps=10.88u w=5u l=1u
X479 a_24102_8260# a_22790_8144# S2P S2P pfet_06v0 ad=2.5p pd=10.5u as=4.4p ps=20.88u w=10u l=1u
X480 a_58922_69248# a_50418_69132# a_57282_65848# S2P pfet_06v0 ad=1.3p pd=5.52u as=2.2p ps=10.88u w=5u l=1u
X481 a_28314_74376# a_23834_75936# a_27382_74260# S2P nfet_06v0 ad=0.25p pd=1.5u as=0.44p ps=2.88u w=1u l=1u
X482 a_29274_17056# a_26038_16940# S2P S2P pfet_06v0 ad=2.5p pd=10.5u as=4.4p ps=20.88u w=10u l=1u
X483 a_64402_34300# a_64402_34300# a_66026_34300# S2P pfet_06v0 ad=4.4p pd=20.88u as=4.4p ps=20.88u w=10u l=1u
X484 a_33202_31016# a_34842_34416# S2P S2P pfet_06v0 ad=1.3p pd=5.52u as=2.2p ps=10.88u w=5u l=1u
X485 a_18106_31016# a_1918_30900# a_19126_31016# S2P nfet_06v0 ad=2.2p pd=10.88u as=1.25p ps=5.5u w=5u l=1u
X486 S2P a_64526_56900# a_64438_57016# S2P nfet_06v0 ad=0.44p pd=2.88u as=0.44p ps=2.88u w=1u l=1u
X487 a_16950_43092# a_1958_42976# S2P S2P pfet_06v0 ad=2.5p pd=10.5u as=4.4p ps=20.88u w=10u l=1u
X488 a_51010_13656# a_50810_13540# S2P S2P nfet_06v0 ad=1.25p pd=5.5u as=2.2p ps=10.88u w=5u l=1u
X489 a_43622_60336# a_43922_60336# a_58614_60452# S2P pfet_06v0 ad=4.4p pd=20.88u as=2.5p ps=10.5u w=10u l=1u
X490 a_23290_8260# a_23090_8144# a_22990_8260# S2P pfet_06v0 ad=4.4p pd=20.88u as=2.5p ps=10.5u w=10u l=1u
X491 a_50056_39576# a_43922_42976# a_54466_43092# S2P pfet_06v0 ad=4.4p pd=20.88u as=2.5p ps=10.5u w=10u l=1u
X492 a_64528_42506# a_69626_40402# a_69538_40518# S2P nfet_06v0 ad=0.6448p pd=3u as=1.0912p ps=5.84u w=2.48u l=1u
X493 a_14316_57052# a_1918_56936# S2P S2P nfet_06v0 ad=1.25p pd=5.5u as=2.2p ps=10.88u w=5u l=1u
X494 a_66266_13656# a_50078_13540# a_67286_13656# S2P nfet_06v0 ad=2.2p pd=10.88u as=1.25p ps=5.5u w=5u l=1u
X495 a_46046_25732# a_47328_22332# S2P S2P nfet_06v0 ad=1.1p pd=5.88u as=1.1p ps=5.88u w=2.5u l=1u
X496 a_10234_13656# a_16242_16940# a_10762_17056# S2P pfet_06v0 ad=2.2p pd=10.88u as=2.2p ps=10.88u w=5u l=1u
X497 a_44070_17056# a_26038_16940# S2P S2P pfet_06v0 ad=2.5p pd=10.5u as=4.4p ps=20.88u w=10u l=1u
X498 a_56170_48376# a_54516_39692# a_54406_48376# S2P nfet_06v0 ad=1.3p pd=5.52u as=2.2p ps=10.88u w=5u l=1u
X499 a_50418_69132# a_50418_69132# S2P S2P pfet_06v0 ad=0.88p pd=4.88u as=0.88p ps=4.88u w=2u l=1u
X500 a_54766_34416# a_55970_30900# a_56690_34416# S2P pfet_06v0 ad=4.4p pd=20.88u as=2.6p ps=10.52u w=10u l=1u
X501 a_15698_30900# a_15698_30900# a_18106_31016# S2P nfet_06v0 ad=2.2p pd=10.88u as=2.2p ps=10.88u w=5u l=1u
X502 S2P a_34314_13656# a_33726_17056# S2P nfet_06v0 ad=1.1p pd=5.88u as=0.65p ps=3.02u w=2.5u l=1u
X503 a_46578_39692# a_47670_43092# S2P S2P pfet_06v0 ad=2.2p pd=10.88u as=2.2p ps=10.88u w=5u l=1u
X504 S2P a_10234_48376# a_8530_51776# S2P nfet_06v0 ad=0.65p pd=3.02u as=0.65p ps=3.02u w=2.5u l=1u
X505 a_6006_60452# a_8392_56936# a_5664_57052# S2P nfet_06v0 ad=1.1p pd=5.88u as=1.1p ps=5.88u w=2.5u l=1u
X506 a_58394_48376# a_64402_51660# a_58922_51776# S2P pfet_06v0 ad=2.2p pd=10.88u as=2.2p ps=10.88u w=5u l=1u
X507 a_68794_40518# a_64528_42506# S2P S2P nfet_06v0 ad=0.5p pd=2.5u as=0.88p ps=4.88u w=2u l=1u
X508 a_65888_39194# a_65888_39194# w_64222_42326# w_64222_42326# pfet_06v0 ad=0.88p pd=4.88u as=0.88p ps=4.88u w=2u l=1u
X509 a_44122_60452# a_43922_60336# a_44934_60452# S2P pfet_06v0 ad=4.4p pd=20.88u as=2.5p ps=10.5u w=10u l=1u
X510 a_29224_22216# a_23090_25616# a_33634_25732# S2P pfet_06v0 ad=4.4p pd=20.88u as=2.5p ps=10.5u w=10u l=1u
X511 a_46046_8260# a_47328_4860# S2P S2P nfet_06v0 ad=1.1p pd=5.88u as=1.1p ps=5.88u w=2.5u l=1u
X512 a_27962_31016# a_26338_34300# S2P S2P nfet_06v0 ad=0.25p pd=1.5u as=0.44p ps=2.88u w=1u l=1u
X513 a_17562_74376# a_13082_75936# a_16630_74260# S2P nfet_06v0 ad=0.25p pd=1.5u as=0.44p ps=2.88u w=1u l=1u
X514 a_4914_22332# a_6006_25732# S2P S2P pfet_06v0 ad=2.2p pd=10.88u as=2.2p ps=10.88u w=5u l=1u
X515 a_9122_48376# a_10762_51776# S2P S2P pfet_06v0 ad=1.3p pd=5.52u as=1.3p ps=5.52u w=5u l=1u
X516 a_9122_65848# a_10762_69248# S2P S2P pfet_06v0 ad=1.3p pd=5.52u as=2.2p ps=10.88u w=5u l=1u
X517 a_40322_69132# a_40322_69132# a_41946_69132# S2P pfet_06v0 ad=4.4p pd=20.88u as=4.4p ps=20.88u w=10u l=1u
X518 a_50118_51660# a_50418_51660# a_53354_51776# S2P pfet_06v0 ad=4.4p pd=20.88u as=2.5p ps=10.5u w=10u l=1u
X519 a_4914_13656# a_2258_16940# S2P S2P nfet_06v0 ad=0.25p pd=1.5u as=0.44p ps=2.88u w=1u l=1u
X520 a_69538_23158# a_65888_21834# S2P S2P nfet_06v0 ad=0.5456p pd=3.36u as=0.5456p ps=3.36u w=1.24u l=1u
X521 a_26838_8260# a_23090_8144# a_25746_4860# S2P pfet_06v0 ad=2.2p pd=10.88u as=2.2p ps=10.88u w=5u l=1u
X522 a_68484_7790# a_67772_7790# S2P S2P nfet_05v0 ad=0.5808p pd=3.52u as=0.5808p ps=3.52u w=1.32u l=0.6u
X523 a_2158_60452# a_1958_60336# S2P S2P pfet_06v0 ad=2.5p pd=10.5u as=4.4p ps=20.88u w=10u l=1u
X524 a_22950_39692# a_22750_39576# S2P S2P nfet_06v0 ad=1.25p pd=5.5u as=2.2p ps=10.88u w=5u l=1u
X525 a_19990_51776# a_1958_51660# S2P S2P pfet_06v0 ad=2.5p pd=10.5u as=4.4p ps=20.88u w=10u l=1u
X526 a_6606_51776# a_8922_48260# a_9646_51776# S2P pfet_06v0 ad=4.4p pd=20.88u as=2.6p ps=10.52u w=10u l=1u
X527 a_56690_17056# a_55970_13540# a_54766_17056# S2P pfet_06v0 ad=2.6p pd=10.52u as=4.4p ps=20.88u w=10u l=1u
X528 a_48482_8260# a_50056_4744# a_48060_4860# S2P nfet_06v0 ad=1.1p pd=5.88u as=1.1p ps=5.88u w=2.5u l=1u
X529 a_22750_4744# a_23050_4744# a_35148_4860# S2P nfet_06v0 ad=2.2p pd=10.88u as=1.25p ps=5.5u w=5u l=1u
X530 a_25998_30900# a_26338_34300# a_26238_34416# S2P pfet_06v0 ad=4.4p pd=20.88u as=2.5p ps=10.5u w=10u l=1u
X531 S2P a_35426_65848# a_44238_65848# S2P nfet_06v0 ad=1.3p pd=5.52u as=1.3p ps=5.52u w=5u l=1u
X532 a_63858_48260# a_63858_48260# a_66266_48376# S2P nfet_06v0 ad=2.2p pd=10.88u as=2.2p ps=10.88u w=5u l=1u
X533 a_25746_22332# a_26838_25732# S2P S2P pfet_06v0 ad=2.2p pd=10.88u as=2.2p ps=10.88u w=5u l=1u
X534 a_47670_60452# a_50056_56936# a_47328_57052# S2P nfet_06v0 ad=1.1p pd=5.88u as=1.1p ps=5.88u w=2.5u l=1u
X535 a_6246_31016# a_8922_30900# a_9122_31016# S2P nfet_06v0 ad=2.2p pd=10.88u as=1.3p ps=5.52u w=5u l=1u
X536 a_64438_23158# a_64526_23042# a_64528_25146# S2P nfet_06v0 ad=1.0912p pd=5.84u as=0.6448p ps=3u w=2.48u l=1u
X537 a_26238_69248# a_26038_69132# S2P S2P pfet_06v0 ad=2.5p pd=10.5u as=4.4p ps=20.88u w=10u l=1u
X538 a_3882_13656# a_2258_16940# S2P S2P nfet_06v0 ad=0.25p pd=1.5u as=0.44p ps=2.88u w=1u l=1u
X539 a_25014_4860# a_26838_8260# S2P S2P pfet_06v0 ad=2.2p pd=10.88u as=2.2p ps=10.88u w=5u l=1u
X540 S2P a_13082_75936# a_12982_76052# S2P pfet_06v0 ad=1.32p pd=6.88u as=0.75p ps=3.5u w=3u l=1u
X541 a_23090_8144# a_23090_8144# a_37212_4860# S2P nfet_06v0 ad=0.44p pd=2.88u as=0.25p ps=1.5u w=1u l=1u
X542 a_30326_65848# a_25998_65732# a_31058_65848# S2P nfet_06v0 ad=2.2p pd=10.88u as=1.25p ps=5.5u w=5u l=1u
X543 a_33726_69248# a_34314_65848# S2P S2P nfet_06v0 ad=0.65p pd=3.02u as=0.65p ps=3.02u w=2.5u l=1u
X544 S2P a_1918_74260# a_4114_74260# S2P pfet_06v0 ad=1.32p pd=6.88u as=1.32p ps=6.88u w=3u l=1u
X545 a_33726_17056# a_34314_13656# S2P S2P nfet_06v0 ad=0.65p pd=3.02u as=1.1p ps=5.88u w=2.5u l=1u
X546 a_45846_22332# a_47670_25732# S2P S2P pfet_06v0 ad=2.2p pd=10.88u as=2.2p ps=10.88u w=5u l=1u
X547 a_44238_48376# a_35426_48376# S2P S2P nfet_06v0 ad=2.2p pd=10.88u as=1.3p ps=5.52u w=5u l=1u
X548 a_2650_48260# a_2258_51660# a_3270_51776# S2P pfet_06v0 ad=4.4p pd=20.88u as=2.5p ps=10.5u w=10u l=1u
X549 a_20158_31016# a_11346_31016# S2P S2P nfet_06v0 ad=1.3p pd=5.52u as=2.2p ps=10.88u w=5u l=1u
X550 a_47328_22332# a_43882_22216# a_46858_25732# S2P nfet_06v0 ad=1.1p pd=5.88u as=1.1p ps=5.88u w=2.5u l=1u
X551 a_33634_43092# a_22790_42976# S2P S2P pfet_06v0 ad=2.5p pd=10.5u as=4.4p ps=20.88u w=10u l=1u
X552 a_57806_69248# a_50078_65732# a_58394_65848# S2P nfet_06v0 ad=1.1p pd=5.88u as=0.65p ps=3.02u w=2.5u l=1u
X553 a_68318_65848# a_56170_65848# cap_mim_2f0_m4m5_noshield c_width=20u c_length=10u
X554 a_25998_65732# a_25998_65732# S2P S2P nfet_06v0 ad=0.44p pd=2.88u as=0.44p ps=2.88u w=1u l=1u
X555 a_46858_8260# a_47328_4860# S2P S2P nfet_06v0 ad=1.1p pd=5.88u as=1.1p ps=5.88u w=2.5u l=1u
X556 a_44814_4860# a_43582_4744# S2P S2P nfet_06v0 ad=1.25p pd=5.5u as=2.2p ps=10.88u w=5u l=1u
X557 a_56690_17056# a_68318_13656# cap_mim_2f0_m4m5_noshield c_width=20u c_length=10u
X558 a_67394_23158# a_64528_25146# a_64528_25146# S2P nfet_06v0 ad=0.88p pd=4.88u as=0.52p ps=2.52u w=2u l=1u
X559 a_6396_57052# a_2218_56936# a_4382_60452# S2P nfet_06v0 ad=1.1p pd=5.88u as=1.1p ps=5.88u w=2.5u l=1u
X560 a_17362_65848# a_2650_65732# S2P S2P nfet_06v0 ad=1.25p pd=5.5u as=2.2p ps=10.88u w=5u l=1u
X561 a_30326_13656# a_31890_13540# a_32090_13656# S2P nfet_06v0 ad=2.2p pd=10.88u as=1.3p ps=5.52u w=5u l=1u
X562 a_65550_40518# a_65888_39194# S2P S2P nfet_06v0 ad=0.5456p pd=3.36u as=0.5456p ps=3.36u w=1.24u l=1u
X563 a_9646_34416# a_8922_30900# a_6606_34416# S2P pfet_06v0 ad=2.6p pd=10.52u as=4.4p ps=20.88u w=10u l=1u
X564 a_32652_4860# a_31632_4860# S2P S2P nfet_06v0 ad=1.25p pd=5.5u as=2.2p ps=10.88u w=5u l=1u
X565 a_43882_39576# a_43922_42976# a_55578_43092# S2P pfet_06v0 ad=4.4p pd=20.88u as=2.5p ps=10.5u w=10u l=1u
X566 a_58394_65848# a_64402_69132# a_58922_69248# S2P pfet_06v0 ad=2.2p pd=10.88u as=2.2p ps=10.88u w=5u l=1u
X567 a_2850_48376# a_2650_48260# S2P S2P nfet_06v0 ad=1.25p pd=5.5u as=2.2p ps=10.88u w=5u l=1u
X568 a_42146_51776# a_41946_51660# S2P S2P pfet_06v0 ad=2.5p pd=10.5u as=4.4p ps=20.88u w=10u l=1u
X569 a_12802_25732# a_1958_25616# S2P S2P pfet_06v0 ad=2.5p pd=10.5u as=4.4p ps=20.88u w=10u l=1u
X570 a_26930_65848# a_26730_65732# S2P S2P nfet_06v0 ad=1.25p pd=5.5u as=2.2p ps=10.88u w=5u l=1u
X571 a_29224_4744# a_23090_8144# a_33634_8260# S2P pfet_06v0 ad=4.4p pd=20.88u as=2.5p ps=10.5u w=10u l=1u
X572 a_48060_57052# a_50718_60336# a_48482_60452# S2P pfet_06v0 ad=2.2p pd=10.88u as=2.2p ps=10.88u w=5u l=1u
X573 a_43882_39576# a_43882_39576# S2P S2P nfet_06v0 ad=0.44p pd=2.88u as=0.44p ps=2.88u w=1u l=1u
X574 a_16380_57052# a_2258_60336# S2P S2P nfet_06v0 ad=0.25p pd=1.5u as=0.44p ps=2.88u w=1u l=1u
X575 a_44238_13656# a_35958_17056# S2P S2P pfet_06v0 ad=2.6p pd=10.52u as=4.4p ps=20.88u w=10u l=1u
X576 a_50056_22216# a_50056_22216# a_52464_22332# S2P nfet_06v0 ad=2.2p pd=10.88u as=2.2p ps=10.88u w=5u l=1u
X577 a_9122_65848# a_10762_69248# S2P S2P pfet_06v0 ad=1.3p pd=5.52u as=1.3p ps=5.52u w=5u l=1u
X578 S2P a_59506_31016# a_68318_31016# S2P nfet_06v0 ad=1.3p pd=5.52u as=1.3p ps=5.52u w=5u l=1u
X579 S2P a_1918_74260# a_1830_74376# S2P nfet_06v0 ad=0.44p pd=2.88u as=0.44p ps=2.88u w=1u l=1u
X580 a_50118_69132# a_50418_69132# a_53354_69248# S2P pfet_06v0 ad=4.4p pd=20.88u as=2.5p ps=10.5u w=10u l=1u
X581 a_33684_39692# a_27650_43092# S2P S2P pfet_06v0 ad=0.308p pd=2.28u as=0.308p ps=2.28u w=0.7u l=20u
X582 a_6306_51776# a_1958_51660# S2P S2P pfet_06v0 ad=2.5p pd=10.5u as=4.4p ps=20.88u w=10u l=1u
X583 S2P a_34314_65848# a_32610_69248# S2P nfet_06v0 ad=1.1p pd=5.88u as=0.65p ps=3.02u w=2.5u l=1u
X584 S2P a_34314_13656# a_32610_17056# S2P nfet_06v0 ad=0.65p pd=3.02u as=0.65p ps=3.02u w=2.5u l=1u
X585 a_33684_57052# a_27228_57052# S2P S2P nfet_06v0 ad=0.44p pd=2.88u as=0.44p ps=2.88u w=1u l=1u
X586 a_19990_69248# a_1958_69132# S2P S2P pfet_06v0 ad=2.5p pd=10.5u as=4.4p ps=20.88u w=10u l=1u
X587 a_8010_13656# a_7810_13540# a_6246_13656# S2P nfet_06v0 ad=1.3p pd=5.52u as=2.2p ps=10.88u w=5u l=1u
X588 a_6606_69248# a_8922_65732# a_9646_69248# S2P pfet_06v0 ad=4.4p pd=20.88u as=2.6p ps=10.52u w=10u l=1u
X589 a_1918_22216# a_2218_22216# a_14316_22332# S2P nfet_06v0 ad=2.2p pd=10.88u as=1.25p ps=5.5u w=5u l=1u
X590 a_57806_69248# a_58394_65848# S2P S2P nfet_06v0 ad=0.65p pd=3.02u as=0.65p ps=3.02u w=2.5u l=1u
X591 a_23050_22216# a_23090_25616# a_34746_25732# S2P pfet_06v0 ad=4.4p pd=20.88u as=2.5p ps=10.5u w=10u l=1u
X592 a_54406_31016# a_50078_30900# a_55138_31016# S2P nfet_06v0 ad=2.2p pd=10.88u as=1.25p ps=5.5u w=5u l=1u
X593 a_48482_60452# a_50056_56936# a_48060_57052# S2P nfet_06v0 ad=1.1p pd=5.88u as=1.1p ps=5.88u w=2.5u l=1u
X594 S2P a_58922_51776# a_57282_48376# S2P pfet_06v0 ad=2.2p pd=10.88u as=1.3p ps=5.52u w=5u l=1u
X595 a_44238_31016# a_35426_31016# S2P S2P nfet_06v0 ad=1.3p pd=5.52u as=2.2p ps=10.88u w=5u l=1u
X596 a_69196_42622# Z S2P S2P nfet_05v0 ad=0.5808p pd=3.52u as=0.5808p ps=3.52u w=1.32u l=0.6u
X597 a_8530_34416# a_1918_30900# a_11346_31016# S2P nfet_06v0 ad=1.1p pd=5.88u as=0.65p ps=3.02u w=2.5u l=1u
X598 a_8530_69248# a_10234_65848# S2P S2P nfet_06v0 ad=0.65p pd=3.02u as=0.65p ps=3.02u w=2.5u l=1u
X599 a_54766_51776# a_50418_51660# a_54466_51776# S2P pfet_06v0 ad=4.4p pd=20.88u as=2.5p ps=10.5u w=10u l=1u
X600 a_44082_4860# a_43882_4744# a_43782_4860# S2P nfet_06v0 ad=2.2p pd=10.88u as=1.25p ps=5.5u w=5u l=1u
X601 a_15698_48260# a_2258_51660# a_19990_51776# S2P pfet_06v0 ad=4.4p pd=20.88u as=2.5p ps=10.5u w=10u l=1u
X602 a_50078_65732# a_50078_65732# S2P S2P nfet_06v0 ad=0.44p pd=2.88u as=0.44p ps=2.88u w=1u l=1u
X603 a_9122_48376# a_2258_51660# a_10762_51776# S2P pfet_06v0 ad=2.2p pd=10.88u as=1.3p ps=5.52u w=5u l=1u
X604 a_19126_65848# a_18106_65848# S2P S2P nfet_06v0 ad=1.25p pd=5.5u as=2.2p ps=10.88u w=5u l=1u
X605 a_26026_43092# a_25546_39576# a_23290_43092# S2P pfet_06v0 ad=4.4p pd=20.88u as=4.4p ps=20.88u w=10u l=1u
X606 a_35958_17056# a_39778_13540# a_35426_13656# S2P nfet_06v0 ad=1.1p pd=5.88u as=1.1p ps=5.88u w=2.5u l=1u
X607 a_58614_25732# a_43622_25616# S2P S2P pfet_06v0 ad=2.5p pd=10.5u as=4.4p ps=20.88u w=10u l=1u
X608 a_2650_65732# a_2258_69132# a_3270_69248# S2P pfet_06v0 ad=4.4p pd=20.88u as=2.5p ps=10.5u w=10u l=1u
X609 a_1958_60336# a_2258_60336# a_16950_60452# S2P pfet_06v0 ad=4.4p pd=20.88u as=2.5p ps=10.5u w=10u l=1u
X610 a_16380_4860# a_2258_8144# S2P S2P nfet_06v0 ad=0.25p pd=1.5u as=0.44p ps=2.88u w=1u l=1u
X611 a_2218_22216# a_2218_22216# S2P S2P nfet_06v0 ad=0.44p pd=2.88u as=0.44p ps=2.88u w=1u l=1u
X612 a_10678_42976# a_2258_42976# a_10878_43092# S2P pfet_06v0 ad=4.4p pd=20.88u as=2.5p ps=10.5u w=10u l=1u
X613 a_51720_57052# a_43582_56936# S2P S2P nfet_06v0 ad=1.25p pd=5.5u as=2.2p ps=10.88u w=5u l=1u
X614 a_64528_7674# a_64526_4362# a_64438_4478# S2P nfet_06v0 ad=0.6448p pd=3u as=1.0912p ps=5.84u w=2.48u l=1u
X615 a_65550_23158# a_65638_23042# a_64528_25146# S2P nfet_06v0 ad=1.0912p pd=5.84u as=0.6448p ps=3u w=2.48u l=1u
X616 a_64528_7674# a_64528_7674# w_64222_7494# w_64222_7494# pfet_06v0 ad=0.52p pd=2.52u as=0.52p ps=2.52u w=2u l=1u
X617 a_30888_22332# a_22750_22216# S2P S2P nfet_06v0 ad=1.25p pd=5.5u as=2.2p ps=10.88u w=5u l=1u
X618 a_56170_48376# a_58922_51776# S2P S2P pfet_06v0 ad=1.3p pd=5.52u as=1.3p ps=5.52u w=5u l=1u
X619 a_68318_13656# a_59506_13656# S2P S2P nfet_06v0 ad=2.2p pd=10.88u as=1.3p ps=5.52u w=5u l=1u
X620 a_39778_30900# a_26338_34300# a_44070_34416# S2P pfet_06v0 ad=4.4p pd=20.88u as=2.5p ps=10.5u w=10u l=1u
X621 a_32610_69248# a_44238_65848# cap_mim_2f0_m4m5_noshield c_width=20u c_length=10u
X622 a_34746_43092# a_22790_42976# S2P S2P pfet_06v0 ad=2.5p pd=10.5u as=4.4p ps=20.88u w=10u l=1u
X623 a_43822_8260# a_43622_8144# S2P S2P pfet_06v0 ad=2.5p pd=10.5u as=4.4p ps=20.88u w=10u l=1u
X624 a_33202_31016# a_26338_34300# a_34842_34416# S2P pfet_06v0 ad=2.2p pd=10.88u as=1.3p ps=5.52u w=5u l=1u
X625 S2P a_58394_65848# a_56690_69248# S2P nfet_06v0 ad=1.1p pd=5.88u as=0.65p ps=3.02u w=2.5u l=1u
X626 a_4182_39692# a_6006_43092# S2P S2P pfet_06v0 ad=2.2p pd=10.88u as=2.2p ps=10.88u w=5u l=1u
X627 a_44122_60452# a_43922_60336# a_43822_60452# S2P pfet_06v0 ad=4.4p pd=20.88u as=2.5p ps=10.5u w=10u l=1u
X628 a_1918_4744# a_2218_4744# a_14316_4860# S2P nfet_06v0 ad=2.2p pd=10.88u as=1.25p ps=5.5u w=5u l=1u
X629 S2P a_12670_74260# a_15798_74376# S2P nfet_06v0 ad=0.44p pd=2.88u as=0.25p ps=1.5u w=1u l=1u
X630 a_4914_57052# S3N a_2418_57052# S2P nfet_06v0 ad=2.2p pd=10.88u as=2.2p ps=10.88u w=5u l=1u
X631 a_36180_22332# a_23090_25616# S2P S2P nfet_06v0 ad=0.25p pd=1.5u as=0.44p ps=2.88u w=1u l=1u
X632 a_6396_22332# a_9054_25616# a_6818_25732# S2P pfet_06v0 ad=2.2p pd=10.88u as=2.2p ps=10.88u w=5u l=1u
X633 a_26550_74376# a_24798_74376# a_25618_74260# S2P nfet_06v0 ad=0.25p pd=1.5u as=0.44p ps=2.88u w=1u l=1u
X634 a_6606_34416# a_2258_34300# a_6306_34416# S2P pfet_06v0 ad=4.4p pd=20.88u as=2.5p ps=10.5u w=10u l=1u
X635 a_42146_69248# a_41946_69132# S2P S2P pfet_06v0 ad=2.5p pd=10.5u as=4.4p ps=20.88u w=10u l=1u
X636 a_32090_13656# a_34842_17056# S2P S2P pfet_06v0 ad=1.3p pd=5.52u as=2.2p ps=10.88u w=5u l=1u
X637 a_1918_13540# a_2258_16940# a_2158_17056# S2P pfet_06v0 ad=4.4p pd=20.88u as=2.5p ps=10.5u w=10u l=1u
X638 a_16242_34300# a_1918_30900# a_17362_31016# S2P nfet_06v0 ad=2.2p pd=10.88u as=1.25p ps=5.5u w=5u l=1u
X639 a_5194_34416# a_1958_34300# S2P S2P pfet_06v0 ad=2.5p pd=10.5u as=4.4p ps=20.88u w=10u l=1u
X640 a_56690_34416# a_68318_31016# cap_mim_2f0_m4m5_noshield c_width=20u c_length=10u
X641 a_44814_22332# a_43582_22216# S2P S2P nfet_06v0 ad=1.25p pd=5.5u as=2.2p ps=10.88u w=5u l=1u
X642 a_33202_65848# a_33002_65732# a_30326_65848# S2P nfet_06v0 ad=1.3p pd=5.52u as=2.2p ps=10.88u w=5u l=1u
X643 a_4382_60452# a_5664_57052# S2P S2P nfet_06v0 ad=1.1p pd=5.88u as=1.1p ps=5.88u w=2.5u l=1u
X644 a_43922_42976# a_43922_42976# a_58044_39692# S2P nfet_06v0 ad=0.44p pd=2.88u as=0.25p ps=1.5u w=1u l=1u
X645 a_69196_25262# a_68484_25262# S2P S2P nfet_05v0 ad=0.5808p pd=3.52u as=0.5808p ps=3.52u w=1.32u l=0.6u
X646 a_25014_39692# a_26838_43092# S2P S2P pfet_06v0 ad=2.2p pd=10.88u as=2.2p ps=10.88u w=5u l=1u
X647 a_6306_69248# a_1958_69132# S2P S2P pfet_06v0 ad=2.5p pd=10.5u as=4.4p ps=20.88u w=10u l=1u
X648 a_27350_34416# a_26038_34300# S2P S2P pfet_06v0 ad=2.5p pd=10.5u as=4.4p ps=20.88u w=10u l=1u
X649 a_25746_57052# S4N a_23250_57052# S2P nfet_06v0 ad=2.2p pd=10.88u as=2.2p ps=10.88u w=5u l=1u
X650 a_32610_34416# a_34314_31016# S2P S2P nfet_06v0 ad=0.65p pd=3.02u as=0.65p ps=3.02u w=2.5u l=1u
X651 a_25214_60452# a_24814_56936# a_23290_60452# S2P pfet_06v0 ad=4.4p pd=20.88u as=4.4p ps=20.88u w=10u l=1u
X652 a_54406_65848# a_50078_65732# a_54106_65848# S2P nfet_06v0 ad=2.2p pd=10.88u as=1.25p ps=5.5u w=5u l=1u
X653 S2P a_16630_74260# a_16542_74376# S2P nfet_06v0 ad=0.44p pd=2.88u as=0.44p ps=2.88u w=1u l=1u
X654 a_34842_17056# a_26338_16940# a_33202_13656# S2P pfet_06v0 ad=1.3p pd=5.52u as=2.2p ps=10.88u w=5u l=1u
X655 a_43582_22216# a_43922_25616# a_56690_25732# S2P pfet_06v0 ad=4.4p pd=20.88u as=2.5p ps=10.5u w=10u l=1u
X656 a_43206_65848# a_42186_65848# S2P S2P nfet_06v0 ad=1.25p pd=5.5u as=2.2p ps=10.88u w=5u l=1u
X657 a_13914_25732# a_1958_25616# S2P S2P pfet_06v0 ad=2.5p pd=10.5u as=4.4p ps=20.88u w=10u l=1u
X658 a_52342_60336# a_43922_60336# a_52542_60452# S2P pfet_06v0 ad=4.4p pd=20.88u as=2.5p ps=10.5u w=10u l=1u
X659 a_44238_65848# a_32090_65848# cap_mim_2f0_m4m5_noshield c_width=20u c_length=10u
X660 a_69196_42622# Z w_64222_42326# w_64222_42326# pfet_05v0 ad=0.8052p pd=4.54u as=0.8052p ps=4.54u w=1.83u l=0.5u
X661 a_25214_60452# a_26496_57052# S2P S2P nfet_06v0 ad=1.1p pd=5.88u as=1.1p ps=5.88u w=2.5u l=1u
X662 a_35958_51776# a_26338_51660# a_32090_48376# S2P pfet_06v0 ad=1.3p pd=5.52u as=2.2p ps=10.88u w=5u l=1u
X663 a_2418_4860# a_2218_4744# a_3150_4860# S2P nfet_06v0 ad=2.2p pd=10.88u as=1.25p ps=5.5u w=5u l=1u
X664 a_46046_43092# a_54516_39692# cap_mim_2f0_m4m5_noshield c_width=20u c_length=10u
X665 S2P a_58922_69248# a_57282_65848# S2P pfet_06v0 ad=2.2p pd=10.88u as=1.3p ps=5.52u w=5u l=1u
X666 S2P a_11878_17056# a_20158_13656# S2P pfet_06v0 ad=2.6p pd=10.52u as=2.6p ps=10.52u w=10u l=1u
X667 a_30326_48376# a_33002_48260# a_33202_48376# S2P nfet_06v0 ad=2.2p pd=10.88u as=1.3p ps=5.52u w=5u l=1u
X668 S2P a_58922_17056# a_57282_13656# S2P pfet_06v0 ad=1.3p pd=5.52u as=1.3p ps=5.52u w=5u l=1u
X669 a_26026_8260# a_26496_4860# S2P S2P nfet_06v0 ad=1.1p pd=5.88u as=1.1p ps=5.88u w=2.5u l=1u
X670 a_43782_22332# a_43582_22216# S2P S2P nfet_06v0 ad=1.25p pd=5.5u as=2.2p ps=10.88u w=5u l=1u
X671 a_15698_65732# a_2258_69132# a_19990_69248# S2P pfet_06v0 ad=4.4p pd=20.88u as=2.5p ps=10.5u w=10u l=1u
X672 a_54766_69248# a_50418_69132# a_54466_69248# S2P pfet_06v0 ad=4.4p pd=20.88u as=2.5p ps=10.5u w=10u l=1u
X673 a_7418_51776# a_1958_51660# S2P S2P pfet_06v0 ad=2.5p pd=10.5u as=4.4p ps=20.88u w=10u l=1u
X674 a_64402_51660# a_50078_48260# a_65522_48376# S2P nfet_06v0 ad=2.2p pd=10.88u as=1.25p ps=5.5u w=5u l=1u
X675 a_46046_25732# a_54516_22332# cap_mim_2f0_m4m5_noshield c_width=20u c_length=10u
X676 a_9122_65848# a_2258_69132# a_10762_69248# S2P pfet_06v0 ad=2.2p pd=10.88u as=1.3p ps=5.52u w=5u l=1u
X677 a_2118_22332# a_1918_22216# S2P S2P nfet_06v0 ad=1.25p pd=5.5u as=2.2p ps=10.88u w=5u l=1u
X678 a_9122_13656# a_8922_13540# a_6246_13656# S2P nfet_06v0 ad=1.3p pd=5.52u as=2.2p ps=10.88u w=5u l=1u
X679 a_50418_69132# a_50418_69132# a_53074_65848# S2P nfet_06v0 ad=0.44p pd=2.88u as=0.25p ps=1.5u w=1u l=1u
X680 a_32610_34416# a_31890_30900# a_30686_34416# S2P pfet_06v0 ad=2.6p pd=10.52u as=4.4p ps=20.88u w=10u l=1u
X681 a_56690_69248# a_58394_65848# S2P S2P nfet_06v0 ad=0.65p pd=3.02u as=1.1p ps=5.88u w=2.5u l=1u
X682 a_11820_4860# a_10800_4860# S2P S2P nfet_06v0 ad=1.25p pd=5.5u as=2.2p ps=10.88u w=5u l=1u
X683 a_5664_4860# a_2218_4744# a_5194_8260# S2P nfet_06v0 ad=1.1p pd=5.88u as=1.1p ps=5.88u w=2.5u l=1u
X684 a_22750_22216# a_23090_25616# a_35858_25732# S2P pfet_06v0 ad=4.4p pd=20.88u as=2.5p ps=10.5u w=10u l=1u
X685 Z a_67772_42622# S2P S2P nfet_05v0 ad=0.5808p pd=3.52u as=0.5808p ps=3.52u w=1.32u l=0.6u
X686 a_2650_13540# a_1918_13540# a_2850_13656# S2P nfet_06v0 ad=2.2p pd=10.88u as=1.25p ps=5.5u w=5u l=1u
X687 S2P a_10234_31016# a_9646_34416# S2P nfet_06v0 ad=0.65p pd=3.02u as=0.65p ps=3.02u w=2.5u l=1u
X688 a_10762_69248# a_15698_65732# a_10234_65848# S2P nfet_06v0 ad=1.1p pd=5.88u as=1.1p ps=5.88u w=2.5u l=1u
X689 a_54766_51776# a_50418_51660# a_55578_51776# S2P pfet_06v0 ad=4.4p pd=20.88u as=2.5p ps=10.5u w=10u l=1u
X690 a_8392_4744# a_2258_8144# a_12802_8260# S2P pfet_06v0 ad=4.4p pd=20.88u as=2.5p ps=10.5u w=10u l=1u
X691 a_32090_13656# a_26338_16940# a_35958_17056# S2P pfet_06v0 ad=2.2p pd=10.88u as=1.3p ps=5.52u w=5u l=1u
X692 a_2258_25616# a_2258_25616# a_16380_22332# S2P nfet_06v0 ad=0.44p pd=2.88u as=0.25p ps=1.5u w=1u l=1u
X693 a_68318_31016# a_60038_34416# S2P S2P pfet_06v0 ad=2.6p pd=10.52u as=4.4p ps=20.88u w=10u l=1u
X694 S2P a_34842_51776# a_33202_48376# S2P pfet_06v0 ad=1.3p pd=5.52u as=1.3p ps=5.52u w=5u l=1u
X695 a_56170_65848# a_58922_69248# S2P S2P pfet_06v0 ad=1.3p pd=5.52u as=1.3p ps=5.52u w=5u l=1u
X696 a_60038_34416# a_50418_34300# a_56170_31016# S2P pfet_06v0 ad=1.3p pd=5.52u as=2.2p ps=10.88u w=5u l=1u
X697 a_60038_51776# a_63858_48260# a_59506_48376# S2P nfet_06v0 ad=1.1p pd=5.88u as=1.1p ps=5.88u w=2.5u l=1u
X698 a_56690_43092# a_43622_42976# S2P S2P pfet_06v0 ad=2.5p pd=10.5u as=4.4p ps=20.88u w=10u l=1u
X699 S2P a_23834_75936# a_23334_74376# S2P nfet_06v0 ad=0.44p pd=2.88u as=0.44p ps=2.88u w=1u l=1u
X700 a_2418_22332# a_2218_22216# a_3150_22332# S2P nfet_06v0 ad=2.2p pd=10.88u as=1.25p ps=5.5u w=5u l=1u
X701 a_5664_57052# a_2218_56936# a_5194_60452# S2P nfet_06v0 ad=1.1p pd=5.88u as=1.1p ps=5.88u w=2.5u l=1u
X702 a_11878_69248# a_15698_65732# a_11346_65848# S2P nfet_06v0 ad=1.1p pd=5.88u as=1.1p ps=5.88u w=2.5u l=1u
X703 a_9054_60336# a_2218_56936# a_10056_57052# S2P nfet_06v0 ad=2.2p pd=10.88u as=1.25p ps=5.5u w=5u l=1u
X704 a_50810_30900# a_50078_30900# a_51010_31016# S2P nfet_06v0 ad=2.2p pd=10.88u as=1.25p ps=5.5u w=5u l=1u
X705 a_56690_51776# a_12670_74260# cap_mim_2f0_m4m5_noshield c_width=20u c_length=10u
X706 a_32090_13656# a_34842_17056# S2P S2P pfet_06v0 ad=1.3p pd=5.52u as=1.3p ps=5.52u w=5u l=1u
X707 S2P a_64938_58576# a_64838_58692# S2P pfet_06v0 ad=1.32p pd=6.88u as=0.75p ps=3.5u w=3u l=1u
X708 S2P a_11346_13656# a_20158_13656# S2P nfet_06v0 ad=1.3p pd=5.52u as=1.3p ps=5.52u w=5u l=1u
X709 S2P a_58394_48376# a_57806_51776# S2P nfet_06v0 ad=0.65p pd=3.02u as=0.65p ps=3.02u w=2.5u l=1u
X710 a_23250_22332# a_23050_22216# a_23982_22332# S2P nfet_06v0 ad=2.2p pd=10.88u as=1.25p ps=5.5u w=5u l=1u
X711 a_37212_39692# a_23090_42976# S2P S2P nfet_06v0 ad=0.25p pd=1.5u as=0.44p ps=2.88u w=1u l=1u
X712 a_6246_65848# a_1918_65732# a_6978_65848# S2P nfet_06v0 ad=2.2p pd=10.88u as=1.25p ps=5.5u w=5u l=1u
X713 S2P a_23834_75936# a_23734_76052# S2P pfet_06v0 ad=1.32p pd=6.88u as=0.75p ps=3.5u w=3u l=1u
X714 a_26038_16940# a_26338_16940# a_27962_13656# S2P nfet_06v0 ad=0.44p pd=2.88u as=0.25p ps=1.5u w=1u l=1u
X715 a_35858_43092# a_22790_42976# S2P S2P pfet_06v0 ad=2.5p pd=10.5u as=4.4p ps=20.88u w=10u l=1u
X716 a_26496_57052# a_23050_56936# a_26026_60452# S2P nfet_06v0 ad=1.1p pd=5.88u as=1.1p ps=5.88u w=2.5u l=1u
X717 a_54516_39692# a_48060_39692# S2P S2P nfet_06v0 ad=0.44p pd=2.88u as=0.44p ps=2.88u w=1u l=1u
X718 a_31710_60452# a_31510_60336# S2P S2P pfet_06v0 ad=2.5p pd=10.5u as=4.4p ps=20.88u w=10u l=1u
X719 a_55138_65848# a_50810_65732# S2P S2P nfet_06v0 ad=1.25p pd=5.5u as=2.2p ps=10.88u w=5u l=1u
X720 a_50718_25616# a_43882_22216# a_51720_22332# S2P nfet_06v0 ad=2.2p pd=10.88u as=1.25p ps=5.5u w=5u l=1u
X721 a_6606_34416# a_2258_34300# a_7418_34416# S2P pfet_06v0 ad=4.4p pd=20.88u as=2.5p ps=10.5u w=10u l=1u
X722 a_9646_17056# a_10234_13656# S2P S2P nfet_06v0 ad=0.65p pd=3.02u as=0.65p ps=3.02u w=2.5u l=1u
X723 a_47670_8260# a_50056_4744# a_47328_4860# S2P nfet_06v0 ad=1.1p pd=5.88u as=1.1p ps=5.88u w=2.5u l=1u
X724 a_35958_69248# a_26338_69132# a_32090_65848# S2P pfet_06v0 ad=1.3p pd=5.52u as=2.2p ps=10.88u w=5u l=1u
X725 a_31632_57052# a_23050_56936# a_32652_57052# S2P nfet_06v0 ad=2.2p pd=10.88u as=1.25p ps=5.5u w=5u l=1u
X726 a_34314_65848# a_25998_65732# a_33726_69248# S2P nfet_06v0 ad=0.65p pd=3.02u as=1.1p ps=5.88u w=2.5u l=1u
X727 a_68484_25262# a_67772_25262# S2P S2P nfet_05v0 ad=0.5808p pd=3.52u as=0.5808p ps=3.52u w=1.32u l=0.6u
X728 a_32090_31016# a_31890_30900# a_30326_31016# S2P nfet_06v0 ad=1.3p pd=5.52u as=2.2p ps=10.88u w=5u l=1u
X729 a_50318_51776# a_50118_51660# S2P S2P pfet_06v0 ad=2.5p pd=10.5u as=4.4p ps=20.88u w=10u l=1u
X730 a_7418_69248# a_1958_69132# S2P S2P pfet_06v0 ad=2.5p pd=10.5u as=4.4p ps=20.88u w=10u l=1u
X731 a_50718_8144# a_50718_8144# a_52342_8144# S2P pfet_06v0 ad=4.4p pd=20.88u as=4.4p ps=20.88u w=10u l=1u
X732 a_26338_34300# a_26338_34300# S2P S2P pfet_06v0 ad=0.88p pd=4.88u as=0.88p ps=4.88u w=2u l=1u
X733 a_20158_31016# a_11878_34416# S2P S2P pfet_06v0 ad=2.6p pd=10.52u as=4.4p ps=20.88u w=10u l=1u
X734 a_57282_31016# a_58922_34416# S2P S2P pfet_06v0 ad=1.3p pd=5.52u as=2.2p ps=10.88u w=5u l=1u
X735 a_53354_17056# a_50118_16940# S2P S2P pfet_06v0 ad=2.5p pd=10.5u as=4.4p ps=20.88u w=10u l=1u
X736 a_34842_34416# a_39778_30900# a_34314_31016# S2P nfet_06v0 ad=1.1p pd=5.88u as=1.1p ps=5.88u w=2.5u l=1u
X737 a_42186_31016# a_25998_30900# a_43206_31016# S2P nfet_06v0 ad=2.2p pd=10.88u as=1.25p ps=5.5u w=5u l=1u
X738 a_53484_39692# a_52464_39692# S2P S2P nfet_06v0 ad=1.25p pd=5.5u as=2.2p ps=10.88u w=5u l=1u
X739 a_9054_42976# a_9054_42976# a_10678_42976# S2P pfet_06v0 ad=4.4p pd=20.88u as=4.4p ps=20.88u w=10u l=1u
X740 a_15026_25732# a_1958_25616# S2P S2P pfet_06v0 ad=2.5p pd=10.5u as=4.4p ps=20.88u w=10u l=1u
X741 a_2258_34300# a_2258_34300# a_4914_31016# S2P nfet_06v0 ad=0.44p pd=2.88u as=0.25p ps=1.5u w=1u l=1u
X742 a_23250_57052# a_23050_56936# a_22950_57052# S2P nfet_06v0 ad=2.2p pd=10.88u as=1.25p ps=5.5u w=5u l=1u
X743 a_33726_51776# a_25998_48260# a_34314_48376# S2P nfet_06v0 ad=1.1p pd=5.88u as=0.65p ps=3.02u w=2.5u l=1u
X744 a_26730_48260# a_25998_48260# a_26930_48376# S2P nfet_06v0 ad=2.2p pd=10.88u as=1.25p ps=5.5u w=5u l=1u
X745 a_6246_48376# a_7810_48260# a_8010_48376# S2P nfet_06v0 ad=2.2p pd=10.88u as=1.3p ps=5.52u w=5u l=1u
X746 a_54766_69248# a_50418_69132# a_55578_69248# S2P pfet_06v0 ad=4.4p pd=20.88u as=2.5p ps=10.5u w=10u l=1u
X747 S2P a_10762_34416# a_8010_31016# S2P pfet_06v0 ad=2.2p pd=10.88u as=1.3p ps=5.52u w=5u l=1u
X748 S2P a_10762_51776# a_8010_48376# S2P pfet_06v0 ad=1.3p pd=5.52u as=1.3p ps=5.52u w=5u l=1u
X749 a_15348_39692# a_2258_42976# S2P S2P nfet_06v0 ad=0.25p pd=1.5u as=0.44p ps=2.88u w=1u l=1u
X750 a_34314_13656# a_40322_16940# a_34842_17056# S2P pfet_06v0 ad=2.2p pd=10.88u as=2.2p ps=10.88u w=5u l=1u
X751 S2P a_34842_69248# a_33202_65848# S2P pfet_06v0 ad=1.3p pd=5.52u as=1.3p ps=5.52u w=5u l=1u
X752 a_12852_22332# a_6396_22332# S2P S2P nfet_06v0 ad=0.44p pd=2.88u as=0.44p ps=2.88u w=1u l=1u
X753 a_43622_8144# a_43922_8144# a_58614_8260# S2P pfet_06v0 ad=4.4p pd=20.88u as=2.5p ps=10.5u w=10u l=1u
X754 a_39778_30900# a_39778_30900# a_42186_31016# S2P nfet_06v0 ad=2.2p pd=10.88u as=2.2p ps=10.88u w=5u l=1u
X755 a_48482_60452# a_43922_60336# a_45846_57052# S2P pfet_06v0 ad=2.2p pd=10.88u as=2.2p ps=10.88u w=5u l=1u
X756 a_30026_13656# a_26730_13540# S2P S2P nfet_06v0 ad=1.25p pd=5.5u as=2.2p ps=10.88u w=5u l=1u
X757 S2P a_58394_13656# a_57806_17056# S2P nfet_06v0 ad=1.1p pd=5.88u as=0.65p ps=3.02u w=2.5u l=1u
X758 S2P a_24886_74260# a_24798_74376# S2P nfet_06v0 ad=0.44p pd=2.88u as=0.44p ps=2.88u w=1u l=1u
X759 a_54516_4860# a_48482_8260# S2P S2P pfet_06v0 ad=0.308p pd=2.28u as=0.308p ps=2.28u w=0.7u l=20u
X760 a_64528_25146# a_64528_25146# w_64222_24966# w_64222_24966# pfet_06v0 ad=0.52p pd=2.52u as=0.52p ps=2.52u w=2u l=1u
X761 a_29274_51776# a_26038_51660# S2P S2P pfet_06v0 ad=2.5p pd=10.5u as=4.4p ps=20.88u w=10u l=1u
X762 a_43822_25732# a_43622_25616# S2P S2P pfet_06v0 ad=2.5p pd=10.5u as=4.4p ps=20.88u w=10u l=1u
X763 a_4182_22332# S1P a_2418_22332# S2P nfet_06v0 ad=2.2p pd=10.88u as=2.2p ps=10.88u w=5u l=1u
X764 S2P a_10234_13656# a_8530_17056# S2P nfet_06v0 ad=1.1p pd=5.88u as=0.65p ps=3.02u w=2.5u l=1u
X765 a_3270_17056# a_1958_16940# S2P S2P pfet_06v0 ad=2.5p pd=10.5u as=4.4p ps=20.88u w=10u l=1u
X766 a_6818_60452# a_2258_60336# a_4182_57052# S2P pfet_06v0 ad=2.2p pd=10.88u as=2.2p ps=10.88u w=5u l=1u
X767 a_6006_8260# a_2258_8144# a_4914_4860# S2P pfet_06v0 ad=2.2p pd=10.88u as=2.2p ps=10.88u w=5u l=1u
X768 a_8392_56936# a_8392_56936# a_10800_57052# S2P nfet_06v0 ad=2.2p pd=10.88u as=2.2p ps=10.88u w=5u l=1u
X769 a_52042_31016# a_50418_34300# S2P S2P nfet_06v0 ad=0.25p pd=1.5u as=0.44p ps=2.88u w=1u l=1u
X770 a_1918_4744# a_2258_8144# a_15026_8260# S2P pfet_06v0 ad=4.4p pd=20.88u as=2.5p ps=10.5u w=10u l=1u
X771 a_20158_31016# a_11346_31016# S2P S2P nfet_06v0 ad=2.2p pd=10.88u as=1.3p ps=5.52u w=5u l=1u
X772 a_10234_48376# a_16242_51660# a_10762_51776# S2P pfet_06v0 ad=2.2p pd=10.88u as=2.2p ps=10.88u w=5u l=1u
X773 a_28994_13656# a_26338_16940# S2P S2P nfet_06v0 ad=0.25p pd=1.5u as=0.44p ps=2.88u w=1u l=1u
X774 S2P a_34842_34416# a_32090_31016# S2P pfet_06v0 ad=1.3p pd=5.52u as=1.3p ps=5.52u w=5u l=1u
X775 a_18106_48376# a_1918_48260# a_19126_48376# S2P nfet_06v0 ad=2.2p pd=10.88u as=1.25p ps=5.5u w=5u l=1u
X776 a_44070_51776# a_26038_51660# S2P S2P pfet_06v0 ad=2.5p pd=10.5u as=4.4p ps=20.88u w=10u l=1u
X777 a_24102_60452# a_22790_60336# S2P S2P pfet_06v0 ad=2.5p pd=10.5u as=4.4p ps=20.88u w=10u l=1u
X778 a_50078_30900# a_50418_34300# a_50318_34416# S2P pfet_06v0 ad=4.4p pd=20.88u as=2.5p ps=10.5u w=10u l=1u
X779 a_52542_25732# a_52342_25616# S2P S2P pfet_06v0 ad=2.5p pd=10.5u as=4.4p ps=20.88u w=10u l=1u
X780 a_65888_4362# a_65888_4362# w_64222_7494# w_64222_7494# pfet_06v0 ad=0.88p pd=4.88u as=0.88p ps=4.88u w=2u l=1u
X781 a_4182_4860# a_6006_8260# S2P S2P pfet_06v0 ad=2.2p pd=10.88u as=2.2p ps=10.88u w=5u l=1u
X782 a_11820_57052# a_10800_57052# S2P S2P nfet_06v0 ad=1.25p pd=5.5u as=2.2p ps=10.88u w=5u l=1u
X783 S2P a_2330_75936# a_5878_74260# S2P pfet_06v0 ad=1.32p pd=6.88u as=1.32p ps=6.88u w=3u l=1u
X784 a_46046_43092# a_47328_39692# S2P S2P nfet_06v0 ad=1.1p pd=5.88u as=1.1p ps=5.88u w=2.5u l=1u
X785 a_25014_57052# a_24814_56936# a_23250_57052# S2P nfet_06v0 ad=2.2p pd=10.88u as=2.2p ps=10.88u w=5u l=1u
X786 a_8010_31016# a_10762_34416# S2P S2P pfet_06v0 ad=1.3p pd=5.52u as=2.2p ps=10.88u w=5u l=1u
X787 a_50318_69248# a_50118_69132# S2P S2P pfet_06v0 ad=2.5p pd=10.5u as=4.4p ps=20.88u w=10u l=1u
X788 a_56690_69248# a_50078_65732# a_59506_65848# S2P nfet_06v0 ad=1.1p pd=5.88u as=0.65p ps=3.02u w=2.5u l=1u
X789 a_3150_57052# a_1918_56936# S2P S2P nfet_06v0 ad=1.25p pd=5.5u as=2.2p ps=10.88u w=5u l=1u
X790 a_15698_48260# a_15698_48260# a_18106_48376# S2P nfet_06v0 ad=2.2p pd=10.88u as=2.2p ps=10.88u w=5u l=1u
X791 a_36180_4860# a_23090_8144# S2P S2P nfet_06v0 ad=0.25p pd=1.5u as=0.44p ps=2.88u w=1u l=1u
X792 a_54516_39692# a_45846_39692# cap_mim_2f0_m4m5_noshield c_width=20u c_length=10u
X793 a_26026_60452# a_26496_57052# S2P S2P nfet_06v0 ad=1.1p pd=5.88u as=1.1p ps=5.88u w=2.5u l=1u
X794 a_57806_17056# a_58394_13656# S2P S2P nfet_06v0 ad=0.65p pd=3.02u as=1.1p ps=5.88u w=2.5u l=1u
X795 a_23090_25616# a_23090_25616# S2P S2P pfet_06v0 ad=0.88p pd=4.88u as=0.88p ps=4.88u w=2u l=1u
X796 a_29886_60336# a_29886_60336# a_31510_60336# S2P pfet_06v0 ad=4.4p pd=20.88u as=4.4p ps=20.88u w=10u l=1u
X797 a_5946_31016# a_2650_30900# S2P S2P nfet_06v0 ad=1.25p pd=5.5u as=2.2p ps=10.88u w=5u l=1u
X798 a_56690_51776# a_54516_39692# a_54766_51776# S2P pfet_06v0 ad=2.6p pd=10.52u as=4.4p ps=20.88u w=10u l=1u
X799 a_8530_17056# a_10234_13656# S2P S2P nfet_06v0 ad=0.65p pd=3.02u as=1.1p ps=5.88u w=2.5u l=1u
X800 a_59506_13656# a_64402_16940# a_60038_17056# S2P pfet_06v0 ad=2.2p pd=10.88u as=2.2p ps=10.88u w=5u l=1u
X801 a_68150_34416# a_50118_34300# S2P S2P pfet_06v0 ad=2.5p pd=10.5u as=4.4p ps=20.88u w=10u l=1u
X802 a_35426_65848# a_25998_65732# a_32610_69248# S2P nfet_06v0 ad=0.65p pd=3.02u as=1.1p ps=5.88u w=2.5u l=1u
X803 a_2458_43092# a_2258_42976# a_2158_43092# S2P pfet_06v0 ad=4.4p pd=20.88u as=2.5p ps=10.5u w=10u l=1u
X804 a_23982_57052# a_22750_56936# S2P S2P nfet_06v0 ad=1.25p pd=5.5u as=2.2p ps=10.88u w=5u l=1u
X805 a_5194_60452# S3N a_2458_60452# S2P pfet_06v0 ad=4.4p pd=20.88u as=4.4p ps=20.88u w=10u l=1u
X806 a_30686_17056# a_31890_13540# a_32610_17056# S2P pfet_06v0 ad=4.4p pd=20.88u as=2.6p ps=10.52u w=10u l=1u
X807 a_27962_48376# a_26338_51660# S2P S2P nfet_06v0 ad=0.25p pd=1.5u as=0.44p ps=2.88u w=1u l=1u
X808 S2P a_10762_69248# a_8010_65848# S2P pfet_06v0 ad=1.3p pd=5.52u as=1.3p ps=5.52u w=5u l=1u
X809 a_26038_34300# a_26338_34300# a_29274_34416# S2P pfet_06v0 ad=4.4p pd=20.88u as=2.5p ps=10.5u w=10u l=1u
X810 a_41442_65848# a_26730_65732# S2P S2P nfet_06v0 ad=1.25p pd=5.5u as=2.2p ps=10.88u w=5u l=1u
X811 a_64438_5686# a_65888_4362# S2P S2P nfet_06v0 ad=0.5456p pd=3.36u as=0.5456p ps=3.36u w=1.24u l=1u
X812 a_54466_17056# a_50118_16940# S2P S2P pfet_06v0 ad=2.5p pd=10.5u as=4.4p ps=20.88u w=10u l=1u
X813 S2P a_60038_17056# a_68318_13656# S2P pfet_06v0 ad=2.6p pd=10.52u as=2.6p ps=10.52u w=10u l=1u
X814 a_2258_25616# a_2258_25616# S2P S2P pfet_06v0 ad=0.88p pd=4.88u as=0.88p ps=4.88u w=2u l=1u
X815 a_29274_69248# a_26038_69132# S2P S2P pfet_06v0 ad=2.5p pd=10.5u as=4.4p ps=20.88u w=10u l=1u
X816 a_37782_8260# a_22790_8144# S2P S2P pfet_06v0 ad=2.5p pd=10.5u as=4.4p ps=20.88u w=10u l=1u
X817 a_23290_25732# a_23090_25616# a_22990_25732# S2P pfet_06v0 ad=4.4p pd=20.88u as=2.5p ps=10.5u w=10u l=1u
X818 a_6246_48376# a_8922_48260# a_9122_48376# S2P nfet_06v0 ad=2.2p pd=10.88u as=1.3p ps=5.52u w=5u l=1u
X819 a_25214_8260# S2P a_23290_8260# S2P pfet_06v0 ad=4.4p pd=20.88u as=4.4p ps=20.88u w=10u l=1u
X820 a_51010_65848# a_50810_65732# S2P S2P nfet_06v0 ad=1.25p pd=5.5u as=2.2p ps=10.88u w=5u l=1u
X821 a_67552_39310# a_65888_39194# S2P S2P nfet_06v0 ad=0.175p pd=1.2u as=0.308p ps=2.28u w=0.7u l=1u
X822 w_64222_42326# a_64528_42506# a_64528_42506# w_64222_42326# pfet_06v0 ad=0.52p pd=2.52u as=0.52p ps=2.52u w=2u l=1u
X823 S2P a_23422_74260# a_23334_74376# S2P nfet_06v0 ad=0.44p pd=2.88u as=0.44p ps=2.88u w=1u l=1u
X824 a_30326_13656# a_25998_13540# a_30026_13656# S2P nfet_06v0 ad=2.2p pd=10.88u as=1.25p ps=5.5u w=5u l=1u
X825 a_27650_8260# a_29224_4744# a_27228_4860# S2P nfet_06v0 ad=1.1p pd=5.88u as=1.1p ps=5.88u w=2.5u l=1u
X826 S2P a_58394_13656# a_56690_17056# S2P nfet_06v0 ad=0.65p pd=3.02u as=0.65p ps=3.02u w=2.5u l=1u
X827 a_29886_8144# a_29886_8144# a_31510_8144# S2P pfet_06v0 ad=4.4p pd=20.88u as=4.4p ps=20.88u w=10u l=1u
X828 a_66266_65848# a_50078_65732# a_67286_65848# S2P nfet_06v0 ad=2.2p pd=10.88u as=1.25p ps=5.5u w=5u l=1u
X829 a_10234_65848# a_16242_69132# a_10762_69248# S2P pfet_06v0 ad=2.2p pd=10.88u as=2.2p ps=10.88u w=5u l=1u
X830 a_44934_25732# a_43622_25616# S2P S2P pfet_06v0 ad=2.5p pd=10.5u as=4.4p ps=20.88u w=10u l=1u
X831 a_8530_34416# a_7810_30900# a_6606_34416# S2P pfet_06v0 ad=2.6p pd=10.52u as=4.4p ps=20.88u w=10u l=1u
X832 a_20158_48376# a_11346_48376# S2P S2P nfet_06v0 ad=1.3p pd=5.52u as=2.2p ps=10.88u w=5u l=1u
X833 a_44070_69248# a_26038_69132# S2P S2P pfet_06v0 ad=2.5p pd=10.5u as=4.4p ps=20.88u w=10u l=1u
X834 a_30686_17056# a_26338_16940# a_30386_17056# S2P pfet_06v0 ad=4.4p pd=20.88u as=2.5p ps=10.5u w=10u l=1u
X835 a_47328_39692# a_43882_39576# a_46858_43092# S2P nfet_06v0 ad=1.1p pd=5.88u as=1.1p ps=5.88u w=2.5u l=1u
X836 a_2258_16940# a_2258_16940# S2P S2P pfet_06v0 ad=0.88p pd=4.88u as=0.88p ps=4.88u w=2u l=1u
X837 S2P a_34314_65848# a_33726_69248# S2P nfet_06v0 ad=1.1p pd=5.88u as=0.65p ps=3.02u w=2.5u l=1u
X838 S2P a_58922_17056# a_56170_13656# S2P pfet_06v0 ad=2.2p pd=10.88u as=1.3p ps=5.52u w=5u l=1u
X839 a_64528_42506# a_64526_40402# a_64438_40518# S2P nfet_06v0 ad=0.6448p pd=3u as=1.0912p ps=5.84u w=2.48u l=1u
X840 a_44238_31016# a_35958_34416# S2P S2P pfet_06v0 ad=4.4p pd=20.88u as=2.6p ps=10.52u w=10u l=1u
X841 a_44238_48376# a_35958_51776# S2P S2P pfet_06v0 ad=2.6p pd=10.52u as=4.4p ps=20.88u w=10u l=1u
X842 a_59506_31016# a_50078_30900# a_56690_34416# S2P nfet_06v0 ad=0.65p pd=3.02u as=1.1p ps=5.88u w=2.5u l=1u
X843 a_54516_57052# a_45846_57052# cap_mim_2f0_m4m5_noshield c_width=20u c_length=10u
X844 a_4914_65848# a_2258_69132# S2P S2P nfet_06v0 ad=0.25p pd=1.5u as=0.44p ps=2.88u w=1u l=1u
X845 a_57806_17056# a_57082_13540# a_54766_17056# S2P pfet_06v0 ad=2.6p pd=10.52u as=4.4p ps=20.88u w=10u l=1u
X846 a_50718_25616# a_50718_25616# a_52342_25616# S2P pfet_06v0 ad=4.4p pd=20.88u as=4.4p ps=20.88u w=10u l=1u
X847 S2P a_12670_74260# a_12582_74376# S2P nfet_06v0 ad=0.44p pd=2.88u as=0.44p ps=2.88u w=1u l=1u
X848 a_56690_69248# a_55970_65732# a_54766_69248# S2P pfet_06v0 ad=2.6p pd=10.52u as=4.4p ps=20.88u w=10u l=1u
X849 a_65522_31016# a_50810_30900# S2P S2P nfet_06v0 ad=1.25p pd=5.5u as=2.2p ps=10.88u w=5u l=1u
X850 a_18066_34416# a_17866_34300# S2P S2P pfet_06v0 ad=2.5p pd=10.5u as=4.4p ps=20.88u w=10u l=1u
X851 a_1918_30900# a_1918_30900# S2P S2P nfet_06v0 ad=0.44p pd=2.88u as=0.44p ps=2.88u w=1u l=1u
X852 a_50056_39576# a_50056_39576# a_52464_39692# S2P nfet_06v0 ad=2.2p pd=10.88u as=2.2p ps=10.88u w=5u l=1u
X853 S2P a_59506_48376# a_12670_74260# S2P nfet_06v0 ad=1.3p pd=5.52u as=1.3p ps=5.52u w=5u l=1u
X854 a_25530_74376# a_25618_74260# S2P S2P pfet_06v0 ad=1.32p pd=6.88u as=1.32p ps=6.88u w=3u l=1u
X855 a_67552_21950# a_65888_21834# S2P S2P nfet_06v0 ad=0.175p pd=1.2u as=0.308p ps=2.28u w=0.7u l=1u
X856 a_22790_25616# a_23090_25616# a_37782_25732# S2P pfet_06v0 ad=4.4p pd=20.88u as=2.5p ps=10.5u w=10u l=1u
X857 a_3882_65848# a_2258_69132# S2P S2P nfet_06v0 ad=0.25p pd=1.5u as=0.44p ps=2.88u w=1u l=1u
X858 a_47670_8260# a_43922_8144# a_46578_4860# S2P pfet_06v0 ad=2.2p pd=10.88u as=2.2p ps=10.88u w=5u l=1u
X859 a_29224_56936# a_23090_60336# a_33634_60452# S2P pfet_06v0 ad=4.4p pd=20.88u as=2.5p ps=10.5u w=10u l=1u
X860 a_4914_57052# a_6006_60452# S2P S2P pfet_06v0 ad=2.2p pd=10.88u as=2.2p ps=10.88u w=5u l=1u
X861 a_66026_16940# a_50418_16940# a_66226_17056# S2P pfet_06v0 ad=4.4p pd=20.88u as=2.5p ps=10.5u w=10u l=1u
X862 a_1918_39576# a_2218_39576# a_14316_39692# S2P nfet_06v0 ad=2.2p pd=10.88u as=1.25p ps=5.5u w=5u l=1u
X863 a_54406_48376# a_50078_48260# a_55138_48376# S2P nfet_06v0 ad=2.2p pd=10.88u as=1.25p ps=5.5u w=5u l=1u
X864 a_33726_69248# a_34314_65848# S2P S2P nfet_06v0 ad=0.65p pd=3.02u as=1.1p ps=5.88u w=2.5u l=1u
X865 a_43582_4744# a_43882_4744# a_55980_4860# S2P nfet_06v0 ad=2.2p pd=10.88u as=1.25p ps=5.5u w=5u l=1u
X866 a_57282_13656# a_50418_16940# a_58922_17056# S2P pfet_06v0 ad=2.2p pd=10.88u as=1.3p ps=5.52u w=5u l=1u
X867 S2P a_34842_34416# a_33202_31016# S2P pfet_06v0 ad=2.2p pd=10.88u as=1.3p ps=5.52u w=5u l=1u
X868 a_44238_48376# a_35426_48376# S2P S2P nfet_06v0 ad=1.3p pd=5.52u as=2.2p ps=10.88u w=5u l=1u
X869 a_10800_22332# a_2218_22216# a_11820_22332# S2P nfet_06v0 ad=2.2p pd=10.88u as=1.25p ps=5.5u w=5u l=1u
X870 a_8530_51776# a_1918_48260# a_11346_48376# S2P nfet_06v0 ad=1.1p pd=5.88u as=0.65p ps=3.02u w=2.5u l=1u
X871 a_56170_13656# a_58922_17056# S2P S2P pfet_06v0 ad=1.3p pd=5.52u as=2.2p ps=10.88u w=5u l=1u
X872 a_64528_7674# a_64528_7674# w_64222_7494# w_64222_7494# pfet_06v0 ad=0.52p pd=2.52u as=0.88p ps=4.88u w=2u l=1u
X873 a_2458_25732# a_2258_25616# a_3270_25732# S2P pfet_06v0 ad=4.4p pd=20.88u as=2.5p ps=10.5u w=10u l=1u
X874 a_40322_34300# a_25998_30900# a_41442_31016# S2P nfet_06v0 ad=2.2p pd=10.88u as=1.25p ps=5.5u w=5u l=1u
X875 a_31058_13656# a_26730_13540# S2P S2P nfet_06v0 ad=1.25p pd=5.5u as=2.2p ps=10.88u w=5u l=1u
X876 a_55578_17056# a_50118_16940# S2P S2P pfet_06v0 ad=2.5p pd=10.5u as=4.4p ps=20.88u w=10u l=1u
X877 a_25746_57052# a_26838_60452# S2P S2P pfet_06v0 ad=2.2p pd=10.88u as=2.2p ps=10.88u w=5u l=1u
X878 a_54516_57052# a_48482_60452# S2P S2P pfet_06v0 ad=0.308p pd=2.28u as=0.308p ps=2.28u w=0.7u l=20u
X879 a_68484_25262# a_67772_25262# w_64222_24966# w_64222_24966# pfet_05v0 ad=0.8052p pd=4.54u as=0.8052p ps=4.54u w=1.83u l=0.5u
X880 a_10234_13656# a_1918_13540# a_9646_17056# S2P nfet_06v0 ad=0.65p pd=3.02u as=1.1p ps=5.88u w=2.5u l=1u
X881 a_11878_17056# a_2258_16940# a_8010_13656# S2P pfet_06v0 ad=1.3p pd=5.52u as=2.2p ps=10.88u w=5u l=1u
X882 a_51430_34416# a_50118_34300# S2P S2P pfet_06v0 ad=2.5p pd=10.5u as=4.4p ps=20.88u w=10u l=1u
X883 a_56690_34416# a_58394_31016# S2P S2P nfet_06v0 ad=0.65p pd=3.02u as=0.65p ps=3.02u w=2.5u l=1u
X884 a_30686_34416# a_33002_30900# a_33726_34416# S2P pfet_06v0 ad=4.4p pd=20.88u as=2.6p ps=10.52u w=10u l=1u
X885 a_2218_39576# a_2218_39576# S2P S2P nfet_06v0 ad=0.44p pd=2.88u as=0.44p ps=2.88u w=1u l=1u
X886 a_30326_65848# a_31890_65732# a_32090_65848# S2P nfet_06v0 ad=2.2p pd=10.88u as=1.3p ps=5.52u w=5u l=1u
X887 a_54516_4860# a_48060_4860# S2P S2P nfet_06v0 ad=0.44p pd=2.88u as=0.44p ps=2.88u w=1u l=1u
X888 a_14778_74376# a_14866_74260# S2P S2P pfet_06v0 ad=1.32p pd=6.88u as=1.32p ps=6.88u w=3u l=1u
X889 a_33202_13656# a_34842_17056# S2P S2P pfet_06v0 ad=1.3p pd=5.52u as=1.3p ps=5.52u w=5u l=1u
X890 a_45846_57052# a_47670_60452# S2P S2P pfet_06v0 ad=2.2p pd=10.88u as=2.2p ps=10.88u w=5u l=1u
X891 a_30888_39692# a_22750_39576# S2P S2P nfet_06v0 ad=1.25p pd=5.5u as=2.2p ps=10.88u w=5u l=1u
X892 a_37782_43092# a_22790_42976# S2P S2P pfet_06v0 ad=2.5p pd=10.5u as=4.4p ps=20.88u w=10u l=1u
X893 a_67772_42622# a_64528_42506# S2P S2P nfet_05v0 ad=0.5808p pd=3.52u as=0.5808p ps=3.52u w=1.32u l=0.6u
X894 a_32090_48376# a_34842_51776# S2P S2P pfet_06v0 ad=1.3p pd=5.52u as=2.2p ps=10.88u w=5u l=1u
X895 a_1918_48260# a_2258_51660# a_2158_51776# S2P pfet_06v0 ad=4.4p pd=20.88u as=2.5p ps=10.5u w=10u l=1u
X896 a_46046_25732# S4P a_44122_25732# S2P pfet_06v0 ad=4.4p pd=20.88u as=4.4p ps=20.88u w=10u l=1u
X897 a_30686_17056# a_26338_16940# a_31498_17056# S2P pfet_06v0 ad=4.4p pd=20.88u as=2.5p ps=10.5u w=10u l=1u
X898 a_44238_65848# a_35958_69248# S2P S2P pfet_06v0 ad=2.6p pd=10.52u as=4.4p ps=20.88u w=10u l=1u
X899 a_69538_5686# a_69626_5570# a_64528_7674# S2P nfet_06v0 ad=1.0912p pd=5.84u as=0.6448p ps=3u w=2.48u l=1u
X900 a_1958_16940# a_2258_16940# a_5194_17056# S2P pfet_06v0 ad=4.4p pd=20.88u as=2.5p ps=10.5u w=10u l=1u
X901 S2P a_34314_65848# a_32610_69248# S2P nfet_06v0 ad=0.65p pd=3.02u as=0.65p ps=3.02u w=2.5u l=1u
X902 S2P a_10762_17056# a_9122_13656# S2P pfet_06v0 ad=1.3p pd=5.52u as=1.3p ps=5.52u w=5u l=1u
X903 a_3270_43092# a_1958_42976# S2P S2P pfet_06v0 ad=2.5p pd=10.5u as=4.4p ps=20.88u w=10u l=1u
X904 a_16950_8260# a_1958_8144# S2P S2P pfet_06v0 ad=2.5p pd=10.5u as=4.4p ps=20.88u w=10u l=1u
X905 a_36180_39692# a_23090_42976# S2P S2P nfet_06v0 ad=0.25p pd=1.5u as=0.44p ps=2.88u w=1u l=1u
X906 a_8010_65848# a_7810_65732# a_6246_65848# S2P nfet_06v0 ad=1.3p pd=5.52u as=2.2p ps=10.88u w=5u l=1u
X907 a_33684_22332# a_25014_22332# cap_mim_2f0_m4m5_noshield c_width=20u c_length=10u
X908 a_34842_51776# a_26338_51660# a_33202_48376# S2P pfet_06v0 ad=1.3p pd=5.52u as=2.2p ps=10.88u w=5u l=1u
X909 a_16242_51660# a_1918_48260# a_17362_48376# S2P nfet_06v0 ad=2.2p pd=10.88u as=1.25p ps=5.5u w=5u l=1u
X910 a_56170_13656# a_50418_16940# a_60038_17056# S2P pfet_06v0 ad=2.2p pd=10.88u as=1.3p ps=5.52u w=5u l=1u
X911 a_44814_39692# a_43582_39576# S2P S2P nfet_06v0 ad=1.25p pd=5.5u as=2.2p ps=10.88u w=5u l=1u
X912 a_8530_69248# a_20158_65848# cap_mim_2f0_m4m5_noshield c_width=20u c_length=10u
X913 a_64528_42506# a_65638_40402# a_65550_40518# S2P nfet_06v0 ad=0.6448p pd=3u as=1.0912p ps=5.84u w=2.48u l=1u
X914 S2P a_11878_51776# a_20158_48376# S2P pfet_06v0 ad=2.6p pd=10.52u as=2.6p ps=10.52u w=10u l=1u
X915 S2P a_58922_51776# a_57282_48376# S2P pfet_06v0 ad=1.3p pd=5.52u as=1.3p ps=5.52u w=5u l=1u
X916 a_16950_25732# a_1958_25616# S2P S2P pfet_06v0 ad=2.5p pd=10.5u as=4.4p ps=20.88u w=10u l=1u
X917 a_12802_60452# a_1958_60336# S2P S2P pfet_06v0 ad=2.5p pd=10.5u as=4.4p ps=20.88u w=10u l=1u
X918 a_32610_51776# a_34314_48376# S2P S2P nfet_06v0 ad=0.65p pd=3.02u as=0.65p ps=3.02u w=2.5u l=1u
X919 a_50056_22216# a_43922_25616# a_54466_25732# S2P pfet_06v0 ad=4.4p pd=20.88u as=2.5p ps=10.5u w=10u l=1u
X920 a_64438_39310# a_65888_39194# S2P S2P nfet_06v0 ad=0.5456p pd=3.36u as=0.5456p ps=3.36u w=1.24u l=1u
X921 a_16242_34300# a_16242_34300# a_17866_34300# S2P pfet_06v0 ad=4.4p pd=20.88u as=4.4p ps=20.88u w=10u l=1u
X922 a_52464_4860# a_43882_4744# a_53484_4860# S2P nfet_06v0 ad=2.2p pd=10.88u as=1.25p ps=5.5u w=5u l=1u
X923 a_65888_39194# a_65888_39194# a_68152_39310# S2P nfet_06v0 ad=0.308p pd=2.28u as=0.175p ps=1.2u w=0.7u l=1u
X924 a_51720_4860# a_43582_4744# S2P S2P nfet_06v0 ad=1.25p pd=5.5u as=2.2p ps=10.88u w=5u l=1u
X925 a_35958_69248# a_39778_65732# a_35426_65848# S2P nfet_06v0 ad=1.1p pd=5.88u as=1.1p ps=5.88u w=2.5u l=1u
X926 a_43782_39692# a_43582_39576# S2P S2P nfet_06v0 ad=1.25p pd=5.5u as=2.2p ps=10.88u w=5u l=1u
X927 a_54406_31016# a_55970_30900# a_56170_31016# S2P nfet_06v0 ad=2.2p pd=10.88u as=1.3p ps=5.52u w=5u l=1u
X928 a_32090_48376# a_26338_51660# a_35958_51776# S2P pfet_06v0 ad=2.2p pd=10.88u as=1.3p ps=5.52u w=5u l=1u
X929 a_46578_22332# a_47670_25732# S2P S2P pfet_06v0 ad=2.2p pd=10.88u as=2.2p ps=10.88u w=5u l=1u
X930 a_1958_34300# a_2258_34300# a_3882_31016# S2P nfet_06v0 ad=0.44p pd=2.88u as=0.25p ps=1.5u w=1u l=1u
X931 a_58922_34416# a_50418_34300# a_57282_31016# S2P pfet_06v0 ad=1.3p pd=5.52u as=2.2p ps=10.88u w=5u l=1u
X932 a_50118_16940# a_50418_16940# a_52042_13656# S2P nfet_06v0 ad=0.44p pd=2.88u as=0.25p ps=1.5u w=1u l=1u
X933 a_23050_56936# a_23090_60336# a_34746_60452# S2P pfet_06v0 ad=4.4p pd=20.88u as=2.5p ps=10.5u w=10u l=1u
X934 a_2118_39692# a_1918_39576# S2P S2P nfet_06v0 ad=1.25p pd=5.5u as=2.2p ps=10.88u w=5u l=1u
X935 a_27228_39692# a_29886_42976# a_27650_43092# S2P pfet_06v0 ad=2.2p pd=10.88u as=2.2p ps=10.88u w=5u l=1u
X936 a_68318_65848# a_59506_65848# S2P S2P nfet_06v0 ad=2.2p pd=10.88u as=1.3p ps=5.52u w=5u l=1u
X937 a_67772_25262# a_64528_25146# S2P S2P nfet_05v0 ad=0.5808p pd=3.52u as=0.5808p ps=3.52u w=1.32u l=0.6u
X938 a_64438_40518# a_65888_39194# S2P S2P nfet_06v0 ad=0.5456p pd=3.36u as=0.5456p ps=3.36u w=1.24u l=1u
X939 a_68318_13656# a_59506_13656# S2P S2P nfet_06v0 ad=1.3p pd=5.52u as=2.2p ps=10.88u w=5u l=1u
X940 a_32610_17056# a_25998_13540# a_35426_13656# S2P nfet_06v0 ad=1.1p pd=5.88u as=0.65p ps=3.02u w=2.5u l=1u
X941 a_2158_8260# a_1958_8144# S2P S2P pfet_06v0 ad=2.5p pd=10.5u as=4.4p ps=20.88u w=10u l=1u
X942 a_9646_34416# a_1918_30900# a_10234_31016# S2P nfet_06v0 ad=1.1p pd=5.88u as=0.65p ps=3.02u w=2.5u l=1u
X943 S2P a_10234_48376# a_9646_51776# S2P nfet_06v0 ad=0.65p pd=3.02u as=0.65p ps=3.02u w=2.5u l=1u
X944 a_6606_17056# a_7810_13540# a_8530_17056# S2P pfet_06v0 ad=4.4p pd=20.88u as=2.6p ps=10.52u w=10u l=1u
X945 a_57282_13656# a_57082_13540# a_54406_13656# S2P nfet_06v0 ad=1.3p pd=5.52u as=2.2p ps=10.88u w=5u l=1u
X946 a_2258_42976# a_2258_42976# a_16380_39692# S2P nfet_06v0 ad=0.44p pd=2.88u as=0.25p ps=1.5u w=1u l=1u
X947 a_58614_60452# a_43622_60336# S2P S2P pfet_06v0 ad=2.5p pd=10.5u as=4.4p ps=20.88u w=10u l=1u
X948 a_6818_60452# a_8392_56936# a_6396_57052# S2P nfet_06v0 ad=1.1p pd=5.88u as=1.1p ps=5.88u w=2.5u l=1u
X949 a_54466_43092# a_43622_42976# S2P S2P pfet_06v0 ad=2.5p pd=10.5u as=4.4p ps=20.88u w=10u l=1u
X950 a_32090_65848# a_34842_69248# S2P S2P pfet_06v0 ad=1.3p pd=5.52u as=2.2p ps=10.88u w=5u l=1u
X951 a_32090_48376# a_34842_51776# S2P S2P pfet_06v0 ad=1.3p pd=5.52u as=1.3p ps=5.52u w=5u l=1u
X952 a_1918_65732# a_2258_69132# a_2158_69248# S2P pfet_06v0 ad=4.4p pd=20.88u as=2.5p ps=10.5u w=10u l=1u
X953 a_11346_13656# a_1918_13540# a_8530_17056# S2P nfet_06v0 ad=0.65p pd=3.02u as=1.1p ps=5.88u w=2.5u l=1u
X954 a_26496_4860# a_29886_8144# a_26838_8260# S2P pfet_06v0 ad=2.2p pd=10.88u as=2.2p ps=10.88u w=5u l=1u
X955 a_50418_34300# a_50418_34300# S2P S2P pfet_06v0 ad=0.88p pd=4.88u as=0.88p ps=4.88u w=2u l=1u
X956 a_43622_25616# a_43922_25616# a_57012_22332# S2P nfet_06v0 ad=0.44p pd=2.88u as=0.25p ps=1.5u w=1u l=1u
X957 a_58922_34416# a_63858_30900# a_58394_31016# S2P nfet_06v0 ad=1.1p pd=5.88u as=1.1p ps=5.88u w=2.5u l=1u
X958 a_67772_42622# a_64528_42506# w_64222_42326# w_64222_42326# pfet_05v0 ad=0.8052p pd=4.54u as=0.8052p ps=4.54u w=1.83u l=0.5u
X959 a_67286_13656# a_66266_13656# S2P S2P nfet_06v0 ad=1.25p pd=5.5u as=2.2p ps=10.88u w=5u l=1u
X960 a_2418_39692# a_2218_39576# a_3150_39692# S2P nfet_06v0 ad=2.2p pd=10.88u as=1.25p ps=5.5u w=5u l=1u
X961 a_16542_74376# a_16630_74260# S2P S2P pfet_06v0 ad=1.32p pd=6.88u as=1.32p ps=6.88u w=3u l=1u
X962 a_52542_8260# a_52342_8144# S2P S2P pfet_06v0 ad=2.5p pd=10.5u as=4.4p ps=20.88u w=10u l=1u
X963 S2P a_64526_56900# a_66722_56900# S2P pfet_06v0 ad=1.32p pd=6.88u as=1.32p ps=6.88u w=3u l=1u
X964 a_26338_34300# a_26338_34300# a_28994_31016# S2P nfet_06v0 ad=0.44p pd=2.88u as=0.25p ps=1.5u w=1u l=1u
X965 a_69538_40518# a_69626_40402# a_64528_42506# S2P nfet_06v0 ad=1.0912p pd=5.84u as=0.6448p ps=3u w=2.48u l=1u
X966 a_32610_34416# a_34314_31016# S2P S2P nfet_06v0 ad=0.65p pd=3.02u as=1.1p ps=5.88u w=2.5u l=1u
X967 S2P a_23422_74260# a_25618_74260# S2P pfet_06v0 ad=1.32p pd=6.88u as=1.32p ps=6.88u w=3u l=1u
X968 a_6246_13656# a_1918_13540# a_5946_13656# S2P nfet_06v0 ad=2.2p pd=10.88u as=1.25p ps=5.5u w=5u l=1u
X969 a_64438_21950# a_65888_21834# S2P S2P nfet_06v0 ad=0.5456p pd=3.36u as=0.5456p ps=3.36u w=1.24u l=1u
X970 a_67394_23158# a_64528_25146# a_68794_23158# S2P nfet_06v0 ad=0.88p pd=4.88u as=0.5p ps=2.5u w=2u l=1u
X971 a_50810_48260# a_50078_48260# a_51010_48376# S2P nfet_06v0 ad=2.2p pd=10.88u as=1.25p ps=5.5u w=5u l=1u
X972 a_34842_69248# a_26338_69132# a_33202_65848# S2P pfet_06v0 ad=1.3p pd=5.52u as=2.2p ps=10.88u w=5u l=1u
X973 a_40322_34300# a_40322_34300# a_41946_34300# S2P pfet_06v0 ad=4.4p pd=20.88u as=4.4p ps=20.88u w=10u l=1u
X974 a_9122_31016# a_10762_34416# S2P S2P pfet_06v0 ad=1.3p pd=5.52u as=2.2p ps=10.88u w=5u l=1u
X975 a_23250_39692# a_23050_39576# a_23982_39692# S2P nfet_06v0 ad=2.2p pd=10.88u as=1.25p ps=5.5u w=5u l=1u
X976 a_65888_21834# a_65888_21834# a_68152_21950# S2P nfet_06v0 ad=0.308p pd=2.28u as=0.175p ps=1.2u w=0.7u l=1u
X977 S2P a_11878_69248# a_20158_65848# S2P pfet_06v0 ad=2.6p pd=10.52u as=2.6p ps=10.52u w=10u l=1u
X978 a_43582_22216# a_43882_22216# a_55980_22332# S2P nfet_06v0 ad=2.2p pd=10.88u as=1.25p ps=5.5u w=5u l=1u
X979 S2P a_58922_69248# a_57282_65848# S2P pfet_06v0 ad=1.3p pd=5.52u as=1.3p ps=5.52u w=5u l=1u
X980 a_6396_57052# a_9054_60336# a_6818_60452# S2P pfet_06v0 ad=2.2p pd=10.88u as=2.2p ps=10.88u w=5u l=1u
X981 a_64528_7674# a_65638_5570# a_65550_5686# S2P nfet_06v0 ad=0.6448p pd=3u as=1.0912p ps=5.84u w=2.48u l=1u
X982 a_33634_25732# a_22790_25616# S2P S2P pfet_06v0 ad=2.5p pd=10.5u as=4.4p ps=20.88u w=10u l=1u
X983 a_54106_13656# a_50810_13540# S2P S2P nfet_06v0 ad=1.25p pd=5.5u as=2.2p ps=10.88u w=5u l=1u
X984 a_4382_43092# S3P a_2458_43092# S2P pfet_06v0 ad=4.4p pd=20.88u as=4.4p ps=20.88u w=10u l=1u
X985 a_53354_51776# a_50118_51660# S2P S2P pfet_06v0 ad=2.5p pd=10.5u as=4.4p ps=20.88u w=10u l=1u
X986 a_50718_42976# a_43882_39576# a_51720_39692# S2P nfet_06v0 ad=2.2p pd=10.88u as=1.25p ps=5.5u w=5u l=1u
X987 a_9122_65848# a_8922_65732# a_6246_65848# S2P nfet_06v0 ad=1.3p pd=5.52u as=2.2p ps=10.88u w=5u l=1u
X988 a_43922_8144# a_43922_8144# S2P S2P pfet_06v0 ad=0.88p pd=4.88u as=0.88p ps=4.88u w=2u l=1u
X989 a_64438_23158# a_65888_21834# S2P S2P nfet_06v0 ad=0.5456p pd=3.36u as=0.5456p ps=3.36u w=1.24u l=1u
X990 a_32090_48376# a_31890_48260# a_30326_48376# S2P nfet_06v0 ad=1.3p pd=5.52u as=2.2p ps=10.88u w=5u l=1u
X991 a_2650_65732# a_1918_65732# a_2850_65848# S2P nfet_06v0 ad=2.2p pd=10.88u as=1.25p ps=5.5u w=5u l=1u
X992 a_26238_34416# a_26038_34300# S2P S2P pfet_06v0 ad=2.5p pd=10.5u as=4.4p ps=20.88u w=10u l=1u
X993 S2P a_10234_13656# a_9646_17056# S2P nfet_06v0 ad=1.1p pd=5.88u as=0.65p ps=3.02u w=2.5u l=1u
X994 a_43582_56936# a_43922_60336# a_56690_60452# S2P pfet_06v0 ad=4.4p pd=20.88u as=2.5p ps=10.5u w=10u l=1u
X995 a_13914_60452# a_1958_60336# S2P S2P pfet_06v0 ad=2.5p pd=10.5u as=4.4p ps=20.88u w=10u l=1u
X996 a_32090_65848# a_26338_69132# a_35958_69248# S2P pfet_06v0 ad=2.2p pd=10.88u as=1.3p ps=5.52u w=5u l=1u
X997 a_22750_22216# a_23050_22216# a_35148_22332# S2P nfet_06v0 ad=2.2p pd=10.88u as=1.25p ps=5.5u w=5u l=1u
X998 a_43882_22216# a_43922_25616# a_55578_25732# S2P pfet_06v0 ad=4.4p pd=20.88u as=2.5p ps=10.5u w=10u l=1u
X999 a_34842_51776# a_39778_48260# a_34314_48376# S2P nfet_06v0 ad=1.1p pd=5.88u as=1.1p ps=5.88u w=2.5u l=1u
X1000 a_34314_48376# a_40322_51660# a_34842_51776# S2P pfet_06v0 ad=2.2p pd=10.88u as=2.2p ps=10.88u w=5u l=1u
X1001 a_53074_13656# a_50418_16940# S2P S2P nfet_06v0 ad=0.25p pd=1.5u as=0.44p ps=2.88u w=1u l=1u
X1002 a_42186_48376# a_25998_48260# a_43206_48376# S2P nfet_06v0 ad=2.2p pd=10.88u as=1.25p ps=5.5u w=5u l=1u
X1003 a_2258_51660# a_2258_51660# a_4914_48376# S2P nfet_06v0 ad=0.44p pd=2.88u as=0.25p ps=1.5u w=1u l=1u
X1004 a_2218_4744# a_2258_8144# a_13914_8260# S2P pfet_06v0 ad=4.4p pd=20.88u as=2.5p ps=10.5u w=10u l=1u
X1005 a_26838_8260# a_29224_4744# a_26496_4860# S2P nfet_06v0 ad=1.1p pd=5.88u as=1.1p ps=5.88u w=2.5u l=1u
X1006 a_46858_43092# S1N a_44122_43092# S2P pfet_06v0 ad=4.4p pd=20.88u as=4.4p ps=20.88u w=10u l=1u
X1007 a_3270_51776# a_1958_51660# S2P S2P pfet_06v0 ad=2.5p pd=10.5u as=4.4p ps=20.88u w=10u l=1u
X1008 a_54406_31016# a_57082_30900# a_57282_31016# S2P nfet_06v0 ad=2.2p pd=10.88u as=1.3p ps=5.52u w=5u l=1u
X1009 a_30888_4860# a_22750_4744# S2P S2P nfet_06v0 ad=1.25p pd=5.5u as=2.2p ps=10.88u w=5u l=1u
X1010 a_22750_56936# a_23090_60336# a_35858_60452# S2P pfet_06v0 ad=4.4p pd=20.88u as=2.5p ps=10.5u w=10u l=1u
X1011 a_10056_57052# a_1918_56936# S2P S2P nfet_06v0 ad=1.25p pd=5.5u as=2.2p ps=10.88u w=5u l=1u
X1012 a_12852_39692# a_6396_39692# S2P S2P nfet_06v0 ad=0.44p pd=2.88u as=0.44p ps=2.88u w=1u l=1u
X1013 a_32090_65848# a_34842_69248# S2P S2P pfet_06v0 ad=1.3p pd=5.52u as=1.3p ps=5.52u w=5u l=1u
X1014 S2P a_11346_65848# a_20158_65848# S2P nfet_06v0 ad=1.3p pd=5.52u as=1.3p ps=5.52u w=5u l=1u
X1015 a_15348_4860# a_2258_8144# S2P S2P nfet_06v0 ad=0.25p pd=1.5u as=0.44p ps=2.88u w=1u l=1u
X1016 a_39778_48260# a_39778_48260# a_42186_48376# S2P nfet_06v0 ad=2.2p pd=10.88u as=2.2p ps=10.88u w=5u l=1u
X1017 a_44082_4860# a_43882_4744# a_44814_4860# S2P nfet_06v0 ad=2.2p pd=10.88u as=1.25p ps=5.5u w=5u l=1u
X1018 a_58044_22332# a_43922_25616# S2P S2P nfet_06v0 ad=0.25p pd=1.5u as=0.44p ps=2.88u w=1u l=1u
X1019 S2P a_34314_13656# a_33726_17056# S2P nfet_06v0 ad=0.65p pd=3.02u as=0.65p ps=3.02u w=2.5u l=1u
X1020 a_12852_22332# a_6818_25732# S2P S2P pfet_06v0 ad=0.308p pd=2.28u as=0.308p ps=2.28u w=0.7u l=20u
X1021 a_4182_39692# S3P a_2418_39692# S2P nfet_06v0 ad=2.2p pd=10.88u as=2.2p ps=10.88u w=5u l=1u
X1022 a_26038_69132# a_26338_69132# a_27962_65848# S2P nfet_06v0 ad=0.44p pd=2.88u as=0.25p ps=1.5u w=1u l=1u
X1023 a_58394_31016# a_64402_34300# a_58922_34416# S2P pfet_06v0 ad=2.2p pd=10.88u as=2.2p ps=10.88u w=5u l=1u
X1024 a_58394_13656# a_50078_13540# a_57806_17056# S2P nfet_06v0 ad=0.65p pd=3.02u as=1.1p ps=5.88u w=2.5u l=1u
X1025 a_31632_4860# a_23050_4744# a_32652_4860# S2P nfet_06v0 ad=2.2p pd=10.88u as=1.25p ps=5.5u w=5u l=1u
X1026 a_23050_56936# a_23050_56936# S2P S2P nfet_06v0 ad=0.44p pd=2.88u as=0.44p ps=2.88u w=1u l=1u
X1027 a_6978_13656# a_2650_13540# S2P S2P nfet_06v0 ad=1.25p pd=5.5u as=2.2p ps=10.88u w=5u l=1u
X1028 a_23290_43092# a_23090_42976# a_24102_43092# S2P pfet_06v0 ad=4.4p pd=20.88u as=2.5p ps=10.5u w=10u l=1u
X1029 a_64528_7674# a_64528_7674# w_64222_7494# w_64222_7494# pfet_06v0 ad=0.52p pd=2.52u as=0.52p ps=2.52u w=2u l=1u
X1030 a_52042_48376# a_50418_51660# S2P S2P nfet_06v0 ad=0.25p pd=1.5u as=0.44p ps=2.88u w=1u l=1u
X1031 a_55578_43092# a_43622_42976# S2P S2P pfet_06v0 ad=2.5p pd=10.5u as=4.4p ps=20.88u w=10u l=1u
X1032 a_9122_31016# a_10762_34416# S2P S2P pfet_06v0 ad=1.3p pd=5.52u as=1.3p ps=5.52u w=5u l=1u
X1033 a_22990_43092# a_22790_42976# S2P S2P pfet_06v0 ad=2.5p pd=10.5u as=4.4p ps=20.88u w=10u l=1u
X1034 a_9646_69248# a_10234_65848# S2P S2P nfet_06v0 ad=0.65p pd=3.02u as=0.65p ps=3.02u w=2.5u l=1u
X1035 a_26026_25732# a_25546_22216# a_23290_25732# S2P pfet_06v0 ad=4.4p pd=20.88u as=4.4p ps=20.88u w=10u l=1u
X1036 a_50118_34300# a_50418_34300# a_53354_34416# S2P pfet_06v0 ad=4.4p pd=20.88u as=2.5p ps=10.5u w=10u l=1u
X1037 a_9646_17056# a_10234_13656# S2P S2P nfet_06v0 ad=0.65p pd=3.02u as=1.1p ps=5.88u w=2.5u l=1u
X1038 a_20158_48376# a_11346_48376# S2P S2P nfet_06v0 ad=2.2p pd=10.88u as=1.3p ps=5.52u w=5u l=1u
X1039 a_33684_4860# a_27650_8260# S2P S2P pfet_06v0 ad=0.308p pd=2.28u as=0.308p ps=2.28u w=0.7u l=20u
X1040 a_11346_13656# a_16242_16940# a_11878_17056# S2P pfet_06v0 ad=2.2p pd=10.88u as=2.2p ps=10.88u w=5u l=1u
X1041 a_19990_34416# a_1958_34300# S2P S2P pfet_06v0 ad=2.5p pd=10.5u as=4.4p ps=20.88u w=10u l=1u
X1042 a_6606_34416# a_8922_30900# a_9646_34416# S2P pfet_06v0 ad=4.4p pd=20.88u as=2.6p ps=10.52u w=10u l=1u
X1043 a_10678_25616# a_2258_25616# a_10878_25732# S2P pfet_06v0 ad=4.4p pd=20.88u as=2.5p ps=10.5u w=10u l=1u
X1044 a_25214_8260# a_26496_4860# S2P S2P nfet_06v0 ad=1.1p pd=5.88u as=1.1p ps=5.88u w=2.5u l=1u
X1045 a_53354_69248# a_50118_69132# S2P S2P pfet_06v0 ad=2.5p pd=10.5u as=4.4p ps=20.88u w=10u l=1u
X1046 a_4382_60452# a_12852_57052# cap_mim_2f0_m4m5_noshield c_width=20u c_length=10u
X1047 a_46578_57052# S2N a_44082_57052# S2P nfet_06v0 ad=2.2p pd=10.88u as=2.2p ps=10.88u w=5u l=1u
X1048 a_59506_48376# a_64402_51660# a_60038_51776# S2P pfet_06v0 ad=2.2p pd=10.88u as=2.2p ps=10.88u w=5u l=1u
X1049 a_57012_57052# a_43922_60336# S2P S2P nfet_06v0 ad=0.25p pd=1.5u as=0.44p ps=2.88u w=1u l=1u
X1050 a_14316_22332# a_1918_22216# S2P S2P nfet_06v0 ad=1.25p pd=5.5u as=2.2p ps=10.88u w=5u l=1u
X1051 a_30686_51776# a_31890_48260# a_32610_51776# S2P pfet_06v0 ad=4.4p pd=20.88u as=2.6p ps=10.52u w=10u l=1u
X1052 a_34746_25732# a_22790_25616# S2P S2P pfet_06v0 ad=2.5p pd=10.5u as=4.4p ps=20.88u w=10u l=1u
X1053 a_63858_13540# a_50418_16940# a_68150_17056# S2P pfet_06v0 ad=4.4p pd=20.88u as=2.5p ps=10.5u w=10u l=1u
X1054 a_6396_4860# a_2218_4744# a_4382_8260# S2P nfet_06v0 ad=1.1p pd=5.88u as=1.1p ps=5.88u w=2.5u l=1u
X1055 a_4182_22332# a_6006_25732# S2P S2P pfet_06v0 ad=2.2p pd=10.88u as=2.2p ps=10.88u w=5u l=1u
X1056 S2P a_3382_74260# a_6810_74376# S2P nfet_06v0 ad=0.44p pd=2.88u as=0.25p ps=1.5u w=1u l=1u
X1057 a_34314_65848# a_40322_69132# a_34842_69248# S2P pfet_06v0 ad=2.2p pd=10.88u as=2.2p ps=10.88u w=5u l=1u
X1058 a_54466_51776# a_50118_51660# S2P S2P pfet_06v0 ad=2.5p pd=10.5u as=4.4p ps=20.88u w=10u l=1u
X1059 a_68318_13656# a_56170_13656# cap_mim_2f0_m4m5_noshield c_width=20u c_length=10u
X1060 S2P a_60038_51776# a_12670_74260# S2P pfet_06v0 ad=2.6p pd=10.52u as=2.6p ps=10.52u w=10u l=1u
X1061 a_2650_30900# a_2258_34300# a_3270_34416# S2P pfet_06v0 ad=4.4p pd=20.88u as=2.5p ps=10.5u w=10u l=1u
X1062 a_2418_4860# a_2218_4744# a_2118_4860# S2P nfet_06v0 ad=2.2p pd=10.88u as=1.25p ps=5.5u w=5u l=1u
X1063 a_5946_48376# a_2650_48260# S2P S2P nfet_06v0 ad=1.25p pd=5.5u as=2.2p ps=10.88u w=5u l=1u
X1064 a_56170_13656# a_55970_13540# a_54406_13656# S2P nfet_06v0 ad=1.3p pd=5.52u as=2.2p ps=10.88u w=5u l=1u
X1065 a_30026_65848# a_26730_65732# S2P S2P nfet_06v0 ad=1.25p pd=5.5u as=2.2p ps=10.88u w=5u l=1u
X1066 a_31710_8260# a_31510_8144# S2P S2P pfet_06v0 ad=2.5p pd=10.5u as=4.4p ps=20.88u w=10u l=1u
X1067 S2P a_58394_65848# a_57806_69248# S2P nfet_06v0 ad=1.1p pd=5.88u as=0.65p ps=3.02u w=2.5u l=1u
X1068 S2P a_35426_31016# a_44238_31016# S2P nfet_06v0 ad=1.3p pd=5.52u as=1.3p ps=5.52u w=5u l=1u
X1069 a_2258_8144# a_2258_8144# a_16380_4860# S2P nfet_06v0 ad=0.44p pd=2.88u as=0.25p ps=1.5u w=1u l=1u
X1070 S2P a_10234_65848# a_8530_69248# S2P nfet_06v0 ad=1.1p pd=5.88u as=0.65p ps=3.02u w=2.5u l=1u
X1071 S2P a_10234_13656# a_8530_17056# S2P nfet_06v0 ad=0.65p pd=3.02u as=0.65p ps=3.02u w=2.5u l=1u
X1072 a_25014_22332# a_26838_25732# S2P S2P pfet_06v0 ad=2.2p pd=10.88u as=2.2p ps=10.88u w=5u l=1u
X1073 a_6006_25732# a_8392_22216# a_5664_22332# S2P nfet_06v0 ad=1.1p pd=5.88u as=1.1p ps=5.88u w=2.5u l=1u
X1074 a_55980_57052# a_43582_56936# S2P S2P nfet_06v0 ad=1.25p pd=5.5u as=2.2p ps=10.88u w=5u l=1u
X1075 a_3270_69248# a_1958_69132# S2P S2P pfet_06v0 ad=2.5p pd=10.5u as=4.4p ps=20.88u w=10u l=1u
X1076 a_15026_60452# a_1958_60336# S2P S2P pfet_06v0 ad=2.5p pd=10.5u as=4.4p ps=20.88u w=10u l=1u
X1077 a_10878_43092# a_10678_42976# S2P S2P pfet_06v0 ad=2.5p pd=10.5u as=4.4p ps=20.88u w=10u l=1u
X1078 a_25214_43092# a_33684_39692# cap_mim_2f0_m4m5_noshield c_width=20u c_length=10u
X1079 a_12852_22332# a_4182_22332# cap_mim_2f0_m4m5_noshield c_width=20u c_length=10u
X1080 a_69196_7790# a_68484_7790# w_64222_7494# w_64222_7494# pfet_05v0 ad=0.8052p pd=4.54u as=0.8052p ps=4.54u w=1.83u l=0.5u
X1081 a_30326_31016# a_25998_30900# a_31058_31016# S2P nfet_06v0 ad=2.2p pd=10.88u as=1.25p ps=5.5u w=5u l=1u
X1082 a_33726_34416# a_34314_31016# S2P S2P nfet_06v0 ad=0.65p pd=3.02u as=0.65p ps=3.02u w=2.5u l=1u
X1083 a_28994_65848# a_26338_69132# S2P S2P nfet_06v0 ad=0.25p pd=1.5u as=0.44p ps=2.88u w=1u l=1u
X1084 S2P a_24886_74260# a_27382_74260# S2P pfet_06v0 ad=1.32p pd=6.88u as=1.32p ps=6.88u w=3u l=1u
X1085 a_30686_51776# a_26338_51660# a_30386_51776# S2P pfet_06v0 ad=4.4p pd=20.88u as=2.5p ps=10.5u w=10u l=1u
X1086 a_23982_4860# a_22750_4744# S2P S2P nfet_06v0 ad=1.25p pd=5.5u as=2.2p ps=10.88u w=5u l=1u
X1087 a_25214_25732# a_33684_22332# cap_mim_2f0_m4m5_noshield c_width=20u c_length=10u
X1088 a_42146_34416# a_41946_34300# S2P S2P pfet_06v0 ad=2.5p pd=10.5u as=4.4p ps=20.88u w=10u l=1u
X1089 a_2258_51660# a_2258_51660# S2P S2P pfet_06v0 ad=0.88p pd=4.88u as=0.88p ps=4.88u w=2u l=1u
X1090 a_44122_8260# a_43922_8144# a_43822_8260# S2P pfet_06v0 ad=4.4p pd=20.88u as=2.5p ps=10.5u w=10u l=1u
X1091 a_57806_34416# a_50078_30900# a_58394_31016# S2P nfet_06v0 ad=1.1p pd=5.88u as=0.65p ps=3.02u w=2.5u l=1u
X1092 a_35148_57052# a_22750_56936# S2P S2P nfet_06v0 ad=1.25p pd=5.5u as=2.2p ps=10.88u w=5u l=1u
X1093 a_63858_13540# a_63858_13540# a_66266_13656# S2P nfet_06v0 ad=2.2p pd=10.88u as=2.2p ps=10.88u w=5u l=1u
X1094 S2P a_58922_51776# a_56170_48376# S2P pfet_06v0 ad=2.2p pd=10.88u as=1.3p ps=5.52u w=5u l=1u
X1095 a_43822_60452# a_43622_60336# S2P S2P pfet_06v0 ad=2.5p pd=10.5u as=4.4p ps=20.88u w=10u l=1u
X1096 a_47670_25732# a_50056_22216# a_47328_22332# S2P nfet_06v0 ad=1.1p pd=5.88u as=1.1p ps=5.88u w=2.5u l=1u
X1097 a_25998_30900# a_25998_30900# S2P S2P nfet_06v0 ad=0.44p pd=2.88u as=0.44p ps=2.88u w=1u l=1u
X1098 a_15798_74376# a_14046_74376# a_14866_74260# S2P nfet_06v0 ad=0.25p pd=1.5u as=0.44p ps=2.88u w=1u l=1u
X1099 a_23090_60336# a_23090_60336# a_37212_57052# S2P nfet_06v0 ad=0.44p pd=2.88u as=0.25p ps=1.5u w=1u l=1u
X1100 a_6306_34416# a_1958_34300# S2P S2P pfet_06v0 ad=2.5p pd=10.5u as=4.4p ps=20.88u w=10u l=1u
X1101 a_26838_60452# a_29224_56936# a_26496_57052# S2P nfet_06v0 ad=1.1p pd=5.88u as=1.1p ps=5.88u w=2.5u l=1u
X1102 a_17362_31016# a_2650_30900# S2P S2P nfet_06v0 ad=1.25p pd=5.5u as=2.2p ps=10.88u w=5u l=1u
X1103 a_26730_13540# a_26338_16940# a_27350_17056# S2P pfet_06v0 ad=4.4p pd=20.88u as=2.5p ps=10.5u w=10u l=1u
X1104 a_58044_4860# a_43922_8144# S2P S2P nfet_06v0 ad=0.25p pd=1.5u as=0.44p ps=2.88u w=1u l=1u
X1105 a_57806_51776# a_57082_48260# a_54766_51776# S2P pfet_06v0 ad=2.6p pd=10.52u as=4.4p ps=20.88u w=10u l=1u
X1106 a_57806_69248# a_58394_65848# S2P S2P nfet_06v0 ad=0.65p pd=3.02u as=1.1p ps=5.88u w=2.5u l=1u
X1107 a_44238_13656# a_35426_13656# S2P S2P nfet_06v0 ad=2.2p pd=10.88u as=1.3p ps=5.52u w=5u l=1u
X1108 S2P a_58922_34416# a_57282_31016# S2P pfet_06v0 ad=2.2p pd=10.88u as=1.3p ps=5.52u w=5u l=1u
X1109 a_8530_69248# a_10234_65848# S2P S2P nfet_06v0 ad=0.65p pd=3.02u as=1.1p ps=5.88u w=2.5u l=1u
X1110 a_59506_65848# a_64402_69132# a_60038_69248# S2P pfet_06v0 ad=2.2p pd=10.88u as=2.2p ps=10.88u w=5u l=1u
X1111 a_26930_31016# a_26730_30900# S2P S2P nfet_06v0 ad=1.25p pd=5.5u as=2.2p ps=10.88u w=5u l=1u
X1112 a_54766_34416# a_50418_34300# a_54466_34416# S2P pfet_06v0 ad=4.4p pd=20.88u as=2.5p ps=10.5u w=10u l=1u
X1113 a_15698_30900# a_2258_34300# a_19990_34416# S2P pfet_06v0 ad=4.4p pd=20.88u as=2.5p ps=10.5u w=10u l=1u
X1114 a_56690_25732# a_43622_25616# S2P S2P pfet_06v0 ad=2.5p pd=10.5u as=4.4p ps=20.88u w=10u l=1u
X1115 a_22790_60336# a_23090_60336# a_36180_57052# S2P nfet_06v0 ad=0.44p pd=2.88u as=0.25p ps=1.5u w=1u l=1u
X1116 a_52542_60452# a_52342_60336# S2P S2P pfet_06v0 ad=2.5p pd=10.5u as=4.4p ps=20.88u w=10u l=1u
X1117 a_30686_69248# a_31890_65732# a_32610_69248# S2P pfet_06v0 ad=4.4p pd=20.88u as=2.6p ps=10.52u w=10u l=1u
X1118 a_9122_31016# a_2258_34300# a_10762_34416# S2P pfet_06v0 ad=2.2p pd=10.88u as=1.3p ps=5.52u w=5u l=1u
X1119 a_17866_16940# a_2258_16940# a_18066_17056# S2P pfet_06v0 ad=4.4p pd=20.88u as=2.5p ps=10.5u w=10u l=1u
X1120 a_59506_48376# a_50078_48260# a_56690_51776# S2P nfet_06v0 ad=0.65p pd=3.02u as=1.1p ps=5.88u w=2.5u l=1u
X1121 S2P a_34314_31016# a_32610_34416# S2P nfet_06v0 ad=1.1p pd=5.88u as=0.65p ps=3.02u w=2.5u l=1u
X1122 a_54466_69248# a_50118_69132# S2P S2P pfet_06v0 ad=2.5p pd=10.5u as=4.4p ps=20.88u w=10u l=1u
X1123 a_6396_22332# a_2218_22216# a_4382_25732# S2P nfet_06v0 ad=1.1p pd=5.88u as=1.1p ps=5.88u w=2.5u l=1u
X1124 a_52464_57052# a_43882_56936# a_53484_57052# S2P nfet_06v0 ad=2.2p pd=10.88u as=1.25p ps=5.5u w=5u l=1u
X1125 S2P a_60038_69248# a_68318_65848# S2P pfet_06v0 ad=2.6p pd=10.52u as=2.6p ps=10.52u w=10u l=1u
X1126 a_47670_43092# a_43922_42976# a_46578_39692# S2P pfet_06v0 ad=2.2p pd=10.88u as=2.2p ps=10.88u w=5u l=1u
X1127 a_65522_48376# a_50810_48260# S2P S2P nfet_06v0 ad=1.25p pd=5.5u as=2.2p ps=10.88u w=5u l=1u
X1128 a_46858_8260# S3N a_44122_8260# S2P pfet_06v0 ad=4.4p pd=20.88u as=4.4p ps=20.88u w=10u l=1u
X1129 a_66026_51660# a_50418_51660# a_66226_51776# S2P pfet_06v0 ad=4.4p pd=20.88u as=2.5p ps=10.5u w=10u l=1u
X1130 a_10800_4860# a_2218_4744# a_11820_4860# S2P nfet_06v0 ad=2.2p pd=10.88u as=1.25p ps=5.5u w=5u l=1u
X1131 a_20158_13656# a_11878_17056# S2P S2P pfet_06v0 ad=4.4p pd=20.88u as=2.6p ps=10.52u w=10u l=1u
X1132 a_1918_48260# a_1918_48260# S2P S2P nfet_06v0 ad=0.44p pd=2.88u as=0.44p ps=2.88u w=1u l=1u
X1133 a_23090_60336# a_23090_60336# S2P S2P pfet_06v0 ad=0.88p pd=4.88u as=0.88p ps=4.88u w=2u l=1u
X1134 a_57282_13656# a_58922_17056# S2P S2P pfet_06v0 ad=1.3p pd=5.52u as=1.3p ps=5.52u w=5u l=1u
X1135 a_25214_8260# a_33684_4860# cap_mim_2f0_m4m5_noshield c_width=20u c_length=10u
X1136 a_57806_34416# a_58394_31016# S2P S2P nfet_06v0 ad=0.65p pd=3.02u as=0.65p ps=3.02u w=2.5u l=1u
X1137 w_64222_24966# a_64528_25146# a_64528_25146# w_64222_24966# pfet_06v0 ad=0.88p pd=4.88u as=0.52p ps=2.52u w=2u l=1u
X1138 a_57282_48376# a_50418_51660# a_58922_51776# S2P pfet_06v0 ad=2.2p pd=10.88u as=1.3p ps=5.52u w=5u l=1u
X1139 a_6006_43092# a_2258_42976# a_4914_39692# S2P pfet_06v0 ad=2.2p pd=10.88u as=2.2p ps=10.88u w=5u l=1u
X1140 a_35858_25732# a_22790_25616# S2P S2P pfet_06v0 ad=2.5p pd=10.5u as=4.4p ps=20.88u w=10u l=1u
X1141 a_56170_31016# a_58922_34416# S2P S2P pfet_06v0 ad=1.3p pd=5.52u as=1.3p ps=5.52u w=5u l=1u
X1142 a_56170_48376# a_58922_51776# S2P S2P pfet_06v0 ad=1.3p pd=5.52u as=2.2p ps=10.88u w=5u l=1u
X1143 a_2850_13656# a_2650_13540# S2P S2P nfet_06v0 ad=1.25p pd=5.5u as=2.2p ps=10.88u w=5u l=1u
X1144 a_32610_17056# a_44238_13656# cap_mim_2f0_m4m5_noshield c_width=20u c_length=10u
X1145 a_8530_34416# a_10234_31016# S2P S2P nfet_06v0 ad=0.65p pd=3.02u as=0.65p ps=3.02u w=2.5u l=1u
X1146 a_1958_60336# a_2258_60336# a_15348_57052# S2P nfet_06v0 ad=0.44p pd=2.88u as=0.25p ps=1.5u w=1u l=1u
X1147 a_30326_65848# a_25998_65732# a_30026_65848# S2P nfet_06v0 ad=2.2p pd=10.88u as=1.25p ps=5.5u w=5u l=1u
X1148 a_45846_4860# a_47670_8260# S2P S2P pfet_06v0 ad=2.2p pd=10.88u as=2.2p ps=10.88u w=5u l=1u
X1149 a_55578_51776# a_50118_51660# S2P S2P pfet_06v0 ad=2.5p pd=10.5u as=4.4p ps=20.88u w=10u l=1u
X1150 a_10762_17056# a_2258_16940# a_9122_13656# S2P pfet_06v0 ad=1.3p pd=5.52u as=2.2p ps=10.88u w=5u l=1u
X1151 a_16380_22332# a_2258_25616# S2P S2P nfet_06v0 ad=0.25p pd=1.5u as=0.44p ps=2.88u w=1u l=1u
X1152 a_50078_30900# a_50078_30900# S2P S2P nfet_06v0 ad=0.44p pd=2.88u as=0.44p ps=2.88u w=1u l=1u
X1153 a_19126_31016# a_18106_31016# S2P S2P nfet_06v0 ad=1.25p pd=5.5u as=2.2p ps=10.88u w=5u l=1u
X1154 a_11878_51776# a_2258_51660# a_8010_48376# S2P pfet_06v0 ad=1.3p pd=5.52u as=2.2p ps=10.88u w=5u l=1u
X1155 S2P a_58394_65848# a_56690_69248# S2P nfet_06v0 ad=0.65p pd=3.02u as=0.65p ps=3.02u w=2.5u l=1u
X1156 a_26838_43092# a_23090_42976# a_25746_39692# S2P pfet_06v0 ad=2.2p pd=10.88u as=2.2p ps=10.88u w=5u l=1u
X1157 a_2418_57052# a_2218_56936# a_2118_57052# S2P nfet_06v0 ad=2.2p pd=10.88u as=1.25p ps=5.5u w=5u l=1u
X1158 a_30686_69248# a_26338_69132# a_30386_69248# S2P pfet_06v0 ad=4.4p pd=20.88u as=2.5p ps=10.5u w=10u l=1u
X1159 a_33684_22332# a_27228_22332# S2P S2P nfet_06v0 ad=0.44p pd=2.88u as=0.44p ps=2.88u w=1u l=1u
X1160 a_46578_4860# a_47670_8260# S2P S2P pfet_06v0 ad=2.2p pd=10.88u as=2.2p ps=10.88u w=5u l=1u
X1161 a_10800_39692# a_2218_39576# a_11820_39692# S2P nfet_06v0 ad=2.2p pd=10.88u as=1.25p ps=5.5u w=5u l=1u
X1162 a_27228_57052# a_23050_56936# a_25214_60452# S2P nfet_06v0 ad=1.1p pd=5.88u as=1.1p ps=5.88u w=2.5u l=1u
X1163 a_2258_69132# a_2258_69132# S2P S2P pfet_06v0 ad=0.88p pd=4.88u as=0.88p ps=4.88u w=2u l=1u
X1164 a_40322_51660# a_25998_48260# a_41442_48376# S2P nfet_06v0 ad=2.2p pd=10.88u as=1.25p ps=5.5u w=5u l=1u
X1165 a_2258_60336# a_2258_60336# S2P S2P pfet_06v0 ad=0.88p pd=4.88u as=0.88p ps=4.88u w=2u l=1u
X1166 a_10878_8260# a_10678_8144# S2P S2P pfet_06v0 ad=2.5p pd=10.5u as=4.4p ps=20.88u w=10u l=1u
X1167 a_33202_48376# a_34842_51776# S2P S2P pfet_06v0 ad=1.3p pd=5.52u as=1.3p ps=5.52u w=5u l=1u
X1168 S2P a_58922_69248# a_56170_65848# S2P pfet_06v0 ad=2.2p pd=10.88u as=1.3p ps=5.52u w=5u l=1u
X1169 a_48482_25732# a_50056_22216# a_48060_22332# S2P nfet_06v0 ad=1.1p pd=5.88u as=1.1p ps=5.88u w=2.5u l=1u
X1170 a_23290_60452# a_23090_60336# a_22990_60452# S2P pfet_06v0 ad=4.4p pd=20.88u as=2.5p ps=10.5u w=10u l=1u
X1171 a_22990_8260# a_22790_8144# S2P S2P pfet_06v0 ad=2.5p pd=10.5u as=4.4p ps=20.88u w=10u l=1u
X1172 a_9054_25616# a_9054_25616# a_10678_25616# S2P pfet_06v0 ad=4.4p pd=20.88u as=4.4p ps=20.88u w=10u l=1u
X1173 a_64838_58692# a_64526_56900# a_64438_57016# S2P pfet_06v0 ad=0.75p pd=3.5u as=1.32p ps=6.88u w=3u l=1u
X1174 a_27650_60452# a_29224_56936# a_27228_57052# S2P nfet_06v0 ad=1.1p pd=5.88u as=1.1p ps=5.88u w=2.5u l=1u
X1175 a_44238_13656# a_32090_13656# cap_mim_2f0_m4m5_noshield c_width=20u c_length=10u
X1176 S2P a_10762_17056# a_9122_13656# S2P pfet_06v0 ad=2.2p pd=10.88u as=1.3p ps=5.52u w=5u l=1u
X1177 a_56690_51776# a_58394_48376# S2P S2P nfet_06v0 ad=0.65p pd=3.02u as=0.65p ps=3.02u w=2.5u l=1u
X1178 a_30686_51776# a_26338_51660# a_31498_51776# S2P pfet_06v0 ad=4.4p pd=20.88u as=2.5p ps=10.5u w=10u l=1u
X1179 a_23734_76052# a_23422_74260# a_23334_74376# S2P pfet_06v0 ad=0.75p pd=3.5u as=1.32p ps=6.88u w=3u l=1u
X1180 a_3294_74376# a_3382_74260# S2P S2P pfet_06v0 ad=1.32p pd=6.88u as=1.32p ps=6.88u w=3u l=1u
X1181 S2P a_14134_74260# a_14046_74376# S2P nfet_06v0 ad=0.44p pd=2.88u as=0.44p ps=2.88u w=1u l=1u
X1182 a_67772_7790# a_64528_7674# S2P S2P nfet_05v0 ad=0.5808p pd=3.52u as=0.5808p ps=3.52u w=1.32u l=0.6u
X1183 a_1958_51660# a_2258_51660# a_5194_51776# S2P pfet_06v0 ad=4.4p pd=20.88u as=2.5p ps=10.5u w=10u l=1u
X1184 S2P a_58394_31016# a_56690_34416# S2P nfet_06v0 ad=1.1p pd=5.88u as=0.65p ps=3.02u w=2.5u l=1u
X1185 a_57806_69248# a_57082_65732# a_54766_69248# S2P pfet_06v0 ad=2.6p pd=10.52u as=4.4p ps=20.88u w=10u l=1u
X1186 a_31510_42976# a_23090_42976# a_31710_43092# S2P pfet_06v0 ad=4.4p pd=20.88u as=2.5p ps=10.5u w=10u l=1u
X1187 S2P a_10762_51776# a_9122_48376# S2P pfet_06v0 ad=1.3p pd=5.52u as=1.3p ps=5.52u w=5u l=1u
X1188 a_35958_34416# a_26338_34300# a_32090_31016# S2P pfet_06v0 ad=1.3p pd=5.52u as=2.2p ps=10.88u w=5u l=1u
X1189 a_5664_39692# a_9054_42976# a_6006_43092# S2P pfet_06v0 ad=2.2p pd=10.88u as=2.2p ps=10.88u w=5u l=1u
X1190 S2P a_34842_17056# a_32090_13656# S2P pfet_06v0 ad=2.2p pd=10.88u as=1.3p ps=5.52u w=5u l=1u
X1191 a_44934_60452# a_43622_60336# S2P S2P pfet_06v0 ad=2.5p pd=10.5u as=4.4p ps=20.88u w=10u l=1u
X1192 a_51720_22332# a_43582_22216# S2P S2P nfet_06v0 ad=1.25p pd=5.5u as=2.2p ps=10.88u w=5u l=1u
X1193 a_65550_5686# a_65888_4362# S2P S2P nfet_06v0 ad=0.5456p pd=3.36u as=0.5456p ps=3.36u w=1.24u l=1u
X1194 a_7418_34416# a_1958_34300# S2P S2P pfet_06v0 ad=2.5p pd=10.5u as=4.4p ps=20.88u w=10u l=1u
X1195 a_56170_48376# a_50418_51660# a_60038_51776# S2P pfet_06v0 ad=2.2p pd=10.88u as=1.3p ps=5.52u w=5u l=1u
X1196 a_2258_8144# a_2258_8144# S2P S2P pfet_06v0 ad=0.88p pd=4.88u as=0.88p ps=4.88u w=2u l=1u
X1197 a_33202_31016# a_33002_30900# a_30326_31016# S2P nfet_06v0 ad=1.3p pd=5.52u as=2.2p ps=10.88u w=5u l=1u
X1198 a_32652_57052# a_31632_57052# S2P S2P nfet_06v0 ad=1.25p pd=5.5u as=2.2p ps=10.88u w=5u l=1u
X1199 a_45846_57052# S2P a_44082_57052# S2P nfet_06v0 ad=2.2p pd=10.88u as=2.2p ps=10.88u w=5u l=1u
X1200 a_8010_13656# a_10762_17056# S2P S2P pfet_06v0 ad=1.3p pd=5.52u as=1.3p ps=5.52u w=5u l=1u
X1201 a_54406_31016# a_50078_30900# a_54106_31016# S2P nfet_06v0 ad=2.2p pd=10.88u as=1.25p ps=5.5u w=5u l=1u
X1202 a_67552_4478# a_65888_4362# S2P S2P nfet_06v0 ad=0.175p pd=1.2u as=0.308p ps=2.28u w=0.7u l=1u
X1203 a_43206_31016# a_42186_31016# S2P S2P nfet_06v0 ad=1.25p pd=5.5u as=2.2p ps=10.88u w=5u l=1u
X1204 S2P a_65990_56900# a_68486_56900# S2P pfet_06v0 ad=1.32p pd=6.88u as=1.32p ps=6.88u w=3u l=1u
X1205 a_66026_69132# a_50418_69132# a_66226_69248# S2P pfet_06v0 ad=4.4p pd=20.88u as=2.5p ps=10.5u w=10u l=1u
X1206 a_54766_34416# a_50418_34300# a_55578_34416# S2P pfet_06v0 ad=4.4p pd=20.88u as=2.5p ps=10.5u w=10u l=1u
X1207 a_46858_60452# a_47328_57052# S2P S2P nfet_06v0 ad=1.1p pd=5.88u as=1.1p ps=5.88u w=2.5u l=1u
X1208 S2P a_25618_74260# a_25530_74376# S2P nfet_06v0 ad=0.44p pd=2.88u as=0.44p ps=2.88u w=1u l=1u
X1209 a_50718_60336# a_50718_60336# a_52342_60336# S2P pfet_06v0 ad=4.4p pd=20.88u as=4.4p ps=20.88u w=10u l=1u
X1210 a_57282_65848# a_50418_69132# a_58922_69248# S2P pfet_06v0 ad=2.2p pd=10.88u as=1.3p ps=5.52u w=5u l=1u
X1211 a_35148_4860# a_22750_4744# S2P S2P nfet_06v0 ad=1.25p pd=5.5u as=2.2p ps=10.88u w=5u l=1u
X1212 a_4914_22332# S1N a_2418_22332# S2P nfet_06v0 ad=2.2p pd=10.88u as=2.2p ps=10.88u w=5u l=1u
X1213 S2P a_34842_34416# a_33202_31016# S2P pfet_06v0 ad=1.3p pd=5.52u as=1.3p ps=5.52u w=5u l=1u
X1214 a_56170_65848# a_58922_69248# S2P S2P pfet_06v0 ad=1.3p pd=5.52u as=2.2p ps=10.88u w=5u l=1u
X1215 a_5194_60452# a_5664_57052# S2P S2P nfet_06v0 ad=1.1p pd=5.88u as=1.1p ps=5.88u w=2.5u l=1u
X1216 a_12982_76052# a_12670_74260# a_12582_74376# S2P pfet_06v0 ad=0.75p pd=3.5u as=1.32p ps=6.88u w=3u l=1u
X1217 a_55578_69248# a_50118_69132# S2P S2P pfet_06v0 ad=2.5p pd=10.5u as=4.4p ps=20.88u w=10u l=1u
X1218 a_64528_42506# a_64528_42506# w_64222_42326# w_64222_42326# pfet_06v0 ad=0.52p pd=2.52u as=0.52p ps=2.52u w=2u l=1u
X1219 a_31058_65848# a_26730_65732# S2P S2P nfet_06v0 ad=1.25p pd=5.5u as=2.2p ps=10.88u w=5u l=1u
X1220 a_4382_25732# a_5664_22332# S2P S2P nfet_06v0 ad=1.1p pd=5.88u as=1.1p ps=5.88u w=2.5u l=1u
X1221 a_11878_69248# a_2258_69132# a_8010_65848# S2P pfet_06v0 ad=1.3p pd=5.52u as=2.2p ps=10.88u w=5u l=1u
X1222 a_10234_65848# a_1918_65732# a_9646_69248# S2P nfet_06v0 ad=0.65p pd=3.02u as=1.1p ps=5.88u w=2.5u l=1u
X1223 a_25746_22332# a_25546_22216# a_23250_22332# S2P nfet_06v0 ad=2.2p pd=10.88u as=2.2p ps=10.88u w=5u l=1u
X1224 a_50418_34300# a_50418_34300# a_53074_31016# S2P nfet_06v0 ad=0.44p pd=2.88u as=0.25p ps=1.5u w=1u l=1u
X1225 a_22790_60336# a_23090_60336# a_37782_60452# S2P pfet_06v0 ad=4.4p pd=20.88u as=2.5p ps=10.5u w=10u l=1u
X1226 a_56690_34416# a_58394_31016# S2P S2P nfet_06v0 ad=0.65p pd=3.02u as=1.1p ps=5.88u w=2.5u l=1u
X1227 a_32610_34416# a_44238_31016# cap_mim_2f0_m4m5_noshield c_width=20u c_length=10u
X1228 a_6606_51776# a_7810_48260# a_8530_51776# S2P pfet_06v0 ad=4.4p pd=20.88u as=2.6p ps=10.52u w=10u l=1u
X1229 a_10762_34416# a_15698_30900# a_10234_31016# S2P nfet_06v0 ad=1.1p pd=5.88u as=1.1p ps=5.88u w=2.5u l=1u
X1230 a_54406_48376# a_54516_39692# a_56170_48376# S2P nfet_06v0 ad=2.2p pd=10.88u as=1.3p ps=5.52u w=5u l=1u
X1231 a_1958_51660# a_2258_51660# a_3882_48376# S2P nfet_06v0 ad=0.44p pd=2.88u as=0.25p ps=1.5u w=1u l=1u
X1232 a_33202_65848# a_34842_69248# S2P S2P pfet_06v0 ad=1.3p pd=5.52u as=1.3p ps=5.52u w=5u l=1u
X1233 a_25214_25732# a_26496_22332# S2P S2P nfet_06v0 ad=1.1p pd=5.88u as=1.1p ps=5.88u w=2.5u l=1u
X1234 a_30326_13656# a_33002_13540# a_33202_13656# S2P nfet_06v0 ad=2.2p pd=10.88u as=1.3p ps=5.52u w=5u l=1u
X1235 a_2458_60452# a_2258_60336# a_3270_60452# S2P pfet_06v0 ad=4.4p pd=20.88u as=2.5p ps=10.5u w=10u l=1u
X1236 w_64222_24966# a_64528_25146# a_64528_25146# w_64222_24966# pfet_06v0 ad=0.52p pd=2.52u as=0.52p ps=2.52u w=2u l=1u
X1237 a_9646_51776# a_1918_48260# a_10234_48376# S2P nfet_06v0 ad=1.1p pd=5.88u as=0.65p ps=3.02u w=2.5u l=1u
X1238 a_2458_25732# a_2258_25616# a_2158_25732# S2P pfet_06v0 ad=4.4p pd=20.88u as=2.5p ps=10.5u w=10u l=1u
X1239 a_64402_16940# a_50078_13540# a_65522_13656# S2P nfet_06v0 ad=2.2p pd=10.88u as=1.25p ps=5.5u w=5u l=1u
X1240 a_30686_69248# a_26338_69132# a_31498_69248# S2P pfet_06v0 ad=4.4p pd=20.88u as=2.5p ps=10.5u w=10u l=1u
X1241 S2P a_14866_74260# a_14778_74376# S2P nfet_06v0 ad=0.44p pd=2.88u as=0.44p ps=2.88u w=1u l=1u
X1242 a_1958_69132# a_2258_69132# a_5194_69248# S2P pfet_06v0 ad=4.4p pd=20.88u as=2.5p ps=10.5u w=10u l=1u
X1243 a_64528_7674# a_64526_5570# a_64438_5686# S2P nfet_06v0 ad=0.6448p pd=3u as=1.0912p ps=5.84u w=2.48u l=1u
X1244 S2P a_10762_69248# a_9122_65848# S2P pfet_06v0 ad=1.3p pd=5.52u as=1.3p ps=5.52u w=5u l=1u
X1245 a_26026_8260# a_25546_4744# a_23290_8260# S2P pfet_06v0 ad=4.4p pd=20.88u as=4.4p ps=20.88u w=10u l=1u
X1246 a_11878_34416# a_15698_30900# a_11346_31016# S2P nfet_06v0 ad=1.1p pd=5.88u as=1.1p ps=5.88u w=2.5u l=1u
X1247 a_50318_34416# a_50118_34300# S2P S2P pfet_06v0 ad=2.5p pd=10.5u as=4.4p ps=20.88u w=10u l=1u
X1248 a_56170_65848# a_50418_69132# a_60038_69248# S2P pfet_06v0 ad=2.2p pd=10.88u as=1.3p ps=5.52u w=5u l=1u
X1249 a_43622_42976# a_43922_42976# a_57012_39692# S2P nfet_06v0 ad=0.44p pd=2.88u as=0.25p ps=1.5u w=1u l=1u
X1250 a_58922_51776# a_63858_48260# a_58394_48376# S2P nfet_06v0 ad=1.1p pd=5.88u as=1.1p ps=5.88u w=2.5u l=1u
X1251 a_6246_31016# a_1918_30900# a_6978_31016# S2P nfet_06v0 ad=2.2p pd=10.88u as=1.25p ps=5.5u w=5u l=1u
X1252 a_60038_17056# a_63858_13540# a_59506_13656# S2P nfet_06v0 ad=1.1p pd=5.88u as=1.1p ps=5.88u w=2.5u l=1u
X1253 a_26338_51660# a_26338_51660# a_28994_48376# S2P nfet_06v0 ad=0.44p pd=2.88u as=0.25p ps=1.5u w=1u l=1u
X1254 a_32610_51776# a_34314_48376# S2P S2P nfet_06v0 ad=0.65p pd=3.02u as=1.1p ps=5.88u w=2.5u l=1u
X1255 a_46046_60452# S2P a_44122_60452# S2P pfet_06v0 ad=4.4p pd=20.88u as=4.4p ps=20.88u w=10u l=1u
X1256 a_25746_4860# a_26838_8260# S2P S2P pfet_06v0 ad=2.2p pd=10.88u as=2.2p ps=10.88u w=5u l=1u
X1257 a_55138_31016# a_50810_30900# S2P S2P nfet_06v0 ad=1.25p pd=5.5u as=2.2p ps=10.88u w=5u l=1u
X1258 S2P a_10762_34416# a_8010_31016# S2P pfet_06v0 ad=1.3p pd=5.52u as=1.3p ps=5.52u w=5u l=1u
X1259 a_5664_22332# a_2218_22216# a_5194_25732# S2P nfet_06v0 ad=1.1p pd=5.88u as=1.1p ps=5.88u w=2.5u l=1u
X1260 a_34314_31016# a_25998_30900# a_33726_34416# S2P nfet_06v0 ad=0.65p pd=3.02u as=1.1p ps=5.88u w=2.5u l=1u
X1261 a_43582_39576# a_43882_39576# a_55980_39692# S2P nfet_06v0 ad=2.2p pd=10.88u as=1.25p ps=5.5u w=5u l=1u
X1262 a_9054_25616# a_2218_22216# a_10056_22332# S2P nfet_06v0 ad=2.2p pd=10.88u as=1.25p ps=5.5u w=5u l=1u
X1263 S2P a_58394_13656# a_57806_17056# S2P nfet_06v0 ad=0.65p pd=3.02u as=0.65p ps=3.02u w=2.5u l=1u
X1264 a_27650_43092# a_23090_42976# a_25014_39692# S2P pfet_06v0 ad=2.2p pd=10.88u as=2.2p ps=10.88u w=5u l=1u
X1265 a_29274_34416# a_26038_34300# S2P S2P pfet_06v0 ad=2.5p pd=10.5u as=4.4p ps=20.88u w=10u l=1u
X1266 a_64528_25146# a_64528_25146# w_64222_24966# w_64222_24966# pfet_06v0 ad=0.52p pd=2.52u as=0.88p ps=4.88u w=2u l=1u
X1267 a_50118_69132# a_50418_69132# a_52042_65848# S2P nfet_06v0 ad=0.44p pd=2.88u as=0.25p ps=1.5u w=1u l=1u
X1268 a_2218_39576# a_2258_42976# a_13914_43092# S2P pfet_06v0 ad=4.4p pd=20.88u as=2.5p ps=10.5u w=10u l=1u
X1269 a_16950_60452# a_1958_60336# S2P S2P pfet_06v0 ad=2.5p pd=10.5u as=4.4p ps=20.88u w=10u l=1u
X1270 a_26496_22332# a_23050_22216# a_26026_25732# S2P nfet_06v0 ad=1.1p pd=5.88u as=1.1p ps=5.88u w=2.5u l=1u
X1271 a_68318_65848# a_59506_65848# S2P S2P nfet_06v0 ad=1.3p pd=5.52u as=2.2p ps=10.88u w=5u l=1u
X1272 a_32610_69248# a_25998_65732# a_35426_65848# S2P nfet_06v0 ad=1.1p pd=5.88u as=0.65p ps=3.02u w=2.5u l=1u
X1273 a_50056_56936# a_43922_60336# a_54466_60452# S2P pfet_06v0 ad=4.4p pd=20.88u as=2.5p ps=10.5u w=10u l=1u
X1274 a_22790_8144# a_23090_8144# a_37782_8260# S2P pfet_06v0 ad=4.4p pd=20.88u as=2.5p ps=10.5u w=10u l=1u
X1275 a_32610_51776# a_44238_48376# cap_mim_2f0_m4m5_noshield c_width=20u c_length=10u
X1276 a_6606_69248# a_7810_65732# a_8530_69248# S2P pfet_06v0 ad=4.4p pd=20.88u as=2.6p ps=10.52u w=10u l=1u
X1277 a_57282_65848# a_57082_65732# a_54406_65848# S2P nfet_06v0 ad=1.3p pd=5.52u as=2.2p ps=10.88u w=5u l=1u
X1278 a_4382_8260# a_5664_4860# S2P S2P nfet_06v0 ad=1.1p pd=5.88u as=1.1p ps=5.88u w=2.5u l=1u
X1279 a_23250_4860# a_23050_4744# a_22950_4860# S2P nfet_06v0 ad=2.2p pd=10.88u as=1.25p ps=5.5u w=5u l=1u
X1280 a_22750_39576# a_23050_39576# a_35148_39692# S2P nfet_06v0 ad=2.2p pd=10.88u as=1.25p ps=5.5u w=5u l=1u
X1281 a_68318_13656# a_60038_17056# S2P S2P pfet_06v0 ad=4.4p pd=20.88u as=2.6p ps=10.52u w=10u l=1u
X1282 a_10234_31016# a_16242_34300# a_10762_34416# S2P pfet_06v0 ad=2.2p pd=10.88u as=2.2p ps=10.88u w=5u l=1u
X1283 S2P a_3294_74376# a_4114_74260# S2P pfet_06v0 ad=1.32p pd=6.88u as=1.32p ps=6.88u w=3u l=1u
X1284 a_31632_22332# a_23050_22216# a_32652_22332# S2P nfet_06v0 ad=2.2p pd=10.88u as=1.25p ps=5.5u w=5u l=1u
X1285 a_35426_13656# a_40322_16940# a_35958_17056# S2P pfet_06v0 ad=2.2p pd=10.88u as=2.2p ps=10.88u w=5u l=1u
X1286 a_44070_34416# a_26038_34300# S2P S2P pfet_06v0 ad=2.5p pd=10.5u as=4.4p ps=20.88u w=10u l=1u
X1287 a_43882_4744# a_43882_4744# S2P S2P nfet_06v0 ad=0.44p pd=2.88u as=0.44p ps=2.88u w=1u l=1u
X1288 a_11346_65848# a_1918_65732# a_8530_69248# S2P nfet_06v0 ad=0.65p pd=3.02u as=1.1p ps=5.88u w=2.5u l=1u
X1289 a_46578_57052# a_47670_60452# S2P S2P pfet_06v0 ad=2.2p pd=10.88u as=2.2p ps=10.88u w=5u l=1u
X1290 a_67286_65848# a_66266_65848# S2P S2P nfet_06v0 ad=1.25p pd=5.5u as=2.2p ps=10.88u w=5u l=1u
X1291 a_30386_17056# a_26038_16940# S2P S2P pfet_06v0 ad=2.5p pd=10.5u as=4.4p ps=20.88u w=10u l=1u
X1292 S2P a_35958_17056# a_44238_13656# S2P pfet_06v0 ad=2.6p pd=10.52u as=2.6p ps=10.52u w=10u l=1u
X1293 a_20158_48376# a_8010_48376# cap_mim_2f0_m4m5_noshield c_width=20u c_length=10u
X1294 a_54406_48376# a_57082_48260# a_57282_48376# S2P nfet_06v0 ad=2.2p pd=10.88u as=1.3p ps=5.52u w=5u l=1u
X1295 a_2158_17056# a_1958_16940# S2P S2P pfet_06v0 ad=2.5p pd=10.5u as=4.4p ps=20.88u w=10u l=1u
X1296 a_29886_60336# a_23050_56936# a_30888_57052# S2P nfet_06v0 ad=2.2p pd=10.88u as=1.25p ps=5.5u w=5u l=1u
X1297 a_43622_8144# a_43922_8144# a_57012_4860# S2P nfet_06v0 ad=0.44p pd=2.88u as=0.25p ps=1.5u w=1u l=1u
X1298 a_23250_22332# a_23050_22216# a_22950_22332# S2P nfet_06v0 ad=2.2p pd=10.88u as=1.25p ps=5.5u w=5u l=1u
X1299 a_6246_65848# a_1918_65732# a_5946_65848# S2P nfet_06v0 ad=2.2p pd=10.88u as=1.25p ps=5.5u w=5u l=1u
X1300 a_33726_17056# a_25998_13540# a_34314_13656# S2P nfet_06v0 ad=1.1p pd=5.88u as=0.65p ps=3.02u w=2.5u l=1u
X1301 S2P a_13082_75936# a_12582_74376# S2P nfet_06v0 ad=0.44p pd=2.88u as=0.44p ps=2.88u w=1u l=1u
X1302 a_26730_13540# a_25998_13540# a_26930_13656# S2P nfet_06v0 ad=2.2p pd=10.88u as=1.25p ps=5.5u w=5u l=1u
X1303 a_6246_13656# a_7810_13540# a_8010_13656# S2P nfet_06v0 ad=2.2p pd=10.88u as=1.3p ps=5.52u w=5u l=1u
X1304 a_58044_39692# a_43922_42976# S2P S2P nfet_06v0 ad=0.25p pd=1.5u as=0.44p ps=2.88u w=1u l=1u
X1305 a_69538_40518# a_65888_39194# S2P S2P nfet_06v0 ad=0.5456p pd=3.36u as=0.5456p ps=3.36u w=1.24u l=1u
X1306 a_20158_31016# a_8010_31016# cap_mim_2f0_m4m5_noshield c_width=20u c_length=10u
X1307 a_12852_39692# a_6818_43092# S2P S2P pfet_06v0 ad=0.308p pd=2.28u as=0.308p ps=2.28u w=0.7u l=20u
X1308 a_69538_5686# a_65888_4362# S2P S2P nfet_06v0 ad=0.5456p pd=3.36u as=0.5456p ps=3.36u w=1.24u l=1u
X1309 a_11346_48376# a_16242_51660# a_11878_51776# S2P pfet_06v0 ad=2.2p pd=10.88u as=2.2p ps=10.88u w=5u l=1u
X1310 a_56690_34416# a_55970_30900# a_54766_34416# S2P pfet_06v0 ad=2.6p pd=10.52u as=4.4p ps=20.88u w=10u l=1u
X1311 a_54106_65848# a_50810_65732# S2P S2P nfet_06v0 ad=1.25p pd=5.5u as=2.2p ps=10.88u w=5u l=1u
X1312 a_12852_4860# a_4182_4860# cap_mim_2f0_m4m5_noshield c_width=20u c_length=10u
X1313 a_29224_56936# a_29224_56936# a_31632_57052# S2P nfet_06v0 ad=2.2p pd=10.88u as=2.2p ps=10.88u w=5u l=1u
X1314 a_44082_57052# a_43882_56936# a_44814_57052# S2P nfet_06v0 ad=2.2p pd=10.88u as=1.25p ps=5.5u w=5u l=1u
X1315 a_64438_40518# a_64526_40402# a_64528_42506# S2P nfet_06v0 ad=1.0912p pd=5.84u as=0.6448p ps=3u w=2.48u l=1u
X1316 a_3150_4860# a_1918_4744# S2P S2P nfet_06v0 ad=1.25p pd=5.5u as=2.2p ps=10.88u w=5u l=1u
X1317 a_8392_22216# a_8392_22216# a_10800_22332# S2P nfet_06v0 ad=2.2p pd=10.88u as=2.2p ps=10.88u w=5u l=1u
X1318 a_56690_34416# a_50078_30900# a_59506_31016# S2P nfet_06v0 ad=1.1p pd=5.88u as=0.65p ps=3.02u w=2.5u l=1u
X1319 a_68794_5686# a_64528_7674# S2P S2P nfet_06v0 ad=0.5p pd=2.5u as=0.88p ps=4.88u w=2u l=1u
X1320 S2P a_10234_65848# a_9646_69248# S2P nfet_06v0 ad=1.1p pd=5.88u as=0.65p ps=3.02u w=2.5u l=1u
X1321 a_63858_48260# a_50418_51660# a_68150_51776# S2P pfet_06v0 ad=4.4p pd=20.88u as=2.5p ps=10.5u w=10u l=1u
X1322 a_54766_17056# a_57082_13540# a_57806_17056# S2P pfet_06v0 ad=4.4p pd=20.88u as=2.6p ps=10.52u w=10u l=1u
X1323 a_48060_57052# a_43882_56936# a_46046_60452# S2P nfet_06v0 ad=1.1p pd=5.88u as=1.1p ps=5.88u w=2.5u l=1u
X1324 a_35858_8260# a_22790_8144# S2P S2P pfet_06v0 ad=2.5p pd=10.5u as=4.4p ps=20.88u w=10u l=1u
X1325 a_53074_65848# a_50418_69132# S2P S2P nfet_06v0 ad=0.25p pd=1.5u as=0.44p ps=2.88u w=1u l=1u
X1326 a_37782_25732# a_22790_25616# S2P S2P pfet_06v0 ad=2.5p pd=10.5u as=4.4p ps=20.88u w=10u l=1u
X1327 a_18106_13656# a_1918_13540# a_19126_13656# S2P nfet_06v0 ad=2.2p pd=10.88u as=1.25p ps=5.5u w=5u l=1u
X1328 a_33634_60452# a_22790_60336# S2P S2P pfet_06v0 ad=2.5p pd=10.5u as=4.4p ps=20.88u w=10u l=1u
X1329 a_54516_4860# a_45846_4860# cap_mim_2f0_m4m5_noshield c_width=20u c_length=10u
X1330 a_44082_57052# a_43882_56936# a_43782_57052# S2P nfet_06v0 ad=2.2p pd=10.88u as=1.25p ps=5.5u w=5u l=1u
X1331 a_66226_17056# a_66026_16940# S2P S2P pfet_06v0 ad=2.5p pd=10.5u as=4.4p ps=20.88u w=10u l=1u
X1332 a_35426_31016# a_25998_30900# a_32610_34416# S2P nfet_06v0 ad=0.65p pd=3.02u as=1.1p ps=5.88u w=2.5u l=1u
X1333 a_14316_39692# a_1918_39576# S2P S2P nfet_06v0 ad=1.25p pd=5.5u as=2.2p ps=10.88u w=5u l=1u
X1334 a_33726_17056# a_33002_13540# a_30686_17056# S2P pfet_06v0 ad=2.6p pd=10.52u as=4.4p ps=20.88u w=10u l=1u
X1335 a_11820_22332# a_10800_22332# S2P S2P nfet_06v0 ad=1.25p pd=5.5u as=2.2p ps=10.88u w=5u l=1u
X1336 a_25014_22332# S2P a_23250_22332# S2P nfet_06v0 ad=2.2p pd=10.88u as=2.2p ps=10.88u w=5u l=1u
X1337 a_67394_40518# a_64528_42506# a_64528_42506# S2P nfet_06v0 ad=0.88p pd=4.88u as=0.52p ps=2.52u w=2u l=1u
X1338 a_43922_42976# a_43922_42976# S2P S2P pfet_06v0 ad=0.88p pd=4.88u as=0.88p ps=4.88u w=2u l=1u
X1339 a_3270_25732# a_1958_25616# S2P S2P pfet_06v0 ad=2.5p pd=10.5u as=4.4p ps=20.88u w=10u l=1u
X1340 a_41442_31016# a_26730_30900# S2P S2P nfet_06v0 ad=1.25p pd=5.5u as=2.2p ps=10.88u w=5u l=1u
X1341 a_50810_13540# a_50418_16940# a_51430_17056# S2P pfet_06v0 ad=4.4p pd=20.88u as=2.5p ps=10.5u w=10u l=1u
X1342 a_1918_39576# a_2258_42976# a_15026_43092# S2P pfet_06v0 ad=4.4p pd=20.88u as=2.5p ps=10.5u w=10u l=1u
X1343 a_3150_22332# a_1918_22216# S2P S2P nfet_06v0 ad=1.25p pd=5.5u as=2.2p ps=10.88u w=5u l=1u
X1344 a_15698_13540# a_15698_13540# a_18106_13656# S2P nfet_06v0 ad=2.2p pd=10.88u as=2.2p ps=10.88u w=5u l=1u
X1345 S2P a_34314_65848# a_33726_69248# S2P nfet_06v0 ad=0.65p pd=3.02u as=0.65p ps=3.02u w=2.5u l=1u
X1346 a_26026_25732# a_26496_22332# S2P S2P nfet_06v0 ad=1.1p pd=5.88u as=1.1p ps=5.88u w=2.5u l=1u
X1347 S2P a_35426_48376# a_44238_48376# S2P nfet_06v0 ad=1.3p pd=5.52u as=1.3p ps=5.52u w=5u l=1u
X1348 a_43882_56936# a_43922_60336# a_55578_60452# S2P pfet_06v0 ad=4.4p pd=20.88u as=2.5p ps=10.5u w=10u l=1u
X1349 S2P a_58922_17056# a_56170_13656# S2P pfet_06v0 ad=1.3p pd=5.52u as=1.3p ps=5.52u w=5u l=1u
X1350 a_9054_8144# a_9054_8144# a_10678_8144# S2P pfet_06v0 ad=4.4p pd=20.88u as=4.4p ps=20.88u w=10u l=1u
X1351 a_6006_43092# a_8392_39576# a_5664_39692# S2P nfet_06v0 ad=1.1p pd=5.88u as=1.1p ps=5.88u w=2.5u l=1u
X1352 a_58394_65848# a_50078_65732# a_57806_69248# S2P nfet_06v0 ad=0.65p pd=3.02u as=1.1p ps=5.88u w=2.5u l=1u
X1353 a_51010_31016# a_50810_30900# S2P S2P nfet_06v0 ad=1.25p pd=5.5u as=2.2p ps=10.88u w=5u l=1u
X1354 a_23982_22332# a_22750_22216# S2P S2P nfet_06v0 ad=1.25p pd=5.5u as=2.2p ps=10.88u w=5u l=1u
X1355 a_6978_65848# a_2650_65732# S2P S2P nfet_06v0 ad=1.25p pd=5.5u as=2.2p ps=10.88u w=5u l=1u
X1356 a_27962_13656# a_26338_16940# S2P S2P nfet_06v0 ad=0.25p pd=1.5u as=0.44p ps=2.88u w=1u l=1u
X1357 a_41946_16940# a_26338_16940# a_42146_17056# S2P pfet_06v0 ad=4.4p pd=20.88u as=2.5p ps=10.5u w=10u l=1u
X1358 a_8010_13656# a_2258_16940# a_11878_17056# S2P pfet_06v0 ad=2.2p pd=10.88u as=1.3p ps=5.52u w=5u l=1u
X1359 a_44238_31016# a_35958_34416# S2P S2P pfet_06v0 ad=2.6p pd=10.52u as=4.4p ps=20.88u w=10u l=1u
X1360 a_30326_48376# a_25998_48260# a_31058_48376# S2P nfet_06v0 ad=2.2p pd=10.88u as=1.25p ps=5.5u w=5u l=1u
X1361 a_9646_69248# a_10234_65848# S2P S2P nfet_06v0 ad=0.65p pd=3.02u as=1.1p ps=5.88u w=2.5u l=1u
X1362 a_64528_25146# a_64528_25146# a_67394_23158# S2P nfet_06v0 ad=0.52p pd=2.52u as=0.88p ps=4.88u w=2u l=1u
X1363 a_66266_31016# a_50078_30900# a_67286_31016# S2P nfet_06v0 ad=2.2p pd=10.88u as=1.25p ps=5.5u w=5u l=1u
X1364 a_33726_51776# a_34314_48376# S2P S2P nfet_06v0 ad=0.65p pd=3.02u as=0.65p ps=3.02u w=2.5u l=1u
X1365 a_11346_65848# a_16242_69132# a_11878_69248# S2P pfet_06v0 ad=2.2p pd=10.88u as=2.2p ps=10.88u w=5u l=1u
X1366 a_26730_48260# a_26338_51660# a_27350_51776# S2P pfet_06v0 ad=4.4p pd=20.88u as=2.5p ps=10.5u w=10u l=1u
X1367 a_31498_17056# a_26038_16940# S2P S2P pfet_06v0 ad=2.5p pd=10.5u as=4.4p ps=20.88u w=10u l=1u
X1368 S2P a_34314_31016# a_33726_34416# S2P nfet_06v0 ad=1.1p pd=5.88u as=0.65p ps=3.02u w=2.5u l=1u
X1369 a_57806_51776# a_50078_48260# a_58394_48376# S2P nfet_06v0 ad=1.1p pd=5.88u as=0.65p ps=3.02u w=2.5u l=1u
X1370 a_47670_43092# a_50056_39576# a_47328_39692# S2P nfet_06v0 ad=1.1p pd=5.88u as=1.1p ps=5.88u w=2.5u l=1u
X1371 a_25998_48260# a_25998_48260# S2P S2P nfet_06v0 ad=0.44p pd=2.88u as=0.44p ps=2.88u w=1u l=1u
X1372 a_27228_22332# a_29886_25616# a_27650_25732# S2P pfet_06v0 ad=2.2p pd=10.88u as=2.2p ps=10.88u w=5u l=1u
X1373 a_6246_13656# a_8922_13540# a_9122_13656# S2P nfet_06v0 ad=2.2p pd=10.88u as=1.3p ps=5.52u w=5u l=1u
X1374 a_26496_39692# a_29886_42976# a_26838_43092# S2P pfet_06v0 ad=2.2p pd=10.88u as=2.2p ps=10.88u w=5u l=1u
X1375 a_68484_7790# a_67772_7790# w_64222_7494# w_64222_7494# pfet_05v0 ad=0.8052p pd=4.54u as=0.8052p ps=4.54u w=1.83u l=0.5u
X1376 a_17362_48376# a_2650_48260# S2P S2P nfet_06v0 ad=1.25p pd=5.5u as=2.2p ps=10.88u w=5u l=1u
X1377 a_8392_39576# a_2258_42976# a_12802_43092# S2P pfet_06v0 ad=4.4p pd=20.88u as=2.5p ps=10.5u w=10u l=1u
X1378 a_17866_51660# a_2258_51660# a_18066_51776# S2P pfet_06v0 ad=4.4p pd=20.88u as=2.5p ps=10.5u w=10u l=1u
X1379 a_63858_65732# a_50418_69132# a_68150_69248# S2P pfet_06v0 ad=4.4p pd=20.88u as=2.5p ps=10.5u w=10u l=1u
X1380 a_23050_4744# a_23050_4744# S2P S2P nfet_06v0 ad=0.44p pd=2.88u as=0.44p ps=2.88u w=1u l=1u
X1381 a_26026_60452# S4N a_23290_60452# S2P pfet_06v0 ad=4.4p pd=20.88u as=4.4p ps=20.88u w=10u l=1u
X1382 a_4914_31016# a_2258_34300# S2P S2P nfet_06v0 ad=0.25p pd=1.5u as=0.44p ps=2.88u w=1u l=1u
X1383 a_47328_39692# a_50718_42976# a_47670_43092# S2P pfet_06v0 ad=2.2p pd=10.88u as=2.2p ps=10.88u w=5u l=1u
X1384 a_20158_13656# a_11346_13656# S2P S2P nfet_06v0 ad=1.3p pd=5.52u as=2.2p ps=10.88u w=5u l=1u
X1385 a_54466_25732# a_43622_25616# S2P S2P pfet_06v0 ad=2.5p pd=10.5u as=4.4p ps=20.88u w=10u l=1u
X1386 a_22950_57052# a_22750_56936# S2P S2P nfet_06v0 ad=1.25p pd=5.5u as=2.2p ps=10.88u w=5u l=1u
X1387 a_56170_65848# a_55970_65732# a_54406_65848# S2P nfet_06v0 ad=1.3p pd=5.52u as=2.2p ps=10.88u w=5u l=1u
X1388 a_26930_48376# a_26730_48260# S2P S2P nfet_06v0 ad=1.25p pd=5.5u as=2.2p ps=10.88u w=5u l=1u
X1389 a_10678_60336# a_2258_60336# a_10878_60452# S2P pfet_06v0 ad=4.4p pd=20.88u as=2.5p ps=10.5u w=10u l=1u
X1390 a_50718_8144# a_43882_4744# a_51720_4860# S2P nfet_06v0 ad=2.2p pd=10.88u as=1.25p ps=5.5u w=5u l=1u
X1391 a_65550_40518# a_65638_40402# a_64528_42506# S2P nfet_06v0 ad=1.0912p pd=5.84u as=0.6448p ps=3u w=2.48u l=1u
X1392 a_20158_48376# a_11878_51776# S2P S2P pfet_06v0 ad=4.4p pd=20.88u as=2.6p ps=10.52u w=10u l=1u
X1393 a_57282_48376# a_58922_51776# S2P S2P pfet_06v0 ad=1.3p pd=5.52u as=1.3p ps=5.52u w=5u l=1u
X1394 S2P a_65990_56900# a_69418_57016# S2P nfet_06v0 ad=0.44p pd=2.88u as=0.25p ps=1.5u w=1u l=1u
X1395 a_5790_74376# a_5878_74260# S2P S2P pfet_06v0 ad=1.32p pd=6.88u as=1.32p ps=6.88u w=3u l=1u
X1396 a_65902_57016# a_65990_56900# S2P S2P pfet_06v0 ad=1.32p pd=6.88u as=1.32p ps=6.88u w=3u l=1u
X1397 S2P a_10234_65848# a_8530_69248# S2P nfet_06v0 ad=0.65p pd=3.02u as=0.65p ps=3.02u w=2.5u l=1u
X1398 S2P a_34314_48376# a_32610_51776# S2P nfet_06v0 ad=1.1p pd=5.88u as=0.65p ps=3.02u w=2.5u l=1u
X1399 a_6396_39692# a_2218_39576# a_4382_43092# S2P nfet_06v0 ad=1.1p pd=5.88u as=1.1p ps=5.88u w=2.5u l=1u
X1400 a_10762_51776# a_2258_51660# a_9122_48376# S2P pfet_06v0 ad=1.3p pd=5.52u as=2.2p ps=10.88u w=5u l=1u
X1401 a_3882_31016# a_2258_34300# S2P S2P nfet_06v0 ad=0.25p pd=1.5u as=0.44p ps=2.88u w=1u l=1u
X1402 a_34746_60452# a_22790_60336# S2P S2P pfet_06v0 ad=2.5p pd=10.5u as=4.4p ps=20.88u w=10u l=1u
X1403 a_4182_57052# a_6006_60452# S2P S2P pfet_06v0 ad=2.2p pd=10.88u as=2.2p ps=10.88u w=5u l=1u
X1404 a_57806_51776# a_58394_48376# S2P S2P nfet_06v0 ad=0.65p pd=3.02u as=0.65p ps=3.02u w=2.5u l=1u
X1405 a_64402_16940# a_64402_16940# a_66026_16940# S2P pfet_06v0 ad=4.4p pd=20.88u as=4.4p ps=20.88u w=10u l=1u
X1406 a_33202_13656# a_34842_17056# S2P S2P pfet_06v0 ad=1.3p pd=5.52u as=2.2p ps=10.88u w=5u l=1u
X1407 a_33726_34416# a_34314_31016# S2P S2P nfet_06v0 ad=0.65p pd=3.02u as=1.1p ps=5.88u w=2.5u l=1u
X1408 a_45846_4860# S3P a_44082_4860# S2P nfet_06v0 ad=2.2p pd=10.88u as=2.2p ps=10.88u w=5u l=1u
X1409 S2P a_68486_56900# a_68398_57016# S2P nfet_06v0 ad=0.44p pd=2.88u as=0.44p ps=2.88u w=1u l=1u
X1410 a_32090_31016# a_34842_34416# S2P S2P pfet_06v0 ad=1.3p pd=5.52u as=2.2p ps=10.88u w=5u l=1u
X1411 a_8530_51776# a_10234_48376# S2P S2P nfet_06v0 ad=0.65p pd=3.02u as=0.65p ps=3.02u w=2.5u l=1u
X1412 a_1918_30900# a_2258_34300# a_2158_34416# S2P pfet_06v0 ad=4.4p pd=20.88u as=2.5p ps=10.5u w=10u l=1u
X1413 a_4382_25732# S1P a_2458_25732# S2P pfet_06v0 ad=4.4p pd=20.88u as=4.4p ps=20.88u w=10u l=1u
X1414 a_43622_42976# a_43922_42976# a_58614_43092# S2P pfet_06v0 ad=4.4p pd=20.88u as=2.5p ps=10.5u w=10u l=1u
X1415 a_63858_65732# a_63858_65732# a_66266_65848# S2P nfet_06v0 ad=2.2p pd=10.88u as=2.2p ps=10.88u w=5u l=1u
X1416 a_16380_39692# a_2258_42976# S2P S2P nfet_06v0 ad=0.25p pd=1.5u as=0.44p ps=2.88u w=1u l=1u
X1417 a_50078_48260# a_50078_48260# S2P S2P nfet_06v0 ad=0.44p pd=2.88u as=0.44p ps=2.88u w=1u l=1u
X1418 a_64528_25146# a_69626_23042# a_69538_23158# S2P nfet_06v0 ad=0.6448p pd=3u as=1.0912p ps=5.84u w=2.48u l=1u
X1419 a_33684_4860# a_27228_4860# S2P S2P nfet_06v0 ad=0.44p pd=2.88u as=0.44p ps=2.88u w=1u l=1u
X1420 a_25014_57052# a_26838_60452# S2P S2P pfet_06v0 ad=2.2p pd=10.88u as=2.2p ps=10.88u w=5u l=1u
X1421 S2P a_59506_13656# a_68318_13656# S2P nfet_06v0 ad=1.3p pd=5.52u as=1.3p ps=5.52u w=5u l=1u
X1422 a_44122_8260# a_43922_8144# a_44934_8260# S2P pfet_06v0 ad=4.4p pd=20.88u as=2.5p ps=10.5u w=10u l=1u
X1423 a_19126_48376# a_18106_48376# S2P S2P nfet_06v0 ad=1.25p pd=5.5u as=2.2p ps=10.88u w=5u l=1u
X1424 S2P a_10762_51776# a_9122_48376# S2P pfet_06v0 ad=2.2p pd=10.88u as=1.3p ps=5.52u w=5u l=1u
X1425 a_15026_8260# a_1958_8144# S2P S2P pfet_06v0 ad=2.5p pd=10.5u as=4.4p ps=20.88u w=10u l=1u
X1426 a_8530_17056# a_20158_13656# cap_mim_2f0_m4m5_noshield c_width=20u c_length=10u
X1427 a_33684_39692# a_27228_39692# S2P S2P nfet_06v0 ad=0.44p pd=2.88u as=0.44p ps=2.88u w=1u l=1u
X1428 a_26730_65732# a_26338_69132# a_27350_69248# S2P pfet_06v0 ad=4.4p pd=20.88u as=2.5p ps=10.5u w=10u l=1u
X1429 a_30326_31016# a_31890_30900# a_32090_31016# S2P nfet_06v0 ad=2.2p pd=10.88u as=1.3p ps=5.52u w=5u l=1u
X1430 a_34842_34416# a_26338_34300# a_33202_31016# S2P pfet_06v0 ad=1.3p pd=5.52u as=2.2p ps=10.88u w=5u l=1u
X1431 a_52342_8144# a_43922_8144# a_52542_8260# S2P pfet_06v0 ad=4.4p pd=20.88u as=2.5p ps=10.5u w=10u l=1u
X1432 a_54766_17056# a_55970_13540# a_56690_17056# S2P pfet_06v0 ad=4.4p pd=20.88u as=2.6p ps=10.52u w=10u l=1u
X1433 a_54406_13656# a_50078_13540# a_55138_13656# S2P nfet_06v0 ad=2.2p pd=10.88u as=1.25p ps=5.5u w=5u l=1u
X1434 S2P a_11878_34416# a_20158_31016# S2P pfet_06v0 ad=2.6p pd=10.52u as=2.6p ps=10.52u w=10u l=1u
X1435 a_48482_43092# a_50056_39576# a_48060_39692# S2P nfet_06v0 ad=1.1p pd=5.88u as=1.1p ps=5.88u w=2.5u l=1u
X1436 a_44238_65848# a_35426_65848# S2P S2P nfet_06v0 ad=2.2p pd=10.88u as=1.3p ps=5.52u w=5u l=1u
X1437 S2P a_58922_34416# a_57282_31016# S2P pfet_06v0 ad=1.3p pd=5.52u as=1.3p ps=5.52u w=5u l=1u
X1438 S2P a_34842_51776# a_32090_48376# S2P pfet_06v0 ad=2.2p pd=10.88u as=1.3p ps=5.52u w=5u l=1u
X1439 S2P a_12670_74260# a_14866_74260# S2P pfet_06v0 ad=1.32p pd=6.88u as=1.32p ps=6.88u w=3u l=1u
X1440 a_44238_13656# a_35426_13656# S2P S2P nfet_06v0 ad=1.3p pd=5.52u as=2.2p ps=10.88u w=5u l=1u
X1441 a_8530_17056# a_1918_13540# a_11346_13656# S2P nfet_06v0 ad=1.1p pd=5.88u as=0.65p ps=3.02u w=2.5u l=1u
X1442 a_68794_23158# a_64528_25146# S2P S2P nfet_06v0 ad=0.5p pd=2.5u as=0.88p ps=4.88u w=2u l=1u
X1443 a_43882_56936# a_43882_56936# S2P S2P nfet_06v0 ad=0.44p pd=2.88u as=0.44p ps=2.88u w=1u l=1u
X1444 a_10056_4860# a_1918_4744# S2P S2P nfet_06v0 ad=1.25p pd=5.5u as=2.2p ps=10.88u w=5u l=1u
X1445 a_44122_43092# a_43922_42976# a_44934_43092# S2P pfet_06v0 ad=4.4p pd=20.88u as=2.5p ps=10.5u w=10u l=1u
X1446 a_65888_21834# a_65888_21834# w_64222_24966# w_64222_24966# pfet_06v0 ad=0.88p pd=4.88u as=0.88p ps=4.88u w=2u l=1u
X1447 a_54516_22332# a_48482_25732# S2P S2P pfet_06v0 ad=0.308p pd=2.28u as=0.308p ps=2.28u w=0.7u l=20u
X1448 a_17866_69132# a_2258_69132# a_18066_69248# S2P pfet_06v0 ad=4.4p pd=20.88u as=2.5p ps=10.5u w=10u l=1u
X1449 a_46858_25732# a_46378_22216# a_44122_25732# S2P pfet_06v0 ad=4.4p pd=20.88u as=4.4p ps=20.88u w=10u l=1u
X1450 S2P a_58394_48376# a_56690_51776# S2P nfet_06v0 ad=1.1p pd=5.88u as=0.65p ps=3.02u w=2.5u l=1u
X1451 a_33684_57052# a_27650_60452# S2P S2P pfet_06v0 ad=0.308p pd=2.28u as=0.308p ps=2.28u w=0.7u l=20u
X1452 S2P a_1918_74260# a_5046_74376# S2P nfet_06v0 ad=0.44p pd=2.88u as=0.25p ps=1.5u w=1u l=1u
X1453 S2P a_34314_31016# a_32610_34416# S2P nfet_06v0 ad=0.65p pd=3.02u as=0.65p ps=3.02u w=2.5u l=1u
X1454 a_8010_48376# a_10762_51776# S2P S2P pfet_06v0 ad=1.3p pd=5.52u as=1.3p ps=5.52u w=5u l=1u
X1455 a_65888_4362# a_65888_4362# a_68152_4478# S2P nfet_06v0 ad=0.308p pd=2.28u as=0.175p ps=1.2u w=0.7u l=1u
X1456 a_8010_31016# a_7810_30900# a_6246_31016# S2P nfet_06v0 ad=1.3p pd=5.52u as=2.2p ps=10.88u w=5u l=1u
X1457 a_2158_43092# a_1958_42976# S2P S2P pfet_06v0 ad=2.5p pd=10.5u as=4.4p ps=20.88u w=10u l=1u
X1458 a_51720_39692# a_43582_39576# S2P S2P nfet_06v0 ad=1.25p pd=5.5u as=2.2p ps=10.88u w=5u l=1u
X1459 a_20158_65848# a_11878_69248# S2P S2P pfet_06v0 ad=4.4p pd=20.88u as=2.6p ps=10.52u w=10u l=1u
X1460 a_32090_31016# a_26338_34300# a_35958_34416# S2P pfet_06v0 ad=2.2p pd=10.88u as=1.3p ps=5.52u w=5u l=1u
X1461 a_25998_13540# a_26338_16940# a_26238_17056# S2P pfet_06v0 ad=4.4p pd=20.88u as=2.5p ps=10.5u w=10u l=1u
X1462 a_57282_65848# a_58922_69248# S2P S2P pfet_06v0 ad=1.3p pd=5.52u as=1.3p ps=5.52u w=5u l=1u
X1463 a_33202_48376# a_33002_48260# a_30326_48376# S2P nfet_06v0 ad=1.3p pd=5.52u as=2.2p ps=10.88u w=5u l=1u
X1464 a_2850_65848# a_2650_65732# S2P S2P nfet_06v0 ad=1.25p pd=5.5u as=2.2p ps=10.88u w=5u l=1u
X1465 a_56690_60452# a_43622_60336# S2P S2P pfet_06v0 ad=2.5p pd=10.5u as=4.4p ps=20.88u w=10u l=1u
X1466 a_10762_69248# a_2258_69132# a_9122_65848# S2P pfet_06v0 ad=1.3p pd=5.52u as=2.2p ps=10.88u w=5u l=1u
X1467 a_23290_25732# a_23090_25616# a_24102_25732# S2P pfet_06v0 ad=4.4p pd=20.88u as=2.5p ps=10.5u w=10u l=1u
X1468 a_55578_25732# a_43622_25616# S2P S2P pfet_06v0 ad=2.5p pd=10.5u as=4.4p ps=20.88u w=10u l=1u
X1469 a_54406_48376# a_50078_48260# a_54106_48376# S2P nfet_06v0 ad=2.2p pd=10.88u as=1.25p ps=5.5u w=5u l=1u
X1470 a_22990_25732# a_22790_25616# S2P S2P pfet_06v0 ad=2.5p pd=10.5u as=4.4p ps=20.88u w=10u l=1u
X1471 a_43206_48376# a_42186_48376# S2P S2P nfet_06v0 ad=1.25p pd=5.5u as=2.2p ps=10.88u w=5u l=1u
X1472 a_55578_8260# a_43622_8144# S2P S2P pfet_06v0 ad=2.5p pd=10.5u as=4.4p ps=20.88u w=10u l=1u
X1473 a_35958_34416# a_39778_30900# a_35426_31016# S2P nfet_06v0 ad=1.1p pd=5.88u as=1.1p ps=5.88u w=2.5u l=1u
X1474 a_4382_8260# S1P a_2458_8260# S2P pfet_06v0 ad=4.4p pd=20.88u as=4.4p ps=20.88u w=10u l=1u
X1475 a_4914_39692# a_4714_39576# a_2418_39692# S2P nfet_06v0 ad=2.2p pd=10.88u as=2.2p ps=10.88u w=5u l=1u
X1476 a_32090_31016# a_34842_34416# S2P S2P pfet_06v0 ad=1.3p pd=5.52u as=1.3p ps=5.52u w=5u l=1u
X1477 a_16242_16940# a_1918_13540# a_17362_13656# S2P nfet_06v0 ad=2.2p pd=10.88u as=1.25p ps=5.5u w=5u l=1u
X1478 a_64438_4478# a_64526_4362# a_64528_7674# S2P nfet_06v0 ad=1.0912p pd=5.84u as=0.6448p ps=3u w=2.48u l=1u
X1479 a_29886_8144# a_23050_4744# a_30888_4860# S2P nfet_06v0 ad=2.2p pd=10.88u as=1.25p ps=5.5u w=5u l=1u
X1480 a_4914_4860# a_6006_8260# S2P S2P pfet_06v0 ad=2.2p pd=10.88u as=2.2p ps=10.88u w=5u l=1u
X1481 a_4382_43092# a_5664_39692# S2P S2P nfet_06v0 ad=1.1p pd=5.88u as=1.1p ps=5.88u w=2.5u l=1u
X1482 a_1958_8144# a_2258_8144# a_15348_4860# S2P nfet_06v0 ad=0.44p pd=2.88u as=0.25p ps=1.5u w=1u l=1u
X1483 a_35858_60452# a_22790_60336# S2P S2P pfet_06v0 ad=2.5p pd=10.5u as=4.4p ps=20.88u w=10u l=1u
X1484 S2P a_10762_69248# a_9122_65848# S2P pfet_06v0 ad=2.2p pd=10.88u as=1.3p ps=5.52u w=5u l=1u
X1485 a_68318_31016# a_59506_31016# S2P S2P nfet_06v0 ad=2.2p pd=10.88u as=1.3p ps=5.52u w=5u l=1u
X1486 a_25746_39692# a_25546_39576# a_23250_39692# S2P nfet_06v0 ad=2.2p pd=10.88u as=2.2p ps=10.88u w=5u l=1u
X1487 a_50418_51660# a_50418_51660# a_53074_48376# S2P nfet_06v0 ad=0.44p pd=2.88u as=0.25p ps=1.5u w=1u l=1u
X1488 a_32610_17056# a_34314_13656# S2P S2P nfet_06v0 ad=0.65p pd=3.02u as=0.65p ps=3.02u w=2.5u l=1u
X1489 a_56690_51776# a_58394_48376# S2P S2P nfet_06v0 ad=0.65p pd=3.02u as=1.1p ps=5.88u w=2.5u l=1u
X1490 a_10762_51776# a_15698_48260# a_10234_48376# S2P nfet_06v0 ad=1.1p pd=5.88u as=1.1p ps=5.88u w=2.5u l=1u
X1491 a_65550_23158# a_65888_21834# S2P S2P nfet_06v0 ad=0.5456p pd=3.36u as=0.5456p ps=3.36u w=1.24u l=1u
X1492 a_9646_17056# a_8922_13540# a_6606_17056# S2P pfet_06v0 ad=2.6p pd=10.52u as=4.4p ps=20.88u w=10u l=1u
X1493 a_25214_43092# a_26496_39692# S2P S2P nfet_06v0 ad=1.1p pd=5.88u as=1.1p ps=5.88u w=2.5u l=1u
X1494 S2P a_34842_69248# a_32090_65848# S2P pfet_06v0 ad=2.2p pd=10.88u as=1.3p ps=5.52u w=5u l=1u
X1495 a_48060_39692# a_50718_42976# a_48482_43092# S2P pfet_06v0 ad=2.2p pd=10.88u as=2.2p ps=10.88u w=5u l=1u
X1496 a_54516_22332# a_45846_22332# cap_mim_2f0_m4m5_noshield c_width=20u c_length=10u
X1497 a_53354_34416# a_50118_34300# S2P S2P pfet_06v0 ad=2.5p pd=10.5u as=4.4p ps=20.88u w=10u l=1u
X1498 a_8530_34416# a_20158_31016# cap_mim_2f0_m4m5_noshield c_width=20u c_length=10u
X1499 a_43922_60336# a_43922_60336# a_58044_57052# S2P nfet_06v0 ad=0.44p pd=2.88u as=0.25p ps=1.5u w=1u l=1u
X1500 a_9054_60336# a_9054_60336# a_10678_60336# S2P pfet_06v0 ad=4.4p pd=20.88u as=4.4p ps=20.88u w=10u l=1u
X1501 S2P a_14134_74260# a_16630_74260# S2P pfet_06v0 ad=1.32p pd=6.88u as=1.32p ps=6.88u w=3u l=1u
X1502 S2P a_5878_74260# a_5790_74376# S2P nfet_06v0 ad=0.44p pd=2.88u as=0.44p ps=2.88u w=1u l=1u
X1503 a_20158_65848# a_8010_65848# cap_mim_2f0_m4m5_noshield c_width=20u c_length=10u
X1504 a_10878_25732# a_10678_25616# S2P S2P pfet_06v0 ad=2.5p pd=10.5u as=4.4p ps=20.88u w=10u l=1u
X1505 a_11878_51776# a_15698_48260# a_11346_48376# S2P nfet_06v0 ad=1.1p pd=5.88u as=1.1p ps=5.88u w=2.5u l=1u
X1506 a_8010_65848# a_10762_69248# S2P S2P pfet_06v0 ad=1.3p pd=5.52u as=1.3p ps=5.52u w=5u l=1u
X1507 S2P a_65902_57016# a_66722_56900# S2P pfet_06v0 ad=1.32p pd=6.88u as=1.32p ps=6.88u w=3u l=1u
X1508 a_25014_4860# S2P a_23250_4860# S2P nfet_06v0 ad=2.2p pd=10.88u as=2.2p ps=10.88u w=5u l=1u
X1509 S2P a_10234_13656# a_9646_17056# S2P nfet_06v0 ad=0.65p pd=3.02u as=0.65p ps=3.02u w=2.5u l=1u
X1510 S2P a_24798_74376# a_25618_74260# S2P pfet_06v0 ad=1.32p pd=6.88u as=1.32p ps=6.88u w=3u l=1u
X1511 a_6246_48376# a_1918_48260# a_6978_48376# S2P nfet_06v0 ad=2.2p pd=10.88u as=1.25p ps=5.5u w=5u l=1u
X1512 a_34314_31016# a_40322_34300# a_34842_34416# S2P pfet_06v0 ad=2.2p pd=10.88u as=2.2p ps=10.88u w=5u l=1u
X1513 a_23090_8144# a_23090_8144# S2P S2P pfet_06v0 ad=0.88p pd=4.88u as=0.88p ps=4.88u w=2u l=1u
X1514 a_6818_25732# a_8392_22216# a_6396_22332# S2P nfet_06v0 ad=1.1p pd=5.88u as=1.1p ps=5.88u w=2.5u l=1u
X1515 a_12852_4860# a_6396_4860# S2P S2P nfet_06v0 ad=0.44p pd=2.88u as=0.44p ps=2.88u w=1u l=1u
X1516 a_23290_8260# a_23090_8144# a_24102_8260# S2P pfet_06v0 ad=4.4p pd=20.88u as=2.5p ps=10.5u w=10u l=1u
X1517 a_64528_42506# a_64526_39194# a_64438_39310# S2P nfet_06v0 ad=0.6448p pd=3u as=1.0912p ps=5.84u w=2.48u l=1u
X1518 a_64528_42506# a_64528_42506# w_64222_42326# w_64222_42326# pfet_06v0 ad=0.52p pd=2.52u as=0.52p ps=2.52u w=2u l=1u
X1519 a_6810_74376# a_2330_75936# a_5878_74260# S2P nfet_06v0 ad=0.25p pd=1.5u as=0.44p ps=2.88u w=1u l=1u
X1520 a_9122_31016# a_8922_30900# a_6246_31016# S2P nfet_06v0 ad=1.3p pd=5.52u as=2.2p ps=10.88u w=5u l=1u
X1521 a_55138_48376# a_50810_48260# S2P S2P nfet_06v0 ad=1.25p pd=5.5u as=2.2p ps=10.88u w=5u l=1u
X1522 a_3270_34416# a_1958_34300# S2P S2P pfet_06v0 ad=2.5p pd=10.5u as=4.4p ps=20.88u w=10u l=1u
X1523 a_31510_8144# a_23090_8144# a_31710_8260# S2P pfet_06v0 ad=4.4p pd=20.88u as=2.5p ps=10.5u w=10u l=1u
X1524 a_5664_39692# a_2218_39576# a_5194_43092# S2P nfet_06v0 ad=1.1p pd=5.88u as=1.1p ps=5.88u w=2.5u l=1u
X1525 a_34314_48376# a_25998_48260# a_33726_51776# S2P nfet_06v0 ad=0.65p pd=3.02u as=1.1p ps=5.88u w=2.5u l=1u
X1526 a_2650_30900# a_1918_30900# a_2850_31016# S2P nfet_06v0 ad=2.2p pd=10.88u as=1.25p ps=5.5u w=5u l=1u
X1527 a_9054_42976# a_2218_39576# a_10056_39692# S2P nfet_06v0 ad=2.2p pd=10.88u as=1.25p ps=5.5u w=5u l=1u
X1528 a_1958_42976# a_2258_42976# a_16950_43092# S2P pfet_06v0 ad=4.4p pd=20.88u as=2.5p ps=10.5u w=10u l=1u
X1529 a_55980_4860# a_43582_4744# S2P S2P nfet_06v0 ad=1.25p pd=5.5u as=2.2p ps=10.88u w=5u l=1u
X1530 a_50810_13540# a_50078_13540# a_51010_13656# S2P nfet_06v0 ad=2.2p pd=10.88u as=1.25p ps=5.5u w=5u l=1u
X1531 a_12670_74260# a_60038_51776# S2P S2P pfet_06v0 ad=4.4p pd=20.88u as=2.6p ps=10.52u w=10u l=1u
X1532 a_46046_8260# a_54516_4860# cap_mim_2f0_m4m5_noshield c_width=20u c_length=10u
X1533 a_30326_65848# a_33002_65732# a_33202_65848# S2P nfet_06v0 ad=2.2p pd=10.88u as=1.3p ps=5.52u w=5u l=1u
X1534 a_35426_48376# a_40322_51660# a_35958_51776# S2P pfet_06v0 ad=2.2p pd=10.88u as=2.2p ps=10.88u w=5u l=1u
X1535 S2P a_64526_56900# a_67654_57016# S2P nfet_06v0 ad=0.44p pd=2.88u as=0.25p ps=1.5u w=1u l=1u
X1536 a_26496_39692# a_23050_39576# a_26026_43092# S2P nfet_06v0 ad=1.1p pd=5.88u as=1.1p ps=5.88u w=2.5u l=1u
X1537 a_64402_69132# a_50078_65732# a_65522_65848# S2P nfet_06v0 ad=2.2p pd=10.88u as=1.25p ps=5.5u w=5u l=1u
X1538 a_39778_13540# a_26338_16940# a_44070_17056# S2P pfet_06v0 ad=4.4p pd=20.88u as=2.5p ps=10.5u w=10u l=1u
X1539 S2P a_2330_75936# a_2230_76052# S2P pfet_06v0 ad=1.32p pd=6.88u as=0.75p ps=3.5u w=3u l=1u
X1540 a_30386_51776# a_26038_51660# S2P S2P pfet_06v0 ad=2.5p pd=10.5u as=4.4p ps=20.88u w=10u l=1u
X1541 S2P a_35958_51776# a_44238_48376# S2P pfet_06v0 ad=2.6p pd=10.52u as=2.6p ps=10.52u w=10u l=1u
X1542 a_33202_13656# a_26338_16940# a_34842_17056# S2P pfet_06v0 ad=2.2p pd=10.88u as=1.3p ps=5.52u w=5u l=1u
X1543 a_44122_43092# a_43922_42976# a_43822_43092# S2P pfet_06v0 ad=4.4p pd=20.88u as=2.5p ps=10.5u w=10u l=1u
X1544 a_2158_51776# a_1958_51660# S2P S2P pfet_06v0 ad=2.5p pd=10.5u as=4.4p ps=20.88u w=10u l=1u
X1545 a_31632_39692# a_23050_39576# a_32652_39692# S2P nfet_06v0 ad=2.2p pd=10.88u as=1.25p ps=5.5u w=5u l=1u
X1546 a_32090_13656# a_31890_13540# a_30326_13656# S2P nfet_06v0 ad=1.3p pd=5.52u as=2.2p ps=10.88u w=5u l=1u
X1547 a_47670_25732# a_43922_25616# a_46578_22332# S2P pfet_06v0 ad=2.2p pd=10.88u as=2.2p ps=10.88u w=5u l=1u
X1548 a_6606_17056# a_2258_16940# a_6306_17056# S2P pfet_06v0 ad=4.4p pd=20.88u as=2.5p ps=10.5u w=10u l=1u
X1549 S2P a_11346_31016# a_20158_31016# S2P nfet_06v0 ad=1.3p pd=5.52u as=1.3p ps=5.52u w=5u l=1u
X1550 a_8530_51776# a_20158_48376# cap_mim_2f0_m4m5_noshield c_width=20u c_length=10u
X1551 a_5194_17056# a_1958_16940# S2P S2P pfet_06v0 ad=2.5p pd=10.5u as=4.4p ps=20.88u w=10u l=1u
X1552 a_37212_57052# a_23090_60336# S2P S2P nfet_06v0 ad=0.25p pd=1.5u as=0.44p ps=2.88u w=1u l=1u
X1553 a_34842_17056# a_39778_13540# a_34314_13656# S2P nfet_06v0 ad=1.1p pd=5.88u as=1.1p ps=5.88u w=2.5u l=1u
X1554 a_26038_34300# a_26338_34300# a_27962_31016# S2P nfet_06v0 ad=0.44p pd=2.88u as=0.25p ps=1.5u w=1u l=1u
X1555 a_42186_13656# a_25998_13540# a_43206_13656# S2P nfet_06v0 ad=2.2p pd=10.88u as=1.25p ps=5.5u w=5u l=1u
X1556 a_64528_7674# a_64528_7674# a_67394_5686# S2P nfet_06v0 ad=0.52p pd=2.52u as=0.88p ps=4.88u w=2u l=1u
X1557 a_6006_25732# a_2258_25616# a_4914_22332# S2P pfet_06v0 ad=2.2p pd=10.88u as=2.2p ps=10.88u w=5u l=1u
X1558 a_12852_4860# a_6818_8260# S2P S2P pfet_06v0 ad=0.308p pd=2.28u as=0.308p ps=2.28u w=0.7u l=20u
X1559 a_60038_69248# a_63858_65732# a_59506_65848# S2P nfet_06v0 ad=1.1p pd=5.88u as=1.1p ps=5.88u w=2.5u l=1u
X1560 a_2258_16940# a_2258_16940# a_4914_13656# S2P nfet_06v0 ad=0.44p pd=2.88u as=0.25p ps=1.5u w=1u l=1u
X1561 a_59506_31016# a_64402_34300# a_60038_34416# S2P pfet_06v0 ad=2.2p pd=10.88u as=2.2p ps=10.88u w=5u l=1u
X1562 a_34746_8260# a_22790_8144# S2P S2P pfet_06v0 ad=2.5p pd=10.5u as=4.4p ps=20.88u w=10u l=1u
X1563 a_27350_17056# a_26038_16940# S2P S2P pfet_06v0 ad=2.5p pd=10.5u as=4.4p ps=20.88u w=10u l=1u
X1564 a_54516_57052# a_48060_57052# S2P S2P nfet_06v0 ad=0.44p pd=2.88u as=0.44p ps=2.88u w=1u l=1u
X1565 a_64528_25146# a_64526_21834# a_64438_21950# S2P nfet_06v0 ad=0.6448p pd=3u as=1.0912p ps=5.84u w=2.48u l=1u
X1566 a_2458_60452# a_2258_60336# a_2158_60452# S2P pfet_06v0 ad=4.4p pd=20.88u as=2.5p ps=10.5u w=10u l=1u
X1567 a_30686_34416# a_31890_30900# a_32610_34416# S2P pfet_06v0 ad=4.4p pd=20.88u as=2.6p ps=10.52u w=10u l=1u
X1568 a_23250_39692# a_23050_39576# a_22950_39692# S2P nfet_06v0 ad=2.2p pd=10.88u as=1.25p ps=5.5u w=5u l=1u
X1569 a_25214_43092# a_24814_39576# a_23290_43092# S2P pfet_06v0 ad=4.4p pd=20.88u as=4.4p ps=20.88u w=10u l=1u
X1570 a_9646_34416# a_10234_31016# S2P S2P nfet_06v0 ad=0.65p pd=3.02u as=0.65p ps=3.02u w=2.5u l=1u
X1571 a_52342_42976# a_43922_42976# a_52542_43092# S2P pfet_06v0 ad=4.4p pd=20.88u as=2.5p ps=10.5u w=10u l=1u
X1572 a_69196_25262# a_68484_25262# w_64222_24966# w_64222_24966# pfet_05v0 ad=0.8052p pd=4.54u as=0.8052p ps=4.54u w=1.83u l=0.5u
X1573 a_26838_25732# a_23090_25616# a_25746_22332# S2P pfet_06v0 ad=2.2p pd=10.88u as=2.2p ps=10.88u w=5u l=1u
X1574 a_54466_34416# a_50118_34300# S2P S2P pfet_06v0 ad=2.5p pd=10.5u as=4.4p ps=20.88u w=10u l=1u
X1575 S2P a_60038_34416# a_68318_31016# S2P pfet_06v0 ad=2.6p pd=10.52u as=2.6p ps=10.52u w=10u l=1u
X1576 a_10056_22332# a_1918_22216# S2P S2P nfet_06v0 ad=1.25p pd=5.5u as=2.2p ps=10.88u w=5u l=1u
X1577 a_54766_51776# a_57082_48260# a_57806_51776# S2P pfet_06v0 ad=4.4p pd=20.88u as=2.6p ps=10.52u w=10u l=1u
X1578 a_39778_13540# a_39778_13540# a_42186_13656# S2P nfet_06v0 ad=2.2p pd=10.88u as=2.2p ps=10.88u w=5u l=1u
X1579 S2P a_58394_65848# a_57806_69248# S2P nfet_06v0 ad=0.65p pd=3.02u as=0.65p ps=3.02u w=2.5u l=1u
X1580 a_68152_39310# a_65888_39194# a_67852_39310# S2P nfet_06v0 ad=0.175p pd=1.2u as=0.175p ps=1.2u w=0.7u l=1u
X1581 a_53484_57052# a_52464_57052# S2P S2P nfet_06v0 ad=1.25p pd=5.5u as=2.2p ps=10.88u w=5u l=1u
X1582 a_32610_17056# a_31890_13540# a_30686_17056# S2P pfet_06v0 ad=2.6p pd=10.52u as=4.4p ps=20.88u w=10u l=1u
X1583 a_66226_51776# a_66026_51660# S2P S2P pfet_06v0 ad=2.5p pd=10.5u as=4.4p ps=20.88u w=10u l=1u
X1584 S2P a_3382_74260# a_3294_74376# S2P nfet_06v0 ad=0.44p pd=2.88u as=0.44p ps=2.88u w=1u l=1u
X1585 a_23050_22216# a_23050_22216# S2P S2P nfet_06v0 ad=0.44p pd=2.88u as=0.44p ps=2.88u w=1u l=1u
X1586 a_8392_39576# a_8392_39576# a_10800_39692# S2P nfet_06v0 ad=2.2p pd=10.88u as=2.2p ps=10.88u w=5u l=1u
X1587 a_56690_51776# a_50078_48260# a_59506_48376# S2P nfet_06v0 ad=1.1p pd=5.88u as=0.65p ps=3.02u w=2.5u l=1u
X1588 a_52042_13656# a_50418_16940# S2P S2P nfet_06v0 ad=0.25p pd=1.5u as=0.44p ps=2.88u w=1u l=1u
X1589 a_33726_51776# a_33002_48260# a_30686_51776# S2P pfet_06v0 ad=2.6p pd=10.52u as=4.4p ps=20.88u w=10u l=1u
X1590 a_68318_65848# a_60038_69248# S2P S2P pfet_06v0 ad=4.4p pd=20.88u as=2.6p ps=10.52u w=10u l=1u
X1591 a_20158_13656# a_11346_13656# S2P S2P nfet_06v0 ad=2.2p pd=10.88u as=1.3p ps=5.52u w=5u l=1u
X1592 a_68318_13656# a_60038_17056# S2P S2P pfet_06v0 ad=2.6p pd=10.52u as=4.4p ps=20.88u w=10u l=1u
X1593 a_31510_25616# a_23090_25616# a_31710_25732# S2P pfet_06v0 ad=4.4p pd=20.88u as=2.5p ps=10.5u w=10u l=1u
X1594 a_15348_57052# a_2258_60336# S2P S2P nfet_06v0 ad=0.25p pd=1.5u as=0.44p ps=2.88u w=1u l=1u
X1595 a_5664_22332# a_9054_25616# a_6006_25732# S2P pfet_06v0 ad=2.2p pd=10.88u as=2.2p ps=10.88u w=5u l=1u
X1596 a_30686_34416# a_26338_34300# a_30386_34416# S2P pfet_06v0 ad=4.4p pd=20.88u as=2.5p ps=10.5u w=10u l=1u
X1597 a_35426_65848# a_40322_69132# a_35958_69248# S2P pfet_06v0 ad=2.2p pd=10.88u as=2.2p ps=10.88u w=5u l=1u
X1598 a_50810_48260# a_50418_51660# a_51430_51776# S2P pfet_06v0 ad=4.4p pd=20.88u as=2.5p ps=10.5u w=10u l=1u
X1599 a_60038_17056# a_50418_16940# a_56170_13656# S2P pfet_06v0 ad=1.3p pd=5.52u as=2.2p ps=10.88u w=5u l=1u
X1600 a_2258_34300# a_2258_34300# S2P S2P pfet_06v0 ad=0.88p pd=4.88u as=0.88p ps=4.88u w=2u l=1u
X1601 a_30026_31016# a_26730_30900# S2P S2P nfet_06v0 ad=1.25p pd=5.5u as=2.2p ps=10.88u w=5u l=1u
X1602 S2P a_58394_31016# a_57806_34416# S2P nfet_06v0 ad=1.1p pd=5.88u as=0.65p ps=3.02u w=2.5u l=1u
X1603 a_35426_48376# a_25998_48260# a_32610_51776# S2P nfet_06v0 ad=0.65p pd=3.02u as=1.1p ps=5.88u w=2.5u l=1u
X1604 S2P a_58922_34416# a_56170_31016# S2P pfet_06v0 ad=2.2p pd=10.88u as=1.3p ps=5.52u w=5u l=1u
X1605 S2P a_58922_51776# a_56170_48376# S2P pfet_06v0 ad=1.3p pd=5.52u as=1.3p ps=5.52u w=5u l=1u
X1606 S2P a_10234_31016# a_8530_34416# S2P nfet_06v0 ad=1.1p pd=5.88u as=0.65p ps=3.02u w=2.5u l=1u
X1607 a_30386_69248# a_26038_69132# S2P S2P pfet_06v0 ad=2.5p pd=10.5u as=4.4p ps=20.88u w=10u l=1u
X1608 S2P a_35958_69248# a_44238_65848# S2P pfet_06v0 ad=2.6p pd=10.52u as=2.6p ps=10.52u w=10u l=1u
X1609 w_64222_7494# a_64528_7674# a_64528_7674# w_64222_7494# pfet_06v0 ad=0.88p pd=4.88u as=0.52p ps=2.52u w=2u l=1u
X1610 a_46578_22332# a_46378_22216# a_44082_22332# S2P nfet_06v0 ad=2.2p pd=10.88u as=2.2p ps=10.88u w=5u l=1u
X1611 a_11820_39692# a_10800_39692# S2P S2P nfet_06v0 ad=1.25p pd=5.5u as=2.2p ps=10.88u w=5u l=1u
X1612 a_47328_4860# a_43882_4744# a_46858_8260# S2P nfet_06v0 ad=1.1p pd=5.88u as=1.1p ps=5.88u w=2.5u l=1u
X1613 a_25014_39692# a_24814_39576# a_23250_39692# S2P nfet_06v0 ad=2.2p pd=10.88u as=2.2p ps=10.88u w=5u l=1u
X1614 a_10678_8144# a_2258_8144# a_10878_8260# S2P pfet_06v0 ad=4.4p pd=20.88u as=2.5p ps=10.5u w=10u l=1u
X1615 a_2158_69248# a_1958_69132# S2P S2P pfet_06v0 ad=2.5p pd=10.5u as=4.4p ps=20.88u w=10u l=1u
X1616 a_41442_48376# a_26730_48260# S2P S2P nfet_06v0 ad=1.25p pd=5.5u as=2.2p ps=10.88u w=5u l=1u
X1617 a_57012_22332# a_43922_25616# S2P S2P nfet_06v0 ad=0.25p pd=1.5u as=0.44p ps=2.88u w=1u l=1u
X1618 a_41946_51660# a_26338_51660# a_42146_51776# S2P pfet_06v0 ad=4.4p pd=20.88u as=2.5p ps=10.5u w=10u l=1u
X1619 a_8010_48376# a_2258_51660# a_11878_51776# S2P pfet_06v0 ad=2.2p pd=10.88u as=1.3p ps=5.52u w=5u l=1u
X1620 a_33726_69248# a_25998_65732# a_34314_65848# S2P nfet_06v0 ad=1.1p pd=5.88u as=0.65p ps=3.02u w=2.5u l=1u
X1621 a_26730_65732# a_25998_65732# a_26930_65848# S2P nfet_06v0 ad=2.2p pd=10.88u as=1.25p ps=5.5u w=5u l=1u
X1622 a_3150_39692# a_1918_39576# S2P S2P nfet_06v0 ad=1.25p pd=5.5u as=2.2p ps=10.88u w=5u l=1u
X1623 a_6246_65848# a_7810_65732# a_8010_65848# S2P nfet_06v0 ad=2.2p pd=10.88u as=1.3p ps=5.52u w=5u l=1u
X1624 a_57806_34416# a_57082_30900# a_54766_34416# S2P pfet_06v0 ad=2.6p pd=10.52u as=4.4p ps=20.88u w=10u l=1u
X1625 a_26026_43092# a_26496_39692# S2P S2P nfet_06v0 ad=1.1p pd=5.88u as=1.1p ps=5.88u w=2.5u l=1u
X1626 a_28994_31016# a_26338_34300# S2P S2P nfet_06v0 ad=0.25p pd=1.5u as=0.44p ps=2.88u w=1u l=1u
X1627 a_6818_8260# a_8392_4744# a_6396_4860# S2P nfet_06v0 ad=1.1p pd=5.88u as=1.1p ps=5.88u w=2.5u l=1u
X1628 S2P a_23834_75936# a_27382_74260# S2P pfet_06v0 ad=1.32p pd=6.88u as=1.32p ps=6.88u w=3u l=1u
X1629 a_5946_13656# a_2650_13540# S2P S2P nfet_06v0 ad=1.25p pd=5.5u as=2.2p ps=10.88u w=5u l=1u
X1630 a_51010_48376# a_50810_48260# S2P S2P nfet_06v0 ad=1.25p pd=5.5u as=2.2p ps=10.88u w=5u l=1u
X1631 a_31498_51776# a_26038_51660# S2P S2P pfet_06v0 ad=2.5p pd=10.5u as=4.4p ps=20.88u w=10u l=1u
X1632 a_68152_21950# a_65888_21834# a_67852_21950# S2P nfet_06v0 ad=0.175p pd=1.2u as=0.175p ps=1.2u w=0.7u l=1u
X1633 a_23982_39692# a_22750_39576# S2P S2P nfet_06v0 ad=1.25p pd=5.5u as=2.2p ps=10.88u w=5u l=1u
X1634 a_31710_43092# a_31510_42976# S2P S2P pfet_06v0 ad=2.5p pd=10.5u as=4.4p ps=20.88u w=10u l=1u
X1635 a_55980_22332# a_43582_22216# S2P S2P nfet_06v0 ad=1.25p pd=5.5u as=2.2p ps=10.88u w=5u l=1u
X1636 a_6606_17056# a_2258_16940# a_7418_17056# S2P pfet_06v0 ad=4.4p pd=20.88u as=2.5p ps=10.5u w=10u l=1u
X1637 a_46046_60452# a_47328_57052# S2P S2P nfet_06v0 ad=1.1p pd=5.88u as=1.1p ps=5.88u w=2.5u l=1u
X1638 a_66266_48376# a_50078_48260# a_67286_48376# S2P nfet_06v0 ad=2.2p pd=10.88u as=1.25p ps=5.5u w=5u l=1u
X1639 a_54766_69248# a_57082_65732# a_57806_69248# S2P pfet_06v0 ad=4.4p pd=20.88u as=2.6p ps=10.52u w=10u l=1u
X1640 a_66026_34300# a_50418_34300# a_66226_34416# S2P pfet_06v0 ad=4.4p pd=20.88u as=2.5p ps=10.5u w=10u l=1u
X1641 S2P a_34314_48376# a_33726_51776# S2P nfet_06v0 ad=1.1p pd=5.88u as=0.65p ps=3.02u w=2.5u l=1u
X1642 a_26338_16940# a_26338_16940# S2P S2P pfet_06v0 ad=0.88p pd=4.88u as=0.88p ps=4.88u w=2u l=1u
X1643 a_20158_13656# a_11878_17056# S2P S2P pfet_06v0 ad=2.6p pd=10.52u as=4.4p ps=20.88u w=10u l=1u
X1644 a_57282_13656# a_58922_17056# S2P S2P pfet_06v0 ad=1.3p pd=5.52u as=2.2p ps=10.88u w=5u l=1u
X1645 a_57806_34416# a_58394_31016# S2P S2P nfet_06v0 ad=0.65p pd=3.02u as=1.1p ps=5.88u w=2.5u l=1u
X1646 a_57282_31016# a_50418_34300# a_58922_34416# S2P pfet_06v0 ad=2.2p pd=10.88u as=1.3p ps=5.52u w=5u l=1u
X1647 a_18106_65848# a_1918_65732# a_19126_65848# S2P nfet_06v0 ad=2.2p pd=10.88u as=1.25p ps=5.5u w=5u l=1u
X1648 a_67852_4478# a_65888_4362# a_67552_4478# S2P nfet_06v0 ad=0.175p pd=1.2u as=0.175p ps=1.2u w=0.7u l=1u
X1649 a_56170_31016# a_58922_34416# S2P S2P pfet_06v0 ad=1.3p pd=5.52u as=2.2p ps=10.88u w=5u l=1u
X1650 a_8530_34416# a_10234_31016# S2P S2P nfet_06v0 ad=0.65p pd=3.02u as=1.1p ps=5.88u w=2.5u l=1u
X1651 a_55578_34416# a_50118_34300# S2P S2P pfet_06v0 ad=2.5p pd=10.5u as=4.4p ps=20.88u w=10u l=1u
X1652 a_66226_69248# a_66026_69132# S2P S2P pfet_06v0 ad=2.5p pd=10.5u as=4.4p ps=20.88u w=10u l=1u
X1653 a_35148_22332# a_22750_22216# S2P S2P nfet_06v0 ad=1.25p pd=5.5u as=2.2p ps=10.88u w=5u l=1u
X1654 a_33726_69248# a_33002_65732# a_30686_69248# S2P pfet_06v0 ad=2.6p pd=10.52u as=4.4p ps=20.88u w=10u l=1u
X1655 Z a_67772_42622# w_64222_42326# w_64222_42326# pfet_05v0 ad=0.8052p pd=4.54u as=0.8052p ps=4.54u w=1.83u l=0.5u
X1656 a_11878_34416# a_2258_34300# a_8010_31016# S2P pfet_06v0 ad=1.3p pd=5.52u as=2.2p ps=10.88u w=5u l=1u
X1657 a_23090_25616# a_23090_25616# a_37212_22332# S2P nfet_06v0 ad=0.44p pd=2.88u as=0.25p ps=1.5u w=1u l=1u
X1658 S2P a_10762_17056# a_8010_13656# S2P pfet_06v0 ad=2.2p pd=10.88u as=1.3p ps=5.52u w=5u l=1u
X1659 a_4914_48376# a_2258_51660# S2P S2P nfet_06v0 ad=0.25p pd=1.5u as=0.44p ps=2.88u w=1u l=1u
X1660 a_26838_25732# a_29224_22216# a_26496_22332# S2P nfet_06v0 ad=1.1p pd=5.88u as=1.1p ps=5.88u w=2.5u l=1u
X1661 a_56690_8260# a_43622_8144# S2P S2P pfet_06v0 ad=2.5p pd=10.5u as=4.4p ps=20.88u w=10u l=1u
X1662 a_50810_65732# a_50418_69132# a_51430_69248# S2P pfet_06v0 ad=4.4p pd=20.88u as=2.5p ps=10.5u w=10u l=1u
X1663 a_6006_8260# a_8392_4744# a_5664_4860# S2P nfet_06v0 ad=1.1p pd=5.88u as=1.1p ps=5.88u w=2.5u l=1u
X1664 a_48482_43092# a_43922_42976# a_45846_39692# S2P pfet_06v0 ad=2.2p pd=10.88u as=2.2p ps=10.88u w=5u l=1u
X1665 a_15698_65732# a_15698_65732# a_18106_65848# S2P nfet_06v0 ad=2.2p pd=10.88u as=2.2p ps=10.88u w=5u l=1u
X1666 a_13914_8260# a_1958_8144# S2P S2P pfet_06v0 ad=2.5p pd=10.5u as=4.4p ps=20.88u w=10u l=1u
X1667 a_67772_7790# a_64528_7674# w_64222_7494# w_64222_7494# pfet_05v0 ad=0.8052p pd=4.54u as=0.8052p ps=4.54u w=1.83u l=0.5u
X1668 a_33202_31016# a_34842_34416# S2P S2P pfet_06v0 ad=1.3p pd=5.52u as=1.3p ps=5.52u w=5u l=1u
X1669 a_64402_51660# a_64402_51660# a_66026_51660# S2P pfet_06v0 ad=4.4p pd=20.88u as=4.4p ps=20.88u w=10u l=1u
X1670 a_33202_48376# a_34842_51776# S2P S2P pfet_06v0 ad=1.3p pd=5.52u as=2.2p ps=10.88u w=5u l=1u
X1671 S2P a_58922_69248# a_56170_65848# S2P pfet_06v0 ad=1.3p pd=5.52u as=1.3p ps=5.52u w=5u l=1u
X1672 a_37782_60452# a_22790_60336# S2P S2P pfet_06v0 ad=2.5p pd=10.5u as=4.4p ps=20.88u w=10u l=1u
X1673 a_48060_4860# a_50718_8144# a_48482_8260# S2P pfet_06v0 ad=2.2p pd=10.88u as=2.2p ps=10.88u w=5u l=1u
X1674 a_6818_43092# a_2258_42976# a_4182_39692# S2P pfet_06v0 ad=2.2p pd=10.88u as=2.2p ps=10.88u w=5u l=1u
X1675 a_30326_31016# a_25998_30900# a_30026_31016# S2P nfet_06v0 ad=2.2p pd=10.88u as=1.25p ps=5.5u w=5u l=1u
X1676 a_22790_25616# a_23090_25616# a_36180_22332# S2P nfet_06v0 ad=0.44p pd=2.88u as=0.25p ps=1.5u w=1u l=1u
X1677 a_3882_48376# a_2258_51660# S2P S2P nfet_06v0 ad=0.25p pd=1.5u as=0.44p ps=2.88u w=1u l=1u
X1678 a_8010_65848# a_2258_69132# a_11878_69248# S2P pfet_06v0 ad=2.2p pd=10.88u as=1.3p ps=5.52u w=5u l=1u
X1679 a_41946_69132# a_26338_69132# a_42146_69248# S2P pfet_06v0 ad=4.4p pd=20.88u as=2.5p ps=10.5u w=10u l=1u
X1680 a_30686_34416# a_26338_34300# a_31498_34416# S2P pfet_06v0 ad=4.4p pd=20.88u as=2.5p ps=10.5u w=10u l=1u
X1681 a_27962_65848# a_26338_69132# S2P S2P nfet_06v0 ad=0.25p pd=1.5u as=0.44p ps=2.88u w=1u l=1u
X1682 a_1958_34300# a_2258_34300# a_5194_34416# S2P pfet_06v0 ad=4.4p pd=20.88u as=2.5p ps=10.5u w=10u l=1u
X1683 a_59506_13656# a_50078_13540# a_56690_17056# S2P nfet_06v0 ad=0.65p pd=3.02u as=1.1p ps=5.88u w=2.5u l=1u
X1684 S2P a_58394_31016# a_56690_34416# S2P nfet_06v0 ad=0.65p pd=3.02u as=0.65p ps=3.02u w=2.5u l=1u
X1685 S2P a_10762_34416# a_9122_31016# S2P pfet_06v0 ad=1.3p pd=5.52u as=1.3p ps=5.52u w=5u l=1u
X1686 a_3270_60452# a_1958_60336# S2P S2P pfet_06v0 ad=2.5p pd=10.5u as=4.4p ps=20.88u w=10u l=1u
X1687 a_52464_22332# a_43882_22216# a_53484_22332# S2P nfet_06v0 ad=2.2p pd=10.88u as=1.25p ps=5.5u w=5u l=1u
X1688 a_33726_51776# a_34314_48376# S2P S2P nfet_06v0 ad=0.65p pd=3.02u as=1.1p ps=5.88u w=2.5u l=1u
X1689 S2P a_34842_17056# a_32090_13656# S2P pfet_06v0 ad=1.3p pd=5.52u as=1.3p ps=5.52u w=5u l=1u
X1690 a_47328_57052# a_43882_56936# a_46858_60452# S2P nfet_06v0 ad=1.1p pd=5.88u as=1.1p ps=5.88u w=2.5u l=1u
X1691 a_65522_13656# a_50810_13540# S2P S2P nfet_06v0 ad=1.25p pd=5.5u as=2.2p ps=10.88u w=5u l=1u
X1692 a_24102_43092# a_22790_42976# S2P S2P pfet_06v0 ad=2.5p pd=10.5u as=4.4p ps=20.88u w=10u l=1u
X1693 a_31498_69248# a_26038_69132# S2P S2P pfet_06v0 ad=2.5p pd=10.5u as=4.4p ps=20.88u w=10u l=1u
X1694 a_54766_51776# a_54516_39692# a_56690_51776# S2P pfet_06v0 ad=4.4p pd=20.88u as=2.6p ps=10.52u w=10u l=1u
X1695 a_27650_25732# a_23090_25616# a_25014_22332# S2P pfet_06v0 ad=2.2p pd=10.88u as=2.2p ps=10.88u w=5u l=1u
X1696 a_56170_31016# a_50418_34300# a_60038_34416# S2P pfet_06v0 ad=2.2p pd=10.88u as=1.3p ps=5.52u w=5u l=1u
X1697 S2P a_65990_56900# a_65902_57016# S2P nfet_06v0 ad=0.44p pd=2.88u as=0.44p ps=2.88u w=1u l=1u
X1698 a_50078_13540# a_50418_16940# a_50318_17056# S2P pfet_06v0 ad=4.4p pd=20.88u as=2.5p ps=10.5u w=10u l=1u
X1699 a_1918_13540# a_1918_13540# S2P S2P nfet_06v0 ad=0.44p pd=2.88u as=0.44p ps=2.88u w=1u l=1u
X1700 a_4382_43092# a_12852_39692# cap_mim_2f0_m4m5_noshield c_width=20u c_length=10u
X1701 a_2218_22216# a_2258_25616# a_13914_25732# S2P pfet_06v0 ad=4.4p pd=20.88u as=2.5p ps=10.5u w=10u l=1u
X1702 a_6246_65848# a_8922_65732# a_9122_65848# S2P nfet_06v0 ad=2.2p pd=10.88u as=1.3p ps=5.52u w=5u l=1u
X1703 a_1958_25616# a_2258_25616# a_15348_22332# S2P nfet_06v0 ad=0.44p pd=2.88u as=0.25p ps=1.5u w=1u l=1u
X1704 a_8010_13656# a_10762_17056# S2P S2P pfet_06v0 ad=1.3p pd=5.52u as=2.2p ps=10.88u w=5u l=1u
X1705 a_30326_48376# a_31890_48260# a_32090_48376# S2P nfet_06v0 ad=2.2p pd=10.88u as=1.3p ps=5.52u w=5u l=1u
X1706 a_4382_25732# a_12852_22332# cap_mim_2f0_m4m5_noshield c_width=20u c_length=10u
.ends
