* Extracted by KLayout with GF180MCU LVS runset on : 11/08/2026 02:44

.SUBCKT GRADIENT_NAV VDD X XN S2P S1P S3P S1N S2N S3N XP Y YN S4P YP Z ZN S4N
+ ZP VSS
M$1 \$9 X VDD VDD pfet_05v0 L=0.5U W=1.83U AS=0.8052P AD=0.8052P PS=4.54U
+ PD=4.54U
M$2 XP \$9 VDD VDD pfet_05v0 L=0.5U W=1.83U AS=0.8052P AD=0.8052P PS=4.54U
+ PD=4.54U
M$3 XN XP VDD VDD pfet_05v0 L=0.5U W=1.83U AS=0.8052P AD=0.8052P PS=4.54U
+ PD=4.54U
M$4 \$3584 Y VDD VDD pfet_05v0 L=0.5U W=1.83U AS=0.8052P AD=0.8052P PS=4.54U
+ PD=4.54U
M$5 YP \$3584 VDD VDD pfet_05v0 L=0.5U W=1.83U AS=0.8052P AD=0.8052P PS=4.54U
+ PD=4.54U
M$6 YN YP VDD VDD pfet_05v0 L=0.5U W=1.83U AS=0.8052P AD=0.8052P PS=4.54U
+ PD=4.54U
M$7 \$7131 Z VDD VDD pfet_05v0 L=0.5U W=1.83U AS=0.8052P AD=0.8052P PS=4.54U
+ PD=4.54U
M$8 ZP \$7131 VDD VDD pfet_05v0 L=0.5U W=1.83U AS=0.8052P AD=0.8052P PS=4.54U
+ PD=4.54U
M$9 ZN ZP VDD VDD pfet_05v0 L=0.5U W=1.83U AS=0.8052P AD=0.8052P PS=4.54U
+ PD=4.54U
M$10 \$30 \$61 VDD VDD pfet_06v0 L=20U W=0.7U AS=0.308P AD=0.308P PS=2.28U
+ PD=2.28U
M$11 \$41 \$62 VDD VDD pfet_06v0 L=20U W=0.7U AS=0.308P AD=0.308P PS=2.28U
+ PD=2.28U
M$12 \$52 \$63 VDD VDD pfet_06v0 L=20U W=0.7U AS=0.308P AD=0.308P PS=2.28U
+ PD=2.28U
M$13 \$1779 \$103 VDD VDD pfet_06v0 L=1U W=10U AS=4.4P AD=2.5P PS=20.88U
+ PD=10.5U
M$14 \$645 \$100 \$1779 VDD pfet_06v0 L=1U W=10U AS=2.5P AD=4.4P PS=10.5U
+ PD=20.88U
M$15 \$1780 \$103 VDD VDD pfet_06v0 L=1U W=10U AS=4.4P AD=2.5P PS=20.88U
+ PD=10.5U
M$16 \$645 \$100 \$1780 VDD pfet_06v0 L=1U W=10U AS=2.5P AD=4.4P PS=10.5U
+ PD=20.88U
M$17 \$26 S1P \$645 VDD pfet_06v0 L=1U W=10U AS=4.4P AD=4.4P PS=20.88U PD=20.88U
M$18 \$24 S1N \$645 VDD pfet_06v0 L=1U W=10U AS=4.4P AD=4.4P PS=20.88U PD=20.88U
M$19 \$414 \$100 \$23 VDD pfet_06v0 L=1U W=5U AS=2.2P AD=2.2P PS=10.88U
+ PD=10.88U
M$20 \$61 \$100 \$22 VDD pfet_06v0 L=1U W=5U AS=2.2P AD=2.2P PS=10.88U PD=10.88U
M$21 \$23 \$414 VDD VDD pfet_06v0 L=1U W=5U AS=2.2P AD=2.2P PS=10.88U PD=10.88U
M$22 \$22 \$414 VDD VDD pfet_06v0 L=1U W=5U AS=2.2P AD=2.2P PS=10.88U PD=10.88U
M$23 \$25 \$28 \$414 VDD pfet_06v0 L=1U W=5U AS=2.2P AD=2.2P PS=10.88U PD=10.88U
M$24 \$27 \$28 \$61 VDD pfet_06v0 L=1U W=5U AS=2.2P AD=2.2P PS=10.88U PD=10.88U
M$25 \$1785 \$335 VDD VDD pfet_06v0 L=1U W=10U AS=4.4P AD=2.5P PS=20.88U
+ PD=10.5U
M$26 \$335 \$100 \$1785 VDD pfet_06v0 L=1U W=10U AS=2.5P AD=4.4P PS=10.5U
+ PD=20.88U
M$27 \$28 \$28 \$335 VDD pfet_06v0 L=1U W=10U AS=4.4P AD=4.4P PS=20.88U
+ PD=20.88U
M$28 \$1786 \$103 VDD VDD pfet_06v0 L=1U W=10U AS=4.4P AD=2.5P PS=20.88U
+ PD=10.5U
M$29 \$12 \$100 \$1786 VDD pfet_06v0 L=1U W=10U AS=2.5P AD=4.4P PS=10.5U
+ PD=20.88U
M$30 \$1787 \$103 VDD VDD pfet_06v0 L=1U W=10U AS=4.4P AD=2.5P PS=20.88U
+ PD=10.5U
M$31 \$11 \$100 \$1787 VDD pfet_06v0 L=1U W=10U AS=2.5P AD=4.4P PS=10.5U
+ PD=20.88U
M$32 \$1788 \$103 VDD VDD pfet_06v0 L=1U W=10U AS=4.4P AD=2.5P PS=20.88U
+ PD=10.5U
M$33 \$10 \$100 \$1788 VDD pfet_06v0 L=1U W=10U AS=2.5P AD=4.4P PS=10.5U
+ PD=20.88U
M$34 \$100 \$100 VDD VDD pfet_06v0 L=1U W=2U AS=0.88P AD=0.88P PS=4.88U PD=4.88U
M$35 \$1791 \$103 VDD VDD pfet_06v0 L=1U W=10U AS=4.4P AD=2.5P PS=20.88U
+ PD=10.5U
M$36 \$103 \$100 \$1791 VDD pfet_06v0 L=1U W=10U AS=2.5P AD=4.4P PS=10.5U
+ PD=20.88U
M$37 \$1794 \$104 VDD VDD pfet_06v0 L=1U W=10U AS=4.4P AD=2.5P PS=20.88U
+ PD=10.5U
M$38 \$646 \$101 \$1794 VDD pfet_06v0 L=1U W=10U AS=2.5P AD=4.4P PS=10.5U
+ PD=20.88U
M$39 \$1795 \$104 VDD VDD pfet_06v0 L=1U W=10U AS=4.4P AD=2.5P PS=20.88U
+ PD=10.5U
M$40 \$646 \$101 \$1795 VDD pfet_06v0 L=1U W=10U AS=2.5P AD=4.4P PS=10.5U
+ PD=20.88U
M$41 \$37 S2P \$646 VDD pfet_06v0 L=1U W=10U AS=4.4P AD=4.4P PS=20.88U PD=20.88U
M$42 \$35 S2N \$646 VDD pfet_06v0 L=1U W=10U AS=4.4P AD=4.4P PS=20.88U PD=20.88U
M$43 \$416 \$101 \$34 VDD pfet_06v0 L=1U W=5U AS=2.2P AD=2.2P PS=10.88U
+ PD=10.88U
M$44 \$62 \$101 \$33 VDD pfet_06v0 L=1U W=5U AS=2.2P AD=2.2P PS=10.88U PD=10.88U
M$45 \$34 \$416 VDD VDD pfet_06v0 L=1U W=5U AS=2.2P AD=2.2P PS=10.88U PD=10.88U
M$46 \$33 \$416 VDD VDD pfet_06v0 L=1U W=5U AS=2.2P AD=2.2P PS=10.88U PD=10.88U
M$47 \$36 \$39 \$416 VDD pfet_06v0 L=1U W=5U AS=2.2P AD=2.2P PS=10.88U PD=10.88U
M$48 \$38 \$39 \$62 VDD pfet_06v0 L=1U W=5U AS=2.2P AD=2.2P PS=10.88U PD=10.88U
M$49 \$1798 \$336 VDD VDD pfet_06v0 L=1U W=10U AS=4.4P AD=2.5P PS=20.88U
+ PD=10.5U
M$50 \$336 \$101 \$1798 VDD pfet_06v0 L=1U W=10U AS=2.5P AD=4.4P PS=10.5U
+ PD=20.88U
M$51 \$39 \$39 \$336 VDD pfet_06v0 L=1U W=10U AS=4.4P AD=4.4P PS=20.88U
+ PD=20.88U
M$52 \$1797 \$104 VDD VDD pfet_06v0 L=1U W=10U AS=4.4P AD=2.5P PS=20.88U
+ PD=10.5U
M$53 \$15 \$101 \$1797 VDD pfet_06v0 L=1U W=10U AS=2.5P AD=4.4P PS=10.5U
+ PD=20.88U
M$54 \$1796 \$104 VDD VDD pfet_06v0 L=1U W=10U AS=4.4P AD=2.5P PS=20.88U
+ PD=10.5U
M$55 \$14 \$101 \$1796 VDD pfet_06v0 L=1U W=10U AS=2.5P AD=4.4P PS=10.5U
+ PD=20.88U
M$56 \$1793 \$104 VDD VDD pfet_06v0 L=1U W=10U AS=4.4P AD=2.5P PS=20.88U
+ PD=10.5U
M$57 \$13 \$101 \$1793 VDD pfet_06v0 L=1U W=10U AS=2.5P AD=4.4P PS=10.5U
+ PD=20.88U
M$58 \$101 \$101 VDD VDD pfet_06v0 L=1U W=2U AS=0.88P AD=0.88P PS=4.88U PD=4.88U
M$59 \$1792 \$104 VDD VDD pfet_06v0 L=1U W=10U AS=4.4P AD=2.5P PS=20.88U
+ PD=10.5U
M$60 \$104 \$101 \$1792 VDD pfet_06v0 L=1U W=10U AS=2.5P AD=4.4P PS=10.5U
+ PD=20.88U
M$61 \$1790 \$105 VDD VDD pfet_06v0 L=1U W=10U AS=4.4P AD=2.5P PS=20.88U
+ PD=10.5U
M$62 \$647 \$102 \$1790 VDD pfet_06v0 L=1U W=10U AS=2.5P AD=4.4P PS=10.5U
+ PD=20.88U
M$63 \$1789 \$105 VDD VDD pfet_06v0 L=1U W=10U AS=4.4P AD=2.5P PS=20.88U
+ PD=10.5U
M$64 \$647 \$102 \$1789 VDD pfet_06v0 L=1U W=10U AS=2.5P AD=4.4P PS=10.5U
+ PD=20.88U
M$65 \$48 S3P \$647 VDD pfet_06v0 L=1U W=10U AS=4.4P AD=4.4P PS=20.88U PD=20.88U
M$66 \$46 S3N \$647 VDD pfet_06v0 L=1U W=10U AS=4.4P AD=4.4P PS=20.88U PD=20.88U
M$67 \$418 \$102 \$45 VDD pfet_06v0 L=1U W=5U AS=2.2P AD=2.2P PS=10.88U
+ PD=10.88U
M$68 \$63 \$102 \$44 VDD pfet_06v0 L=1U W=5U AS=2.2P AD=2.2P PS=10.88U PD=10.88U
M$69 \$45 \$418 VDD VDD pfet_06v0 L=1U W=5U AS=2.2P AD=2.2P PS=10.88U PD=10.88U
M$70 \$44 \$418 VDD VDD pfet_06v0 L=1U W=5U AS=2.2P AD=2.2P PS=10.88U PD=10.88U
M$71 \$47 \$50 \$418 VDD pfet_06v0 L=1U W=5U AS=2.2P AD=2.2P PS=10.88U PD=10.88U
M$72 \$49 \$50 \$63 VDD pfet_06v0 L=1U W=5U AS=2.2P AD=2.2P PS=10.88U PD=10.88U
M$73 \$1784 \$337 VDD VDD pfet_06v0 L=1U W=10U AS=4.4P AD=2.5P PS=20.88U
+ PD=10.5U
M$74 \$337 \$102 \$1784 VDD pfet_06v0 L=1U W=10U AS=2.5P AD=4.4P PS=10.5U
+ PD=20.88U
M$75 \$50 \$50 \$337 VDD pfet_06v0 L=1U W=10U AS=4.4P AD=4.4P PS=20.88U
+ PD=20.88U
M$76 \$1783 \$105 VDD VDD pfet_06v0 L=1U W=10U AS=4.4P AD=2.5P PS=20.88U
+ PD=10.5U
M$77 \$18 \$102 \$1783 VDD pfet_06v0 L=1U W=10U AS=2.5P AD=4.4P PS=10.5U
+ PD=20.88U
M$78 \$1782 \$105 VDD VDD pfet_06v0 L=1U W=10U AS=4.4P AD=2.5P PS=20.88U
+ PD=10.5U
M$79 \$17 \$102 \$1782 VDD pfet_06v0 L=1U W=10U AS=2.5P AD=4.4P PS=10.5U
+ PD=20.88U
M$80 \$1781 \$105 VDD VDD pfet_06v0 L=1U W=10U AS=4.4P AD=2.5P PS=20.88U
+ PD=10.5U
M$81 \$16 \$102 \$1781 VDD pfet_06v0 L=1U W=10U AS=2.5P AD=4.4P PS=10.5U
+ PD=20.88U
M$82 \$102 \$102 VDD VDD pfet_06v0 L=1U W=2U AS=0.88P AD=0.88P PS=4.88U PD=4.88U
M$83 \$1778 \$105 VDD VDD pfet_06v0 L=1U W=10U AS=4.4P AD=2.5P PS=20.88U
+ PD=10.5U
M$84 \$105 \$102 \$1778 VDD pfet_06v0 L=1U W=10U AS=2.5P AD=4.4P PS=10.5U
+ PD=20.88U
M$85 \$3546 \$2712 VDD VDD pfet_06v0 L=1U W=10U AS=4.4P AD=2.5P PS=20.88U
+ PD=10.5U
M$86 \$1803 \$2865 \$3546 VDD pfet_06v0 L=1U W=10U AS=2.5P AD=4.4P PS=10.5U
+ PD=20.88U
M$87 \$3547 \$2712 VDD VDD pfet_06v0 L=1U W=10U AS=4.4P AD=2.5P PS=20.88U
+ PD=10.5U
M$88 \$1804 \$2865 \$3547 VDD pfet_06v0 L=1U W=10U AS=2.5P AD=4.4P PS=10.5U
+ PD=20.88U
M$89 \$2865 \$2865 VDD VDD pfet_06v0 L=1U W=2U AS=0.88P AD=0.88P PS=4.88U
+ PD=4.88U
M$90 \$3549 \$2712 VDD VDD pfet_06v0 L=1U W=10U AS=4.4P AD=2.5P PS=20.88U
+ PD=10.5U
M$91 \$2712 \$2865 \$3549 VDD pfet_06v0 L=1U W=10U AS=2.5P AD=4.4P PS=10.5U
+ PD=20.88U
M$92 \$3550 \$2712 VDD VDD pfet_06v0 L=1U W=10U AS=4.4P AD=2.5P PS=20.88U
+ PD=10.5U
M$93 \$2031 \$2865 \$3550 VDD pfet_06v0 L=1U W=10U AS=2.5P AD=4.4P PS=10.5U
+ PD=20.88U
M$94 \$3551 \$2712 VDD VDD pfet_06v0 L=1U W=10U AS=4.4P AD=2.5P PS=20.88U
+ PD=10.5U
M$95 \$2031 \$2865 \$3551 VDD pfet_06v0 L=1U W=10U AS=2.5P AD=4.4P PS=10.5U
+ PD=20.88U
M$96 \$1817 \$41 \$2031 VDD pfet_06v0 L=1U W=10U AS=4.4P AD=2.6P PS=20.88U
+ PD=10.52U
M$97 \$2031 \$41 \$1817 VDD pfet_06v0 L=1U W=10U AS=2.6P AD=4.4P PS=10.52U
+ PD=20.88U
M$98 \$1815 \$30 \$2031 VDD pfet_06v0 L=1U W=10U AS=4.4P AD=2.6P PS=20.88U
+ PD=10.52U
M$99 \$2031 \$30 \$1815 VDD pfet_06v0 L=1U W=10U AS=2.6P AD=4.4P PS=10.52U
+ PD=20.88U
M$100 \$2184 \$2865 \$1814 VDD pfet_06v0 L=1U W=5U AS=2.2P AD=1.3P PS=10.88U
+ PD=5.52U
M$101 \$1814 \$2865 \$2184 VDD pfet_06v0 L=1U W=5U AS=1.3P AD=2.2P PS=5.52U
+ PD=10.88U
M$102 \$1819 \$2865 \$1813 VDD pfet_06v0 L=1U W=5U AS=2.2P AD=1.3P PS=10.88U
+ PD=5.52U
M$103 \$1813 \$2865 \$1819 VDD pfet_06v0 L=1U W=5U AS=1.3P AD=2.2P PS=5.52U
+ PD=10.88U
M$104 \$1814 \$2184 VDD VDD pfet_06v0 L=1U W=5U AS=2.2P AD=1.3P PS=10.88U
+ PD=5.52U
M$105 VDD \$2184 \$1814 VDD pfet_06v0 L=1U W=5U AS=1.3P AD=1.3P PS=5.52U
+ PD=5.52U
M$106 \$1814 \$2184 VDD VDD pfet_06v0 L=1U W=5U AS=1.3P AD=1.3P PS=5.52U
+ PD=5.52U
M$107 VDD \$2184 \$1814 VDD pfet_06v0 L=1U W=5U AS=1.3P AD=2.2P PS=5.52U
+ PD=10.88U
M$108 \$1813 \$2184 VDD VDD pfet_06v0 L=1U W=5U AS=2.2P AD=1.3P PS=10.88U
+ PD=5.52U
M$109 VDD \$2184 \$1813 VDD pfet_06v0 L=1U W=5U AS=1.3P AD=1.3P PS=5.52U
+ PD=5.52U
M$110 \$1813 \$2184 VDD VDD pfet_06v0 L=1U W=5U AS=1.3P AD=1.3P PS=5.52U
+ PD=5.52U
M$111 VDD \$2184 \$1813 VDD pfet_06v0 L=1U W=5U AS=1.3P AD=2.2P PS=5.52U
+ PD=10.88U
M$112 \$1816 \$1820 \$2184 VDD pfet_06v0 L=1U W=5U AS=2.2P AD=2.2P PS=10.88U
+ PD=10.88U
M$113 \$1818 \$1820 \$1819 VDD pfet_06v0 L=1U W=5U AS=2.2P AD=2.2P PS=10.88U
+ PD=10.88U
M$114 \$3553 \$1878 VDD VDD pfet_06v0 L=1U W=10U AS=4.4P AD=2.5P PS=20.88U
+ PD=10.5U
M$115 \$1878 \$2865 \$3553 VDD pfet_06v0 L=1U W=10U AS=2.5P AD=4.4P PS=10.5U
+ PD=20.88U
M$116 \$1820 \$1820 \$1878 VDD pfet_06v0 L=1U W=10U AS=4.4P AD=4.4P PS=20.88U
+ PD=20.88U
M$117 \$3554 \$2712 VDD VDD pfet_06v0 L=1U W=10U AS=4.4P AD=2.5P PS=20.88U
+ PD=10.5U
M$118 \$1805 \$2865 \$3554 VDD pfet_06v0 L=1U W=10U AS=2.5P AD=4.4P PS=10.5U
+ PD=20.88U
M$119 \$1822 \$1819 VDD VDD pfet_06v0 L=1U W=10U AS=4.4P AD=2.6P PS=20.88U
+ PD=10.52U
M$120 VDD \$1819 \$1822 VDD pfet_06v0 L=1U W=10U AS=2.6P AD=2.6P PS=10.52U
+ PD=10.52U
M$121 \$1822 \$1819 VDD VDD pfet_06v0 L=1U W=10U AS=2.6P AD=4.4P PS=10.52U
+ PD=20.88U
M$122 \$3557 \$2713 VDD VDD pfet_06v0 L=1U W=10U AS=4.4P AD=2.5P PS=20.88U
+ PD=10.5U
M$123 \$1806 \$2866 \$3557 VDD pfet_06v0 L=1U W=10U AS=2.5P AD=4.4P PS=10.5U
+ PD=20.88U
M$124 \$3559 \$2713 VDD VDD pfet_06v0 L=1U W=10U AS=4.4P AD=2.5P PS=20.88U
+ PD=10.5U
M$125 \$1807 \$2866 \$3559 VDD pfet_06v0 L=1U W=10U AS=2.5P AD=4.4P PS=10.5U
+ PD=20.88U
M$126 \$2866 \$2866 VDD VDD pfet_06v0 L=1U W=2U AS=0.88P AD=0.88P PS=4.88U
+ PD=4.88U
M$127 \$3561 \$2713 VDD VDD pfet_06v0 L=1U W=10U AS=4.4P AD=2.5P PS=20.88U
+ PD=10.5U
M$128 \$2713 \$2866 \$3561 VDD pfet_06v0 L=1U W=10U AS=2.5P AD=4.4P PS=10.5U
+ PD=20.88U
M$129 \$3562 \$2713 VDD VDD pfet_06v0 L=1U W=10U AS=4.4P AD=2.5P PS=20.88U
+ PD=10.5U
M$130 \$2032 \$2866 \$3562 VDD pfet_06v0 L=1U W=10U AS=2.5P AD=4.4P PS=10.5U
+ PD=20.88U
M$131 \$3564 \$2713 VDD VDD pfet_06v0 L=1U W=10U AS=4.4P AD=2.5P PS=20.88U
+ PD=10.5U
M$132 \$2032 \$2866 \$3564 VDD pfet_06v0 L=1U W=10U AS=2.5P AD=4.4P PS=10.5U
+ PD=20.88U
M$133 \$1828 \$52 \$2032 VDD pfet_06v0 L=1U W=10U AS=4.4P AD=2.6P PS=20.88U
+ PD=10.52U
M$134 \$2032 \$52 \$1828 VDD pfet_06v0 L=1U W=10U AS=2.6P AD=4.4P PS=10.52U
+ PD=20.88U
M$135 \$1826 \$30 \$2032 VDD pfet_06v0 L=1U W=10U AS=4.4P AD=2.6P PS=20.88U
+ PD=10.52U
M$136 \$2032 \$30 \$1826 VDD pfet_06v0 L=1U W=10U AS=2.6P AD=4.4P PS=10.52U
+ PD=20.88U
M$137 \$2185 \$2866 \$1825 VDD pfet_06v0 L=1U W=5U AS=2.2P AD=1.3P PS=10.88U
+ PD=5.52U
M$138 \$1825 \$2866 \$2185 VDD pfet_06v0 L=1U W=5U AS=1.3P AD=2.2P PS=5.52U
+ PD=10.88U
M$139 \$1830 \$2866 \$1824 VDD pfet_06v0 L=1U W=5U AS=2.2P AD=1.3P PS=10.88U
+ PD=5.52U
M$140 \$1824 \$2866 \$1830 VDD pfet_06v0 L=1U W=5U AS=1.3P AD=2.2P PS=5.52U
+ PD=10.88U
M$141 \$1825 \$2185 VDD VDD pfet_06v0 L=1U W=5U AS=2.2P AD=1.3P PS=10.88U
+ PD=5.52U
M$142 VDD \$2185 \$1825 VDD pfet_06v0 L=1U W=5U AS=1.3P AD=1.3P PS=5.52U
+ PD=5.52U
M$143 \$1825 \$2185 VDD VDD pfet_06v0 L=1U W=5U AS=1.3P AD=1.3P PS=5.52U
+ PD=5.52U
M$144 VDD \$2185 \$1825 VDD pfet_06v0 L=1U W=5U AS=1.3P AD=2.2P PS=5.52U
+ PD=10.88U
M$145 \$1824 \$2185 VDD VDD pfet_06v0 L=1U W=5U AS=2.2P AD=1.3P PS=10.88U
+ PD=5.52U
M$146 VDD \$2185 \$1824 VDD pfet_06v0 L=1U W=5U AS=1.3P AD=1.3P PS=5.52U
+ PD=5.52U
M$147 \$1824 \$2185 VDD VDD pfet_06v0 L=1U W=5U AS=1.3P AD=1.3P PS=5.52U
+ PD=5.52U
M$148 VDD \$2185 \$1824 VDD pfet_06v0 L=1U W=5U AS=1.3P AD=2.2P PS=5.52U
+ PD=10.88U
M$149 \$1827 \$1831 \$2185 VDD pfet_06v0 L=1U W=5U AS=2.2P AD=2.2P PS=10.88U
+ PD=10.88U
M$150 \$1829 \$1831 \$1830 VDD pfet_06v0 L=1U W=5U AS=2.2P AD=2.2P PS=10.88U
+ PD=10.88U
M$151 \$3566 \$1879 VDD VDD pfet_06v0 L=1U W=10U AS=4.4P AD=2.5P PS=20.88U
+ PD=10.5U
M$152 \$1879 \$2866 \$3566 VDD pfet_06v0 L=1U W=10U AS=2.5P AD=4.4P PS=10.5U
+ PD=20.88U
M$153 \$1831 \$1831 \$1879 VDD pfet_06v0 L=1U W=10U AS=4.4P AD=4.4P PS=20.88U
+ PD=20.88U
M$154 \$3565 \$2713 VDD VDD pfet_06v0 L=1U W=10U AS=4.4P AD=2.5P PS=20.88U
+ PD=10.5U
M$155 \$1808 \$2866 \$3565 VDD pfet_06v0 L=1U W=10U AS=2.5P AD=4.4P PS=10.5U
+ PD=20.88U
M$156 \$1833 \$1830 VDD VDD pfet_06v0 L=1U W=10U AS=4.4P AD=2.6P PS=20.88U
+ PD=10.52U
M$157 VDD \$1830 \$1833 VDD pfet_06v0 L=1U W=10U AS=2.6P AD=2.6P PS=10.52U
+ PD=10.52U
M$158 \$1833 \$1830 VDD VDD pfet_06v0 L=1U W=10U AS=2.6P AD=4.4P PS=10.52U
+ PD=20.88U
M$159 \$3563 \$2714 VDD VDD pfet_06v0 L=1U W=10U AS=4.4P AD=2.5P PS=20.88U
+ PD=10.5U
M$160 \$1809 \$2867 \$3563 VDD pfet_06v0 L=1U W=10U AS=2.5P AD=4.4P PS=10.5U
+ PD=20.88U
M$161 \$3560 \$2714 VDD VDD pfet_06v0 L=1U W=10U AS=4.4P AD=2.5P PS=20.88U
+ PD=10.5U
M$162 \$1810 \$2867 \$3560 VDD pfet_06v0 L=1U W=10U AS=2.5P AD=4.4P PS=10.5U
+ PD=20.88U
M$163 \$2867 \$2867 VDD VDD pfet_06v0 L=1U W=2U AS=0.88P AD=0.88P PS=4.88U
+ PD=4.88U
M$164 \$3558 \$2714 VDD VDD pfet_06v0 L=1U W=10U AS=4.4P AD=2.5P PS=20.88U
+ PD=10.5U
M$165 \$2714 \$2867 \$3558 VDD pfet_06v0 L=1U W=10U AS=2.5P AD=4.4P PS=10.5U
+ PD=20.88U
M$166 \$3556 \$2714 VDD VDD pfet_06v0 L=1U W=10U AS=4.4P AD=2.5P PS=20.88U
+ PD=10.5U
M$167 \$2033 \$2867 \$3556 VDD pfet_06v0 L=1U W=10U AS=2.5P AD=4.4P PS=10.5U
+ PD=20.88U
M$168 \$3555 \$2714 VDD VDD pfet_06v0 L=1U W=10U AS=4.4P AD=2.5P PS=20.88U
+ PD=10.5U
M$169 \$2033 \$2867 \$3555 VDD pfet_06v0 L=1U W=10U AS=2.5P AD=4.4P PS=10.5U
+ PD=20.88U
M$170 \$1839 \$52 \$2033 VDD pfet_06v0 L=1U W=10U AS=4.4P AD=2.6P PS=20.88U
+ PD=10.52U
M$171 \$2033 \$52 \$1839 VDD pfet_06v0 L=1U W=10U AS=2.6P AD=4.4P PS=10.52U
+ PD=20.88U
M$172 \$1837 \$41 \$2033 VDD pfet_06v0 L=1U W=10U AS=4.4P AD=2.6P PS=20.88U
+ PD=10.52U
M$173 \$2033 \$41 \$1837 VDD pfet_06v0 L=1U W=10U AS=2.6P AD=4.4P PS=10.52U
+ PD=20.88U
M$174 \$2186 \$2867 \$1836 VDD pfet_06v0 L=1U W=5U AS=2.2P AD=1.3P PS=10.88U
+ PD=5.52U
M$175 \$1836 \$2867 \$2186 VDD pfet_06v0 L=1U W=5U AS=1.3P AD=2.2P PS=5.52U
+ PD=10.88U
M$176 \$1841 \$2867 \$1835 VDD pfet_06v0 L=1U W=5U AS=2.2P AD=1.3P PS=10.88U
+ PD=5.52U
M$177 \$1835 \$2867 \$1841 VDD pfet_06v0 L=1U W=5U AS=1.3P AD=2.2P PS=5.52U
+ PD=10.88U
M$178 \$1836 \$2186 VDD VDD pfet_06v0 L=1U W=5U AS=2.2P AD=1.3P PS=10.88U
+ PD=5.52U
M$179 VDD \$2186 \$1836 VDD pfet_06v0 L=1U W=5U AS=1.3P AD=1.3P PS=5.52U
+ PD=5.52U
M$180 \$1836 \$2186 VDD VDD pfet_06v0 L=1U W=5U AS=1.3P AD=1.3P PS=5.52U
+ PD=5.52U
M$181 VDD \$2186 \$1836 VDD pfet_06v0 L=1U W=5U AS=1.3P AD=2.2P PS=5.52U
+ PD=10.88U
M$182 \$1835 \$2186 VDD VDD pfet_06v0 L=1U W=5U AS=2.2P AD=1.3P PS=10.88U
+ PD=5.52U
M$183 VDD \$2186 \$1835 VDD pfet_06v0 L=1U W=5U AS=1.3P AD=1.3P PS=5.52U
+ PD=5.52U
M$184 \$1835 \$2186 VDD VDD pfet_06v0 L=1U W=5U AS=1.3P AD=1.3P PS=5.52U
+ PD=5.52U
M$185 VDD \$2186 \$1835 VDD pfet_06v0 L=1U W=5U AS=1.3P AD=2.2P PS=5.52U
+ PD=10.88U
M$186 \$1838 \$1842 \$2186 VDD pfet_06v0 L=1U W=5U AS=2.2P AD=2.2P PS=10.88U
+ PD=10.88U
M$187 X X VDD VDD pfet_06v0 L=1U W=2U AS=0.88P AD=0.52P PS=4.88U PD=2.52U
M$188 VDD X X VDD pfet_06v0 L=1U W=2U AS=0.52P AD=0.52P PS=2.52U PD=2.52U
M$189 X X VDD VDD pfet_06v0 L=1U W=2U AS=0.52P AD=0.52P PS=2.52U PD=2.52U
M$190 VDD X X VDD pfet_06v0 L=1U W=2U AS=0.52P AD=0.52P PS=2.52U PD=2.52U
M$191 X X VDD VDD pfet_06v0 L=1U W=2U AS=0.52P AD=0.52P PS=2.52U PD=2.52U
M$192 VDD X X VDD pfet_06v0 L=1U W=2U AS=0.52P AD=0.88P PS=2.52U PD=4.88U
M$193 \$1840 \$1842 \$1841 VDD pfet_06v0 L=1U W=5U AS=2.2P AD=2.2P PS=10.88U
+ PD=10.88U
M$194 \$3552 \$1880 VDD VDD pfet_06v0 L=1U W=10U AS=4.4P AD=2.5P PS=20.88U
+ PD=10.5U
M$195 \$1880 \$2867 \$3552 VDD pfet_06v0 L=1U W=10U AS=2.5P AD=4.4P PS=10.5U
+ PD=20.88U
M$196 \$20 \$20 VDD VDD pfet_06v0 L=1U W=2U AS=0.88P AD=0.88P PS=4.88U PD=4.88U
M$197 \$1842 \$1842 \$1880 VDD pfet_06v0 L=1U W=10U AS=4.4P AD=4.4P PS=20.88U
+ PD=20.88U
M$198 \$3548 \$2714 VDD VDD pfet_06v0 L=1U W=10U AS=4.4P AD=2.5P PS=20.88U
+ PD=10.5U
M$199 \$1811 \$2867 \$3548 VDD pfet_06v0 L=1U W=10U AS=2.5P AD=4.4P PS=10.5U
+ PD=20.88U
M$200 \$1844 \$1841 VDD VDD pfet_06v0 L=1U W=10U AS=4.4P AD=2.6P PS=20.88U
+ PD=10.52U
M$201 VDD \$1841 \$1844 VDD pfet_06v0 L=1U W=10U AS=2.6P AD=2.6P PS=10.52U
+ PD=10.52U
M$202 \$1844 \$1841 VDD VDD pfet_06v0 L=1U W=10U AS=2.6P AD=4.4P PS=10.52U
+ PD=20.88U
M$203 \$5338 \$3665 VDD VDD pfet_06v0 L=1U W=10U AS=4.4P AD=2.5P PS=20.88U
+ PD=10.5U
M$204 \$4204 \$3666 \$5338 VDD pfet_06v0 L=1U W=10U AS=2.5P AD=4.4P PS=10.5U
+ PD=20.88U
M$205 \$7105 \$6271 VDD VDD pfet_06v0 L=1U W=10U AS=4.4P AD=2.5P PS=20.88U
+ PD=10.5U
M$206 \$5362 \$6424 \$7105 VDD pfet_06v0 L=1U W=10U AS=2.5P AD=4.4P PS=10.5U
+ PD=20.88U
M$207 \$7106 \$6271 VDD VDD pfet_06v0 L=1U W=10U AS=4.4P AD=2.5P PS=20.88U
+ PD=10.5U
M$208 \$5363 \$6424 \$7106 VDD pfet_06v0 L=1U W=10U AS=2.5P AD=4.4P PS=10.5U
+ PD=20.88U
M$209 \$5340 \$3665 VDD VDD pfet_06v0 L=1U W=10U AS=4.4P AD=2.5P PS=20.88U
+ PD=10.5U
M$210 \$4204 \$3666 \$5340 VDD pfet_06v0 L=1U W=10U AS=2.5P AD=4.4P PS=10.5U
+ PD=20.88U
M$211 \$3590 S1P \$4204 VDD pfet_06v0 L=1U W=10U AS=4.4P AD=4.4P PS=20.88U
+ PD=20.88U
M$212 \$6424 \$6424 VDD VDD pfet_06v0 L=1U W=2U AS=0.88P AD=0.88P PS=4.88U
+ PD=4.88U
M$213 \$3588 S1N \$4204 VDD pfet_06v0 L=1U W=10U AS=4.4P AD=4.4P PS=20.88U
+ PD=20.88U
M$214 \$7107 \$6271 VDD VDD pfet_06v0 L=1U W=10U AS=4.4P AD=2.5P PS=20.88U
+ PD=10.5U
M$215 \$6271 \$6424 \$7107 VDD pfet_06v0 L=1U W=10U AS=2.5P AD=4.4P PS=10.5U
+ PD=20.88U
M$216 \$3976 \$3666 \$3587 VDD pfet_06v0 L=1U W=5U AS=2.2P AD=2.2P PS=10.88U
+ PD=10.88U
M$217 \$7108 \$6271 VDD VDD pfet_06v0 L=1U W=10U AS=4.4P AD=2.5P PS=20.88U
+ PD=10.5U
M$218 \$5590 \$6424 \$7108 VDD pfet_06v0 L=1U W=10U AS=2.5P AD=4.4P PS=10.5U
+ PD=20.88U
M$219 \$3625 \$3666 \$3586 VDD pfet_06v0 L=1U W=5U AS=2.2P AD=2.2P PS=10.88U
+ PD=10.88U
M$220 \$7109 \$6271 VDD VDD pfet_06v0 L=1U W=10U AS=4.4P AD=2.5P PS=20.88U
+ PD=10.5U
M$221 \$5590 \$6424 \$7109 VDD pfet_06v0 L=1U W=10U AS=2.5P AD=4.4P PS=10.5U
+ PD=20.88U
M$222 \$3587 \$3976 VDD VDD pfet_06v0 L=1U W=5U AS=2.2P AD=2.2P PS=10.88U
+ PD=10.88U
M$223 \$3586 \$3976 VDD VDD pfet_06v0 L=1U W=5U AS=2.2P AD=2.2P PS=10.88U
+ PD=10.88U
M$224 \$5365 \$3605 \$5590 VDD pfet_06v0 L=1U W=10U AS=4.4P AD=2.6P PS=20.88U
+ PD=10.52U
M$225 \$5590 \$3605 \$5365 VDD pfet_06v0 L=1U W=10U AS=2.6P AD=4.4P PS=10.52U
+ PD=20.88U
M$226 \$3589 \$3592 \$3976 VDD pfet_06v0 L=1U W=5U AS=2.2P AD=2.2P PS=10.88U
+ PD=10.88U
M$227 \$5364 \$3594 \$5590 VDD pfet_06v0 L=1U W=10U AS=4.4P AD=2.6P PS=20.88U
+ PD=10.52U
M$228 \$5590 \$3594 \$5364 VDD pfet_06v0 L=1U W=10U AS=2.6P AD=4.4P PS=10.52U
+ PD=20.88U
M$229 \$3591 \$3592 \$3625 VDD pfet_06v0 L=1U W=5U AS=2.2P AD=2.2P PS=10.88U
+ PD=10.88U
M$230 \$5668 \$6424 \$5379 VDD pfet_06v0 L=1U W=5U AS=2.2P AD=1.3P PS=10.88U
+ PD=5.52U
M$231 \$5379 \$6424 \$5668 VDD pfet_06v0 L=1U W=5U AS=1.3P AD=2.2P PS=5.52U
+ PD=10.88U
M$232 \$5342 \$3823 VDD VDD pfet_06v0 L=1U W=10U AS=4.4P AD=2.5P PS=20.88U
+ PD=10.5U
M$233 \$3823 \$3666 \$5342 VDD pfet_06v0 L=1U W=10U AS=2.5P AD=4.4P PS=10.5U
+ PD=20.88U
M$234 \$5382 \$6424 \$5378 VDD pfet_06v0 L=1U W=5U AS=2.2P AD=1.3P PS=10.88U
+ PD=5.52U
M$235 \$5378 \$6424 \$5382 VDD pfet_06v0 L=1U W=5U AS=1.3P AD=2.2P PS=5.52U
+ PD=10.88U
M$236 \$3592 \$3592 \$3823 VDD pfet_06v0 L=1U W=10U AS=4.4P AD=4.4P PS=20.88U
+ PD=20.88U
M$237 \$5344 \$3665 VDD VDD pfet_06v0 L=1U W=10U AS=4.4P AD=2.5P PS=20.88U
+ PD=10.5U
M$238 \$3573 \$3666 \$5344 VDD pfet_06v0 L=1U W=10U AS=2.5P AD=4.4P PS=10.5U
+ PD=20.88U
M$239 \$5379 \$5668 VDD VDD pfet_06v0 L=1U W=5U AS=2.2P AD=1.3P PS=10.88U
+ PD=5.52U
M$240 VDD \$5668 \$5379 VDD pfet_06v0 L=1U W=5U AS=1.3P AD=1.3P PS=5.52U
+ PD=5.52U
M$241 \$5379 \$5668 VDD VDD pfet_06v0 L=1U W=5U AS=1.3P AD=1.3P PS=5.52U
+ PD=5.52U
M$242 VDD \$5668 \$5379 VDD pfet_06v0 L=1U W=5U AS=1.3P AD=2.2P PS=5.52U
+ PD=10.88U
M$243 \$5345 \$3665 VDD VDD pfet_06v0 L=1U W=10U AS=4.4P AD=2.5P PS=20.88U
+ PD=10.5U
M$244 \$3572 \$3666 \$5345 VDD pfet_06v0 L=1U W=10U AS=2.5P AD=4.4P PS=10.5U
+ PD=20.88U
M$245 \$5378 \$5668 VDD VDD pfet_06v0 L=1U W=5U AS=2.2P AD=1.3P PS=10.88U
+ PD=5.52U
M$246 VDD \$5668 \$5378 VDD pfet_06v0 L=1U W=5U AS=1.3P AD=1.3P PS=5.52U
+ PD=5.52U
M$247 \$5378 \$5668 VDD VDD pfet_06v0 L=1U W=5U AS=1.3P AD=1.3P PS=5.52U
+ PD=5.52U
M$248 VDD \$5668 \$5378 VDD pfet_06v0 L=1U W=5U AS=1.3P AD=2.2P PS=5.52U
+ PD=10.88U
M$249 \$5347 \$3665 VDD VDD pfet_06v0 L=1U W=10U AS=4.4P AD=2.5P PS=20.88U
+ PD=10.5U
M$250 \$3571 \$3666 \$5347 VDD pfet_06v0 L=1U W=10U AS=2.5P AD=4.4P PS=10.5U
+ PD=20.88U
M$251 \$3666 \$3666 VDD VDD pfet_06v0 L=1U W=2U AS=0.88P AD=0.88P PS=4.88U
+ PD=4.88U
M$252 \$5380 \$5383 \$5668 VDD pfet_06v0 L=1U W=5U AS=2.2P AD=2.2P PS=10.88U
+ PD=10.88U
M$253 \$5348 \$3665 VDD VDD pfet_06v0 L=1U W=10U AS=4.4P AD=2.5P PS=20.88U
+ PD=10.5U
M$254 \$3665 \$3666 \$5348 VDD pfet_06v0 L=1U W=10U AS=2.5P AD=4.4P PS=10.5U
+ PD=20.88U
M$255 \$5381 \$5383 \$5382 VDD pfet_06v0 L=1U W=5U AS=2.2P AD=2.2P PS=10.88U
+ PD=10.88U
M$256 \$7110 \$5437 VDD VDD pfet_06v0 L=1U W=10U AS=4.4P AD=2.5P PS=20.88U
+ PD=10.5U
M$257 \$5437 \$6424 \$7110 VDD pfet_06v0 L=1U W=10U AS=2.5P AD=4.4P PS=10.5U
+ PD=20.88U
M$258 \$3594 \$3625 VDD VDD pfet_06v0 L=20U W=0.7U AS=0.308P AD=0.308P PS=2.28U
+ PD=2.28U
M$259 \$5383 \$5383 \$5437 VDD pfet_06v0 L=1U W=10U AS=4.4P AD=4.4P PS=20.88U
+ PD=20.88U
M$260 \$7112 \$6271 VDD VDD pfet_06v0 L=1U W=10U AS=4.4P AD=2.5P PS=20.88U
+ PD=10.5U
M$261 \$5366 \$6424 \$7112 VDD pfet_06v0 L=1U W=10U AS=2.5P AD=4.4P PS=10.5U
+ PD=20.88U
M$262 \$5385 \$5382 VDD VDD pfet_06v0 L=1U W=10U AS=4.4P AD=2.6P PS=20.88U
+ PD=10.52U
M$263 VDD \$5382 \$5385 VDD pfet_06v0 L=1U W=10U AS=2.6P AD=2.6P PS=10.52U
+ PD=10.52U
M$264 \$5385 \$5382 VDD VDD pfet_06v0 L=1U W=10U AS=2.6P AD=4.4P PS=10.52U
+ PD=20.88U
M$265 \$5349 \$3667 VDD VDD pfet_06v0 L=1U W=10U AS=4.4P AD=2.5P PS=20.88U
+ PD=10.5U
M$266 \$4205 \$3668 \$5349 VDD pfet_06v0 L=1U W=10U AS=2.5P AD=4.4P PS=10.5U
+ PD=20.88U
M$267 \$5351 \$3667 VDD VDD pfet_06v0 L=1U W=10U AS=4.4P AD=2.5P PS=20.88U
+ PD=10.5U
M$268 \$4205 \$3668 \$5351 VDD pfet_06v0 L=1U W=10U AS=2.5P AD=4.4P PS=10.5U
+ PD=20.88U
M$269 \$3601 S2P \$4205 VDD pfet_06v0 L=1U W=10U AS=4.4P AD=4.4P PS=20.88U
+ PD=20.88U
M$270 \$3599 S2N \$4205 VDD pfet_06v0 L=1U W=10U AS=4.4P AD=4.4P PS=20.88U
+ PD=20.88U
M$271 \$7113 \$6272 VDD VDD pfet_06v0 L=1U W=10U AS=4.4P AD=2.5P PS=20.88U
+ PD=10.5U
M$272 \$5367 \$6425 \$7113 VDD pfet_06v0 L=1U W=10U AS=2.5P AD=4.4P PS=10.5U
+ PD=20.88U
M$273 \$3977 \$3668 \$3598 VDD pfet_06v0 L=1U W=5U AS=2.2P AD=2.2P PS=10.88U
+ PD=10.88U
M$274 \$7114 \$6272 VDD VDD pfet_06v0 L=1U W=10U AS=4.4P AD=2.5P PS=20.88U
+ PD=10.5U
M$275 \$5368 \$6425 \$7114 VDD pfet_06v0 L=1U W=10U AS=2.5P AD=4.4P PS=10.5U
+ PD=20.88U
M$276 \$3626 \$3668 \$3597 VDD pfet_06v0 L=1U W=5U AS=2.2P AD=2.2P PS=10.88U
+ PD=10.88U
M$277 \$3598 \$3977 VDD VDD pfet_06v0 L=1U W=5U AS=2.2P AD=2.2P PS=10.88U
+ PD=10.88U
M$278 \$6425 \$6425 VDD VDD pfet_06v0 L=1U W=2U AS=0.88P AD=0.88P PS=4.88U
+ PD=4.88U
M$279 \$7115 \$6272 VDD VDD pfet_06v0 L=1U W=10U AS=4.4P AD=2.5P PS=20.88U
+ PD=10.5U
M$280 \$6272 \$6425 \$7115 VDD pfet_06v0 L=1U W=10U AS=2.5P AD=4.4P PS=10.5U
+ PD=20.88U
M$281 \$3597 \$3977 VDD VDD pfet_06v0 L=1U W=5U AS=2.2P AD=2.2P PS=10.88U
+ PD=10.88U
M$282 \$3600 \$3603 \$3977 VDD pfet_06v0 L=1U W=5U AS=2.2P AD=2.2P PS=10.88U
+ PD=10.88U
M$283 \$7116 \$6272 VDD VDD pfet_06v0 L=1U W=10U AS=4.4P AD=2.5P PS=20.88U
+ PD=10.5U
M$284 \$5591 \$6425 \$7116 VDD pfet_06v0 L=1U W=10U AS=2.5P AD=4.4P PS=10.5U
+ PD=20.88U
M$285 \$3602 \$3603 \$3626 VDD pfet_06v0 L=1U W=5U AS=2.2P AD=2.2P PS=10.88U
+ PD=10.88U
M$286 \$7117 \$6272 VDD VDD pfet_06v0 L=1U W=10U AS=4.4P AD=2.5P PS=20.88U
+ PD=10.5U
M$287 \$5591 \$6425 \$7117 VDD pfet_06v0 L=1U W=10U AS=2.5P AD=4.4P PS=10.5U
+ PD=20.88U
M$288 \$5354 \$3824 VDD VDD pfet_06v0 L=1U W=10U AS=4.4P AD=2.5P PS=20.88U
+ PD=10.5U
M$289 \$3824 \$3668 \$5354 VDD pfet_06v0 L=1U W=10U AS=2.5P AD=4.4P PS=10.5U
+ PD=20.88U
M$290 \$5370 \$3616 \$5591 VDD pfet_06v0 L=1U W=10U AS=4.4P AD=2.6P PS=20.88U
+ PD=10.52U
M$291 \$5591 \$3616 \$5370 VDD pfet_06v0 L=1U W=10U AS=2.6P AD=4.4P PS=10.52U
+ PD=20.88U
M$292 \$3603 \$3603 \$3824 VDD pfet_06v0 L=1U W=10U AS=4.4P AD=4.4P PS=20.88U
+ PD=20.88U
M$293 \$5356 \$3667 VDD VDD pfet_06v0 L=1U W=10U AS=4.4P AD=2.5P PS=20.88U
+ PD=10.5U
M$294 \$3576 \$3668 \$5356 VDD pfet_06v0 L=1U W=10U AS=2.5P AD=4.4P PS=10.5U
+ PD=20.88U
M$295 \$5369 \$3594 \$5591 VDD pfet_06v0 L=1U W=10U AS=4.4P AD=2.6P PS=20.88U
+ PD=10.52U
M$296 \$5591 \$3594 \$5369 VDD pfet_06v0 L=1U W=10U AS=2.6P AD=4.4P PS=10.52U
+ PD=20.88U
M$297 \$5357 \$3667 VDD VDD pfet_06v0 L=1U W=10U AS=4.4P AD=2.5P PS=20.88U
+ PD=10.5U
M$298 \$3575 \$3668 \$5357 VDD pfet_06v0 L=1U W=10U AS=2.5P AD=4.4P PS=10.5U
+ PD=20.88U
M$299 \$5669 \$6425 \$5388 VDD pfet_06v0 L=1U W=5U AS=2.2P AD=1.3P PS=10.88U
+ PD=5.52U
M$300 \$5388 \$6425 \$5669 VDD pfet_06v0 L=1U W=5U AS=1.3P AD=2.2P PS=5.52U
+ PD=10.88U
M$301 \$5355 \$3667 VDD VDD pfet_06v0 L=1U W=10U AS=4.4P AD=2.5P PS=20.88U
+ PD=10.5U
M$302 \$3574 \$3668 \$5355 VDD pfet_06v0 L=1U W=10U AS=2.5P AD=4.4P PS=10.5U
+ PD=20.88U
M$303 \$5391 \$6425 \$5387 VDD pfet_06v0 L=1U W=5U AS=2.2P AD=1.3P PS=10.88U
+ PD=5.52U
M$304 \$5387 \$6425 \$5391 VDD pfet_06v0 L=1U W=5U AS=1.3P AD=2.2P PS=5.52U
+ PD=10.88U
M$305 \$3668 \$3668 VDD VDD pfet_06v0 L=1U W=2U AS=0.88P AD=0.88P PS=4.88U
+ PD=4.88U
M$306 \$5388 \$5669 VDD VDD pfet_06v0 L=1U W=5U AS=2.2P AD=1.3P PS=10.88U
+ PD=5.52U
M$307 VDD \$5669 \$5388 VDD pfet_06v0 L=1U W=5U AS=1.3P AD=1.3P PS=5.52U
+ PD=5.52U
M$308 \$5388 \$5669 VDD VDD pfet_06v0 L=1U W=5U AS=1.3P AD=1.3P PS=5.52U
+ PD=5.52U
M$309 VDD \$5669 \$5388 VDD pfet_06v0 L=1U W=5U AS=1.3P AD=2.2P PS=5.52U
+ PD=10.88U
M$310 \$5353 \$3667 VDD VDD pfet_06v0 L=1U W=10U AS=4.4P AD=2.5P PS=20.88U
+ PD=10.5U
M$311 \$3667 \$3668 \$5353 VDD pfet_06v0 L=1U W=10U AS=2.5P AD=4.4P PS=10.5U
+ PD=20.88U
M$312 \$5387 \$5669 VDD VDD pfet_06v0 L=1U W=5U AS=2.2P AD=1.3P PS=10.88U
+ PD=5.52U
M$313 VDD \$5669 \$5387 VDD pfet_06v0 L=1U W=5U AS=1.3P AD=1.3P PS=5.52U
+ PD=5.52U
M$314 \$5387 \$5669 VDD VDD pfet_06v0 L=1U W=5U AS=1.3P AD=1.3P PS=5.52U
+ PD=5.52U
M$315 VDD \$5669 \$5387 VDD pfet_06v0 L=1U W=5U AS=1.3P AD=2.2P PS=5.52U
+ PD=10.88U
M$316 \$3605 \$3626 VDD VDD pfet_06v0 L=20U W=0.7U AS=0.308P AD=0.308P PS=2.28U
+ PD=2.28U
M$317 \$5389 \$5392 \$5669 VDD pfet_06v0 L=1U W=5U AS=2.2P AD=2.2P PS=10.88U
+ PD=10.88U
M$318 \$5390 \$5392 \$5391 VDD pfet_06v0 L=1U W=5U AS=2.2P AD=2.2P PS=10.88U
+ PD=10.88U
M$319 \$7119 \$5438 VDD VDD pfet_06v0 L=1U W=10U AS=4.4P AD=2.5P PS=20.88U
+ PD=10.5U
M$320 \$5438 \$6425 \$7119 VDD pfet_06v0 L=1U W=10U AS=2.5P AD=4.4P PS=10.5U
+ PD=20.88U
M$321 \$5392 \$5392 \$5438 VDD pfet_06v0 L=1U W=10U AS=4.4P AD=4.4P PS=20.88U
+ PD=20.88U
M$322 \$5352 \$3669 VDD VDD pfet_06v0 L=1U W=10U AS=4.4P AD=2.5P PS=20.88U
+ PD=10.5U
M$323 \$4206 \$3670 \$5352 VDD pfet_06v0 L=1U W=10U AS=2.5P AD=4.4P PS=10.5U
+ PD=20.88U
M$324 \$7120 \$6272 VDD VDD pfet_06v0 L=1U W=10U AS=4.4P AD=2.5P PS=20.88U
+ PD=10.5U
M$325 \$5371 \$6425 \$7120 VDD pfet_06v0 L=1U W=10U AS=2.5P AD=4.4P PS=10.5U
+ PD=20.88U
M$326 \$5350 \$3669 VDD VDD pfet_06v0 L=1U W=10U AS=4.4P AD=2.5P PS=20.88U
+ PD=10.5U
M$327 \$4206 \$3670 \$5350 VDD pfet_06v0 L=1U W=10U AS=2.5P AD=4.4P PS=10.5U
+ PD=20.88U
M$328 \$5394 \$5391 VDD VDD pfet_06v0 L=1U W=10U AS=4.4P AD=2.6P PS=20.88U
+ PD=10.52U
M$329 VDD \$5391 \$5394 VDD pfet_06v0 L=1U W=10U AS=2.6P AD=2.6P PS=10.52U
+ PD=10.52U
M$330 \$5394 \$5391 VDD VDD pfet_06v0 L=1U W=10U AS=2.6P AD=4.4P PS=10.52U
+ PD=20.88U
M$331 \$3612 S4P \$4206 VDD pfet_06v0 L=1U W=10U AS=4.4P AD=4.4P PS=20.88U
+ PD=20.88U
M$332 \$3610 S4N \$4206 VDD pfet_06v0 L=1U W=10U AS=4.4P AD=4.4P PS=20.88U
+ PD=20.88U
M$333 \$3978 \$3670 \$3609 VDD pfet_06v0 L=1U W=5U AS=2.2P AD=2.2P PS=10.88U
+ PD=10.88U
M$334 \$3627 \$3670 \$3608 VDD pfet_06v0 L=1U W=5U AS=2.2P AD=2.2P PS=10.88U
+ PD=10.88U
M$335 \$3609 \$3978 VDD VDD pfet_06v0 L=1U W=5U AS=2.2P AD=2.2P PS=10.88U
+ PD=10.88U
M$336 \$3608 \$3978 VDD VDD pfet_06v0 L=1U W=5U AS=2.2P AD=2.2P PS=10.88U
+ PD=10.88U
M$337 \$7121 \$6273 VDD VDD pfet_06v0 L=1U W=10U AS=4.4P AD=2.5P PS=20.88U
+ PD=10.5U
M$338 \$5372 \$6426 \$7121 VDD pfet_06v0 L=1U W=10U AS=2.5P AD=4.4P PS=10.5U
+ PD=20.88U
M$339 \$3611 \$3614 \$3978 VDD pfet_06v0 L=1U W=5U AS=2.2P AD=2.2P PS=10.88U
+ PD=10.88U
M$340 \$7122 \$6273 VDD VDD pfet_06v0 L=1U W=10U AS=4.4P AD=2.5P PS=20.88U
+ PD=10.5U
M$341 \$5373 \$6426 \$7122 VDD pfet_06v0 L=1U W=10U AS=2.5P AD=4.4P PS=10.5U
+ PD=20.88U
M$342 \$3613 \$3614 \$3627 VDD pfet_06v0 L=1U W=5U AS=2.2P AD=2.2P PS=10.88U
+ PD=10.88U
M$343 \$5346 \$3825 VDD VDD pfet_06v0 L=1U W=10U AS=4.4P AD=2.5P PS=20.88U
+ PD=10.5U
M$344 \$3825 \$3670 \$5346 VDD pfet_06v0 L=1U W=10U AS=2.5P AD=4.4P PS=10.5U
+ PD=20.88U
M$345 \$6426 \$6426 VDD VDD pfet_06v0 L=1U W=2U AS=0.88P AD=0.88P PS=4.88U
+ PD=4.88U
M$346 \$7123 \$6273 VDD VDD pfet_06v0 L=1U W=10U AS=4.4P AD=2.5P PS=20.88U
+ PD=10.5U
M$347 \$6273 \$6426 \$7123 VDD pfet_06v0 L=1U W=10U AS=2.5P AD=4.4P PS=10.5U
+ PD=20.88U
M$348 \$3614 \$3614 \$3825 VDD pfet_06v0 L=1U W=10U AS=4.4P AD=4.4P PS=20.88U
+ PD=20.88U
M$349 \$5343 \$3669 VDD VDD pfet_06v0 L=1U W=10U AS=4.4P AD=2.5P PS=20.88U
+ PD=10.5U
M$350 \$3579 \$3670 \$5343 VDD pfet_06v0 L=1U W=10U AS=2.5P AD=4.4P PS=10.5U
+ PD=20.88U
M$351 \$7124 \$6273 VDD VDD pfet_06v0 L=1U W=10U AS=4.4P AD=2.5P PS=20.88U
+ PD=10.5U
M$352 \$5592 \$6426 \$7124 VDD pfet_06v0 L=1U W=10U AS=2.5P AD=4.4P PS=10.5U
+ PD=20.88U
M$353 \$7125 \$6273 VDD VDD pfet_06v0 L=1U W=10U AS=4.4P AD=2.5P PS=20.88U
+ PD=10.5U
M$354 \$5592 \$6426 \$7125 VDD pfet_06v0 L=1U W=10U AS=2.5P AD=4.4P PS=10.5U
+ PD=20.88U
M$355 \$5341 \$3669 VDD VDD pfet_06v0 L=1U W=10U AS=4.4P AD=2.5P PS=20.88U
+ PD=10.5U
M$356 \$3578 \$3670 \$5341 VDD pfet_06v0 L=1U W=10U AS=2.5P AD=4.4P PS=10.5U
+ PD=20.88U
M$357 \$5339 \$3669 VDD VDD pfet_06v0 L=1U W=10U AS=4.4P AD=2.5P PS=20.88U
+ PD=10.5U
M$358 \$3577 \$3670 \$5339 VDD pfet_06v0 L=1U W=10U AS=2.5P AD=4.4P PS=10.5U
+ PD=20.88U
M$359 \$5375 \$3616 \$5592 VDD pfet_06v0 L=1U W=10U AS=4.4P AD=2.6P PS=20.88U
+ PD=10.52U
M$360 \$5592 \$3616 \$5375 VDD pfet_06v0 L=1U W=10U AS=2.6P AD=4.4P PS=10.52U
+ PD=20.88U
M$361 \$3670 \$3670 VDD VDD pfet_06v0 L=1U W=2U AS=0.88P AD=0.88P PS=4.88U
+ PD=4.88U
M$362 \$5374 \$3605 \$5592 VDD pfet_06v0 L=1U W=10U AS=4.4P AD=2.6P PS=20.88U
+ PD=10.52U
M$363 \$5592 \$3605 \$5374 VDD pfet_06v0 L=1U W=10U AS=2.6P AD=4.4P PS=10.52U
+ PD=20.88U
M$364 \$5337 \$3669 VDD VDD pfet_06v0 L=1U W=10U AS=4.4P AD=2.5P PS=20.88U
+ PD=10.5U
M$365 \$3669 \$3670 \$5337 VDD pfet_06v0 L=1U W=10U AS=2.5P AD=4.4P PS=10.5U
+ PD=20.88U
M$366 \$5670 \$6426 \$5397 VDD pfet_06v0 L=1U W=5U AS=2.2P AD=1.3P PS=10.88U
+ PD=5.52U
M$367 \$5397 \$6426 \$5670 VDD pfet_06v0 L=1U W=5U AS=1.3P AD=2.2P PS=5.52U
+ PD=10.88U
M$368 \$5400 \$6426 \$5396 VDD pfet_06v0 L=1U W=5U AS=2.2P AD=1.3P PS=10.88U
+ PD=5.52U
M$369 \$5396 \$6426 \$5400 VDD pfet_06v0 L=1U W=5U AS=1.3P AD=2.2P PS=5.52U
+ PD=10.88U
M$370 \$3616 \$3627 VDD VDD pfet_06v0 L=20U W=0.7U AS=0.308P AD=0.308P PS=2.28U
+ PD=2.28U
M$371 \$5397 \$5670 VDD VDD pfet_06v0 L=1U W=5U AS=2.2P AD=1.3P PS=10.88U
+ PD=5.52U
M$372 VDD \$5670 \$5397 VDD pfet_06v0 L=1U W=5U AS=1.3P AD=1.3P PS=5.52U
+ PD=5.52U
M$373 \$5397 \$5670 VDD VDD pfet_06v0 L=1U W=5U AS=1.3P AD=1.3P PS=5.52U
+ PD=5.52U
M$374 VDD \$5670 \$5397 VDD pfet_06v0 L=1U W=5U AS=1.3P AD=2.2P PS=5.52U
+ PD=10.88U
M$375 \$5396 \$5670 VDD VDD pfet_06v0 L=1U W=5U AS=2.2P AD=1.3P PS=10.88U
+ PD=5.52U
M$376 VDD \$5670 \$5396 VDD pfet_06v0 L=1U W=5U AS=1.3P AD=1.3P PS=5.52U
+ PD=5.52U
M$377 \$5396 \$5670 VDD VDD pfet_06v0 L=1U W=5U AS=1.3P AD=1.3P PS=5.52U
+ PD=5.52U
M$378 VDD \$5670 \$5396 VDD pfet_06v0 L=1U W=5U AS=1.3P AD=2.2P PS=5.52U
+ PD=10.88U
M$379 \$5398 \$5401 \$5670 VDD pfet_06v0 L=1U W=5U AS=2.2P AD=2.2P PS=10.88U
+ PD=10.88U
M$380 Y Y VDD VDD pfet_06v0 L=1U W=2U AS=0.88P AD=0.52P PS=4.88U PD=2.52U
M$381 VDD Y Y VDD pfet_06v0 L=1U W=2U AS=0.52P AD=0.52P PS=2.52U PD=2.52U
M$382 Y Y VDD VDD pfet_06v0 L=1U W=2U AS=0.52P AD=0.52P PS=2.52U PD=2.52U
M$383 VDD Y Y VDD pfet_06v0 L=1U W=2U AS=0.52P AD=0.52P PS=2.52U PD=2.52U
M$384 Y Y VDD VDD pfet_06v0 L=1U W=2U AS=0.52P AD=0.52P PS=2.52U PD=2.52U
M$385 VDD Y Y VDD pfet_06v0 L=1U W=2U AS=0.52P AD=0.88P PS=2.52U PD=4.88U
M$386 \$5399 \$5401 \$5400 VDD pfet_06v0 L=1U W=5U AS=2.2P AD=2.2P PS=10.88U
+ PD=10.88U
M$387 \$7118 \$5439 VDD VDD pfet_06v0 L=1U W=10U AS=4.4P AD=2.5P PS=20.88U
+ PD=10.5U
M$388 \$5439 \$6426 \$7118 VDD pfet_06v0 L=1U W=10U AS=2.5P AD=4.4P PS=10.5U
+ PD=20.88U
M$389 \$3583 \$3583 VDD VDD pfet_06v0 L=1U W=2U AS=0.88P AD=0.88P PS=4.88U
+ PD=4.88U
M$390 \$5401 \$5401 \$5439 VDD pfet_06v0 L=1U W=10U AS=4.4P AD=4.4P PS=20.88U
+ PD=20.88U
M$391 \$7111 \$6273 VDD VDD pfet_06v0 L=1U W=10U AS=4.4P AD=2.5P PS=20.88U
+ PD=10.5U
M$392 \$5376 \$6426 \$7111 VDD pfet_06v0 L=1U W=10U AS=2.5P AD=4.4P PS=10.5U
+ PD=20.88U
M$393 \$5403 \$5400 VDD VDD pfet_06v0 L=1U W=10U AS=4.4P AD=2.6P PS=20.88U
+ PD=10.52U
M$394 VDD \$5400 \$5403 VDD pfet_06v0 L=1U W=10U AS=2.6P AD=2.6P PS=10.52U
+ PD=10.52U
M$395 \$5403 \$5400 VDD VDD pfet_06v0 L=1U W=10U AS=2.6P AD=4.4P PS=10.52U
+ PD=20.88U
M$396 \$8819 \$7220 VDD VDD pfet_06v0 L=1U W=10U AS=4.4P AD=2.5P PS=20.88U
+ PD=10.5U
M$397 \$7761 \$7221 \$8819 VDD pfet_06v0 L=1U W=10U AS=2.5P AD=4.4P PS=10.5U
+ PD=20.88U
M$398 \$10662 \$9753 VDD VDD pfet_06v0 L=1U W=10U AS=4.4P AD=2.5P PS=20.88U
+ PD=10.5U
M$399 \$8919 \$9981 \$10662 VDD pfet_06v0 L=1U W=10U AS=2.5P AD=4.4P PS=10.5U
+ PD=20.88U
M$400 \$8820 \$7220 VDD VDD pfet_06v0 L=1U W=10U AS=4.4P AD=2.5P PS=20.88U
+ PD=10.5U
M$401 \$7761 \$7221 \$8820 VDD pfet_06v0 L=1U W=10U AS=2.5P AD=4.4P PS=10.5U
+ PD=20.88U
M$402 \$10663 \$9753 VDD VDD pfet_06v0 L=1U W=10U AS=4.4P AD=2.5P PS=20.88U
+ PD=10.5U
M$403 \$8920 \$9981 \$10663 VDD pfet_06v0 L=1U W=10U AS=2.5P AD=4.4P PS=10.5U
+ PD=20.88U
M$404 \$9981 \$9981 VDD VDD pfet_06v0 L=1U W=2U AS=0.88P AD=0.88P PS=4.88U
+ PD=4.88U
M$405 \$7139 S3P \$7761 VDD pfet_06v0 L=1U W=10U AS=4.4P AD=4.4P PS=20.88U
+ PD=20.88U
M$406 \$10665 \$9753 VDD VDD pfet_06v0 L=1U W=10U AS=4.4P AD=2.5P PS=20.88U
+ PD=10.5U
M$407 \$9753 \$9981 \$10665 VDD pfet_06v0 L=1U W=10U AS=2.5P AD=4.4P PS=10.5U
+ PD=20.88U
M$408 \$7137 S3N \$7761 VDD pfet_06v0 L=1U W=10U AS=4.4P AD=4.4P PS=20.88U
+ PD=20.88U
M$409 \$7531 \$7221 \$7136 VDD pfet_06v0 L=1U W=5U AS=2.2P AD=2.2P PS=10.88U
+ PD=10.88U
M$410 \$10667 \$9753 VDD VDD pfet_06v0 L=1U W=10U AS=4.4P AD=2.5P PS=20.88U
+ PD=10.5U
M$411 \$9147 \$9981 \$10667 VDD pfet_06v0 L=1U W=10U AS=2.5P AD=4.4P PS=10.5U
+ PD=20.88U
M$412 \$7175 \$7221 \$7135 VDD pfet_06v0 L=1U W=5U AS=2.2P AD=2.2P PS=10.88U
+ PD=10.88U
M$413 \$10668 \$9753 VDD VDD pfet_06v0 L=1U W=10U AS=4.4P AD=2.5P PS=20.88U
+ PD=10.5U
M$414 \$9147 \$9981 \$10668 VDD pfet_06v0 L=1U W=10U AS=2.5P AD=4.4P PS=10.5U
+ PD=20.88U
M$415 \$7136 \$7531 VDD VDD pfet_06v0 L=1U W=5U AS=2.2P AD=2.2P PS=10.88U
+ PD=10.88U
M$416 \$7135 \$7531 VDD VDD pfet_06v0 L=1U W=5U AS=2.2P AD=2.2P PS=10.88U
+ PD=10.88U
M$417 \$8933 \$7157 \$9147 VDD pfet_06v0 L=1U W=10U AS=4.4P AD=2.6P PS=20.88U
+ PD=10.52U
M$418 \$9147 \$7157 \$8933 VDD pfet_06v0 L=1U W=10U AS=2.6P AD=4.4P PS=10.52U
+ PD=20.88U
M$419 \$7138 \$7142 \$7531 VDD pfet_06v0 L=1U W=5U AS=2.2P AD=2.2P PS=10.88U
+ PD=10.88U
M$420 \$8931 \$7144 \$9147 VDD pfet_06v0 L=1U W=10U AS=4.4P AD=2.6P PS=20.88U
+ PD=10.52U
M$421 \$9147 \$7144 \$8931 VDD pfet_06v0 L=1U W=10U AS=2.6P AD=4.4P PS=10.52U
+ PD=20.88U
M$422 \$7140 \$7142 \$7175 VDD pfet_06v0 L=1U W=5U AS=2.2P AD=2.2P PS=10.88U
+ PD=10.88U
M$423 \$9300 \$9981 \$8930 VDD pfet_06v0 L=1U W=5U AS=2.2P AD=1.3P PS=10.88U
+ PD=5.52U
M$424 \$8930 \$9981 \$9300 VDD pfet_06v0 L=1U W=5U AS=1.3P AD=2.2P PS=5.52U
+ PD=10.88U
M$425 \$8837 \$7378 VDD VDD pfet_06v0 L=1U W=10U AS=4.4P AD=2.5P PS=20.88U
+ PD=10.5U
M$426 \$7378 \$7221 \$8837 VDD pfet_06v0 L=1U W=10U AS=2.5P AD=4.4P PS=10.5U
+ PD=20.88U
M$427 \$8935 \$9981 \$8929 VDD pfet_06v0 L=1U W=5U AS=2.2P AD=1.3P PS=10.88U
+ PD=5.52U
M$428 \$8929 \$9981 \$8935 VDD pfet_06v0 L=1U W=5U AS=1.3P AD=2.2P PS=5.52U
+ PD=10.88U
M$429 \$7142 \$7142 \$7378 VDD pfet_06v0 L=1U W=10U AS=4.4P AD=4.4P PS=20.88U
+ PD=20.88U
M$430 \$8847 \$7220 VDD VDD pfet_06v0 L=1U W=10U AS=4.4P AD=2.5P PS=20.88U
+ PD=10.5U
M$431 \$7141 \$7221 \$8847 VDD pfet_06v0 L=1U W=10U AS=2.5P AD=4.4P PS=10.5U
+ PD=20.88U
M$432 \$8930 \$9300 VDD VDD pfet_06v0 L=1U W=5U AS=2.2P AD=1.3P PS=10.88U
+ PD=5.52U
M$433 VDD \$9300 \$8930 VDD pfet_06v0 L=1U W=5U AS=1.3P AD=1.3P PS=5.52U
+ PD=5.52U
M$434 \$8930 \$9300 VDD VDD pfet_06v0 L=1U W=5U AS=1.3P AD=1.3P PS=5.52U
+ PD=5.52U
M$435 VDD \$9300 \$8930 VDD pfet_06v0 L=1U W=5U AS=1.3P AD=2.2P PS=5.52U
+ PD=10.88U
M$436 \$8848 \$7220 VDD VDD pfet_06v0 L=1U W=10U AS=4.4P AD=2.5P PS=20.88U
+ PD=10.5U
M$437 \$7133 \$7221 \$8848 VDD pfet_06v0 L=1U W=10U AS=2.5P AD=4.4P PS=10.5U
+ PD=20.88U
M$438 \$8929 \$9300 VDD VDD pfet_06v0 L=1U W=5U AS=2.2P AD=1.3P PS=10.88U
+ PD=5.52U
M$439 VDD \$9300 \$8929 VDD pfet_06v0 L=1U W=5U AS=1.3P AD=1.3P PS=5.52U
+ PD=5.52U
M$440 \$8929 \$9300 VDD VDD pfet_06v0 L=1U W=5U AS=1.3P AD=1.3P PS=5.52U
+ PD=5.52U
M$441 VDD \$9300 \$8929 VDD pfet_06v0 L=1U W=5U AS=1.3P AD=2.2P PS=5.52U
+ PD=10.88U
M$442 \$8849 \$7220 VDD VDD pfet_06v0 L=1U W=10U AS=4.4P AD=2.5P PS=20.88U
+ PD=10.5U
M$443 \$7132 \$7221 \$8849 VDD pfet_06v0 L=1U W=10U AS=2.5P AD=4.4P PS=10.5U
+ PD=20.88U
M$444 \$7221 \$7221 VDD VDD pfet_06v0 L=1U W=2U AS=0.88P AD=0.88P PS=4.88U
+ PD=4.88U
M$445 \$8932 \$8936 \$9300 VDD pfet_06v0 L=1U W=5U AS=2.2P AD=2.2P PS=10.88U
+ PD=10.88U
M$446 \$8850 \$7220 VDD VDD pfet_06v0 L=1U W=10U AS=4.4P AD=2.5P PS=20.88U
+ PD=10.5U
M$447 \$7220 \$7221 \$8850 VDD pfet_06v0 L=1U W=10U AS=2.5P AD=4.4P PS=10.5U
+ PD=20.88U
M$448 \$8934 \$8936 \$8935 VDD pfet_06v0 L=1U W=5U AS=2.2P AD=2.2P PS=10.88U
+ PD=10.88U
M$449 \$10673 \$8990 VDD VDD pfet_06v0 L=1U W=10U AS=4.4P AD=2.5P PS=20.88U
+ PD=10.5U
M$450 \$8990 \$9981 \$10673 VDD pfet_06v0 L=1U W=10U AS=2.5P AD=4.4P PS=10.5U
+ PD=20.88U
M$451 \$7144 \$7175 VDD VDD pfet_06v0 L=20U W=0.7U AS=0.308P AD=0.308P PS=2.28U
+ PD=2.28U
M$452 \$8936 \$8936 \$8990 VDD pfet_06v0 L=1U W=10U AS=4.4P AD=4.4P PS=20.88U
+ PD=20.88U
M$453 \$10674 \$9753 VDD VDD pfet_06v0 L=1U W=10U AS=4.4P AD=2.5P PS=20.88U
+ PD=10.5U
M$454 \$8921 \$9981 \$10674 VDD pfet_06v0 L=1U W=10U AS=2.5P AD=4.4P PS=10.5U
+ PD=20.88U
M$455 \$8938 \$8935 VDD VDD pfet_06v0 L=1U W=10U AS=4.4P AD=2.6P PS=20.88U
+ PD=10.52U
M$456 VDD \$8935 \$8938 VDD pfet_06v0 L=1U W=10U AS=2.6P AD=2.6P PS=10.52U
+ PD=10.52U
M$457 \$8938 \$8935 VDD VDD pfet_06v0 L=1U W=10U AS=2.6P AD=4.4P PS=10.52U
+ PD=20.88U
M$458 \$8852 \$7222 VDD VDD pfet_06v0 L=1U W=10U AS=4.4P AD=2.5P PS=20.88U
+ PD=10.5U
M$459 \$7762 \$7223 \$8852 VDD pfet_06v0 L=1U W=10U AS=2.5P AD=4.4P PS=10.5U
+ PD=20.88U
M$460 \$8853 \$7222 VDD VDD pfet_06v0 L=1U W=10U AS=4.4P AD=2.5P PS=20.88U
+ PD=10.5U
M$461 \$7762 \$7223 \$8853 VDD pfet_06v0 L=1U W=10U AS=2.5P AD=4.4P PS=10.5U
+ PD=20.88U
M$462 \$7152 S4P \$7762 VDD pfet_06v0 L=1U W=10U AS=4.4P AD=4.4P PS=20.88U
+ PD=20.88U
M$463 \$7150 S4N \$7762 VDD pfet_06v0 L=1U W=10U AS=4.4P AD=4.4P PS=20.88U
+ PD=20.88U
M$464 \$10676 \$9754 VDD VDD pfet_06v0 L=1U W=10U AS=4.4P AD=2.5P PS=20.88U
+ PD=10.5U
M$465 \$8922 \$9982 \$10676 VDD pfet_06v0 L=1U W=10U AS=2.5P AD=4.4P PS=10.5U
+ PD=20.88U
M$466 \$7533 \$7223 \$7149 VDD pfet_06v0 L=1U W=5U AS=2.2P AD=2.2P PS=10.88U
+ PD=10.88U
M$467 \$10678 \$9754 VDD VDD pfet_06v0 L=1U W=10U AS=4.4P AD=2.5P PS=20.88U
+ PD=10.5U
M$468 \$8923 \$9982 \$10678 VDD pfet_06v0 L=1U W=10U AS=2.5P AD=4.4P PS=10.5U
+ PD=20.88U
M$469 \$7177 \$7223 \$7148 VDD pfet_06v0 L=1U W=5U AS=2.2P AD=2.2P PS=10.88U
+ PD=10.88U
M$470 \$9982 \$9982 VDD VDD pfet_06v0 L=1U W=2U AS=0.88P AD=0.88P PS=4.88U
+ PD=4.88U
M$471 \$7149 \$7533 VDD VDD pfet_06v0 L=1U W=5U AS=2.2P AD=2.2P PS=10.88U
+ PD=10.88U
M$472 \$10679 \$9754 VDD VDD pfet_06v0 L=1U W=10U AS=4.4P AD=2.5P PS=20.88U
+ PD=10.5U
M$473 \$9754 \$9982 \$10679 VDD pfet_06v0 L=1U W=10U AS=2.5P AD=4.4P PS=10.5U
+ PD=20.88U
M$474 \$7148 \$7533 VDD VDD pfet_06v0 L=1U W=5U AS=2.2P AD=2.2P PS=10.88U
+ PD=10.88U
M$475 \$7151 \$7155 \$7533 VDD pfet_06v0 L=1U W=5U AS=2.2P AD=2.2P PS=10.88U
+ PD=10.88U
M$476 \$10681 \$9754 VDD VDD pfet_06v0 L=1U W=10U AS=4.4P AD=2.5P PS=20.88U
+ PD=10.5U
M$477 \$9148 \$9982 \$10681 VDD pfet_06v0 L=1U W=10U AS=2.5P AD=4.4P PS=10.5U
+ PD=20.88U
M$478 \$7153 \$7155 \$7177 VDD pfet_06v0 L=1U W=5U AS=2.2P AD=2.2P PS=10.88U
+ PD=10.88U
M$479 \$10682 \$9754 VDD VDD pfet_06v0 L=1U W=10U AS=4.4P AD=2.5P PS=20.88U
+ PD=10.5U
M$480 \$9148 \$9982 \$10682 VDD pfet_06v0 L=1U W=10U AS=2.5P AD=4.4P PS=10.5U
+ PD=20.88U
M$481 \$8872 \$7379 VDD VDD pfet_06v0 L=1U W=10U AS=4.4P AD=2.5P PS=20.88U
+ PD=10.5U
M$482 \$7379 \$7223 \$8872 VDD pfet_06v0 L=1U W=10U AS=2.5P AD=4.4P PS=10.5U
+ PD=20.88U
M$483 \$8944 \$7170 \$9148 VDD pfet_06v0 L=1U W=10U AS=4.4P AD=2.6P PS=20.88U
+ PD=10.52U
M$484 \$9148 \$7170 \$8944 VDD pfet_06v0 L=1U W=10U AS=2.6P AD=4.4P PS=10.52U
+ PD=20.88U
M$485 \$7155 \$7155 \$7379 VDD pfet_06v0 L=1U W=10U AS=4.4P AD=4.4P PS=20.88U
+ PD=20.88U
M$486 \$8883 \$7222 VDD VDD pfet_06v0 L=1U W=10U AS=4.4P AD=2.5P PS=20.88U
+ PD=10.5U
M$487 \$7154 \$7223 \$8883 VDD pfet_06v0 L=1U W=10U AS=2.5P AD=4.4P PS=10.5U
+ PD=20.88U
M$488 \$8942 \$7144 \$9148 VDD pfet_06v0 L=1U W=10U AS=4.4P AD=2.6P PS=20.88U
+ PD=10.52U
M$489 \$9148 \$7144 \$8942 VDD pfet_06v0 L=1U W=10U AS=2.6P AD=4.4P PS=10.52U
+ PD=20.88U
M$490 \$8884 \$7222 VDD VDD pfet_06v0 L=1U W=10U AS=4.4P AD=2.5P PS=20.88U
+ PD=10.5U
M$491 \$7146 \$7223 \$8884 VDD pfet_06v0 L=1U W=10U AS=2.5P AD=4.4P PS=10.5U
+ PD=20.88U
M$492 \$9301 \$9982 \$8941 VDD pfet_06v0 L=1U W=5U AS=2.2P AD=1.3P PS=10.88U
+ PD=5.52U
M$493 \$8941 \$9982 \$9301 VDD pfet_06v0 L=1U W=5U AS=1.3P AD=2.2P PS=5.52U
+ PD=10.88U
M$494 \$8887 \$7222 VDD VDD pfet_06v0 L=1U W=10U AS=4.4P AD=2.5P PS=20.88U
+ PD=10.5U
M$495 \$7145 \$7223 \$8887 VDD pfet_06v0 L=1U W=10U AS=2.5P AD=4.4P PS=10.5U
+ PD=20.88U
M$496 \$8946 \$9982 \$8940 VDD pfet_06v0 L=1U W=5U AS=2.2P AD=1.3P PS=10.88U
+ PD=5.52U
M$497 \$8940 \$9982 \$8946 VDD pfet_06v0 L=1U W=5U AS=1.3P AD=2.2P PS=5.52U
+ PD=10.88U
M$498 \$7223 \$7223 VDD VDD pfet_06v0 L=1U W=2U AS=0.88P AD=0.88P PS=4.88U
+ PD=4.88U
M$499 \$8941 \$9301 VDD VDD pfet_06v0 L=1U W=5U AS=2.2P AD=1.3P PS=10.88U
+ PD=5.52U
M$500 VDD \$9301 \$8941 VDD pfet_06v0 L=1U W=5U AS=1.3P AD=1.3P PS=5.52U
+ PD=5.52U
M$501 \$8941 \$9301 VDD VDD pfet_06v0 L=1U W=5U AS=1.3P AD=1.3P PS=5.52U
+ PD=5.52U
M$502 VDD \$9301 \$8941 VDD pfet_06v0 L=1U W=5U AS=1.3P AD=2.2P PS=5.52U
+ PD=10.88U
M$503 \$8889 \$7222 VDD VDD pfet_06v0 L=1U W=10U AS=4.4P AD=2.5P PS=20.88U
+ PD=10.5U
M$504 \$7222 \$7223 \$8889 VDD pfet_06v0 L=1U W=10U AS=2.5P AD=4.4P PS=10.5U
+ PD=20.88U
M$505 \$8940 \$9301 VDD VDD pfet_06v0 L=1U W=5U AS=2.2P AD=1.3P PS=10.88U
+ PD=5.52U
M$506 VDD \$9301 \$8940 VDD pfet_06v0 L=1U W=5U AS=1.3P AD=1.3P PS=5.52U
+ PD=5.52U
M$507 \$8940 \$9301 VDD VDD pfet_06v0 L=1U W=5U AS=1.3P AD=1.3P PS=5.52U
+ PD=5.52U
M$508 VDD \$9301 \$8940 VDD pfet_06v0 L=1U W=5U AS=1.3P AD=2.2P PS=5.52U
+ PD=10.88U
M$509 \$7157 \$7177 VDD VDD pfet_06v0 L=20U W=0.7U AS=0.308P AD=0.308P PS=2.28U
+ PD=2.28U
M$510 \$8943 \$8947 \$9301 VDD pfet_06v0 L=1U W=5U AS=2.2P AD=2.2P PS=10.88U
+ PD=10.88U
M$511 \$8945 \$8947 \$8946 VDD pfet_06v0 L=1U W=5U AS=2.2P AD=2.2P PS=10.88U
+ PD=10.88U
M$512 \$10680 \$8993 VDD VDD pfet_06v0 L=1U W=10U AS=4.4P AD=2.5P PS=20.88U
+ PD=10.5U
M$513 \$8993 \$9982 \$10680 VDD pfet_06v0 L=1U W=10U AS=2.5P AD=4.4P PS=10.5U
+ PD=20.88U
M$514 \$8947 \$8947 \$8993 VDD pfet_06v0 L=1U W=10U AS=4.4P AD=4.4P PS=20.88U
+ PD=20.88U
M$515 \$8892 \$7224 VDD VDD pfet_06v0 L=1U W=10U AS=4.4P AD=2.5P PS=20.88U
+ PD=10.5U
M$516 \$7763 \$7225 \$8892 VDD pfet_06v0 L=1U W=10U AS=2.5P AD=4.4P PS=10.5U
+ PD=20.88U
M$517 \$10677 \$9754 VDD VDD pfet_06v0 L=1U W=10U AS=4.4P AD=2.5P PS=20.88U
+ PD=10.5U
M$518 \$8924 \$9982 \$10677 VDD pfet_06v0 L=1U W=10U AS=2.5P AD=4.4P PS=10.5U
+ PD=20.88U
M$519 \$8897 \$7224 VDD VDD pfet_06v0 L=1U W=10U AS=4.4P AD=2.5P PS=20.88U
+ PD=10.5U
M$520 \$7763 \$7225 \$8897 VDD pfet_06v0 L=1U W=10U AS=2.5P AD=4.4P PS=10.5U
+ PD=20.88U
M$521 \$8968 \$8946 VDD VDD pfet_06v0 L=1U W=10U AS=4.4P AD=2.6P PS=20.88U
+ PD=10.52U
M$522 VDD \$8946 \$8968 VDD pfet_06v0 L=1U W=10U AS=2.6P AD=2.6P PS=10.52U
+ PD=10.52U
M$523 \$8968 \$8946 VDD VDD pfet_06v0 L=1U W=10U AS=2.6P AD=4.4P PS=10.52U
+ PD=20.88U
M$524 \$7165 S1P \$7763 VDD pfet_06v0 L=1U W=10U AS=4.4P AD=4.4P PS=20.88U
+ PD=20.88U
M$525 \$7163 S1N \$7763 VDD pfet_06v0 L=1U W=10U AS=4.4P AD=4.4P PS=20.88U
+ PD=20.88U
M$526 \$7534 \$7225 \$7162 VDD pfet_06v0 L=1U W=5U AS=2.2P AD=2.2P PS=10.88U
+ PD=10.88U
M$527 \$7179 \$7225 \$7161 VDD pfet_06v0 L=1U W=5U AS=2.2P AD=2.2P PS=10.88U
+ PD=10.88U
M$528 \$7162 \$7534 VDD VDD pfet_06v0 L=1U W=5U AS=2.2P AD=2.2P PS=10.88U
+ PD=10.88U
M$529 \$7161 \$7534 VDD VDD pfet_06v0 L=1U W=5U AS=2.2P AD=2.2P PS=10.88U
+ PD=10.88U
M$530 \$10675 \$9755 VDD VDD pfet_06v0 L=1U W=10U AS=4.4P AD=2.5P PS=20.88U
+ PD=10.5U
M$531 \$8925 \$9983 \$10675 VDD pfet_06v0 L=1U W=10U AS=2.5P AD=4.4P PS=10.5U
+ PD=20.88U
M$532 \$7164 \$7168 \$7534 VDD pfet_06v0 L=1U W=5U AS=2.2P AD=2.2P PS=10.88U
+ PD=10.88U
M$533 \$10672 \$9755 VDD VDD pfet_06v0 L=1U W=10U AS=4.4P AD=2.5P PS=20.88U
+ PD=10.5U
M$534 \$8926 \$9983 \$10672 VDD pfet_06v0 L=1U W=10U AS=2.5P AD=4.4P PS=10.5U
+ PD=20.88U
M$535 \$7166 \$7168 \$7179 VDD pfet_06v0 L=1U W=5U AS=2.2P AD=2.2P PS=10.88U
+ PD=10.88U
M$536 \$9983 \$9983 VDD VDD pfet_06v0 L=1U W=2U AS=0.88P AD=0.88P PS=4.88U
+ PD=4.88U
M$537 \$8898 \$7380 VDD VDD pfet_06v0 L=1U W=10U AS=4.4P AD=2.5P PS=20.88U
+ PD=10.5U
M$538 \$7380 \$7225 \$8898 VDD pfet_06v0 L=1U W=10U AS=2.5P AD=4.4P PS=10.5U
+ PD=20.88U
M$539 \$10671 \$9755 VDD VDD pfet_06v0 L=1U W=10U AS=4.4P AD=2.5P PS=20.88U
+ PD=10.5U
M$540 \$9755 \$9983 \$10671 VDD pfet_06v0 L=1U W=10U AS=2.5P AD=4.4P PS=10.5U
+ PD=20.88U
M$541 \$7168 \$7168 \$7380 VDD pfet_06v0 L=1U W=10U AS=4.4P AD=4.4P PS=20.88U
+ PD=20.88U
M$542 \$8882 \$7224 VDD VDD pfet_06v0 L=1U W=10U AS=4.4P AD=2.5P PS=20.88U
+ PD=10.5U
M$543 \$7167 \$7225 \$8882 VDD pfet_06v0 L=1U W=10U AS=2.5P AD=4.4P PS=10.5U
+ PD=20.88U
M$544 \$10670 \$9755 VDD VDD pfet_06v0 L=1U W=10U AS=4.4P AD=2.5P PS=20.88U
+ PD=10.5U
M$545 \$9149 \$9983 \$10670 VDD pfet_06v0 L=1U W=10U AS=2.5P AD=4.4P PS=10.5U
+ PD=20.88U
M$546 \$10669 \$9755 VDD VDD pfet_06v0 L=1U W=10U AS=4.4P AD=2.5P PS=20.88U
+ PD=10.5U
M$547 \$9149 \$9983 \$10669 VDD pfet_06v0 L=1U W=10U AS=2.5P AD=4.4P PS=10.5U
+ PD=20.88U
M$548 \$8870 \$7224 VDD VDD pfet_06v0 L=1U W=10U AS=4.4P AD=2.5P PS=20.88U
+ PD=10.5U
M$549 \$7159 \$7225 \$8870 VDD pfet_06v0 L=1U W=10U AS=2.5P AD=4.4P PS=10.5U
+ PD=20.88U
M$550 \$8954 \$7170 \$9149 VDD pfet_06v0 L=1U W=10U AS=4.4P AD=2.6P PS=20.88U
+ PD=10.52U
M$551 \$9149 \$7170 \$8954 VDD pfet_06v0 L=1U W=10U AS=2.6P AD=4.4P PS=10.52U
+ PD=20.88U
M$552 \$8854 \$7224 VDD VDD pfet_06v0 L=1U W=10U AS=4.4P AD=2.5P PS=20.88U
+ PD=10.5U
M$553 \$7158 \$7225 \$8854 VDD pfet_06v0 L=1U W=10U AS=2.5P AD=4.4P PS=10.5U
+ PD=20.88U
M$554 \$7225 \$7225 VDD VDD pfet_06v0 L=1U W=2U AS=0.88P AD=0.88P PS=4.88U
+ PD=4.88U
M$555 \$8952 \$7157 \$9149 VDD pfet_06v0 L=1U W=10U AS=4.4P AD=2.6P PS=20.88U
+ PD=10.52U
M$556 \$9149 \$7157 \$8952 VDD pfet_06v0 L=1U W=10U AS=2.6P AD=4.4P PS=10.52U
+ PD=20.88U
M$557 \$8851 \$7224 VDD VDD pfet_06v0 L=1U W=10U AS=4.4P AD=2.5P PS=20.88U
+ PD=10.5U
M$558 \$7224 \$7225 \$8851 VDD pfet_06v0 L=1U W=10U AS=2.5P AD=4.4P PS=10.5U
+ PD=20.88U
M$559 \$9302 \$9983 \$8951 VDD pfet_06v0 L=1U W=5U AS=2.2P AD=1.3P PS=10.88U
+ PD=5.52U
M$560 \$8951 \$9983 \$9302 VDD pfet_06v0 L=1U W=5U AS=1.3P AD=2.2P PS=5.52U
+ PD=10.88U
M$561 \$8956 \$9983 \$8950 VDD pfet_06v0 L=1U W=5U AS=2.2P AD=1.3P PS=10.88U
+ PD=5.52U
M$562 \$8950 \$9983 \$8956 VDD pfet_06v0 L=1U W=5U AS=1.3P AD=2.2P PS=5.52U
+ PD=10.88U
M$563 \$7170 \$7179 VDD VDD pfet_06v0 L=20U W=0.7U AS=0.308P AD=0.308P PS=2.28U
+ PD=2.28U
M$564 \$8951 \$9302 VDD VDD pfet_06v0 L=1U W=5U AS=2.2P AD=1.3P PS=10.88U
+ PD=5.52U
M$565 VDD \$9302 \$8951 VDD pfet_06v0 L=1U W=5U AS=1.3P AD=1.3P PS=5.52U
+ PD=5.52U
M$566 \$8951 \$9302 VDD VDD pfet_06v0 L=1U W=5U AS=1.3P AD=1.3P PS=5.52U
+ PD=5.52U
M$567 VDD \$9302 \$8951 VDD pfet_06v0 L=1U W=5U AS=1.3P AD=2.2P PS=5.52U
+ PD=10.88U
M$568 \$8950 \$9302 VDD VDD pfet_06v0 L=1U W=5U AS=2.2P AD=1.3P PS=10.88U
+ PD=5.52U
M$569 VDD \$9302 \$8950 VDD pfet_06v0 L=1U W=5U AS=1.3P AD=1.3P PS=5.52U
+ PD=5.52U
M$570 \$8950 \$9302 VDD VDD pfet_06v0 L=1U W=5U AS=1.3P AD=1.3P PS=5.52U
+ PD=5.52U
M$571 VDD \$9302 \$8950 VDD pfet_06v0 L=1U W=5U AS=1.3P AD=2.2P PS=5.52U
+ PD=10.88U
M$572 \$8953 \$8957 \$9302 VDD pfet_06v0 L=1U W=5U AS=2.2P AD=2.2P PS=10.88U
+ PD=10.88U
M$573 Z Z VDD VDD pfet_06v0 L=1U W=2U AS=0.88P AD=0.52P PS=4.88U PD=2.52U
M$574 VDD Z Z VDD pfet_06v0 L=1U W=2U AS=0.52P AD=0.52P PS=2.52U PD=2.52U
M$575 Z Z VDD VDD pfet_06v0 L=1U W=2U AS=0.52P AD=0.52P PS=2.52U PD=2.52U
M$576 VDD Z Z VDD pfet_06v0 L=1U W=2U AS=0.52P AD=0.52P PS=2.52U PD=2.52U
M$577 Z Z VDD VDD pfet_06v0 L=1U W=2U AS=0.52P AD=0.52P PS=2.52U PD=2.52U
M$578 VDD Z Z VDD pfet_06v0 L=1U W=2U AS=0.52P AD=0.88P PS=2.52U PD=4.88U
M$579 \$8955 \$8957 \$8956 VDD pfet_06v0 L=1U W=5U AS=2.2P AD=2.2P PS=10.88U
+ PD=10.88U
M$580 \$10666 \$8996 VDD VDD pfet_06v0 L=1U W=10U AS=4.4P AD=2.5P PS=20.88U
+ PD=10.5U
M$581 \$8996 \$9983 \$10666 VDD pfet_06v0 L=1U W=10U AS=2.5P AD=4.4P PS=10.5U
+ PD=20.88U
M$582 \$7172 \$7172 VDD VDD pfet_06v0 L=1U W=2U AS=0.88P AD=0.88P PS=4.88U
+ PD=4.88U
M$583 \$8957 \$8957 \$8996 VDD pfet_06v0 L=1U W=10U AS=4.4P AD=4.4P PS=20.88U
+ PD=20.88U
M$584 \$10664 \$9755 VDD VDD pfet_06v0 L=1U W=10U AS=4.4P AD=2.5P PS=20.88U
+ PD=10.5U
M$585 \$8927 \$9983 \$10664 VDD pfet_06v0 L=1U W=10U AS=2.5P AD=4.4P PS=10.5U
+ PD=20.88U
M$586 \$8959 \$8956 VDD VDD pfet_06v0 L=1U W=10U AS=4.4P AD=2.6P PS=20.88U
+ PD=10.52U
M$587 VDD \$8956 \$8959 VDD pfet_06v0 L=1U W=10U AS=2.6P AD=2.6P PS=10.52U
+ PD=10.52U
M$588 \$8959 \$8956 VDD VDD pfet_06v0 L=1U W=10U AS=2.6P AD=4.4P PS=10.52U
+ PD=20.88U
M$589 \$14208 \$13374 VDD VDD pfet_06v0 L=1U W=10U AS=4.4P AD=2.5P PS=20.88U
+ PD=10.5U
M$590 \$12465 \$13527 \$14208 VDD pfet_06v0 L=1U W=10U AS=2.5P AD=4.4P PS=10.5U
+ PD=20.88U
M$591 \$12365 \$10774 VDD VDD pfet_06v0 L=1U W=10U AS=4.4P AD=2.5P PS=20.88U
+ PD=10.5U
M$592 \$11309 \$10765 \$12365 VDD pfet_06v0 L=1U W=10U AS=2.5P AD=4.4P PS=10.5U
+ PD=20.88U
M$593 \$14209 \$13374 VDD VDD pfet_06v0 L=1U W=10U AS=4.4P AD=2.5P PS=20.88U
+ PD=10.5U
M$594 \$12466 \$13527 \$14209 VDD pfet_06v0 L=1U W=10U AS=2.5P AD=4.4P PS=10.5U
+ PD=20.88U
M$595 \$12366 \$10774 VDD VDD pfet_06v0 L=1U W=10U AS=4.4P AD=2.5P PS=20.88U
+ PD=10.5U
M$596 \$11309 \$10765 \$12366 VDD pfet_06v0 L=1U W=10U AS=2.5P AD=4.4P PS=10.5U
+ PD=20.88U
M$597 \$10704 S3P \$11309 VDD pfet_06v0 L=1U W=10U AS=4.4P AD=4.4P PS=20.88U
+ PD=20.88U
M$598 \$13527 \$13527 VDD VDD pfet_06v0 L=1U W=2U AS=0.88P AD=0.88P PS=4.88U
+ PD=4.88U
M$599 \$14210 \$13374 VDD VDD pfet_06v0 L=1U W=10U AS=4.4P AD=2.5P PS=20.88U
+ PD=10.5U
M$600 \$13374 \$13527 \$14210 VDD pfet_06v0 L=1U W=10U AS=2.5P AD=4.4P PS=10.5U
+ PD=20.88U
M$601 \$10702 S3N \$11309 VDD pfet_06v0 L=1U W=10U AS=4.4P AD=4.4P PS=20.88U
+ PD=20.88U
M$602 \$11081 \$10765 \$10701 VDD pfet_06v0 L=1U W=5U AS=2.2P AD=2.2P PS=10.88U
+ PD=10.88U
M$603 \$14211 \$13374 VDD VDD pfet_06v0 L=1U W=10U AS=4.4P AD=2.5P PS=20.88U
+ PD=10.5U
M$604 \$12693 \$13527 \$14211 VDD pfet_06v0 L=1U W=10U AS=2.5P AD=4.4P PS=10.5U
+ PD=20.88U
M$605 \$10740 \$10765 \$10700 VDD pfet_06v0 L=1U W=5U AS=2.2P AD=2.2P PS=10.88U
+ PD=10.88U
M$606 \$14212 \$13374 VDD VDD pfet_06v0 L=1U W=10U AS=4.4P AD=2.5P PS=20.88U
+ PD=10.5U
M$607 \$12693 \$13527 \$14212 VDD pfet_06v0 L=1U W=10U AS=2.5P AD=4.4P PS=10.5U
+ PD=20.88U
M$608 \$10701 \$11081 VDD VDD pfet_06v0 L=1U W=5U AS=2.2P AD=2.2P PS=10.88U
+ PD=10.88U
M$609 \$10700 \$11081 VDD VDD pfet_06v0 L=1U W=5U AS=2.2P AD=2.2P PS=10.88U
+ PD=10.88U
M$610 \$12479 \$10719 \$12693 VDD pfet_06v0 L=1U W=10U AS=4.4P AD=2.6P
+ PS=20.88U PD=10.52U
M$611 \$12693 \$10719 \$12479 VDD pfet_06v0 L=1U W=10U AS=2.6P AD=4.4P
+ PS=10.52U PD=20.88U
M$612 \$10703 \$10706 \$11081 VDD pfet_06v0 L=1U W=5U AS=2.2P AD=2.2P PS=10.88U
+ PD=10.88U
M$613 \$12477 \$10708 \$12693 VDD pfet_06v0 L=1U W=10U AS=4.4P AD=2.6P
+ PS=20.88U PD=10.52U
M$614 \$12693 \$10708 \$12477 VDD pfet_06v0 L=1U W=10U AS=2.6P AD=4.4P
+ PS=10.52U PD=20.88U
M$615 \$10705 \$10706 \$10740 VDD pfet_06v0 L=1U W=5U AS=2.2P AD=2.2P PS=10.88U
+ PD=10.88U
M$616 \$12771 \$13527 \$12476 VDD pfet_06v0 L=1U W=5U AS=2.2P AD=1.3P PS=10.88U
+ PD=5.52U
M$617 \$12476 \$13527 \$12771 VDD pfet_06v0 L=1U W=5U AS=1.3P AD=2.2P PS=5.52U
+ PD=10.88U
M$618 \$12384 \$10928 VDD VDD pfet_06v0 L=1U W=10U AS=4.4P AD=2.5P PS=20.88U
+ PD=10.5U
M$619 \$10928 \$10765 \$12384 VDD pfet_06v0 L=1U W=10U AS=2.5P AD=4.4P PS=10.5U
+ PD=20.88U
M$620 \$12481 \$13527 \$12475 VDD pfet_06v0 L=1U W=5U AS=2.2P AD=1.3P PS=10.88U
+ PD=5.52U
M$621 \$12475 \$13527 \$12481 VDD pfet_06v0 L=1U W=5U AS=1.3P AD=2.2P PS=5.52U
+ PD=10.88U
M$622 \$10706 \$10706 \$10928 VDD pfet_06v0 L=1U W=10U AS=4.4P AD=4.4P
+ PS=20.88U PD=20.88U
M$623 \$12395 \$10774 VDD VDD pfet_06v0 L=1U W=10U AS=4.4P AD=2.5P PS=20.88U
+ PD=10.5U
M$624 \$10689 \$10765 \$12395 VDD pfet_06v0 L=1U W=10U AS=2.5P AD=4.4P PS=10.5U
+ PD=20.88U
M$625 \$12476 \$12771 VDD VDD pfet_06v0 L=1U W=5U AS=2.2P AD=1.3P PS=10.88U
+ PD=5.52U
M$626 VDD \$12771 \$12476 VDD pfet_06v0 L=1U W=5U AS=1.3P AD=1.3P PS=5.52U
+ PD=5.52U
M$627 \$12476 \$12771 VDD VDD pfet_06v0 L=1U W=5U AS=1.3P AD=1.3P PS=5.52U
+ PD=5.52U
M$628 VDD \$12771 \$12476 VDD pfet_06v0 L=1U W=5U AS=1.3P AD=2.2P PS=5.52U
+ PD=10.88U
M$629 \$12396 \$10774 VDD VDD pfet_06v0 L=1U W=10U AS=4.4P AD=2.5P PS=20.88U
+ PD=10.5U
M$630 \$10688 \$10765 \$12396 VDD pfet_06v0 L=1U W=10U AS=2.5P AD=4.4P PS=10.5U
+ PD=20.88U
M$631 \$12475 \$12771 VDD VDD pfet_06v0 L=1U W=5U AS=2.2P AD=1.3P PS=10.88U
+ PD=5.52U
M$632 VDD \$12771 \$12475 VDD pfet_06v0 L=1U W=5U AS=1.3P AD=1.3P PS=5.52U
+ PD=5.52U
M$633 \$12475 \$12771 VDD VDD pfet_06v0 L=1U W=5U AS=1.3P AD=1.3P PS=5.52U
+ PD=5.52U
M$634 VDD \$12771 \$12475 VDD pfet_06v0 L=1U W=5U AS=1.3P AD=2.2P PS=5.52U
+ PD=10.88U
M$635 \$12397 \$10774 VDD VDD pfet_06v0 L=1U W=10U AS=4.4P AD=2.5P PS=20.88U
+ PD=10.5U
M$636 \$10687 \$10765 \$12397 VDD pfet_06v0 L=1U W=10U AS=2.5P AD=4.4P PS=10.5U
+ PD=20.88U
M$637 \$10765 \$10765 VDD VDD pfet_06v0 L=1U W=2U AS=0.88P AD=0.88P PS=4.88U
+ PD=4.88U
M$638 \$12478 \$12482 \$12771 VDD pfet_06v0 L=1U W=5U AS=2.2P AD=2.2P PS=10.88U
+ PD=10.88U
M$639 \$12399 \$10774 VDD VDD pfet_06v0 L=1U W=10U AS=4.4P AD=2.5P PS=20.88U
+ PD=10.5U
M$640 \$10774 \$10765 \$12399 VDD pfet_06v0 L=1U W=10U AS=2.5P AD=4.4P PS=10.5U
+ PD=20.88U
M$641 \$12480 \$12482 \$12481 VDD pfet_06v0 L=1U W=5U AS=2.2P AD=2.2P PS=10.88U
+ PD=10.88U
M$642 \$14214 \$12540 VDD VDD pfet_06v0 L=1U W=10U AS=4.4P AD=2.5P PS=20.88U
+ PD=10.5U
M$643 \$12540 \$13527 \$14214 VDD pfet_06v0 L=1U W=10U AS=2.5P AD=4.4P PS=10.5U
+ PD=20.88U
M$644 \$10708 \$10740 VDD VDD pfet_06v0 L=20U W=0.7U AS=0.308P AD=0.308P
+ PS=2.28U PD=2.28U
M$645 \$12482 \$12482 \$12540 VDD pfet_06v0 L=1U W=10U AS=4.4P AD=4.4P
+ PS=20.88U PD=20.88U
M$646 \$14215 \$13374 VDD VDD pfet_06v0 L=1U W=10U AS=4.4P AD=2.5P PS=20.88U
+ PD=10.5U
M$647 \$12467 \$13527 \$14215 VDD pfet_06v0 L=1U W=10U AS=2.5P AD=4.4P PS=10.5U
+ PD=20.88U
M$648 \$12484 \$12481 VDD VDD pfet_06v0 L=1U W=10U AS=4.4P AD=2.6P PS=20.88U
+ PD=10.52U
M$649 VDD \$12481 \$12484 VDD pfet_06v0 L=1U W=10U AS=2.6P AD=2.6P PS=10.52U
+ PD=10.52U
M$650 \$12484 \$12481 VDD VDD pfet_06v0 L=1U W=10U AS=2.6P AD=4.4P PS=10.52U
+ PD=20.88U
M$651 \$12401 \$10775 VDD VDD pfet_06v0 L=1U W=10U AS=4.4P AD=2.5P PS=20.88U
+ PD=10.5U
M$652 \$11310 \$10768 \$12401 VDD pfet_06v0 L=1U W=10U AS=2.5P AD=4.4P PS=10.5U
+ PD=20.88U
M$653 \$12403 \$10775 VDD VDD pfet_06v0 L=1U W=10U AS=4.4P AD=2.5P PS=20.88U
+ PD=10.5U
M$654 \$11310 \$10768 \$12403 VDD pfet_06v0 L=1U W=10U AS=2.5P AD=4.4P PS=10.5U
+ PD=20.88U
M$655 \$10715 S4P \$11310 VDD pfet_06v0 L=1U W=10U AS=4.4P AD=4.4P PS=20.88U
+ PD=20.88U
M$656 \$10713 S4N \$11310 VDD pfet_06v0 L=1U W=10U AS=4.4P AD=4.4P PS=20.88U
+ PD=20.88U
M$657 \$14216 \$13375 VDD VDD pfet_06v0 L=1U W=10U AS=4.4P AD=2.5P PS=20.88U
+ PD=10.5U
M$658 \$12468 \$13528 \$14216 VDD pfet_06v0 L=1U W=10U AS=2.5P AD=4.4P PS=10.5U
+ PD=20.88U
M$659 \$11082 \$10768 \$10712 VDD pfet_06v0 L=1U W=5U AS=2.2P AD=2.2P PS=10.88U
+ PD=10.88U
M$660 \$14218 \$13375 VDD VDD pfet_06v0 L=1U W=10U AS=4.4P AD=2.5P PS=20.88U
+ PD=10.5U
M$661 \$12469 \$13528 \$14218 VDD pfet_06v0 L=1U W=10U AS=2.5P AD=4.4P PS=10.5U
+ PD=20.88U
M$662 \$10741 \$10768 \$10711 VDD pfet_06v0 L=1U W=5U AS=2.2P AD=2.2P PS=10.88U
+ PD=10.88U
M$663 \$13528 \$13528 VDD VDD pfet_06v0 L=1U W=2U AS=0.88P AD=0.88P PS=4.88U
+ PD=4.88U
M$664 \$10712 \$11082 VDD VDD pfet_06v0 L=1U W=5U AS=2.2P AD=2.2P PS=10.88U
+ PD=10.88U
M$665 \$10711 \$11082 VDD VDD pfet_06v0 L=1U W=5U AS=2.2P AD=2.2P PS=10.88U
+ PD=10.88U
M$666 \$14219 \$13375 VDD VDD pfet_06v0 L=1U W=10U AS=4.4P AD=2.5P PS=20.88U
+ PD=10.5U
M$667 \$13375 \$13528 \$14219 VDD pfet_06v0 L=1U W=10U AS=2.5P AD=4.4P PS=10.5U
+ PD=20.88U
M$668 \$10714 \$10717 \$11082 VDD pfet_06v0 L=1U W=5U AS=2.2P AD=2.2P PS=10.88U
+ PD=10.88U
M$669 \$14220 \$13375 VDD VDD pfet_06v0 L=1U W=10U AS=4.4P AD=2.5P PS=20.88U
+ PD=10.5U
M$670 \$12694 \$13528 \$14220 VDD pfet_06v0 L=1U W=10U AS=2.5P AD=4.4P PS=10.5U
+ PD=20.88U
M$671 \$10716 \$10717 \$10741 VDD pfet_06v0 L=1U W=5U AS=2.2P AD=2.2P PS=10.88U
+ PD=10.88U
M$672 \$14221 \$13375 VDD VDD pfet_06v0 L=1U W=10U AS=4.4P AD=2.5P PS=20.88U
+ PD=10.5U
M$673 \$12694 \$13528 \$14221 VDD pfet_06v0 L=1U W=10U AS=2.5P AD=4.4P PS=10.5U
+ PD=20.88U
M$674 \$12425 \$10929 VDD VDD pfet_06v0 L=1U W=10U AS=4.4P AD=2.5P PS=20.88U
+ PD=10.5U
M$675 \$10929 \$10768 \$12425 VDD pfet_06v0 L=1U W=10U AS=2.5P AD=4.4P PS=10.5U
+ PD=20.88U
M$676 \$12490 \$10730 \$12694 VDD pfet_06v0 L=1U W=10U AS=4.4P AD=2.6P
+ PS=20.88U PD=10.52U
M$677 \$12694 \$10730 \$12490 VDD pfet_06v0 L=1U W=10U AS=2.6P AD=4.4P
+ PS=10.52U PD=20.88U
M$678 \$10717 \$10717 \$10929 VDD pfet_06v0 L=1U W=10U AS=4.4P AD=4.4P
+ PS=20.88U PD=20.88U
M$679 \$12436 \$10775 VDD VDD pfet_06v0 L=1U W=10U AS=4.4P AD=2.5P PS=20.88U
+ PD=10.5U
M$680 \$10692 \$10768 \$12436 VDD pfet_06v0 L=1U W=10U AS=2.5P AD=4.4P PS=10.5U
+ PD=20.88U
M$681 \$12488 \$10708 \$12694 VDD pfet_06v0 L=1U W=10U AS=4.4P AD=2.6P
+ PS=20.88U PD=10.52U
M$682 \$12694 \$10708 \$12488 VDD pfet_06v0 L=1U W=10U AS=2.6P AD=4.4P
+ PS=10.52U PD=20.88U
M$683 \$12437 \$10775 VDD VDD pfet_06v0 L=1U W=10U AS=4.4P AD=2.5P PS=20.88U
+ PD=10.5U
M$684 \$10691 \$10768 \$12437 VDD pfet_06v0 L=1U W=10U AS=2.5P AD=4.4P PS=10.5U
+ PD=20.88U
M$685 \$12772 \$13528 \$12487 VDD pfet_06v0 L=1U W=5U AS=2.2P AD=1.3P PS=10.88U
+ PD=5.52U
M$686 \$12487 \$13528 \$12772 VDD pfet_06v0 L=1U W=5U AS=1.3P AD=2.2P PS=5.52U
+ PD=10.88U
M$687 \$12442 \$10775 VDD VDD pfet_06v0 L=1U W=10U AS=4.4P AD=2.5P PS=20.88U
+ PD=10.5U
M$688 \$10690 \$10768 \$12442 VDD pfet_06v0 L=1U W=10U AS=2.5P AD=4.4P PS=10.5U
+ PD=20.88U
M$689 \$12492 \$13528 \$12486 VDD pfet_06v0 L=1U W=5U AS=2.2P AD=1.3P PS=10.88U
+ PD=5.52U
M$690 \$12486 \$13528 \$12492 VDD pfet_06v0 L=1U W=5U AS=1.3P AD=2.2P PS=5.52U
+ PD=10.88U
M$691 \$10768 \$10768 VDD VDD pfet_06v0 L=1U W=2U AS=0.88P AD=0.88P PS=4.88U
+ PD=4.88U
M$692 \$12487 \$12772 VDD VDD pfet_06v0 L=1U W=5U AS=2.2P AD=1.3P PS=10.88U
+ PD=5.52U
M$693 VDD \$12772 \$12487 VDD pfet_06v0 L=1U W=5U AS=1.3P AD=1.3P PS=5.52U
+ PD=5.52U
M$694 \$12487 \$12772 VDD VDD pfet_06v0 L=1U W=5U AS=1.3P AD=1.3P PS=5.52U
+ PD=5.52U
M$695 VDD \$12772 \$12487 VDD pfet_06v0 L=1U W=5U AS=1.3P AD=2.2P PS=5.52U
+ PD=10.88U
M$696 \$12445 \$10775 VDD VDD pfet_06v0 L=1U W=10U AS=4.4P AD=2.5P PS=20.88U
+ PD=10.5U
M$697 \$10775 \$10768 \$12445 VDD pfet_06v0 L=1U W=10U AS=2.5P AD=4.4P PS=10.5U
+ PD=20.88U
M$698 \$12486 \$12772 VDD VDD pfet_06v0 L=1U W=5U AS=2.2P AD=1.3P PS=10.88U
+ PD=5.52U
M$699 VDD \$12772 \$12486 VDD pfet_06v0 L=1U W=5U AS=1.3P AD=1.3P PS=5.52U
+ PD=5.52U
M$700 \$12486 \$12772 VDD VDD pfet_06v0 L=1U W=5U AS=1.3P AD=1.3P PS=5.52U
+ PD=5.52U
M$701 VDD \$12772 \$12486 VDD pfet_06v0 L=1U W=5U AS=1.3P AD=2.2P PS=5.52U
+ PD=10.88U
M$702 \$10719 \$10741 VDD VDD pfet_06v0 L=20U W=0.7U AS=0.308P AD=0.308P
+ PS=2.28U PD=2.28U
M$703 \$12489 \$12493 \$12772 VDD pfet_06v0 L=1U W=5U AS=2.2P AD=2.2P PS=10.88U
+ PD=10.88U
M$704 \$12491 \$12493 \$12492 VDD pfet_06v0 L=1U W=5U AS=2.2P AD=2.2P PS=10.88U
+ PD=10.88U
M$705 \$14222 \$12541 VDD VDD pfet_06v0 L=1U W=10U AS=4.4P AD=2.5P PS=20.88U
+ PD=10.5U
M$706 \$12541 \$13528 \$14222 VDD pfet_06v0 L=1U W=10U AS=2.5P AD=4.4P PS=10.5U
+ PD=20.88U
M$707 \$12493 \$12493 \$12541 VDD pfet_06v0 L=1U W=10U AS=4.4P AD=4.4P
+ PS=20.88U PD=20.88U
M$708 \$12451 \$10776 VDD VDD pfet_06v0 L=1U W=10U AS=4.4P AD=2.5P PS=20.88U
+ PD=10.5U
M$709 \$11311 \$10771 \$12451 VDD pfet_06v0 L=1U W=10U AS=2.5P AD=4.4P PS=10.5U
+ PD=20.88U
M$710 \$14223 \$13375 VDD VDD pfet_06v0 L=1U W=10U AS=4.4P AD=2.5P PS=20.88U
+ PD=10.5U
M$711 \$12470 \$13528 \$14223 VDD pfet_06v0 L=1U W=10U AS=2.5P AD=4.4P PS=10.5U
+ PD=20.88U
M$712 \$12454 \$10776 VDD VDD pfet_06v0 L=1U W=10U AS=4.4P AD=2.5P PS=20.88U
+ PD=10.5U
M$713 \$11311 \$10771 \$12454 VDD pfet_06v0 L=1U W=10U AS=2.5P AD=4.4P PS=10.5U
+ PD=20.88U
M$714 \$12495 \$12492 VDD VDD pfet_06v0 L=1U W=10U AS=4.4P AD=2.6P PS=20.88U
+ PD=10.52U
M$715 VDD \$12492 \$12495 VDD pfet_06v0 L=1U W=10U AS=2.6P AD=2.6P PS=10.52U
+ PD=10.52U
M$716 \$12495 \$12492 VDD VDD pfet_06v0 L=1U W=10U AS=2.6P AD=4.4P PS=10.52U
+ PD=20.88U
M$717 \$10726 S2P \$11311 VDD pfet_06v0 L=1U W=10U AS=4.4P AD=4.4P PS=20.88U
+ PD=20.88U
M$718 \$10724 S2N \$11311 VDD pfet_06v0 L=1U W=10U AS=4.4P AD=4.4P PS=20.88U
+ PD=20.88U
M$719 \$11083 \$10771 \$10723 VDD pfet_06v0 L=1U W=5U AS=2.2P AD=2.2P PS=10.88U
+ PD=10.88U
M$720 \$10742 \$10771 \$10722 VDD pfet_06v0 L=1U W=5U AS=2.2P AD=2.2P PS=10.88U
+ PD=10.88U
M$721 \$10723 \$11083 VDD VDD pfet_06v0 L=1U W=5U AS=2.2P AD=2.2P PS=10.88U
+ PD=10.88U
M$722 \$10722 \$11083 VDD VDD pfet_06v0 L=1U W=5U AS=2.2P AD=2.2P PS=10.88U
+ PD=10.88U
M$723 \$14224 \$13376 VDD VDD pfet_06v0 L=1U W=10U AS=4.4P AD=2.5P PS=20.88U
+ PD=10.5U
M$724 \$12471 \$13529 \$14224 VDD pfet_06v0 L=1U W=10U AS=2.5P AD=4.4P PS=10.5U
+ PD=20.88U
M$725 \$10725 \$10728 \$11083 VDD pfet_06v0 L=1U W=5U AS=2.2P AD=2.2P PS=10.88U
+ PD=10.88U
M$726 \$14225 \$13376 VDD VDD pfet_06v0 L=1U W=10U AS=4.4P AD=2.5P PS=20.88U
+ PD=10.5U
M$727 \$12472 \$13529 \$14225 VDD pfet_06v0 L=1U W=10U AS=2.5P AD=4.4P PS=10.5U
+ PD=20.88U
M$728 \$10727 \$10728 \$10742 VDD pfet_06v0 L=1U W=5U AS=2.2P AD=2.2P PS=10.88U
+ PD=10.88U
M$729 \$12440 \$10930 VDD VDD pfet_06v0 L=1U W=10U AS=4.4P AD=2.5P PS=20.88U
+ PD=10.5U
M$730 \$10930 \$10771 \$12440 VDD pfet_06v0 L=1U W=10U AS=2.5P AD=4.4P PS=10.5U
+ PD=20.88U
M$731 \$13529 \$13529 VDD VDD pfet_06v0 L=1U W=2U AS=0.88P AD=0.88P PS=4.88U
+ PD=4.88U
M$732 \$14226 \$13376 VDD VDD pfet_06v0 L=1U W=10U AS=4.4P AD=2.5P PS=20.88U
+ PD=10.5U
M$733 \$13376 \$13529 \$14226 VDD pfet_06v0 L=1U W=10U AS=2.5P AD=4.4P PS=10.5U
+ PD=20.88U
M$734 \$10728 \$10728 \$10930 VDD pfet_06v0 L=1U W=10U AS=4.4P AD=4.4P
+ PS=20.88U PD=20.88U
M$735 \$12400 \$10776 VDD VDD pfet_06v0 L=1U W=10U AS=4.4P AD=2.5P PS=20.88U
+ PD=10.5U
M$736 \$10695 \$10771 \$12400 VDD pfet_06v0 L=1U W=10U AS=2.5P AD=4.4P PS=10.5U
+ PD=20.88U
M$737 \$14227 \$13376 VDD VDD pfet_06v0 L=1U W=10U AS=4.4P AD=2.5P PS=20.88U
+ PD=10.5U
M$738 \$12695 \$13529 \$14227 VDD pfet_06v0 L=1U W=10U AS=2.5P AD=4.4P PS=10.5U
+ PD=20.88U
M$739 \$14228 \$13376 VDD VDD pfet_06v0 L=1U W=10U AS=4.4P AD=2.5P PS=20.88U
+ PD=10.5U
M$740 \$12695 \$13529 \$14228 VDD pfet_06v0 L=1U W=10U AS=2.5P AD=4.4P PS=10.5U
+ PD=20.88U
M$741 \$12398 \$10776 VDD VDD pfet_06v0 L=1U W=10U AS=4.4P AD=2.5P PS=20.88U
+ PD=10.5U
M$742 \$10694 \$10771 \$12398 VDD pfet_06v0 L=1U W=10U AS=2.5P AD=4.4P PS=10.5U
+ PD=20.88U
M$743 \$12394 \$10776 VDD VDD pfet_06v0 L=1U W=10U AS=4.4P AD=2.5P PS=20.88U
+ PD=10.5U
M$744 \$10693 \$10771 \$12394 VDD pfet_06v0 L=1U W=10U AS=2.5P AD=4.4P PS=10.5U
+ PD=20.88U
M$745 \$12501 \$10730 \$12695 VDD pfet_06v0 L=1U W=10U AS=4.4P AD=2.6P
+ PS=20.88U PD=10.52U
M$746 \$12695 \$10730 \$12501 VDD pfet_06v0 L=1U W=10U AS=2.6P AD=4.4P
+ PS=10.52U PD=20.88U
M$747 \$10771 \$10771 VDD VDD pfet_06v0 L=1U W=2U AS=0.88P AD=0.88P PS=4.88U
+ PD=4.88U
M$748 \$12499 \$10719 \$12695 VDD pfet_06v0 L=1U W=10U AS=4.4P AD=2.6P
+ PS=20.88U PD=10.52U
M$749 \$12695 \$10719 \$12499 VDD pfet_06v0 L=1U W=10U AS=2.6P AD=4.4P
+ PS=10.52U PD=20.88U
M$750 \$12367 \$10776 VDD VDD pfet_06v0 L=1U W=10U AS=4.4P AD=2.5P PS=20.88U
+ PD=10.5U
M$751 \$10776 \$10771 \$12367 VDD pfet_06v0 L=1U W=10U AS=2.5P AD=4.4P PS=10.5U
+ PD=20.88U
M$752 \$12773 \$13529 \$12498 VDD pfet_06v0 L=1U W=5U AS=2.2P AD=1.3P PS=10.88U
+ PD=5.52U
M$753 \$12498 \$13529 \$12773 VDD pfet_06v0 L=1U W=5U AS=1.3P AD=2.2P PS=5.52U
+ PD=10.88U
M$754 \$12503 \$13529 \$12497 VDD pfet_06v0 L=1U W=5U AS=2.2P AD=1.3P PS=10.88U
+ PD=5.52U
M$755 \$12497 \$13529 \$12503 VDD pfet_06v0 L=1U W=5U AS=1.3P AD=2.2P PS=5.52U
+ PD=10.88U
M$756 \$10730 \$10742 VDD VDD pfet_06v0 L=20U W=0.7U AS=0.308P AD=0.308P
+ PS=2.28U PD=2.28U
M$757 \$12498 \$12773 VDD VDD pfet_06v0 L=1U W=5U AS=2.2P AD=1.3P PS=10.88U
+ PD=5.52U
M$758 VDD \$12773 \$12498 VDD pfet_06v0 L=1U W=5U AS=1.3P AD=1.3P PS=5.52U
+ PD=5.52U
M$759 \$12498 \$12773 VDD VDD pfet_06v0 L=1U W=5U AS=1.3P AD=1.3P PS=5.52U
+ PD=5.52U
M$760 VDD \$12773 \$12498 VDD pfet_06v0 L=1U W=5U AS=1.3P AD=2.2P PS=5.52U
+ PD=10.88U
M$761 \$12497 \$12773 VDD VDD pfet_06v0 L=1U W=5U AS=2.2P AD=1.3P PS=10.88U
+ PD=5.52U
M$762 VDD \$12773 \$12497 VDD pfet_06v0 L=1U W=5U AS=1.3P AD=1.3P PS=5.52U
+ PD=5.52U
M$763 \$12497 \$12773 VDD VDD pfet_06v0 L=1U W=5U AS=1.3P AD=1.3P PS=5.52U
+ PD=5.52U
M$764 VDD \$12773 \$12497 VDD pfet_06v0 L=1U W=5U AS=1.3P AD=2.2P PS=5.52U
+ PD=10.88U
M$765 \$12500 \$12504 \$12773 VDD pfet_06v0 L=1U W=5U AS=2.2P AD=2.2P PS=10.88U
+ PD=10.88U
M$766 \$10798 \$1844 \$7227 VDD pfet_06v0 L=1U W=3U AS=1.32P AD=0.75P PS=6.88U
+ PD=3.5U
M$767 VDD \$1833 \$10798 VDD pfet_06v0 L=1U W=3U AS=0.75P AD=1.32P PS=3.5U
+ PD=6.88U
M$768 \$12502 \$12504 \$12503 VDD pfet_06v0 L=1U W=5U AS=2.2P AD=2.2P PS=10.88U
+ PD=10.88U
M$769 \$10696 \$1822 VDD VDD pfet_06v0 L=1U W=3U AS=1.32P AD=1.32P PS=6.88U
+ PD=6.88U
M$770 \$14217 \$12542 VDD VDD pfet_06v0 L=1U W=10U AS=4.4P AD=2.5P PS=20.88U
+ PD=10.5U
M$771 \$12542 \$13529 \$14217 VDD pfet_06v0 L=1U W=10U AS=2.5P AD=4.4P PS=10.5U
+ PD=20.88U
M$772 \$3654 \$10697 VDD VDD pfet_06v0 L=1U W=3U AS=1.32P AD=1.32P PS=6.88U
+ PD=6.88U
M$773 \$12504 \$12504 \$12542 VDD pfet_06v0 L=1U W=10U AS=4.4P AD=4.4P
+ PS=20.88U PD=20.88U
M$774 VDD \$1844 \$10697 VDD pfet_06v0 L=1U W=3U AS=1.32P AD=1.32P PS=6.88U
+ PD=6.88U
M$775 \$14213 \$13376 VDD VDD pfet_06v0 L=1U W=10U AS=4.4P AD=2.5P PS=20.88U
+ PD=10.5U
M$776 \$12473 \$13529 \$14213 VDD pfet_06v0 L=1U W=10U AS=2.5P AD=4.4P PS=10.5U
+ PD=20.88U
M$777 VDD \$10696 \$10697 VDD pfet_06v0 L=1U W=3U AS=1.32P AD=1.32P PS=6.88U
+ PD=6.88U
M$778 \$12506 \$12503 VDD VDD pfet_06v0 L=1U W=10U AS=4.4P AD=2.6P PS=20.88U
+ PD=10.52U
M$779 VDD \$12503 \$12506 VDD pfet_06v0 L=1U W=10U AS=2.6P AD=2.6P PS=10.52U
+ PD=10.52U
M$780 \$12506 \$12503 VDD VDD pfet_06v0 L=1U W=10U AS=2.6P AD=4.4P PS=10.52U
+ PD=20.88U
M$781 \$99 \$10698 VDD VDD pfet_06v0 L=1U W=3U AS=1.32P AD=1.32P PS=6.88U
+ PD=6.88U
M$782 VDD \$1822 \$10698 VDD pfet_06v0 L=1U W=3U AS=1.32P AD=1.32P PS=6.88U
+ PD=6.88U
M$783 VDD \$1833 \$10698 VDD pfet_06v0 L=1U W=3U AS=1.32P AD=1.32P PS=6.88U
+ PD=6.88U
M$784 \$14253 \$5403 \$7535 VDD pfet_06v0 L=1U W=3U AS=1.32P AD=0.75P PS=6.88U
+ PD=3.5U
M$785 VDD \$5394 \$14253 VDD pfet_06v0 L=1U W=3U AS=0.75P AD=1.32P PS=3.5U
+ PD=6.88U
M$786 \$14233 \$5385 VDD VDD pfet_06v0 L=1U W=3U AS=1.32P AD=1.32P PS=6.88U
+ PD=6.88U
M$787 \$3653 \$14234 VDD VDD pfet_06v0 L=1U W=3U AS=1.32P AD=1.32P PS=6.88U
+ PD=6.88U
M$788 VDD \$5403 \$14234 VDD pfet_06v0 L=1U W=3U AS=1.32P AD=1.32P PS=6.88U
+ PD=6.88U
M$789 VDD \$14233 \$14234 VDD pfet_06v0 L=1U W=3U AS=1.32P AD=1.32P PS=6.88U
+ PD=6.88U
M$790 \$419 \$14235 VDD VDD pfet_06v0 L=1U W=3U AS=1.32P AD=1.32P PS=6.88U
+ PD=6.88U
M$791 VDD \$5385 \$14235 VDD pfet_06v0 L=1U W=3U AS=1.32P AD=1.32P PS=6.88U
+ PD=6.88U
M$792 VDD \$5394 \$14235 VDD pfet_06v0 L=1U W=3U AS=1.32P AD=1.32P PS=6.88U
+ PD=6.88U
M$793 \$14254 \$8959 \$14236 VDD pfet_06v0 L=1U W=3U AS=1.32P AD=0.75P PS=6.88U
+ PD=3.5U
M$794 VDD \$8968 \$14254 VDD pfet_06v0 L=1U W=3U AS=0.75P AD=1.32P PS=3.5U
+ PD=6.88U
M$795 \$14237 \$8938 VDD VDD pfet_06v0 L=1U W=3U AS=1.32P AD=1.32P PS=6.88U
+ PD=6.88U
M$796 \$3580 \$14238 VDD VDD pfet_06v0 L=1U W=3U AS=1.32P AD=1.32P PS=6.88U
+ PD=6.88U
M$797 VDD \$8959 \$14238 VDD pfet_06v0 L=1U W=3U AS=1.32P AD=1.32P PS=6.88U
+ PD=6.88U
M$798 VDD \$14237 \$14238 VDD pfet_06v0 L=1U W=3U AS=1.32P AD=1.32P PS=6.88U
+ PD=6.88U
M$799 \$19 \$14239 VDD VDD pfet_06v0 L=1U W=3U AS=1.32P AD=1.32P PS=6.88U
+ PD=6.88U
M$800 VDD \$8938 \$14239 VDD pfet_06v0 L=1U W=3U AS=1.32P AD=1.32P PS=6.88U
+ PD=6.88U
M$801 VDD \$8968 \$14239 VDD pfet_06v0 L=1U W=3U AS=1.32P AD=1.32P PS=6.88U
+ PD=6.88U
M$802 \$14255 \$12506 \$14243 VDD pfet_06v0 L=1U W=3U AS=1.32P AD=0.75P
+ PS=6.88U PD=3.5U
M$803 VDD \$12495 \$14255 VDD pfet_06v0 L=1U W=3U AS=0.75P AD=1.32P PS=3.5U
+ PD=6.88U
M$804 \$14240 \$12484 VDD VDD pfet_06v0 L=1U W=3U AS=1.32P AD=1.32P PS=6.88U
+ PD=6.88U
M$805 \$3652 \$14241 VDD VDD pfet_06v0 L=1U W=3U AS=1.32P AD=1.32P PS=6.88U
+ PD=6.88U
M$806 VDD \$12506 \$14241 VDD pfet_06v0 L=1U W=3U AS=1.32P AD=1.32P PS=6.88U
+ PD=6.88U
M$807 VDD \$14240 \$14241 VDD pfet_06v0 L=1U W=3U AS=1.32P AD=1.32P PS=6.88U
+ PD=6.88U
M$808 \$95 \$14242 VDD VDD pfet_06v0 L=1U W=3U AS=1.32P AD=1.32P PS=6.88U
+ PD=6.88U
M$809 VDD \$12484 \$14242 VDD pfet_06v0 L=1U W=3U AS=1.32P AD=1.32P PS=6.88U
+ PD=6.88U
M$810 VDD \$12495 \$14242 VDD pfet_06v0 L=1U W=3U AS=1.32P AD=1.32P PS=6.88U
+ PD=6.88U
M$811 \$9 X VSS VSS nfet_05v0 L=0.6U W=1.32U AS=0.5808P AD=0.5808P PS=3.52U
+ PD=3.52U
M$812 XP \$9 VSS VSS nfet_05v0 L=0.6U W=1.32U AS=0.5808P AD=0.5808P PS=3.52U
+ PD=3.52U
M$813 XN XP VSS VSS nfet_05v0 L=0.6U W=1.32U AS=0.5808P AD=0.5808P PS=3.52U
+ PD=3.52U
M$814 \$3584 Y VSS VSS nfet_05v0 L=0.6U W=1.32U AS=0.5808P AD=0.5808P PS=3.52U
+ PD=3.52U
M$815 YP \$3584 VSS VSS nfet_05v0 L=0.6U W=1.32U AS=0.5808P AD=0.5808P PS=3.52U
+ PD=3.52U
M$816 YN YP VSS VSS nfet_05v0 L=0.6U W=1.32U AS=0.5808P AD=0.5808P PS=3.52U
+ PD=3.52U
M$817 \$7131 Z VSS VSS nfet_05v0 L=0.6U W=1.32U AS=0.5808P AD=0.5808P PS=3.52U
+ PD=3.52U
M$818 ZP \$7131 VSS VSS nfet_05v0 L=0.6U W=1.32U AS=0.5808P AD=0.5808P PS=3.52U
+ PD=3.52U
M$819 ZN ZP VSS VSS nfet_05v0 L=0.6U W=1.32U AS=0.5808P AD=0.5808P PS=3.52U
+ PD=3.52U
M$820 \$73 \$10 VSS VSS nfet_06v0 L=1U W=5U AS=2.2P AD=1.25P PS=10.88U PD=5.5U
M$821 \$21 \$11 \$73 VSS nfet_06v0 L=1U W=5U AS=1.25P AD=2.2P PS=5.5U PD=10.88U
M$822 \$74 \$10 VSS VSS nfet_06v0 L=1U W=5U AS=2.2P AD=1.25P PS=10.88U PD=5.5U
M$823 \$21 \$11 \$74 VSS nfet_06v0 L=1U W=5U AS=1.25P AD=2.2P PS=5.5U PD=10.88U
M$824 \$22 S1P \$21 VSS nfet_06v0 L=1U W=5U AS=2.2P AD=2.2P PS=10.88U PD=10.88U
M$825 \$23 S1N \$21 VSS nfet_06v0 L=1U W=5U AS=2.2P AD=2.2P PS=10.88U PD=10.88U
M$826 \$25 \$11 \$24 VSS nfet_06v0 L=1U W=2.5U AS=1.1P AD=1.1P PS=5.88U PD=5.88U
M$827 \$27 \$11 \$26 VSS nfet_06v0 L=1U W=2.5U AS=1.1P AD=1.1P PS=5.88U PD=5.88U
M$828 \$24 \$25 VSS VSS nfet_06v0 L=1U W=2.5U AS=1.1P AD=1.1P PS=5.88U PD=5.88U
M$829 \$26 \$25 VSS VSS nfet_06v0 L=1U W=2.5U AS=1.1P AD=1.1P PS=5.88U PD=5.88U
M$830 \$414 \$12 \$25 VSS nfet_06v0 L=1U W=2.5U AS=1.1P AD=1.1P PS=5.88U
+ PD=5.88U
M$831 \$61 \$12 \$27 VSS nfet_06v0 L=1U W=2.5U AS=1.1P AD=1.1P PS=5.88U PD=5.88U
M$832 \$75 \$10 VSS VSS nfet_06v0 L=1U W=5U AS=2.2P AD=1.25P PS=10.88U PD=5.5U
M$833 \$28 \$11 \$75 VSS nfet_06v0 L=1U W=5U AS=1.25P AD=2.2P PS=5.5U PD=10.88U
M$834 \$12 \$12 \$29 VSS nfet_06v0 L=1U W=5U AS=2.2P AD=2.2P PS=10.88U PD=10.88U
M$835 \$76 \$29 VSS VSS nfet_06v0 L=1U W=5U AS=2.2P AD=1.25P PS=10.88U PD=5.5U
M$836 \$29 \$11 \$76 VSS nfet_06v0 L=1U W=5U AS=1.25P AD=2.2P PS=5.5U PD=10.88U
M$837 \$30 \$27 VSS VSS nfet_06v0 L=1U W=1U AS=0.44P AD=0.44P PS=2.88U PD=2.88U
M$838 \$11 \$11 VSS VSS nfet_06v0 L=1U W=1U AS=0.44P AD=0.44P PS=2.88U PD=2.88U
M$839 \$77 \$10 VSS VSS nfet_06v0 L=1U W=5U AS=2.2P AD=1.25P PS=10.88U PD=5.5U
M$840 \$10 \$11 \$77 VSS nfet_06v0 L=1U W=5U AS=1.25P AD=2.2P PS=5.5U PD=10.88U
M$841 \$58 \$100 VSS VSS nfet_06v0 L=1U W=1U AS=0.44P AD=0.25P PS=2.88U PD=1.5U
M$842 \$103 \$100 \$58 VSS nfet_06v0 L=1U W=1U AS=0.25P AD=0.44P PS=1.5U
+ PD=2.88U
M$843 \$60 \$100 VSS VSS nfet_06v0 L=1U W=1U AS=0.44P AD=0.25P PS=2.88U PD=1.5U
M$844 \$100 \$100 \$60 VSS nfet_06v0 L=1U W=1U AS=0.25P AD=0.44P PS=1.5U
+ PD=2.88U
M$845 \$79 \$13 VSS VSS nfet_06v0 L=1U W=5U AS=2.2P AD=1.25P PS=10.88U PD=5.5U
M$846 \$32 \$14 \$79 VSS nfet_06v0 L=1U W=5U AS=1.25P AD=2.2P PS=5.5U PD=10.88U
M$847 \$80 \$13 VSS VSS nfet_06v0 L=1U W=5U AS=2.2P AD=1.25P PS=10.88U PD=5.5U
M$848 \$32 \$14 \$80 VSS nfet_06v0 L=1U W=5U AS=1.25P AD=2.2P PS=5.5U PD=10.88U
M$849 \$33 S2P \$32 VSS nfet_06v0 L=1U W=5U AS=2.2P AD=2.2P PS=10.88U PD=10.88U
M$850 \$34 S2N \$32 VSS nfet_06v0 L=1U W=5U AS=2.2P AD=2.2P PS=10.88U PD=10.88U
M$851 \$36 \$14 \$35 VSS nfet_06v0 L=1U W=2.5U AS=1.1P AD=1.1P PS=5.88U PD=5.88U
M$852 \$38 \$14 \$37 VSS nfet_06v0 L=1U W=2.5U AS=1.1P AD=1.1P PS=5.88U PD=5.88U
M$853 \$35 \$36 VSS VSS nfet_06v0 L=1U W=2.5U AS=1.1P AD=1.1P PS=5.88U PD=5.88U
M$854 \$37 \$36 VSS VSS nfet_06v0 L=1U W=2.5U AS=1.1P AD=1.1P PS=5.88U PD=5.88U
M$855 \$416 \$15 \$36 VSS nfet_06v0 L=1U W=2.5U AS=1.1P AD=1.1P PS=5.88U
+ PD=5.88U
M$856 \$62 \$15 \$38 VSS nfet_06v0 L=1U W=2.5U AS=1.1P AD=1.1P PS=5.88U PD=5.88U
M$857 \$83 \$13 VSS VSS nfet_06v0 L=1U W=5U AS=2.2P AD=1.25P PS=10.88U PD=5.5U
M$858 \$39 \$14 \$83 VSS nfet_06v0 L=1U W=5U AS=1.25P AD=2.2P PS=5.5U PD=10.88U
M$859 \$15 \$15 \$40 VSS nfet_06v0 L=1U W=5U AS=2.2P AD=2.2P PS=10.88U PD=10.88U
M$860 \$84 \$40 VSS VSS nfet_06v0 L=1U W=5U AS=2.2P AD=1.25P PS=10.88U PD=5.5U
M$861 \$40 \$14 \$84 VSS nfet_06v0 L=1U W=5U AS=1.25P AD=2.2P PS=5.5U PD=10.88U
M$862 \$41 \$38 VSS VSS nfet_06v0 L=1U W=1U AS=0.44P AD=0.44P PS=2.88U PD=2.88U
M$863 \$14 \$14 VSS VSS nfet_06v0 L=1U W=1U AS=0.44P AD=0.44P PS=2.88U PD=2.88U
M$864 \$85 \$13 VSS VSS nfet_06v0 L=1U W=5U AS=2.2P AD=1.25P PS=10.88U PD=5.5U
M$865 \$13 \$14 \$85 VSS nfet_06v0 L=1U W=5U AS=1.25P AD=2.2P PS=5.5U PD=10.88U
M$866 \$59 \$101 VSS VSS nfet_06v0 L=1U W=1U AS=0.44P AD=0.25P PS=2.88U PD=1.5U
M$867 \$104 \$101 \$59 VSS nfet_06v0 L=1U W=1U AS=0.25P AD=0.44P PS=1.5U
+ PD=2.88U
M$868 \$57 \$101 VSS VSS nfet_06v0 L=1U W=1U AS=0.44P AD=0.25P PS=2.88U PD=1.5U
M$869 \$101 \$101 \$57 VSS nfet_06v0 L=1U W=1U AS=0.25P AD=0.44P PS=1.5U
+ PD=2.88U
M$870 \$86 \$16 VSS VSS nfet_06v0 L=1U W=5U AS=2.2P AD=1.25P PS=10.88U PD=5.5U
M$871 \$43 \$17 \$86 VSS nfet_06v0 L=1U W=5U AS=1.25P AD=2.2P PS=5.5U PD=10.88U
M$872 \$87 \$16 VSS VSS nfet_06v0 L=1U W=5U AS=2.2P AD=1.25P PS=10.88U PD=5.5U
M$873 \$43 \$17 \$87 VSS nfet_06v0 L=1U W=5U AS=1.25P AD=2.2P PS=5.5U PD=10.88U
M$874 \$44 S3P \$43 VSS nfet_06v0 L=1U W=5U AS=2.2P AD=2.2P PS=10.88U PD=10.88U
M$875 \$45 S3N \$43 VSS nfet_06v0 L=1U W=5U AS=2.2P AD=2.2P PS=10.88U PD=10.88U
M$876 \$47 \$17 \$46 VSS nfet_06v0 L=1U W=2.5U AS=1.1P AD=1.1P PS=5.88U PD=5.88U
M$877 \$49 \$17 \$48 VSS nfet_06v0 L=1U W=2.5U AS=1.1P AD=1.1P PS=5.88U PD=5.88U
M$878 \$46 \$47 VSS VSS nfet_06v0 L=1U W=2.5U AS=1.1P AD=1.1P PS=5.88U PD=5.88U
M$879 \$48 \$47 VSS VSS nfet_06v0 L=1U W=2.5U AS=1.1P AD=1.1P PS=5.88U PD=5.88U
M$880 \$418 \$18 \$47 VSS nfet_06v0 L=1U W=2.5U AS=1.1P AD=1.1P PS=5.88U
+ PD=5.88U
M$881 \$63 \$18 \$49 VSS nfet_06v0 L=1U W=2.5U AS=1.1P AD=1.1P PS=5.88U PD=5.88U
M$882 \$82 \$16 VSS VSS nfet_06v0 L=1U W=5U AS=2.2P AD=1.25P PS=10.88U PD=5.5U
M$883 \$50 \$17 \$82 VSS nfet_06v0 L=1U W=5U AS=1.25P AD=2.2P PS=5.5U PD=10.88U
M$884 \$18 \$18 \$51 VSS nfet_06v0 L=1U W=5U AS=2.2P AD=2.2P PS=10.88U PD=10.88U
M$885 \$81 \$51 VSS VSS nfet_06v0 L=1U W=5U AS=2.2P AD=1.25P PS=10.88U PD=5.5U
M$886 \$51 \$17 \$81 VSS nfet_06v0 L=1U W=5U AS=1.25P AD=2.2P PS=5.5U PD=10.88U
M$887 \$52 \$49 VSS VSS nfet_06v0 L=1U W=1U AS=0.44P AD=0.44P PS=2.88U PD=2.88U
M$888 \$17 \$17 VSS VSS nfet_06v0 L=1U W=1U AS=0.44P AD=0.44P PS=2.88U PD=2.88U
M$889 \$78 \$16 VSS VSS nfet_06v0 L=1U W=5U AS=2.2P AD=1.25P PS=10.88U PD=5.5U
M$890 \$16 \$17 \$78 VSS nfet_06v0 L=1U W=5U AS=1.25P AD=2.2P PS=5.5U PD=10.88U
M$891 \$56 \$102 VSS VSS nfet_06v0 L=1U W=1U AS=0.44P AD=0.25P PS=2.88U PD=1.5U
M$892 \$105 \$102 \$56 VSS nfet_06v0 L=1U W=1U AS=0.25P AD=0.44P PS=1.5U
+ PD=2.88U
M$893 \$55 \$102 VSS VSS nfet_06v0 L=1U W=1U AS=0.44P AD=0.25P PS=2.88U PD=1.5U
M$894 \$102 \$102 \$55 VSS nfet_06v0 L=1U W=1U AS=0.25P AD=0.44P PS=1.5U
+ PD=2.88U
M$895 \$1803 \$1803 VSS VSS nfet_06v0 L=1U W=1U AS=0.44P AD=0.44P PS=2.88U
+ PD=2.88U
M$896 \$1857 \$1804 VSS VSS nfet_06v0 L=1U W=5U AS=2.2P AD=1.25P PS=10.88U
+ PD=5.5U
M$897 \$1804 \$1803 \$1857 VSS nfet_06v0 L=1U W=5U AS=1.25P AD=2.2P PS=5.5U
+ PD=10.88U
M$898 \$1845 \$2865 VSS VSS nfet_06v0 L=1U W=1U AS=0.44P AD=0.25P PS=2.88U
+ PD=1.5U
M$899 \$2712 \$2865 \$1845 VSS nfet_06v0 L=1U W=1U AS=0.25P AD=0.44P PS=1.5U
+ PD=2.88U
M$900 \$1846 \$2865 VSS VSS nfet_06v0 L=1U W=1U AS=0.44P AD=0.25P PS=2.88U
+ PD=1.5U
M$901 \$2865 \$2865 \$1846 VSS nfet_06v0 L=1U W=1U AS=0.25P AD=0.44P PS=1.5U
+ PD=2.88U
M$902 \$1858 \$1804 VSS VSS nfet_06v0 L=1U W=5U AS=2.2P AD=1.25P PS=10.88U
+ PD=5.5U
M$903 \$1812 \$1803 \$1858 VSS nfet_06v0 L=1U W=5U AS=1.25P AD=2.2P PS=5.5U
+ PD=10.88U
M$904 \$1859 \$1804 VSS VSS nfet_06v0 L=1U W=5U AS=2.2P AD=1.25P PS=10.88U
+ PD=5.5U
M$905 \$1812 \$1803 \$1859 VSS nfet_06v0 L=1U W=5U AS=1.25P AD=2.2P PS=5.5U
+ PD=10.88U
M$906 \$1813 \$41 \$1812 VSS nfet_06v0 L=1U W=5U AS=2.2P AD=1.3P PS=10.88U
+ PD=5.52U
M$907 \$1812 \$41 \$1813 VSS nfet_06v0 L=1U W=5U AS=1.3P AD=2.2P PS=5.52U
+ PD=10.88U
M$908 \$1814 \$30 \$1812 VSS nfet_06v0 L=1U W=5U AS=2.2P AD=1.3P PS=10.88U
+ PD=5.52U
M$909 \$1812 \$30 \$1814 VSS nfet_06v0 L=1U W=5U AS=1.3P AD=2.2P PS=5.52U
+ PD=10.88U
M$910 \$1816 \$1803 \$1815 VSS nfet_06v0 L=1U W=2.5U AS=1.1P AD=0.65P PS=5.88U
+ PD=3.02U
M$911 \$1815 \$1803 \$1816 VSS nfet_06v0 L=1U W=2.5U AS=0.65P AD=1.1P PS=3.02U
+ PD=5.88U
M$912 \$1818 \$1803 \$1817 VSS nfet_06v0 L=1U W=2.5U AS=1.1P AD=0.65P PS=5.88U
+ PD=3.02U
M$913 \$1817 \$1803 \$1818 VSS nfet_06v0 L=1U W=2.5U AS=0.65P AD=1.1P PS=3.02U
+ PD=5.88U
M$914 \$1815 \$1816 VSS VSS nfet_06v0 L=1U W=2.5U AS=1.1P AD=0.65P PS=5.88U
+ PD=3.02U
M$915 VSS \$1816 \$1815 VSS nfet_06v0 L=1U W=2.5U AS=0.65P AD=0.65P PS=3.02U
+ PD=3.02U
M$916 \$1815 \$1816 VSS VSS nfet_06v0 L=1U W=2.5U AS=0.65P AD=0.65P PS=3.02U
+ PD=3.02U
M$917 VSS \$1816 \$1815 VSS nfet_06v0 L=1U W=2.5U AS=0.65P AD=1.1P PS=3.02U
+ PD=5.88U
M$918 \$1817 \$1816 VSS VSS nfet_06v0 L=1U W=2.5U AS=1.1P AD=0.65P PS=5.88U
+ PD=3.02U
M$919 VSS \$1816 \$1817 VSS nfet_06v0 L=1U W=2.5U AS=0.65P AD=0.65P PS=3.02U
+ PD=3.02U
M$920 \$1817 \$1816 VSS VSS nfet_06v0 L=1U W=2.5U AS=0.65P AD=0.65P PS=3.02U
+ PD=3.02U
M$921 VSS \$1816 \$1817 VSS nfet_06v0 L=1U W=2.5U AS=0.65P AD=1.1P PS=3.02U
+ PD=5.88U
M$922 \$2184 \$1805 \$1816 VSS nfet_06v0 L=1U W=2.5U AS=1.1P AD=1.1P PS=5.88U
+ PD=5.88U
M$923 \$1819 \$1805 \$1818 VSS nfet_06v0 L=1U W=2.5U AS=1.1P AD=1.1P PS=5.88U
+ PD=5.88U
M$924 \$1861 \$1804 VSS VSS nfet_06v0 L=1U W=5U AS=2.2P AD=1.25P PS=10.88U
+ PD=5.5U
M$925 \$1820 \$1803 \$1861 VSS nfet_06v0 L=1U W=5U AS=1.25P AD=2.2P PS=5.5U
+ PD=10.88U
M$926 \$1805 \$1805 \$1821 VSS nfet_06v0 L=1U W=5U AS=2.2P AD=2.2P PS=10.88U
+ PD=10.88U
M$927 \$1862 \$1821 VSS VSS nfet_06v0 L=1U W=5U AS=2.2P AD=1.25P PS=10.88U
+ PD=5.5U
M$928 \$1821 \$1803 \$1862 VSS nfet_06v0 L=1U W=5U AS=1.25P AD=2.2P PS=5.5U
+ PD=10.88U
M$929 \$1822 \$1818 VSS VSS nfet_06v0 L=1U W=5U AS=2.2P AD=1.3P PS=10.88U
+ PD=5.52U
M$930 VSS \$1818 \$1822 VSS nfet_06v0 L=1U W=5U AS=1.3P AD=1.3P PS=5.52U
+ PD=5.52U
M$931 \$1822 \$1818 VSS VSS nfet_06v0 L=1U W=5U AS=1.3P AD=2.2P PS=5.52U
+ PD=10.88U
M$932 \$1806 \$1806 VSS VSS nfet_06v0 L=1U W=1U AS=0.44P AD=0.44P PS=2.88U
+ PD=2.88U
M$933 \$1864 \$1807 VSS VSS nfet_06v0 L=1U W=5U AS=2.2P AD=1.25P PS=10.88U
+ PD=5.5U
M$934 \$1807 \$1806 \$1864 VSS nfet_06v0 L=1U W=5U AS=1.25P AD=2.2P PS=5.5U
+ PD=10.88U
M$935 \$1849 \$2866 VSS VSS nfet_06v0 L=1U W=1U AS=0.44P AD=0.25P PS=2.88U
+ PD=1.5U
M$936 \$2713 \$2866 \$1849 VSS nfet_06v0 L=1U W=1U AS=0.25P AD=0.44P PS=1.5U
+ PD=2.88U
M$937 \$1850 \$2866 VSS VSS nfet_06v0 L=1U W=1U AS=0.44P AD=0.25P PS=2.88U
+ PD=1.5U
M$938 \$2866 \$2866 \$1850 VSS nfet_06v0 L=1U W=1U AS=0.25P AD=0.44P PS=1.5U
+ PD=2.88U
M$939 \$1865 \$1807 VSS VSS nfet_06v0 L=1U W=5U AS=2.2P AD=1.25P PS=10.88U
+ PD=5.5U
M$940 \$1823 \$1806 \$1865 VSS nfet_06v0 L=1U W=5U AS=1.25P AD=2.2P PS=5.5U
+ PD=10.88U
M$941 \$1866 \$1807 VSS VSS nfet_06v0 L=1U W=5U AS=2.2P AD=1.25P PS=10.88U
+ PD=5.5U
M$942 \$1823 \$1806 \$1866 VSS nfet_06v0 L=1U W=5U AS=1.25P AD=2.2P PS=5.5U
+ PD=10.88U
M$943 \$1824 \$52 \$1823 VSS nfet_06v0 L=1U W=5U AS=2.2P AD=1.3P PS=10.88U
+ PD=5.52U
M$944 \$1823 \$52 \$1824 VSS nfet_06v0 L=1U W=5U AS=1.3P AD=2.2P PS=5.52U
+ PD=10.88U
M$945 \$1825 \$30 \$1823 VSS nfet_06v0 L=1U W=5U AS=2.2P AD=1.3P PS=10.88U
+ PD=5.52U
M$946 \$1823 \$30 \$1825 VSS nfet_06v0 L=1U W=5U AS=1.3P AD=2.2P PS=5.52U
+ PD=10.88U
M$947 \$1827 \$1806 \$1826 VSS nfet_06v0 L=1U W=2.5U AS=1.1P AD=0.65P PS=5.88U
+ PD=3.02U
M$948 \$1826 \$1806 \$1827 VSS nfet_06v0 L=1U W=2.5U AS=0.65P AD=1.1P PS=3.02U
+ PD=5.88U
M$949 \$1829 \$1806 \$1828 VSS nfet_06v0 L=1U W=2.5U AS=1.1P AD=0.65P PS=5.88U
+ PD=3.02U
M$950 \$1828 \$1806 \$1829 VSS nfet_06v0 L=1U W=2.5U AS=0.65P AD=1.1P PS=3.02U
+ PD=5.88U
M$951 \$1826 \$1827 VSS VSS nfet_06v0 L=1U W=2.5U AS=1.1P AD=0.65P PS=5.88U
+ PD=3.02U
M$952 VSS \$1827 \$1826 VSS nfet_06v0 L=1U W=2.5U AS=0.65P AD=0.65P PS=3.02U
+ PD=3.02U
M$953 \$1826 \$1827 VSS VSS nfet_06v0 L=1U W=2.5U AS=0.65P AD=0.65P PS=3.02U
+ PD=3.02U
M$954 VSS \$1827 \$1826 VSS nfet_06v0 L=1U W=2.5U AS=0.65P AD=1.1P PS=3.02U
+ PD=5.88U
M$955 \$1828 \$1827 VSS VSS nfet_06v0 L=1U W=2.5U AS=1.1P AD=0.65P PS=5.88U
+ PD=3.02U
M$956 VSS \$1827 \$1828 VSS nfet_06v0 L=1U W=2.5U AS=0.65P AD=0.65P PS=3.02U
+ PD=3.02U
M$957 \$1828 \$1827 VSS VSS nfet_06v0 L=1U W=2.5U AS=0.65P AD=0.65P PS=3.02U
+ PD=3.02U
M$958 VSS \$1827 \$1828 VSS nfet_06v0 L=1U W=2.5U AS=0.65P AD=1.1P PS=3.02U
+ PD=5.88U
M$959 \$2185 \$1808 \$1827 VSS nfet_06v0 L=1U W=2.5U AS=1.1P AD=1.1P PS=5.88U
+ PD=5.88U
M$960 \$1830 \$1808 \$1829 VSS nfet_06v0 L=1U W=2.5U AS=1.1P AD=1.1P PS=5.88U
+ PD=5.88U
M$961 \$1867 \$1807 VSS VSS nfet_06v0 L=1U W=5U AS=2.2P AD=1.25P PS=10.88U
+ PD=5.5U
M$962 \$1831 \$1806 \$1867 VSS nfet_06v0 L=1U W=5U AS=1.25P AD=2.2P PS=5.5U
+ PD=10.88U
M$963 \$1808 \$1808 \$1832 VSS nfet_06v0 L=1U W=5U AS=2.2P AD=2.2P PS=10.88U
+ PD=10.88U
M$964 \$1868 \$1832 VSS VSS nfet_06v0 L=1U W=5U AS=2.2P AD=1.25P PS=10.88U
+ PD=5.5U
M$965 \$1832 \$1806 \$1868 VSS nfet_06v0 L=1U W=5U AS=1.25P AD=2.2P PS=5.5U
+ PD=10.88U
M$966 \$1833 \$1829 VSS VSS nfet_06v0 L=1U W=5U AS=2.2P AD=1.3P PS=10.88U
+ PD=5.52U
M$967 VSS \$1829 \$1833 VSS nfet_06v0 L=1U W=5U AS=1.3P AD=1.3P PS=5.52U
+ PD=5.52U
M$968 \$1833 \$1829 VSS VSS nfet_06v0 L=1U W=5U AS=1.3P AD=2.2P PS=5.52U
+ PD=10.88U
M$969 \$1809 \$1809 VSS VSS nfet_06v0 L=1U W=1U AS=0.44P AD=0.44P PS=2.88U
+ PD=2.88U
M$970 \$1870 \$1810 VSS VSS nfet_06v0 L=1U W=5U AS=2.2P AD=1.25P PS=10.88U
+ PD=5.5U
M$971 \$1810 \$1809 \$1870 VSS nfet_06v0 L=1U W=5U AS=1.25P AD=2.2P PS=5.5U
+ PD=10.88U
M$972 \$1848 \$2867 VSS VSS nfet_06v0 L=1U W=1U AS=0.44P AD=0.25P PS=2.88U
+ PD=1.5U
M$973 \$2714 \$2867 \$1848 VSS nfet_06v0 L=1U W=1U AS=0.25P AD=0.44P PS=1.5U
+ PD=2.88U
M$974 \$1847 \$2867 VSS VSS nfet_06v0 L=1U W=1U AS=0.44P AD=0.25P PS=2.88U
+ PD=1.5U
M$975 \$2867 \$2867 \$1847 VSS nfet_06v0 L=1U W=1U AS=0.25P AD=0.44P PS=1.5U
+ PD=2.88U
M$976 \$1871 \$1810 VSS VSS nfet_06v0 L=1U W=5U AS=2.2P AD=1.25P PS=10.88U
+ PD=5.5U
M$977 \$1834 \$1809 \$1871 VSS nfet_06v0 L=1U W=5U AS=1.25P AD=2.2P PS=5.5U
+ PD=10.88U
M$978 \$1869 \$1810 VSS VSS nfet_06v0 L=1U W=5U AS=2.2P AD=1.25P PS=10.88U
+ PD=5.5U
M$979 \$1834 \$1809 \$1869 VSS nfet_06v0 L=1U W=5U AS=1.25P AD=2.2P PS=5.5U
+ PD=10.88U
M$980 \$1835 \$52 \$1834 VSS nfet_06v0 L=1U W=5U AS=2.2P AD=1.3P PS=10.88U
+ PD=5.52U
M$981 \$1834 \$52 \$1835 VSS nfet_06v0 L=1U W=5U AS=1.3P AD=2.2P PS=5.52U
+ PD=10.88U
M$982 \$1836 \$41 \$1834 VSS nfet_06v0 L=1U W=5U AS=2.2P AD=1.3P PS=10.88U
+ PD=5.52U
M$983 \$1834 \$41 \$1836 VSS nfet_06v0 L=1U W=5U AS=1.3P AD=2.2P PS=5.52U
+ PD=10.88U
M$984 \$1838 \$1809 \$1837 VSS nfet_06v0 L=1U W=2.5U AS=1.1P AD=0.65P PS=5.88U
+ PD=3.02U
M$985 \$1837 \$1809 \$1838 VSS nfet_06v0 L=1U W=2.5U AS=0.65P AD=1.1P PS=3.02U
+ PD=5.88U
M$986 \$1840 \$1809 \$1839 VSS nfet_06v0 L=1U W=2.5U AS=1.1P AD=0.65P PS=5.88U
+ PD=3.02U
M$987 \$1839 \$1809 \$1840 VSS nfet_06v0 L=1U W=2.5U AS=0.65P AD=1.1P PS=3.02U
+ PD=5.88U
M$988 \$1837 \$1838 VSS VSS nfet_06v0 L=1U W=2.5U AS=1.1P AD=0.65P PS=5.88U
+ PD=3.02U
M$989 VSS \$1838 \$1837 VSS nfet_06v0 L=1U W=2.5U AS=0.65P AD=0.65P PS=3.02U
+ PD=3.02U
M$990 \$1837 \$1838 VSS VSS nfet_06v0 L=1U W=2.5U AS=0.65P AD=0.65P PS=3.02U
+ PD=3.02U
M$991 VSS \$1838 \$1837 VSS nfet_06v0 L=1U W=2.5U AS=0.65P AD=1.1P PS=3.02U
+ PD=5.88U
M$992 \$1839 \$1838 VSS VSS nfet_06v0 L=1U W=2.5U AS=1.1P AD=0.65P PS=5.88U
+ PD=3.02U
M$993 VSS \$1838 \$1839 VSS nfet_06v0 L=1U W=2.5U AS=0.65P AD=0.65P PS=3.02U
+ PD=3.02U
M$994 \$1839 \$1838 VSS VSS nfet_06v0 L=1U W=2.5U AS=0.65P AD=0.65P PS=3.02U
+ PD=3.02U
M$995 VSS \$1838 \$1839 VSS nfet_06v0 L=1U W=2.5U AS=0.65P AD=1.1P PS=3.02U
+ PD=5.88U
M$996 \$2186 \$1811 \$1838 VSS nfet_06v0 L=1U W=2.5U AS=1.1P AD=1.1P PS=5.88U
+ PD=5.88U
M$997 X \$19 \$8 VSS nfet_06v0 L=1U W=2.48U AS=1.0912P AD=0.6448P PS=5.84U PD=3U
M$998 \$8 \$19 X VSS nfet_06v0 L=1U W=2.48U AS=0.6448P AD=1.0912P PS=3U PD=5.84U
M$999 X \$95 \$94 VSS nfet_06v0 L=1U W=2.48U AS=1.0912P AD=0.6448P PS=5.84U
+ PD=3U
M$1000 \$94 \$95 X VSS nfet_06v0 L=1U W=2.48U AS=0.6448P AD=1.0912P PS=3U
+ PD=5.84U
M$1001 \$1841 \$1811 \$1840 VSS nfet_06v0 L=1U W=2.5U AS=1.1P AD=1.1P PS=5.88U
+ PD=5.88U
M$1002 \$1863 \$1810 VSS VSS nfet_06v0 L=1U W=5U AS=2.2P AD=1.25P PS=10.88U
+ PD=5.5U
M$1003 \$1842 \$1809 \$1863 VSS nfet_06v0 L=1U W=5U AS=1.25P AD=2.2P PS=5.5U
+ PD=10.88U
M$1004 X \$419 \$96 VSS nfet_06v0 L=1U W=2.48U AS=1.0912P AD=0.6448P PS=5.84U
+ PD=3U
M$1005 \$96 \$419 X VSS nfet_06v0 L=1U W=2.48U AS=0.6448P AD=1.0912P PS=3U
+ PD=5.84U
M$1006 \$8 \$20 VSS VSS nfet_06v0 L=1U W=1.24U AS=0.5456P AD=0.5456P PS=3.36U
+ PD=3.36U
M$1007 \$1811 \$1811 \$1843 VSS nfet_06v0 L=1U W=5U AS=2.2P AD=2.2P PS=10.88U
+ PD=10.88U
M$1008 \$94 \$20 VSS VSS nfet_06v0 L=1U W=1.24U AS=0.5456P AD=0.5456P PS=3.36U
+ PD=3.36U
M$1009 \$96 \$20 VSS VSS nfet_06v0 L=1U W=1.24U AS=0.5456P AD=0.5456P PS=3.36U
+ PD=3.36U
M$1010 \$1860 \$1843 VSS VSS nfet_06v0 L=1U W=5U AS=2.2P AD=1.25P PS=10.88U
+ PD=5.5U
M$1011 \$1843 \$1809 \$1860 VSS nfet_06v0 L=1U W=5U AS=1.25P AD=2.2P PS=5.5U
+ PD=10.88U
M$1012 \$66 \$20 VSS VSS nfet_06v0 L=1U W=0.7U AS=0.308P AD=0.175P PS=2.28U
+ PD=1.2U
M$1013 \$65 \$20 \$66 VSS nfet_06v0 L=1U W=0.7U AS=0.175P AD=0.175P PS=1.2U
+ PD=1.2U
M$1014 \$64 \$20 \$65 VSS nfet_06v0 L=1U W=0.7U AS=0.175P AD=0.175P PS=1.2U
+ PD=1.2U
M$1015 \$20 \$20 \$64 VSS nfet_06v0 L=1U W=0.7U AS=0.175P AD=0.308P PS=1.2U
+ PD=2.28U
M$1016 X X \$97 VSS nfet_06v0 L=1U W=2U AS=0.88P AD=0.52P PS=4.88U PD=2.52U
M$1017 \$97 X X VSS nfet_06v0 L=1U W=2U AS=0.52P AD=0.88P PS=2.52U PD=4.88U
M$1018 \$1844 \$1840 VSS VSS nfet_06v0 L=1U W=5U AS=2.2P AD=1.3P PS=10.88U
+ PD=5.52U
M$1019 VSS \$1840 \$1844 VSS nfet_06v0 L=1U W=5U AS=1.3P AD=1.3P PS=5.52U
+ PD=5.52U
M$1020 \$1844 \$1840 VSS VSS nfet_06v0 L=1U W=5U AS=1.3P AD=2.2P PS=5.52U
+ PD=10.88U
M$1021 \$106 X VSS VSS nfet_06v0 L=1U W=2U AS=0.88P AD=0.5P PS=4.88U PD=2.5U
M$1022 \$97 X \$106 VSS nfet_06v0 L=1U W=2U AS=0.5P AD=0.88P PS=2.5U PD=4.88U
M$1023 X \$99 \$98 VSS nfet_06v0 L=1U W=2.48U AS=1.0912P AD=0.6448P PS=5.84U
+ PD=3U
M$1024 \$98 \$99 X VSS nfet_06v0 L=1U W=2.48U AS=0.6448P AD=1.0912P PS=3U
+ PD=5.84U
M$1025 \$98 \$20 VSS VSS nfet_06v0 L=1U W=1.24U AS=0.5456P AD=0.5456P PS=3.36U
+ PD=3.36U
M$1026 \$5362 \$5362 VSS VSS nfet_06v0 L=1U W=1U AS=0.44P AD=0.44P PS=2.88U
+ PD=2.88U
M$1027 \$3637 \$3571 VSS VSS nfet_06v0 L=1U W=5U AS=2.2P AD=1.25P PS=10.88U
+ PD=5.5U
M$1028 \$3585 \$3572 \$3637 VSS nfet_06v0 L=1U W=5U AS=1.25P AD=2.2P PS=5.5U
+ PD=10.88U
M$1029 \$5416 \$5363 VSS VSS nfet_06v0 L=1U W=5U AS=2.2P AD=1.25P PS=10.88U
+ PD=5.5U
M$1030 \$5363 \$5362 \$5416 VSS nfet_06v0 L=1U W=5U AS=1.25P AD=2.2P PS=5.5U
+ PD=10.88U
M$1031 \$3638 \$3571 VSS VSS nfet_06v0 L=1U W=5U AS=2.2P AD=1.25P PS=10.88U
+ PD=5.5U
M$1032 \$3585 \$3572 \$3638 VSS nfet_06v0 L=1U W=5U AS=1.25P AD=2.2P PS=5.5U
+ PD=10.88U
M$1033 \$5404 \$6424 VSS VSS nfet_06v0 L=1U W=1U AS=0.44P AD=0.25P PS=2.88U
+ PD=1.5U
M$1034 \$6271 \$6424 \$5404 VSS nfet_06v0 L=1U W=1U AS=0.25P AD=0.44P PS=1.5U
+ PD=2.88U
M$1035 \$3586 S1P \$3585 VSS nfet_06v0 L=1U W=5U AS=2.2P AD=2.2P PS=10.88U
+ PD=10.88U
M$1036 \$5405 \$6424 VSS VSS nfet_06v0 L=1U W=1U AS=0.44P AD=0.25P PS=2.88U
+ PD=1.5U
M$1037 \$6424 \$6424 \$5405 VSS nfet_06v0 L=1U W=1U AS=0.25P AD=0.44P PS=1.5U
+ PD=2.88U
M$1038 \$3587 S1N \$3585 VSS nfet_06v0 L=1U W=5U AS=2.2P AD=2.2P PS=10.88U
+ PD=10.88U
M$1039 \$3589 \$3572 \$3588 VSS nfet_06v0 L=1U W=2.5U AS=1.1P AD=1.1P PS=5.88U
+ PD=5.88U
M$1040 \$5417 \$5363 VSS VSS nfet_06v0 L=1U W=5U AS=2.2P AD=1.25P PS=10.88U
+ PD=5.5U
M$1041 \$5377 \$5362 \$5417 VSS nfet_06v0 L=1U W=5U AS=1.25P AD=2.2P PS=5.5U
+ PD=10.88U
M$1042 \$3591 \$3572 \$3590 VSS nfet_06v0 L=1U W=2.5U AS=1.1P AD=1.1P PS=5.88U
+ PD=5.88U
M$1043 \$5418 \$5363 VSS VSS nfet_06v0 L=1U W=5U AS=2.2P AD=1.25P PS=10.88U
+ PD=5.5U
M$1044 \$5377 \$5362 \$5418 VSS nfet_06v0 L=1U W=5U AS=1.25P AD=2.2P PS=5.5U
+ PD=10.88U
M$1045 \$3588 \$3589 VSS VSS nfet_06v0 L=1U W=2.5U AS=1.1P AD=1.1P PS=5.88U
+ PD=5.88U
M$1046 \$3590 \$3589 VSS VSS nfet_06v0 L=1U W=2.5U AS=1.1P AD=1.1P PS=5.88U
+ PD=5.88U
M$1047 \$5378 \$3605 \$5377 VSS nfet_06v0 L=1U W=5U AS=2.2P AD=1.3P PS=10.88U
+ PD=5.52U
M$1048 \$5377 \$3605 \$5378 VSS nfet_06v0 L=1U W=5U AS=1.3P AD=2.2P PS=5.52U
+ PD=10.88U
M$1049 \$3976 \$3573 \$3589 VSS nfet_06v0 L=1U W=2.5U AS=1.1P AD=1.1P PS=5.88U
+ PD=5.88U
M$1050 \$5379 \$3594 \$5377 VSS nfet_06v0 L=1U W=5U AS=2.2P AD=1.3P PS=10.88U
+ PD=5.52U
M$1051 \$5377 \$3594 \$5379 VSS nfet_06v0 L=1U W=5U AS=1.3P AD=2.2P PS=5.52U
+ PD=10.88U
M$1052 \$3625 \$3573 \$3591 VSS nfet_06v0 L=1U W=2.5U AS=1.1P AD=1.1P PS=5.88U
+ PD=5.88U
M$1053 \$3639 \$3571 VSS VSS nfet_06v0 L=1U W=5U AS=2.2P AD=1.25P PS=10.88U
+ PD=5.5U
M$1054 \$3592 \$3572 \$3639 VSS nfet_06v0 L=1U W=5U AS=1.25P AD=2.2P PS=5.5U
+ PD=10.88U
M$1055 \$5380 \$5362 \$5364 VSS nfet_06v0 L=1U W=2.5U AS=1.1P AD=0.65P PS=5.88U
+ PD=3.02U
M$1056 \$5364 \$5362 \$5380 VSS nfet_06v0 L=1U W=2.5U AS=0.65P AD=1.1P PS=3.02U
+ PD=5.88U
M$1057 \$3573 \$3573 \$3593 VSS nfet_06v0 L=1U W=5U AS=2.2P AD=2.2P PS=10.88U
+ PD=10.88U
M$1058 \$5381 \$5362 \$5365 VSS nfet_06v0 L=1U W=2.5U AS=1.1P AD=0.65P PS=5.88U
+ PD=3.02U
M$1059 \$5365 \$5362 \$5381 VSS nfet_06v0 L=1U W=2.5U AS=0.65P AD=1.1P PS=3.02U
+ PD=5.88U
M$1060 \$3640 \$3593 VSS VSS nfet_06v0 L=1U W=5U AS=2.2P AD=1.25P PS=10.88U
+ PD=5.5U
M$1061 \$3593 \$3572 \$3640 VSS nfet_06v0 L=1U W=5U AS=1.25P AD=2.2P PS=5.5U
+ PD=10.88U
M$1062 \$5364 \$5380 VSS VSS nfet_06v0 L=1U W=2.5U AS=1.1P AD=0.65P PS=5.88U
+ PD=3.02U
M$1063 VSS \$5380 \$5364 VSS nfet_06v0 L=1U W=2.5U AS=0.65P AD=0.65P PS=3.02U
+ PD=3.02U
M$1064 \$5364 \$5380 VSS VSS nfet_06v0 L=1U W=2.5U AS=0.65P AD=0.65P PS=3.02U
+ PD=3.02U
M$1065 VSS \$5380 \$5364 VSS nfet_06v0 L=1U W=2.5U AS=0.65P AD=1.1P PS=3.02U
+ PD=5.88U
M$1066 \$3594 \$3591 VSS VSS nfet_06v0 L=1U W=1U AS=0.44P AD=0.44P PS=2.88U
+ PD=2.88U
M$1067 \$3572 \$3572 VSS VSS nfet_06v0 L=1U W=1U AS=0.44P AD=0.44P PS=2.88U
+ PD=2.88U
M$1068 \$5365 \$5380 VSS VSS nfet_06v0 L=1U W=2.5U AS=1.1P AD=0.65P PS=5.88U
+ PD=3.02U
M$1069 VSS \$5380 \$5365 VSS nfet_06v0 L=1U W=2.5U AS=0.65P AD=0.65P PS=3.02U
+ PD=3.02U
M$1070 \$5365 \$5380 VSS VSS nfet_06v0 L=1U W=2.5U AS=0.65P AD=0.65P PS=3.02U
+ PD=3.02U
M$1071 VSS \$5380 \$5365 VSS nfet_06v0 L=1U W=2.5U AS=0.65P AD=1.1P PS=3.02U
+ PD=5.88U
M$1072 \$3641 \$3571 VSS VSS nfet_06v0 L=1U W=5U AS=2.2P AD=1.25P PS=10.88U
+ PD=5.5U
M$1073 \$3571 \$3572 \$3641 VSS nfet_06v0 L=1U W=5U AS=1.25P AD=2.2P PS=5.5U
+ PD=10.88U
M$1074 \$3623 \$3666 VSS VSS nfet_06v0 L=1U W=1U AS=0.44P AD=0.25P PS=2.88U
+ PD=1.5U
M$1075 \$3665 \$3666 \$3623 VSS nfet_06v0 L=1U W=1U AS=0.25P AD=0.44P PS=1.5U
+ PD=2.88U
M$1076 \$5668 \$5366 \$5380 VSS nfet_06v0 L=1U W=2.5U AS=1.1P AD=1.1P PS=5.88U
+ PD=5.88U
M$1077 \$3624 \$3666 VSS VSS nfet_06v0 L=1U W=1U AS=0.44P AD=0.25P PS=2.88U
+ PD=1.5U
M$1078 \$3666 \$3666 \$3624 VSS nfet_06v0 L=1U W=1U AS=0.25P AD=0.44P PS=1.5U
+ PD=2.88U
M$1079 \$5382 \$5366 \$5381 VSS nfet_06v0 L=1U W=2.5U AS=1.1P AD=1.1P PS=5.88U
+ PD=5.88U
M$1080 \$5419 \$5363 VSS VSS nfet_06v0 L=1U W=5U AS=2.2P AD=1.25P PS=10.88U
+ PD=5.5U
M$1081 \$5383 \$5362 \$5419 VSS nfet_06v0 L=1U W=5U AS=1.25P AD=2.2P PS=5.5U
+ PD=10.88U
M$1082 \$5366 \$5366 \$5384 VSS nfet_06v0 L=1U W=5U AS=2.2P AD=2.2P PS=10.88U
+ PD=10.88U
M$1083 \$5421 \$5384 VSS VSS nfet_06v0 L=1U W=5U AS=2.2P AD=1.25P PS=10.88U
+ PD=5.5U
M$1084 \$5384 \$5362 \$5421 VSS nfet_06v0 L=1U W=5U AS=1.25P AD=2.2P PS=5.5U
+ PD=10.88U
M$1085 \$5385 \$5381 VSS VSS nfet_06v0 L=1U W=5U AS=2.2P AD=1.3P PS=10.88U
+ PD=5.52U
M$1086 VSS \$5381 \$5385 VSS nfet_06v0 L=1U W=5U AS=1.3P AD=1.3P PS=5.52U
+ PD=5.52U
M$1087 \$5385 \$5381 VSS VSS nfet_06v0 L=1U W=5U AS=1.3P AD=2.2P PS=5.52U
+ PD=10.88U
M$1088 \$3642 \$3574 VSS VSS nfet_06v0 L=1U W=5U AS=2.2P AD=1.25P PS=10.88U
+ PD=5.5U
M$1089 \$3596 \$3575 \$3642 VSS nfet_06v0 L=1U W=5U AS=1.25P AD=2.2P PS=5.5U
+ PD=10.88U
M$1090 \$3643 \$3574 VSS VSS nfet_06v0 L=1U W=5U AS=2.2P AD=1.25P PS=10.88U
+ PD=5.5U
M$1091 \$3596 \$3575 \$3643 VSS nfet_06v0 L=1U W=5U AS=1.25P AD=2.2P PS=5.5U
+ PD=10.88U
M$1092 \$3597 S2P \$3596 VSS nfet_06v0 L=1U W=5U AS=2.2P AD=2.2P PS=10.88U
+ PD=10.88U
M$1093 \$3598 S2N \$3596 VSS nfet_06v0 L=1U W=5U AS=2.2P AD=2.2P PS=10.88U
+ PD=10.88U
M$1094 \$5367 \$5367 VSS VSS nfet_06v0 L=1U W=1U AS=0.44P AD=0.44P PS=2.88U
+ PD=2.88U
M$1095 \$3600 \$3575 \$3599 VSS nfet_06v0 L=1U W=2.5U AS=1.1P AD=1.1P PS=5.88U
+ PD=5.88U
M$1096 \$5422 \$5368 VSS VSS nfet_06v0 L=1U W=5U AS=2.2P AD=1.25P PS=10.88U
+ PD=5.5U
M$1097 \$5368 \$5367 \$5422 VSS nfet_06v0 L=1U W=5U AS=1.25P AD=2.2P PS=5.5U
+ PD=10.88U
M$1098 \$3602 \$3575 \$3601 VSS nfet_06v0 L=1U W=2.5U AS=1.1P AD=1.1P PS=5.88U
+ PD=5.88U
M$1099 \$3599 \$3600 VSS VSS nfet_06v0 L=1U W=2.5U AS=1.1P AD=1.1P PS=5.88U
+ PD=5.88U
M$1100 \$5408 \$6425 VSS VSS nfet_06v0 L=1U W=1U AS=0.44P AD=0.25P PS=2.88U
+ PD=1.5U
M$1101 \$6272 \$6425 \$5408 VSS nfet_06v0 L=1U W=1U AS=0.25P AD=0.44P PS=1.5U
+ PD=2.88U
M$1102 \$3601 \$3600 VSS VSS nfet_06v0 L=1U W=2.5U AS=1.1P AD=1.1P PS=5.88U
+ PD=5.88U
M$1103 \$5409 \$6425 VSS VSS nfet_06v0 L=1U W=1U AS=0.44P AD=0.25P PS=2.88U
+ PD=1.5U
M$1104 \$6425 \$6425 \$5409 VSS nfet_06v0 L=1U W=1U AS=0.25P AD=0.44P PS=1.5U
+ PD=2.88U
M$1105 \$3977 \$3576 \$3600 VSS nfet_06v0 L=1U W=2.5U AS=1.1P AD=1.1P PS=5.88U
+ PD=5.88U
M$1106 \$5424 \$5368 VSS VSS nfet_06v0 L=1U W=5U AS=2.2P AD=1.25P PS=10.88U
+ PD=5.5U
M$1107 \$5386 \$5367 \$5424 VSS nfet_06v0 L=1U W=5U AS=1.25P AD=2.2P PS=5.5U
+ PD=10.88U
M$1108 \$3626 \$3576 \$3602 VSS nfet_06v0 L=1U W=2.5U AS=1.1P AD=1.1P PS=5.88U
+ PD=5.88U
M$1109 \$3645 \$3574 VSS VSS nfet_06v0 L=1U W=5U AS=2.2P AD=1.25P PS=10.88U
+ PD=5.5U
M$1110 \$3603 \$3575 \$3645 VSS nfet_06v0 L=1U W=5U AS=1.25P AD=2.2P PS=5.5U
+ PD=10.88U
M$1111 \$5425 \$5368 VSS VSS nfet_06v0 L=1U W=5U AS=2.2P AD=1.25P PS=10.88U
+ PD=5.5U
M$1112 \$5386 \$5367 \$5425 VSS nfet_06v0 L=1U W=5U AS=1.25P AD=2.2P PS=5.5U
+ PD=10.88U
M$1113 \$3576 \$3576 \$3604 VSS nfet_06v0 L=1U W=5U AS=2.2P AD=2.2P PS=10.88U
+ PD=10.88U
M$1114 \$5387 \$3616 \$5386 VSS nfet_06v0 L=1U W=5U AS=2.2P AD=1.3P PS=10.88U
+ PD=5.52U
M$1115 \$5386 \$3616 \$5387 VSS nfet_06v0 L=1U W=5U AS=1.3P AD=2.2P PS=5.52U
+ PD=10.88U
M$1116 \$3646 \$3604 VSS VSS nfet_06v0 L=1U W=5U AS=2.2P AD=1.25P PS=10.88U
+ PD=5.5U
M$1117 \$3604 \$3575 \$3646 VSS nfet_06v0 L=1U W=5U AS=1.25P AD=2.2P PS=5.5U
+ PD=10.88U
M$1118 \$5388 \$3594 \$5386 VSS nfet_06v0 L=1U W=5U AS=2.2P AD=1.3P PS=10.88U
+ PD=5.52U
M$1119 \$5386 \$3594 \$5388 VSS nfet_06v0 L=1U W=5U AS=1.3P AD=2.2P PS=5.52U
+ PD=10.88U
M$1120 \$3605 \$3602 VSS VSS nfet_06v0 L=1U W=1U AS=0.44P AD=0.44P PS=2.88U
+ PD=2.88U
M$1121 \$5389 \$5367 \$5369 VSS nfet_06v0 L=1U W=2.5U AS=1.1P AD=0.65P PS=5.88U
+ PD=3.02U
M$1122 \$5369 \$5367 \$5389 VSS nfet_06v0 L=1U W=2.5U AS=0.65P AD=1.1P PS=3.02U
+ PD=5.88U
M$1123 \$3575 \$3575 VSS VSS nfet_06v0 L=1U W=1U AS=0.44P AD=0.44P PS=2.88U
+ PD=2.88U
M$1124 \$3648 \$3574 VSS VSS nfet_06v0 L=1U W=5U AS=2.2P AD=1.25P PS=10.88U
+ PD=5.5U
M$1125 \$3574 \$3575 \$3648 VSS nfet_06v0 L=1U W=5U AS=1.25P AD=2.2P PS=5.5U
+ PD=10.88U
M$1126 \$5390 \$5367 \$5370 VSS nfet_06v0 L=1U W=2.5U AS=1.1P AD=0.65P PS=5.88U
+ PD=3.02U
M$1127 \$5370 \$5367 \$5390 VSS nfet_06v0 L=1U W=2.5U AS=0.65P AD=1.1P PS=3.02U
+ PD=5.88U
M$1128 \$3622 \$3668 VSS VSS nfet_06v0 L=1U W=1U AS=0.44P AD=0.25P PS=2.88U
+ PD=1.5U
M$1129 \$3667 \$3668 \$3622 VSS nfet_06v0 L=1U W=1U AS=0.25P AD=0.44P PS=1.5U
+ PD=2.88U
M$1130 \$5369 \$5389 VSS VSS nfet_06v0 L=1U W=2.5U AS=1.1P AD=0.65P PS=5.88U
+ PD=3.02U
M$1131 VSS \$5389 \$5369 VSS nfet_06v0 L=1U W=2.5U AS=0.65P AD=0.65P PS=3.02U
+ PD=3.02U
M$1132 \$5369 \$5389 VSS VSS nfet_06v0 L=1U W=2.5U AS=0.65P AD=0.65P PS=3.02U
+ PD=3.02U
M$1133 VSS \$5389 \$5369 VSS nfet_06v0 L=1U W=2.5U AS=0.65P AD=1.1P PS=3.02U
+ PD=5.88U
M$1134 \$3621 \$3668 VSS VSS nfet_06v0 L=1U W=1U AS=0.44P AD=0.25P PS=2.88U
+ PD=1.5U
M$1135 \$3668 \$3668 \$3621 VSS nfet_06v0 L=1U W=1U AS=0.25P AD=0.44P PS=1.5U
+ PD=2.88U
M$1136 \$5370 \$5389 VSS VSS nfet_06v0 L=1U W=2.5U AS=1.1P AD=0.65P PS=5.88U
+ PD=3.02U
M$1137 VSS \$5389 \$5370 VSS nfet_06v0 L=1U W=2.5U AS=0.65P AD=0.65P PS=3.02U
+ PD=3.02U
M$1138 \$5370 \$5389 VSS VSS nfet_06v0 L=1U W=2.5U AS=0.65P AD=0.65P PS=3.02U
+ PD=3.02U
M$1139 VSS \$5389 \$5370 VSS nfet_06v0 L=1U W=2.5U AS=0.65P AD=1.1P PS=3.02U
+ PD=5.88U
M$1140 \$5669 \$5371 \$5389 VSS nfet_06v0 L=1U W=2.5U AS=1.1P AD=1.1P PS=5.88U
+ PD=5.88U
M$1141 \$5391 \$5371 \$5390 VSS nfet_06v0 L=1U W=2.5U AS=1.1P AD=1.1P PS=5.88U
+ PD=5.88U
M$1142 \$5426 \$5368 VSS VSS nfet_06v0 L=1U W=5U AS=2.2P AD=1.25P PS=10.88U
+ PD=5.5U
M$1143 \$5392 \$5367 \$5426 VSS nfet_06v0 L=1U W=5U AS=1.25P AD=2.2P PS=5.5U
+ PD=10.88U
M$1144 \$5371 \$5371 \$5393 VSS nfet_06v0 L=1U W=5U AS=2.2P AD=2.2P PS=10.88U
+ PD=10.88U
M$1145 \$5427 \$5393 VSS VSS nfet_06v0 L=1U W=5U AS=2.2P AD=1.25P PS=10.88U
+ PD=5.5U
M$1146 \$5393 \$5367 \$5427 VSS nfet_06v0 L=1U W=5U AS=1.25P AD=2.2P PS=5.5U
+ PD=10.88U
M$1147 \$3650 \$3577 VSS VSS nfet_06v0 L=1U W=5U AS=2.2P AD=1.25P PS=10.88U
+ PD=5.5U
M$1148 \$3607 \$3578 \$3650 VSS nfet_06v0 L=1U W=5U AS=1.25P AD=2.2P PS=5.5U
+ PD=10.88U
M$1149 \$5394 \$5390 VSS VSS nfet_06v0 L=1U W=5U AS=2.2P AD=1.3P PS=10.88U
+ PD=5.52U
M$1150 VSS \$5390 \$5394 VSS nfet_06v0 L=1U W=5U AS=1.3P AD=1.3P PS=5.52U
+ PD=5.52U
M$1151 \$5394 \$5390 VSS VSS nfet_06v0 L=1U W=5U AS=1.3P AD=2.2P PS=5.52U
+ PD=10.88U
M$1152 \$3651 \$3577 VSS VSS nfet_06v0 L=1U W=5U AS=2.2P AD=1.25P PS=10.88U
+ PD=5.5U
M$1153 \$3607 \$3578 \$3651 VSS nfet_06v0 L=1U W=5U AS=1.25P AD=2.2P PS=5.5U
+ PD=10.88U
M$1154 \$3608 S4P \$3607 VSS nfet_06v0 L=1U W=5U AS=2.2P AD=2.2P PS=10.88U
+ PD=10.88U
M$1155 \$3609 S4N \$3607 VSS nfet_06v0 L=1U W=5U AS=2.2P AD=2.2P PS=10.88U
+ PD=10.88U
M$1156 \$3611 \$3578 \$3610 VSS nfet_06v0 L=1U W=2.5U AS=1.1P AD=1.1P PS=5.88U
+ PD=5.88U
M$1157 \$3613 \$3578 \$3612 VSS nfet_06v0 L=1U W=2.5U AS=1.1P AD=1.1P PS=5.88U
+ PD=5.88U
M$1158 \$3610 \$3611 VSS VSS nfet_06v0 L=1U W=2.5U AS=1.1P AD=1.1P PS=5.88U
+ PD=5.88U
M$1159 \$3612 \$3611 VSS VSS nfet_06v0 L=1U W=2.5U AS=1.1P AD=1.1P PS=5.88U
+ PD=5.88U
M$1160 \$3978 \$3579 \$3611 VSS nfet_06v0 L=1U W=2.5U AS=1.1P AD=1.1P PS=5.88U
+ PD=5.88U
M$1161 \$5372 \$5372 VSS VSS nfet_06v0 L=1U W=1U AS=0.44P AD=0.44P PS=2.88U
+ PD=2.88U
M$1162 \$3627 \$3579 \$3613 VSS nfet_06v0 L=1U W=2.5U AS=1.1P AD=1.1P PS=5.88U
+ PD=5.88U
M$1163 \$5428 \$5373 VSS VSS nfet_06v0 L=1U W=5U AS=2.2P AD=1.25P PS=10.88U
+ PD=5.5U
M$1164 \$5373 \$5372 \$5428 VSS nfet_06v0 L=1U W=5U AS=1.25P AD=2.2P PS=5.5U
+ PD=10.88U
M$1165 \$3649 \$3577 VSS VSS nfet_06v0 L=1U W=5U AS=2.2P AD=1.25P PS=10.88U
+ PD=5.5U
M$1166 \$3614 \$3578 \$3649 VSS nfet_06v0 L=1U W=5U AS=1.25P AD=2.2P PS=5.5U
+ PD=10.88U
M$1167 \$5407 \$6426 VSS VSS nfet_06v0 L=1U W=1U AS=0.44P AD=0.25P PS=2.88U
+ PD=1.5U
M$1168 \$6273 \$6426 \$5407 VSS nfet_06v0 L=1U W=1U AS=0.25P AD=0.44P PS=1.5U
+ PD=2.88U
M$1169 \$3579 \$3579 \$3615 VSS nfet_06v0 L=1U W=5U AS=2.2P AD=2.2P PS=10.88U
+ PD=10.88U
M$1170 \$5406 \$6426 VSS VSS nfet_06v0 L=1U W=1U AS=0.44P AD=0.25P PS=2.88U
+ PD=1.5U
M$1171 \$6426 \$6426 \$5406 VSS nfet_06v0 L=1U W=1U AS=0.25P AD=0.44P PS=1.5U
+ PD=2.88U
M$1172 \$3647 \$3615 VSS VSS nfet_06v0 L=1U W=5U AS=2.2P AD=1.25P PS=10.88U
+ PD=5.5U
M$1173 \$3615 \$3578 \$3647 VSS nfet_06v0 L=1U W=5U AS=1.25P AD=2.2P PS=5.5U
+ PD=10.88U
M$1174 \$5429 \$5373 VSS VSS nfet_06v0 L=1U W=5U AS=2.2P AD=1.25P PS=10.88U
+ PD=5.5U
M$1175 \$5395 \$5372 \$5429 VSS nfet_06v0 L=1U W=5U AS=1.25P AD=2.2P PS=5.5U
+ PD=10.88U
M$1176 \$3616 \$3613 VSS VSS nfet_06v0 L=1U W=1U AS=0.44P AD=0.44P PS=2.88U
+ PD=2.88U
M$1177 \$5430 \$5373 VSS VSS nfet_06v0 L=1U W=5U AS=2.2P AD=1.25P PS=10.88U
+ PD=5.5U
M$1178 \$5395 \$5372 \$5430 VSS nfet_06v0 L=1U W=5U AS=1.25P AD=2.2P PS=5.5U
+ PD=10.88U
M$1179 \$3578 \$3578 VSS VSS nfet_06v0 L=1U W=1U AS=0.44P AD=0.44P PS=2.88U
+ PD=2.88U
M$1180 \$3644 \$3577 VSS VSS nfet_06v0 L=1U W=5U AS=2.2P AD=1.25P PS=10.88U
+ PD=5.5U
M$1181 \$3577 \$3578 \$3644 VSS nfet_06v0 L=1U W=5U AS=1.25P AD=2.2P PS=5.5U
+ PD=10.88U
M$1182 \$5396 \$3616 \$5395 VSS nfet_06v0 L=1U W=5U AS=2.2P AD=1.3P PS=10.88U
+ PD=5.52U
M$1183 \$5395 \$3616 \$5396 VSS nfet_06v0 L=1U W=5U AS=1.3P AD=2.2P PS=5.52U
+ PD=10.88U
M$1184 \$3620 \$3670 VSS VSS nfet_06v0 L=1U W=1U AS=0.44P AD=0.25P PS=2.88U
+ PD=1.5U
M$1185 \$3669 \$3670 \$3620 VSS nfet_06v0 L=1U W=1U AS=0.25P AD=0.44P PS=1.5U
+ PD=2.88U
M$1186 \$5397 \$3605 \$5395 VSS nfet_06v0 L=1U W=5U AS=2.2P AD=1.3P PS=10.88U
+ PD=5.52U
M$1187 \$5395 \$3605 \$5397 VSS nfet_06v0 L=1U W=5U AS=1.3P AD=2.2P PS=5.52U
+ PD=10.88U
M$1188 \$3619 \$3670 VSS VSS nfet_06v0 L=1U W=1U AS=0.44P AD=0.25P PS=2.88U
+ PD=1.5U
M$1189 \$3670 \$3670 \$3619 VSS nfet_06v0 L=1U W=1U AS=0.25P AD=0.44P PS=1.5U
+ PD=2.88U
M$1190 \$5398 \$5372 \$5374 VSS nfet_06v0 L=1U W=2.5U AS=1.1P AD=0.65P PS=5.88U
+ PD=3.02U
M$1191 \$5374 \$5372 \$5398 VSS nfet_06v0 L=1U W=2.5U AS=0.65P AD=1.1P PS=3.02U
+ PD=5.88U
M$1192 \$5399 \$5372 \$5375 VSS nfet_06v0 L=1U W=2.5U AS=1.1P AD=0.65P PS=5.88U
+ PD=3.02U
M$1193 \$5375 \$5372 \$5399 VSS nfet_06v0 L=1U W=2.5U AS=0.65P AD=1.1P PS=3.02U
+ PD=5.88U
M$1194 \$5374 \$5398 VSS VSS nfet_06v0 L=1U W=2.5U AS=1.1P AD=0.65P PS=5.88U
+ PD=3.02U
M$1195 VSS \$5398 \$5374 VSS nfet_06v0 L=1U W=2.5U AS=0.65P AD=0.65P PS=3.02U
+ PD=3.02U
M$1196 \$5374 \$5398 VSS VSS nfet_06v0 L=1U W=2.5U AS=0.65P AD=0.65P PS=3.02U
+ PD=3.02U
M$1197 VSS \$5398 \$5374 VSS nfet_06v0 L=1U W=2.5U AS=0.65P AD=1.1P PS=3.02U
+ PD=5.88U
M$1198 \$5375 \$5398 VSS VSS nfet_06v0 L=1U W=2.5U AS=1.1P AD=0.65P PS=5.88U
+ PD=3.02U
M$1199 VSS \$5398 \$5375 VSS nfet_06v0 L=1U W=2.5U AS=0.65P AD=0.65P PS=3.02U
+ PD=3.02U
M$1200 \$5375 \$5398 VSS VSS nfet_06v0 L=1U W=2.5U AS=0.65P AD=0.65P PS=3.02U
+ PD=3.02U
M$1201 VSS \$5398 \$5375 VSS nfet_06v0 L=1U W=2.5U AS=0.65P AD=1.1P PS=3.02U
+ PD=5.88U
M$1202 \$5670 \$5376 \$5398 VSS nfet_06v0 L=1U W=2.5U AS=1.1P AD=1.1P PS=5.88U
+ PD=5.88U
M$1203 Y \$3652 \$3661 VSS nfet_06v0 L=1U W=2.48U AS=1.0912P AD=0.6448P
+ PS=5.84U PD=3U
M$1204 \$3661 \$3652 Y VSS nfet_06v0 L=1U W=2.48U AS=0.6448P AD=1.0912P PS=3U
+ PD=5.84U
M$1205 Y \$3580 \$3581 VSS nfet_06v0 L=1U W=2.48U AS=1.0912P AD=0.6448P
+ PS=5.84U PD=3U
M$1206 \$3581 \$3580 Y VSS nfet_06v0 L=1U W=2.48U AS=0.6448P AD=1.0912P PS=3U
+ PD=5.84U
M$1207 \$5400 \$5376 \$5399 VSS nfet_06v0 L=1U W=2.5U AS=1.1P AD=1.1P PS=5.88U
+ PD=5.88U
M$1208 \$5423 \$5373 VSS VSS nfet_06v0 L=1U W=5U AS=2.2P AD=1.25P PS=10.88U
+ PD=5.5U
M$1209 \$5401 \$5372 \$5423 VSS nfet_06v0 L=1U W=5U AS=1.25P AD=2.2P PS=5.5U
+ PD=10.88U
M$1210 Y \$3653 \$3662 VSS nfet_06v0 L=1U W=2.48U AS=1.0912P AD=0.6448P
+ PS=5.84U PD=3U
M$1211 \$3662 \$3653 Y VSS nfet_06v0 L=1U W=2.48U AS=0.6448P AD=1.0912P PS=3U
+ PD=5.84U
M$1212 \$3581 \$3583 VSS VSS nfet_06v0 L=1U W=1.24U AS=0.5456P AD=0.5456P
+ PS=3.36U PD=3.36U
M$1213 \$5376 \$5376 \$5402 VSS nfet_06v0 L=1U W=5U AS=2.2P AD=2.2P PS=10.88U
+ PD=10.88U
M$1214 \$3661 \$3583 VSS VSS nfet_06v0 L=1U W=1.24U AS=0.5456P AD=0.5456P
+ PS=3.36U PD=3.36U
M$1215 \$3662 \$3583 VSS VSS nfet_06v0 L=1U W=1.24U AS=0.5456P AD=0.5456P
+ PS=3.36U PD=3.36U
M$1216 \$5420 \$5402 VSS VSS nfet_06v0 L=1U W=5U AS=2.2P AD=1.25P PS=10.88U
+ PD=5.5U
M$1217 \$5402 \$5372 \$5420 VSS nfet_06v0 L=1U W=5U AS=1.25P AD=2.2P PS=5.5U
+ PD=10.88U
M$1218 \$3630 \$3583 VSS VSS nfet_06v0 L=1U W=0.7U AS=0.308P AD=0.175P PS=2.28U
+ PD=1.2U
M$1219 \$3629 \$3583 \$3630 VSS nfet_06v0 L=1U W=0.7U AS=0.175P AD=0.175P
+ PS=1.2U PD=1.2U
M$1220 \$3628 \$3583 \$3629 VSS nfet_06v0 L=1U W=0.7U AS=0.175P AD=0.175P
+ PS=1.2U PD=1.2U
M$1221 \$3583 \$3583 \$3628 VSS nfet_06v0 L=1U W=0.7U AS=0.175P AD=0.308P
+ PS=1.2U PD=2.28U
M$1222 Y Y \$3663 VSS nfet_06v0 L=1U W=2U AS=0.88P AD=0.52P PS=4.88U PD=2.52U
M$1223 \$3663 Y Y VSS nfet_06v0 L=1U W=2U AS=0.52P AD=0.88P PS=2.52U PD=4.88U
M$1224 \$5403 \$5399 VSS VSS nfet_06v0 L=1U W=5U AS=2.2P AD=1.3P PS=10.88U
+ PD=5.52U
M$1225 VSS \$5399 \$5403 VSS nfet_06v0 L=1U W=5U AS=1.3P AD=1.3P PS=5.52U
+ PD=5.52U
M$1226 \$5403 \$5399 VSS VSS nfet_06v0 L=1U W=5U AS=1.3P AD=2.2P PS=5.52U
+ PD=10.88U
M$1227 \$3671 Y VSS VSS nfet_06v0 L=1U W=2U AS=0.88P AD=0.5P PS=4.88U PD=2.5U
M$1228 \$3663 Y \$3671 VSS nfet_06v0 L=1U W=2U AS=0.5P AD=0.88P PS=2.5U PD=4.88U
M$1229 Y \$3654 \$3664 VSS nfet_06v0 L=1U W=2.48U AS=1.0912P AD=0.6448P
+ PS=5.84U PD=3U
M$1230 \$3664 \$3654 Y VSS nfet_06v0 L=1U W=2.48U AS=0.6448P AD=1.0912P PS=3U
+ PD=5.84U
M$1231 \$3664 \$3583 VSS VSS nfet_06v0 L=1U W=1.24U AS=0.5456P AD=0.5456P
+ PS=3.36U PD=3.36U
M$1232 \$8919 \$8919 VSS VSS nfet_06v0 L=1U W=1U AS=0.44P AD=0.44P PS=2.88U
+ PD=2.88U
M$1233 \$7186 \$7132 VSS VSS nfet_06v0 L=1U W=5U AS=2.2P AD=1.25P PS=10.88U
+ PD=5.5U
M$1234 \$7134 \$7133 \$7186 VSS nfet_06v0 L=1U W=5U AS=1.25P AD=2.2P PS=5.5U
+ PD=10.88U
M$1235 \$8973 \$8920 VSS VSS nfet_06v0 L=1U W=5U AS=2.2P AD=1.25P PS=10.88U
+ PD=5.5U
M$1236 \$8920 \$8919 \$8973 VSS nfet_06v0 L=1U W=5U AS=1.25P AD=2.2P PS=5.5U
+ PD=10.88U
M$1237 \$7187 \$7132 VSS VSS nfet_06v0 L=1U W=5U AS=2.2P AD=1.25P PS=10.88U
+ PD=5.5U
M$1238 \$7134 \$7133 \$7187 VSS nfet_06v0 L=1U W=5U AS=1.25P AD=2.2P PS=5.5U
+ PD=10.88U
M$1239 \$8960 \$9981 VSS VSS nfet_06v0 L=1U W=1U AS=0.44P AD=0.25P PS=2.88U
+ PD=1.5U
M$1240 \$9753 \$9981 \$8960 VSS nfet_06v0 L=1U W=1U AS=0.25P AD=0.44P PS=1.5U
+ PD=2.88U
M$1241 \$7135 S3P \$7134 VSS nfet_06v0 L=1U W=5U AS=2.2P AD=2.2P PS=10.88U
+ PD=10.88U
M$1242 \$7136 S3N \$7134 VSS nfet_06v0 L=1U W=5U AS=2.2P AD=2.2P PS=10.88U
+ PD=10.88U
M$1243 \$8961 \$9981 VSS VSS nfet_06v0 L=1U W=1U AS=0.44P AD=0.25P PS=2.88U
+ PD=1.5U
M$1244 \$9981 \$9981 \$8961 VSS nfet_06v0 L=1U W=1U AS=0.25P AD=0.44P PS=1.5U
+ PD=2.88U
M$1245 \$7138 \$7133 \$7137 VSS nfet_06v0 L=1U W=2.5U AS=1.1P AD=1.1P PS=5.88U
+ PD=5.88U
M$1246 \$8975 \$8920 VSS VSS nfet_06v0 L=1U W=5U AS=2.2P AD=1.25P PS=10.88U
+ PD=5.5U
M$1247 \$8928 \$8919 \$8975 VSS nfet_06v0 L=1U W=5U AS=1.25P AD=2.2P PS=5.5U
+ PD=10.88U
M$1248 \$7140 \$7133 \$7139 VSS nfet_06v0 L=1U W=2.5U AS=1.1P AD=1.1P PS=5.88U
+ PD=5.88U
M$1249 \$8976 \$8920 VSS VSS nfet_06v0 L=1U W=5U AS=2.2P AD=1.25P PS=10.88U
+ PD=5.5U
M$1250 \$8928 \$8919 \$8976 VSS nfet_06v0 L=1U W=5U AS=1.25P AD=2.2P PS=5.5U
+ PD=10.88U
M$1251 \$7137 \$7138 VSS VSS nfet_06v0 L=1U W=2.5U AS=1.1P AD=1.1P PS=5.88U
+ PD=5.88U
M$1252 \$7139 \$7138 VSS VSS nfet_06v0 L=1U W=2.5U AS=1.1P AD=1.1P PS=5.88U
+ PD=5.88U
M$1253 \$8929 \$7157 \$8928 VSS nfet_06v0 L=1U W=5U AS=2.2P AD=1.3P PS=10.88U
+ PD=5.52U
M$1254 \$8928 \$7157 \$8929 VSS nfet_06v0 L=1U W=5U AS=1.3P AD=2.2P PS=5.52U
+ PD=10.88U
M$1255 \$7531 \$7141 \$7138 VSS nfet_06v0 L=1U W=2.5U AS=1.1P AD=1.1P PS=5.88U
+ PD=5.88U
M$1256 \$8930 \$7144 \$8928 VSS nfet_06v0 L=1U W=5U AS=2.2P AD=1.3P PS=10.88U
+ PD=5.52U
M$1257 \$8928 \$7144 \$8930 VSS nfet_06v0 L=1U W=5U AS=1.3P AD=2.2P PS=5.52U
+ PD=10.88U
M$1258 \$7175 \$7141 \$7140 VSS nfet_06v0 L=1U W=2.5U AS=1.1P AD=1.1P PS=5.88U
+ PD=5.88U
M$1259 \$7191 \$7132 VSS VSS nfet_06v0 L=1U W=5U AS=2.2P AD=1.25P PS=10.88U
+ PD=5.5U
M$1260 \$7142 \$7133 \$7191 VSS nfet_06v0 L=1U W=5U AS=1.25P AD=2.2P PS=5.5U
+ PD=10.88U
M$1261 \$8932 \$8919 \$8931 VSS nfet_06v0 L=1U W=2.5U AS=1.1P AD=0.65P PS=5.88U
+ PD=3.02U
M$1262 \$8931 \$8919 \$8932 VSS nfet_06v0 L=1U W=2.5U AS=0.65P AD=1.1P PS=3.02U
+ PD=5.88U
M$1263 \$7141 \$7141 \$7143 VSS nfet_06v0 L=1U W=5U AS=2.2P AD=2.2P PS=10.88U
+ PD=10.88U
M$1264 \$8934 \$8919 \$8933 VSS nfet_06v0 L=1U W=2.5U AS=1.1P AD=0.65P PS=5.88U
+ PD=3.02U
M$1265 \$8933 \$8919 \$8934 VSS nfet_06v0 L=1U W=2.5U AS=0.65P AD=1.1P PS=3.02U
+ PD=5.88U
M$1266 \$7192 \$7143 VSS VSS nfet_06v0 L=1U W=5U AS=2.2P AD=1.25P PS=10.88U
+ PD=5.5U
M$1267 \$7143 \$7133 \$7192 VSS nfet_06v0 L=1U W=5U AS=1.25P AD=2.2P PS=5.5U
+ PD=10.88U
M$1268 \$8931 \$8932 VSS VSS nfet_06v0 L=1U W=2.5U AS=1.1P AD=0.65P PS=5.88U
+ PD=3.02U
M$1269 VSS \$8932 \$8931 VSS nfet_06v0 L=1U W=2.5U AS=0.65P AD=0.65P PS=3.02U
+ PD=3.02U
M$1270 \$8931 \$8932 VSS VSS nfet_06v0 L=1U W=2.5U AS=0.65P AD=0.65P PS=3.02U
+ PD=3.02U
M$1271 VSS \$8932 \$8931 VSS nfet_06v0 L=1U W=2.5U AS=0.65P AD=1.1P PS=3.02U
+ PD=5.88U
M$1272 \$7144 \$7140 VSS VSS nfet_06v0 L=1U W=1U AS=0.44P AD=0.44P PS=2.88U
+ PD=2.88U
M$1273 \$7133 \$7133 VSS VSS nfet_06v0 L=1U W=1U AS=0.44P AD=0.44P PS=2.88U
+ PD=2.88U
M$1274 \$8933 \$8932 VSS VSS nfet_06v0 L=1U W=2.5U AS=1.1P AD=0.65P PS=5.88U
+ PD=3.02U
M$1275 VSS \$8932 \$8933 VSS nfet_06v0 L=1U W=2.5U AS=0.65P AD=0.65P PS=3.02U
+ PD=3.02U
M$1276 \$8933 \$8932 VSS VSS nfet_06v0 L=1U W=2.5U AS=0.65P AD=0.65P PS=3.02U
+ PD=3.02U
M$1277 VSS \$8932 \$8933 VSS nfet_06v0 L=1U W=2.5U AS=0.65P AD=1.1P PS=3.02U
+ PD=5.88U
M$1278 \$7193 \$7132 VSS VSS nfet_06v0 L=1U W=5U AS=2.2P AD=1.25P PS=10.88U
+ PD=5.5U
M$1279 \$7132 \$7133 \$7193 VSS nfet_06v0 L=1U W=5U AS=1.25P AD=2.2P PS=5.5U
+ PD=10.88U
M$1280 \$7182 \$7221 VSS VSS nfet_06v0 L=1U W=1U AS=0.44P AD=0.25P PS=2.88U
+ PD=1.5U
M$1281 \$7220 \$7221 \$7182 VSS nfet_06v0 L=1U W=1U AS=0.25P AD=0.44P PS=1.5U
+ PD=2.88U
M$1282 \$9300 \$8921 \$8932 VSS nfet_06v0 L=1U W=2.5U AS=1.1P AD=1.1P PS=5.88U
+ PD=5.88U
M$1283 \$7183 \$7221 VSS VSS nfet_06v0 L=1U W=1U AS=0.44P AD=0.25P PS=2.88U
+ PD=1.5U
M$1284 \$7221 \$7221 \$7183 VSS nfet_06v0 L=1U W=1U AS=0.25P AD=0.44P PS=1.5U
+ PD=2.88U
M$1285 \$8935 \$8921 \$8934 VSS nfet_06v0 L=1U W=2.5U AS=1.1P AD=1.1P PS=5.88U
+ PD=5.88U
M$1286 \$8978 \$8920 VSS VSS nfet_06v0 L=1U W=5U AS=2.2P AD=1.25P PS=10.88U
+ PD=5.5U
M$1287 \$8936 \$8919 \$8978 VSS nfet_06v0 L=1U W=5U AS=1.25P AD=2.2P PS=5.5U
+ PD=10.88U
M$1288 \$8921 \$8921 \$8937 VSS nfet_06v0 L=1U W=5U AS=2.2P AD=2.2P PS=10.88U
+ PD=10.88U
M$1289 \$8979 \$8937 VSS VSS nfet_06v0 L=1U W=5U AS=2.2P AD=1.25P PS=10.88U
+ PD=5.5U
M$1290 \$8937 \$8919 \$8979 VSS nfet_06v0 L=1U W=5U AS=1.25P AD=2.2P PS=5.5U
+ PD=10.88U
M$1291 \$8938 \$8934 VSS VSS nfet_06v0 L=1U W=5U AS=2.2P AD=1.3P PS=10.88U
+ PD=5.52U
M$1292 VSS \$8934 \$8938 VSS nfet_06v0 L=1U W=5U AS=1.3P AD=1.3P PS=5.52U
+ PD=5.52U
M$1293 \$8938 \$8934 VSS VSS nfet_06v0 L=1U W=5U AS=1.3P AD=2.2P PS=5.52U
+ PD=10.88U
M$1294 \$7194 \$7145 VSS VSS nfet_06v0 L=1U W=5U AS=2.2P AD=1.25P PS=10.88U
+ PD=5.5U
M$1295 \$7147 \$7146 \$7194 VSS nfet_06v0 L=1U W=5U AS=1.25P AD=2.2P PS=5.5U
+ PD=10.88U
M$1296 \$7196 \$7145 VSS VSS nfet_06v0 L=1U W=5U AS=2.2P AD=1.25P PS=10.88U
+ PD=5.5U
M$1297 \$7147 \$7146 \$7196 VSS nfet_06v0 L=1U W=5U AS=1.25P AD=2.2P PS=5.5U
+ PD=10.88U
M$1298 \$7148 S4P \$7147 VSS nfet_06v0 L=1U W=5U AS=2.2P AD=2.2P PS=10.88U
+ PD=10.88U
M$1299 \$7149 S4N \$7147 VSS nfet_06v0 L=1U W=5U AS=2.2P AD=2.2P PS=10.88U
+ PD=10.88U
M$1300 \$8922 \$8922 VSS VSS nfet_06v0 L=1U W=1U AS=0.44P AD=0.44P PS=2.88U
+ PD=2.88U
M$1301 \$7151 \$7146 \$7150 VSS nfet_06v0 L=1U W=2.5U AS=1.1P AD=1.1P PS=5.88U
+ PD=5.88U
M$1302 \$8983 \$8923 VSS VSS nfet_06v0 L=1U W=5U AS=2.2P AD=1.25P PS=10.88U
+ PD=5.5U
M$1303 \$8923 \$8922 \$8983 VSS nfet_06v0 L=1U W=5U AS=1.25P AD=2.2P PS=5.5U
+ PD=10.88U
M$1304 \$7153 \$7146 \$7152 VSS nfet_06v0 L=1U W=2.5U AS=1.1P AD=1.1P PS=5.88U
+ PD=5.88U
M$1305 \$7150 \$7151 VSS VSS nfet_06v0 L=1U W=2.5U AS=1.1P AD=1.1P PS=5.88U
+ PD=5.88U
M$1306 \$8964 \$9982 VSS VSS nfet_06v0 L=1U W=1U AS=0.44P AD=0.25P PS=2.88U
+ PD=1.5U
M$1307 \$9754 \$9982 \$8964 VSS nfet_06v0 L=1U W=1U AS=0.25P AD=0.44P PS=1.5U
+ PD=2.88U
M$1308 \$7152 \$7151 VSS VSS nfet_06v0 L=1U W=2.5U AS=1.1P AD=1.1P PS=5.88U
+ PD=5.88U
M$1309 \$8965 \$9982 VSS VSS nfet_06v0 L=1U W=1U AS=0.44P AD=0.25P PS=2.88U
+ PD=1.5U
M$1310 \$9982 \$9982 \$8965 VSS nfet_06v0 L=1U W=1U AS=0.25P AD=0.44P PS=1.5U
+ PD=2.88U
M$1311 \$7533 \$7154 \$7151 VSS nfet_06v0 L=1U W=2.5U AS=1.1P AD=1.1P PS=5.88U
+ PD=5.88U
M$1312 \$8984 \$8923 VSS VSS nfet_06v0 L=1U W=5U AS=2.2P AD=1.25P PS=10.88U
+ PD=5.5U
M$1313 \$8939 \$8922 \$8984 VSS nfet_06v0 L=1U W=5U AS=1.25P AD=2.2P PS=5.5U
+ PD=10.88U
M$1314 \$7177 \$7154 \$7153 VSS nfet_06v0 L=1U W=2.5U AS=1.1P AD=1.1P PS=5.88U
+ PD=5.88U
M$1315 \$7199 \$7145 VSS VSS nfet_06v0 L=1U W=5U AS=2.2P AD=1.25P PS=10.88U
+ PD=5.5U
M$1316 \$7155 \$7146 \$7199 VSS nfet_06v0 L=1U W=5U AS=1.25P AD=2.2P PS=5.5U
+ PD=10.88U
M$1317 \$8985 \$8923 VSS VSS nfet_06v0 L=1U W=5U AS=2.2P AD=1.25P PS=10.88U
+ PD=5.5U
M$1318 \$8939 \$8922 \$8985 VSS nfet_06v0 L=1U W=5U AS=1.25P AD=2.2P PS=5.5U
+ PD=10.88U
M$1319 \$7154 \$7154 \$7156 VSS nfet_06v0 L=1U W=5U AS=2.2P AD=2.2P PS=10.88U
+ PD=10.88U
M$1320 \$8940 \$7170 \$8939 VSS nfet_06v0 L=1U W=5U AS=2.2P AD=1.3P PS=10.88U
+ PD=5.52U
M$1321 \$8939 \$7170 \$8940 VSS nfet_06v0 L=1U W=5U AS=1.3P AD=2.2P PS=5.52U
+ PD=10.88U
M$1322 \$7200 \$7156 VSS VSS nfet_06v0 L=1U W=5U AS=2.2P AD=1.25P PS=10.88U
+ PD=5.5U
M$1323 \$7156 \$7146 \$7200 VSS nfet_06v0 L=1U W=5U AS=1.25P AD=2.2P PS=5.5U
+ PD=10.88U
M$1324 \$8941 \$7144 \$8939 VSS nfet_06v0 L=1U W=5U AS=2.2P AD=1.3P PS=10.88U
+ PD=5.52U
M$1325 \$8939 \$7144 \$8941 VSS nfet_06v0 L=1U W=5U AS=1.3P AD=2.2P PS=5.52U
+ PD=10.88U
M$1326 \$7157 \$7153 VSS VSS nfet_06v0 L=1U W=1U AS=0.44P AD=0.44P PS=2.88U
+ PD=2.88U
M$1327 \$8943 \$8922 \$8942 VSS nfet_06v0 L=1U W=2.5U AS=1.1P AD=0.65P PS=5.88U
+ PD=3.02U
M$1328 \$8942 \$8922 \$8943 VSS nfet_06v0 L=1U W=2.5U AS=0.65P AD=1.1P PS=3.02U
+ PD=5.88U
M$1329 \$7146 \$7146 VSS VSS nfet_06v0 L=1U W=1U AS=0.44P AD=0.44P PS=2.88U
+ PD=2.88U
M$1330 \$7201 \$7145 VSS VSS nfet_06v0 L=1U W=5U AS=2.2P AD=1.25P PS=10.88U
+ PD=5.5U
M$1331 \$7145 \$7146 \$7201 VSS nfet_06v0 L=1U W=5U AS=1.25P AD=2.2P PS=5.5U
+ PD=10.88U
M$1332 \$8945 \$8922 \$8944 VSS nfet_06v0 L=1U W=2.5U AS=1.1P AD=0.65P PS=5.88U
+ PD=3.02U
M$1333 \$8944 \$8922 \$8945 VSS nfet_06v0 L=1U W=2.5U AS=0.65P AD=1.1P PS=3.02U
+ PD=5.88U
M$1334 \$7185 \$7223 VSS VSS nfet_06v0 L=1U W=1U AS=0.44P AD=0.25P PS=2.88U
+ PD=1.5U
M$1335 \$7222 \$7223 \$7185 VSS nfet_06v0 L=1U W=1U AS=0.25P AD=0.44P PS=1.5U
+ PD=2.88U
M$1336 \$8942 \$8943 VSS VSS nfet_06v0 L=1U W=2.5U AS=1.1P AD=0.65P PS=5.88U
+ PD=3.02U
M$1337 VSS \$8943 \$8942 VSS nfet_06v0 L=1U W=2.5U AS=0.65P AD=0.65P PS=3.02U
+ PD=3.02U
M$1338 \$8942 \$8943 VSS VSS nfet_06v0 L=1U W=2.5U AS=0.65P AD=0.65P PS=3.02U
+ PD=3.02U
M$1339 VSS \$8943 \$8942 VSS nfet_06v0 L=1U W=2.5U AS=0.65P AD=1.1P PS=3.02U
+ PD=5.88U
M$1340 \$7184 \$7223 VSS VSS nfet_06v0 L=1U W=1U AS=0.44P AD=0.25P PS=2.88U
+ PD=1.5U
M$1341 \$7223 \$7223 \$7184 VSS nfet_06v0 L=1U W=1U AS=0.25P AD=0.44P PS=1.5U
+ PD=2.88U
M$1342 \$8944 \$8943 VSS VSS nfet_06v0 L=1U W=2.5U AS=1.1P AD=0.65P PS=5.88U
+ PD=3.02U
M$1343 VSS \$8943 \$8944 VSS nfet_06v0 L=1U W=2.5U AS=0.65P AD=0.65P PS=3.02U
+ PD=3.02U
M$1344 \$8944 \$8943 VSS VSS nfet_06v0 L=1U W=2.5U AS=0.65P AD=0.65P PS=3.02U
+ PD=3.02U
M$1345 VSS \$8943 \$8944 VSS nfet_06v0 L=1U W=2.5U AS=0.65P AD=1.1P PS=3.02U
+ PD=5.88U
M$1346 \$9301 \$8924 \$8943 VSS nfet_06v0 L=1U W=2.5U AS=1.1P AD=1.1P PS=5.88U
+ PD=5.88U
M$1347 \$8946 \$8924 \$8945 VSS nfet_06v0 L=1U W=2.5U AS=1.1P AD=1.1P PS=5.88U
+ PD=5.88U
M$1348 \$8987 \$8923 VSS VSS nfet_06v0 L=1U W=5U AS=2.2P AD=1.25P PS=10.88U
+ PD=5.5U
M$1349 \$8947 \$8922 \$8987 VSS nfet_06v0 L=1U W=5U AS=1.25P AD=2.2P PS=5.5U
+ PD=10.88U
M$1350 \$8924 \$8924 \$8948 VSS nfet_06v0 L=1U W=5U AS=2.2P AD=2.2P PS=10.88U
+ PD=10.88U
M$1351 \$8986 \$8948 VSS VSS nfet_06v0 L=1U W=5U AS=2.2P AD=1.25P PS=10.88U
+ PD=5.5U
M$1352 \$8948 \$8922 \$8986 VSS nfet_06v0 L=1U W=5U AS=1.25P AD=2.2P PS=5.5U
+ PD=10.88U
M$1353 \$7202 \$7158 VSS VSS nfet_06v0 L=1U W=5U AS=2.2P AD=1.25P PS=10.88U
+ PD=5.5U
M$1354 \$7160 \$7159 \$7202 VSS nfet_06v0 L=1U W=5U AS=1.25P AD=2.2P PS=5.5U
+ PD=10.88U
M$1355 \$8968 \$8945 VSS VSS nfet_06v0 L=1U W=5U AS=2.2P AD=1.3P PS=10.88U
+ PD=5.52U
M$1356 VSS \$8945 \$8968 VSS nfet_06v0 L=1U W=5U AS=1.3P AD=1.3P PS=5.52U
+ PD=5.52U
M$1357 \$8968 \$8945 VSS VSS nfet_06v0 L=1U W=5U AS=1.3P AD=2.2P PS=5.52U
+ PD=10.88U
M$1358 \$7203 \$7158 VSS VSS nfet_06v0 L=1U W=5U AS=2.2P AD=1.25P PS=10.88U
+ PD=5.5U
M$1359 \$7160 \$7159 \$7203 VSS nfet_06v0 L=1U W=5U AS=1.25P AD=2.2P PS=5.5U
+ PD=10.88U
M$1360 \$7161 S1P \$7160 VSS nfet_06v0 L=1U W=5U AS=2.2P AD=2.2P PS=10.88U
+ PD=10.88U
M$1361 \$7162 S1N \$7160 VSS nfet_06v0 L=1U W=5U AS=2.2P AD=2.2P PS=10.88U
+ PD=10.88U
M$1362 \$7164 \$7159 \$7163 VSS nfet_06v0 L=1U W=2.5U AS=1.1P AD=1.1P PS=5.88U
+ PD=5.88U
M$1363 \$7166 \$7159 \$7165 VSS nfet_06v0 L=1U W=2.5U AS=1.1P AD=1.1P PS=5.88U
+ PD=5.88U
M$1364 \$7163 \$7164 VSS VSS nfet_06v0 L=1U W=2.5U AS=1.1P AD=1.1P PS=5.88U
+ PD=5.88U
M$1365 \$7165 \$7164 VSS VSS nfet_06v0 L=1U W=2.5U AS=1.1P AD=1.1P PS=5.88U
+ PD=5.88U
M$1366 \$7534 \$7167 \$7164 VSS nfet_06v0 L=1U W=2.5U AS=1.1P AD=1.1P PS=5.88U
+ PD=5.88U
M$1367 \$8925 \$8925 VSS VSS nfet_06v0 L=1U W=1U AS=0.44P AD=0.44P PS=2.88U
+ PD=2.88U
M$1368 \$7179 \$7167 \$7166 VSS nfet_06v0 L=1U W=2.5U AS=1.1P AD=1.1P PS=5.88U
+ PD=5.88U
M$1369 \$8982 \$8926 VSS VSS nfet_06v0 L=1U W=5U AS=2.2P AD=1.25P PS=10.88U
+ PD=5.5U
M$1370 \$8926 \$8925 \$8982 VSS nfet_06v0 L=1U W=5U AS=1.25P AD=2.2P PS=5.5U
+ PD=10.88U
M$1371 \$7198 \$7158 VSS VSS nfet_06v0 L=1U W=5U AS=2.2P AD=1.25P PS=10.88U
+ PD=5.5U
M$1372 \$7168 \$7159 \$7198 VSS nfet_06v0 L=1U W=5U AS=1.25P AD=2.2P PS=5.5U
+ PD=10.88U
M$1373 \$8963 \$9983 VSS VSS nfet_06v0 L=1U W=1U AS=0.44P AD=0.25P PS=2.88U
+ PD=1.5U
M$1374 \$9755 \$9983 \$8963 VSS nfet_06v0 L=1U W=1U AS=0.25P AD=0.44P PS=1.5U
+ PD=2.88U
M$1375 \$7167 \$7167 \$7169 VSS nfet_06v0 L=1U W=5U AS=2.2P AD=2.2P PS=10.88U
+ PD=10.88U
M$1376 \$8962 \$9983 VSS VSS nfet_06v0 L=1U W=1U AS=0.44P AD=0.25P PS=2.88U
+ PD=1.5U
M$1377 \$9983 \$9983 \$8962 VSS nfet_06v0 L=1U W=1U AS=0.25P AD=0.44P PS=1.5U
+ PD=2.88U
M$1378 \$7197 \$7169 VSS VSS nfet_06v0 L=1U W=5U AS=2.2P AD=1.25P PS=10.88U
+ PD=5.5U
M$1379 \$7169 \$7159 \$7197 VSS nfet_06v0 L=1U W=5U AS=1.25P AD=2.2P PS=5.5U
+ PD=10.88U
M$1380 \$8981 \$8926 VSS VSS nfet_06v0 L=1U W=5U AS=2.2P AD=1.25P PS=10.88U
+ PD=5.5U
M$1381 \$8949 \$8925 \$8981 VSS nfet_06v0 L=1U W=5U AS=1.25P AD=2.2P PS=5.5U
+ PD=10.88U
M$1382 \$7170 \$7166 VSS VSS nfet_06v0 L=1U W=1U AS=0.44P AD=0.44P PS=2.88U
+ PD=2.88U
M$1383 \$8980 \$8926 VSS VSS nfet_06v0 L=1U W=5U AS=2.2P AD=1.25P PS=10.88U
+ PD=5.5U
M$1384 \$8949 \$8925 \$8980 VSS nfet_06v0 L=1U W=5U AS=1.25P AD=2.2P PS=5.5U
+ PD=10.88U
M$1385 \$7159 \$7159 VSS VSS nfet_06v0 L=1U W=1U AS=0.44P AD=0.44P PS=2.88U
+ PD=2.88U
M$1386 \$7195 \$7158 VSS VSS nfet_06v0 L=1U W=5U AS=2.2P AD=1.25P PS=10.88U
+ PD=5.5U
M$1387 \$7158 \$7159 \$7195 VSS nfet_06v0 L=1U W=5U AS=1.25P AD=2.2P PS=5.5U
+ PD=10.88U
M$1388 \$8950 \$7170 \$8949 VSS nfet_06v0 L=1U W=5U AS=2.2P AD=1.3P PS=10.88U
+ PD=5.52U
M$1389 \$8949 \$7170 \$8950 VSS nfet_06v0 L=1U W=5U AS=1.3P AD=2.2P PS=5.52U
+ PD=10.88U
M$1390 \$7181 \$7225 VSS VSS nfet_06v0 L=1U W=1U AS=0.44P AD=0.25P PS=2.88U
+ PD=1.5U
M$1391 \$7224 \$7225 \$7181 VSS nfet_06v0 L=1U W=1U AS=0.25P AD=0.44P PS=1.5U
+ PD=2.88U
M$1392 \$8951 \$7157 \$8949 VSS nfet_06v0 L=1U W=5U AS=2.2P AD=1.3P PS=10.88U
+ PD=5.52U
M$1393 \$8949 \$7157 \$8951 VSS nfet_06v0 L=1U W=5U AS=1.3P AD=2.2P PS=5.52U
+ PD=10.88U
M$1394 \$7180 \$7225 VSS VSS nfet_06v0 L=1U W=1U AS=0.44P AD=0.25P PS=2.88U
+ PD=1.5U
M$1395 \$7225 \$7225 \$7180 VSS nfet_06v0 L=1U W=1U AS=0.25P AD=0.44P PS=1.5U
+ PD=2.88U
M$1396 \$8953 \$8925 \$8952 VSS nfet_06v0 L=1U W=2.5U AS=1.1P AD=0.65P PS=5.88U
+ PD=3.02U
M$1397 \$8952 \$8925 \$8953 VSS nfet_06v0 L=1U W=2.5U AS=0.65P AD=1.1P PS=3.02U
+ PD=5.88U
M$1398 \$8955 \$8925 \$8954 VSS nfet_06v0 L=1U W=2.5U AS=1.1P AD=0.65P PS=5.88U
+ PD=3.02U
M$1399 \$8954 \$8925 \$8955 VSS nfet_06v0 L=1U W=2.5U AS=0.65P AD=1.1P PS=3.02U
+ PD=5.88U
M$1400 \$8952 \$8953 VSS VSS nfet_06v0 L=1U W=2.5U AS=1.1P AD=0.65P PS=5.88U
+ PD=3.02U
M$1401 VSS \$8953 \$8952 VSS nfet_06v0 L=1U W=2.5U AS=0.65P AD=0.65P PS=3.02U
+ PD=3.02U
M$1402 \$8952 \$8953 VSS VSS nfet_06v0 L=1U W=2.5U AS=0.65P AD=0.65P PS=3.02U
+ PD=3.02U
M$1403 VSS \$8953 \$8952 VSS nfet_06v0 L=1U W=2.5U AS=0.65P AD=1.1P PS=3.02U
+ PD=5.88U
M$1404 \$8954 \$8953 VSS VSS nfet_06v0 L=1U W=2.5U AS=1.1P AD=0.65P PS=5.88U
+ PD=3.02U
M$1405 VSS \$8953 \$8954 VSS nfet_06v0 L=1U W=2.5U AS=0.65P AD=0.65P PS=3.02U
+ PD=3.02U
M$1406 \$8954 \$8953 VSS VSS nfet_06v0 L=1U W=2.5U AS=0.65P AD=0.65P PS=3.02U
+ PD=3.02U
M$1407 VSS \$8953 \$8954 VSS nfet_06v0 L=1U W=2.5U AS=0.65P AD=1.1P PS=3.02U
+ PD=5.88U
M$1408 \$9302 \$8927 \$8953 VSS nfet_06v0 L=1U W=2.5U AS=1.1P AD=1.1P PS=5.88U
+ PD=5.88U
M$1409 Z \$14236 \$7130 VSS nfet_06v0 L=1U W=2.48U AS=1.0912P AD=0.6448P
+ PS=5.84U PD=3U
M$1410 \$7130 \$14236 Z VSS nfet_06v0 L=1U W=2.48U AS=0.6448P AD=1.0912P PS=3U
+ PD=5.84U
M$1411 Z \$14243 \$7216 VSS nfet_06v0 L=1U W=2.48U AS=1.0912P AD=0.6448P
+ PS=5.84U PD=3U
M$1412 \$7216 \$14243 Z VSS nfet_06v0 L=1U W=2.48U AS=0.6448P AD=1.0912P PS=3U
+ PD=5.84U
M$1413 \$8956 \$8927 \$8955 VSS nfet_06v0 L=1U W=2.5U AS=1.1P AD=1.1P PS=5.88U
+ PD=5.88U
M$1414 \$8977 \$8926 VSS VSS nfet_06v0 L=1U W=5U AS=2.2P AD=1.25P PS=10.88U
+ PD=5.5U
M$1415 \$8957 \$8925 \$8977 VSS nfet_06v0 L=1U W=5U AS=1.25P AD=2.2P PS=5.5U
+ PD=10.88U
M$1416 Z \$7535 \$7217 VSS nfet_06v0 L=1U W=2.48U AS=1.0912P AD=0.6448P
+ PS=5.84U PD=3U
M$1417 \$7217 \$7535 Z VSS nfet_06v0 L=1U W=2.48U AS=0.6448P AD=1.0912P PS=3U
+ PD=5.84U
M$1418 \$7130 \$7172 VSS VSS nfet_06v0 L=1U W=1.24U AS=0.5456P AD=0.5456P
+ PS=3.36U PD=3.36U
M$1419 \$8927 \$8927 \$8958 VSS nfet_06v0 L=1U W=5U AS=2.2P AD=2.2P PS=10.88U
+ PD=10.88U
M$1420 \$7216 \$7172 VSS VSS nfet_06v0 L=1U W=1.24U AS=0.5456P AD=0.5456P
+ PS=3.36U PD=3.36U
M$1421 \$7217 \$7172 VSS VSS nfet_06v0 L=1U W=1.24U AS=0.5456P AD=0.5456P
+ PS=3.36U PD=3.36U
M$1422 \$8974 \$8958 VSS VSS nfet_06v0 L=1U W=5U AS=2.2P AD=1.25P PS=10.88U
+ PD=5.5U
M$1423 \$8958 \$8925 \$8974 VSS nfet_06v0 L=1U W=5U AS=1.25P AD=2.2P PS=5.5U
+ PD=10.88U
M$1424 \$7190 \$7172 VSS VSS nfet_06v0 L=1U W=0.7U AS=0.308P AD=0.175P PS=2.28U
+ PD=1.2U
M$1425 \$7189 \$7172 \$7190 VSS nfet_06v0 L=1U W=0.7U AS=0.175P AD=0.175P
+ PS=1.2U PD=1.2U
M$1426 \$7188 \$7172 \$7189 VSS nfet_06v0 L=1U W=0.7U AS=0.175P AD=0.175P
+ PS=1.2U PD=1.2U
M$1427 \$7172 \$7172 \$7188 VSS nfet_06v0 L=1U W=0.7U AS=0.175P AD=0.308P
+ PS=1.2U PD=2.28U
M$1428 Z Z \$7218 VSS nfet_06v0 L=1U W=2U AS=0.88P AD=0.52P PS=4.88U PD=2.52U
M$1429 \$7218 Z Z VSS nfet_06v0 L=1U W=2U AS=0.52P AD=0.88P PS=2.52U PD=4.88U
M$1430 \$8959 \$8955 VSS VSS nfet_06v0 L=1U W=5U AS=2.2P AD=1.3P PS=10.88U
+ PD=5.52U
M$1431 VSS \$8955 \$8959 VSS nfet_06v0 L=1U W=5U AS=1.3P AD=1.3P PS=5.52U
+ PD=5.52U
M$1432 \$8959 \$8955 VSS VSS nfet_06v0 L=1U W=5U AS=1.3P AD=2.2P PS=5.52U
+ PD=10.88U
M$1433 \$7226 Z VSS VSS nfet_06v0 L=1U W=2U AS=0.88P AD=0.5P PS=4.88U PD=2.5U
M$1434 \$7218 Z \$7226 VSS nfet_06v0 L=1U W=2U AS=0.5P AD=0.88P PS=2.5U PD=4.88U
M$1435 Z \$7227 \$7219 VSS nfet_06v0 L=1U W=2.48U AS=1.0912P AD=0.6448P
+ PS=5.84U PD=3U
M$1436 \$7219 \$7227 Z VSS nfet_06v0 L=1U W=2.48U AS=0.6448P AD=1.0912P PS=3U
+ PD=5.84U
M$1437 \$7219 \$7172 VSS VSS nfet_06v0 L=1U W=1.24U AS=0.5456P AD=0.5456P
+ PS=3.36U PD=3.36U
M$1438 \$12465 \$12465 VSS VSS nfet_06v0 L=1U W=1U AS=0.44P AD=0.44P PS=2.88U
+ PD=2.88U
M$1439 \$10749 \$10687 VSS VSS nfet_06v0 L=1U W=5U AS=2.2P AD=1.25P PS=10.88U
+ PD=5.5U
M$1440 \$10699 \$10688 \$10749 VSS nfet_06v0 L=1U W=5U AS=1.25P AD=2.2P PS=5.5U
+ PD=10.88U
M$1441 \$12519 \$12466 VSS VSS nfet_06v0 L=1U W=5U AS=2.2P AD=1.25P PS=10.88U
+ PD=5.5U
M$1442 \$12466 \$12465 \$12519 VSS nfet_06v0 L=1U W=5U AS=1.25P AD=2.2P PS=5.5U
+ PD=10.88U
M$1443 \$10750 \$10687 VSS VSS nfet_06v0 L=1U W=5U AS=2.2P AD=1.25P PS=10.88U
+ PD=5.5U
M$1444 \$10699 \$10688 \$10750 VSS nfet_06v0 L=1U W=5U AS=1.25P AD=2.2P PS=5.5U
+ PD=10.88U
M$1445 \$12507 \$13527 VSS VSS nfet_06v0 L=1U W=1U AS=0.44P AD=0.25P PS=2.88U
+ PD=1.5U
M$1446 \$13374 \$13527 \$12507 VSS nfet_06v0 L=1U W=1U AS=0.25P AD=0.44P
+ PS=1.5U PD=2.88U
M$1447 \$10700 S3P \$10699 VSS nfet_06v0 L=1U W=5U AS=2.2P AD=2.2P PS=10.88U
+ PD=10.88U
M$1448 \$12508 \$13527 VSS VSS nfet_06v0 L=1U W=1U AS=0.44P AD=0.25P PS=2.88U
+ PD=1.5U
M$1449 \$13527 \$13527 \$12508 VSS nfet_06v0 L=1U W=1U AS=0.25P AD=0.44P
+ PS=1.5U PD=2.88U
M$1450 \$10701 S3N \$10699 VSS nfet_06v0 L=1U W=5U AS=2.2P AD=2.2P PS=10.88U
+ PD=10.88U
M$1451 \$10703 \$10688 \$10702 VSS nfet_06v0 L=1U W=2.5U AS=1.1P AD=1.1P
+ PS=5.88U PD=5.88U
M$1452 \$12520 \$12466 VSS VSS nfet_06v0 L=1U W=5U AS=2.2P AD=1.25P PS=10.88U
+ PD=5.5U
M$1453 \$12474 \$12465 \$12520 VSS nfet_06v0 L=1U W=5U AS=1.25P AD=2.2P PS=5.5U
+ PD=10.88U
M$1454 \$10705 \$10688 \$10704 VSS nfet_06v0 L=1U W=2.5U AS=1.1P AD=1.1P
+ PS=5.88U PD=5.88U
M$1455 \$12521 \$12466 VSS VSS nfet_06v0 L=1U W=5U AS=2.2P AD=1.25P PS=10.88U
+ PD=5.5U
M$1456 \$12474 \$12465 \$12521 VSS nfet_06v0 L=1U W=5U AS=1.25P AD=2.2P PS=5.5U
+ PD=10.88U
M$1457 \$10702 \$10703 VSS VSS nfet_06v0 L=1U W=2.5U AS=1.1P AD=1.1P PS=5.88U
+ PD=5.88U
M$1458 \$10704 \$10703 VSS VSS nfet_06v0 L=1U W=2.5U AS=1.1P AD=1.1P PS=5.88U
+ PD=5.88U
M$1459 \$12475 \$10719 \$12474 VSS nfet_06v0 L=1U W=5U AS=2.2P AD=1.3P
+ PS=10.88U PD=5.52U
M$1460 \$12474 \$10719 \$12475 VSS nfet_06v0 L=1U W=5U AS=1.3P AD=2.2P PS=5.52U
+ PD=10.88U
M$1461 \$11081 \$10689 \$10703 VSS nfet_06v0 L=1U W=2.5U AS=1.1P AD=1.1P
+ PS=5.88U PD=5.88U
M$1462 \$12476 \$10708 \$12474 VSS nfet_06v0 L=1U W=5U AS=2.2P AD=1.3P
+ PS=10.88U PD=5.52U
M$1463 \$12474 \$10708 \$12476 VSS nfet_06v0 L=1U W=5U AS=1.3P AD=2.2P PS=5.52U
+ PD=10.88U
M$1464 \$10740 \$10689 \$10705 VSS nfet_06v0 L=1U W=2.5U AS=1.1P AD=1.1P
+ PS=5.88U PD=5.88U
M$1465 \$10751 \$10687 VSS VSS nfet_06v0 L=1U W=5U AS=2.2P AD=1.25P PS=10.88U
+ PD=5.5U
M$1466 \$10706 \$10688 \$10751 VSS nfet_06v0 L=1U W=5U AS=1.25P AD=2.2P PS=5.5U
+ PD=10.88U
M$1467 \$12478 \$12465 \$12477 VSS nfet_06v0 L=1U W=2.5U AS=1.1P AD=0.65P
+ PS=5.88U PD=3.02U
M$1468 \$12477 \$12465 \$12478 VSS nfet_06v0 L=1U W=2.5U AS=0.65P AD=1.1P
+ PS=3.02U PD=5.88U
M$1469 \$10689 \$10689 \$10707 VSS nfet_06v0 L=1U W=5U AS=2.2P AD=2.2P
+ PS=10.88U PD=10.88U
M$1470 \$12480 \$12465 \$12479 VSS nfet_06v0 L=1U W=2.5U AS=1.1P AD=0.65P
+ PS=5.88U PD=3.02U
M$1471 \$12479 \$12465 \$12480 VSS nfet_06v0 L=1U W=2.5U AS=0.65P AD=1.1P
+ PS=3.02U PD=5.88U
M$1472 \$10752 \$10707 VSS VSS nfet_06v0 L=1U W=5U AS=2.2P AD=1.25P PS=10.88U
+ PD=5.5U
M$1473 \$10707 \$10688 \$10752 VSS nfet_06v0 L=1U W=5U AS=1.25P AD=2.2P PS=5.5U
+ PD=10.88U
M$1474 \$12477 \$12478 VSS VSS nfet_06v0 L=1U W=2.5U AS=1.1P AD=0.65P PS=5.88U
+ PD=3.02U
M$1475 VSS \$12478 \$12477 VSS nfet_06v0 L=1U W=2.5U AS=0.65P AD=0.65P PS=3.02U
+ PD=3.02U
M$1476 \$12477 \$12478 VSS VSS nfet_06v0 L=1U W=2.5U AS=0.65P AD=0.65P PS=3.02U
+ PD=3.02U
M$1477 VSS \$12478 \$12477 VSS nfet_06v0 L=1U W=2.5U AS=0.65P AD=1.1P PS=3.02U
+ PD=5.88U
M$1478 \$10708 \$10705 VSS VSS nfet_06v0 L=1U W=1U AS=0.44P AD=0.44P PS=2.88U
+ PD=2.88U
M$1479 \$10688 \$10688 VSS VSS nfet_06v0 L=1U W=1U AS=0.44P AD=0.44P PS=2.88U
+ PD=2.88U
M$1480 \$12479 \$12478 VSS VSS nfet_06v0 L=1U W=2.5U AS=1.1P AD=0.65P PS=5.88U
+ PD=3.02U
M$1481 VSS \$12478 \$12479 VSS nfet_06v0 L=1U W=2.5U AS=0.65P AD=0.65P PS=3.02U
+ PD=3.02U
M$1482 \$12479 \$12478 VSS VSS nfet_06v0 L=1U W=2.5U AS=0.65P AD=0.65P PS=3.02U
+ PD=3.02U
M$1483 VSS \$12478 \$12479 VSS nfet_06v0 L=1U W=2.5U AS=0.65P AD=1.1P PS=3.02U
+ PD=5.88U
M$1484 \$10753 \$10687 VSS VSS nfet_06v0 L=1U W=5U AS=2.2P AD=1.25P PS=10.88U
+ PD=5.5U
M$1485 \$10687 \$10688 \$10753 VSS nfet_06v0 L=1U W=5U AS=1.25P AD=2.2P PS=5.5U
+ PD=10.88U
M$1486 \$10736 \$10765 VSS VSS nfet_06v0 L=1U W=1U AS=0.44P AD=0.25P PS=2.88U
+ PD=1.5U
M$1487 \$10774 \$10765 \$10736 VSS nfet_06v0 L=1U W=1U AS=0.25P AD=0.44P
+ PS=1.5U PD=2.88U
M$1488 \$12771 \$12467 \$12478 VSS nfet_06v0 L=1U W=2.5U AS=1.1P AD=1.1P
+ PS=5.88U PD=5.88U
M$1489 \$10737 \$10765 VSS VSS nfet_06v0 L=1U W=1U AS=0.44P AD=0.25P PS=2.88U
+ PD=1.5U
M$1490 \$10765 \$10765 \$10737 VSS nfet_06v0 L=1U W=1U AS=0.25P AD=0.44P
+ PS=1.5U PD=2.88U
M$1491 \$12481 \$12467 \$12480 VSS nfet_06v0 L=1U W=2.5U AS=1.1P AD=1.1P
+ PS=5.88U PD=5.88U
M$1492 \$12523 \$12466 VSS VSS nfet_06v0 L=1U W=5U AS=2.2P AD=1.25P PS=10.88U
+ PD=5.5U
M$1493 \$12482 \$12465 \$12523 VSS nfet_06v0 L=1U W=5U AS=1.25P AD=2.2P PS=5.5U
+ PD=10.88U
M$1494 \$12467 \$12467 \$12483 VSS nfet_06v0 L=1U W=5U AS=2.2P AD=2.2P
+ PS=10.88U PD=10.88U
M$1495 \$12524 \$12483 VSS VSS nfet_06v0 L=1U W=5U AS=2.2P AD=1.25P PS=10.88U
+ PD=5.5U
M$1496 \$12483 \$12465 \$12524 VSS nfet_06v0 L=1U W=5U AS=1.25P AD=2.2P PS=5.5U
+ PD=10.88U
M$1497 \$12484 \$12480 VSS VSS nfet_06v0 L=1U W=5U AS=2.2P AD=1.3P PS=10.88U
+ PD=5.52U
M$1498 VSS \$12480 \$12484 VSS nfet_06v0 L=1U W=5U AS=1.3P AD=1.3P PS=5.52U
+ PD=5.52U
M$1499 \$12484 \$12480 VSS VSS nfet_06v0 L=1U W=5U AS=1.3P AD=2.2P PS=5.52U
+ PD=10.88U
M$1500 \$10754 \$10690 VSS VSS nfet_06v0 L=1U W=5U AS=2.2P AD=1.25P PS=10.88U
+ PD=5.5U
M$1501 \$10710 \$10691 \$10754 VSS nfet_06v0 L=1U W=5U AS=1.25P AD=2.2P PS=5.5U
+ PD=10.88U
M$1502 \$10755 \$10690 VSS VSS nfet_06v0 L=1U W=5U AS=2.2P AD=1.25P PS=10.88U
+ PD=5.5U
M$1503 \$10710 \$10691 \$10755 VSS nfet_06v0 L=1U W=5U AS=1.25P AD=2.2P PS=5.5U
+ PD=10.88U
M$1504 \$10711 S4P \$10710 VSS nfet_06v0 L=1U W=5U AS=2.2P AD=2.2P PS=10.88U
+ PD=10.88U
M$1505 \$10712 S4N \$10710 VSS nfet_06v0 L=1U W=5U AS=2.2P AD=2.2P PS=10.88U
+ PD=10.88U
M$1506 \$12468 \$12468 VSS VSS nfet_06v0 L=1U W=1U AS=0.44P AD=0.44P PS=2.88U
+ PD=2.88U
M$1507 \$10714 \$10691 \$10713 VSS nfet_06v0 L=1U W=2.5U AS=1.1P AD=1.1P
+ PS=5.88U PD=5.88U
M$1508 \$12526 \$12469 VSS VSS nfet_06v0 L=1U W=5U AS=2.2P AD=1.25P PS=10.88U
+ PD=5.5U
M$1509 \$12469 \$12468 \$12526 VSS nfet_06v0 L=1U W=5U AS=1.25P AD=2.2P PS=5.5U
+ PD=10.88U
M$1510 \$10716 \$10691 \$10715 VSS nfet_06v0 L=1U W=2.5U AS=1.1P AD=1.1P
+ PS=5.88U PD=5.88U
M$1511 \$10713 \$10714 VSS VSS nfet_06v0 L=1U W=2.5U AS=1.1P AD=1.1P PS=5.88U
+ PD=5.88U
M$1512 \$12511 \$13528 VSS VSS nfet_06v0 L=1U W=1U AS=0.44P AD=0.25P PS=2.88U
+ PD=1.5U
M$1513 \$13375 \$13528 \$12511 VSS nfet_06v0 L=1U W=1U AS=0.25P AD=0.44P
+ PS=1.5U PD=2.88U
M$1514 \$10715 \$10714 VSS VSS nfet_06v0 L=1U W=2.5U AS=1.1P AD=1.1P PS=5.88U
+ PD=5.88U
M$1515 \$12512 \$13528 VSS VSS nfet_06v0 L=1U W=1U AS=0.44P AD=0.25P PS=2.88U
+ PD=1.5U
M$1516 \$13528 \$13528 \$12512 VSS nfet_06v0 L=1U W=1U AS=0.25P AD=0.44P
+ PS=1.5U PD=2.88U
M$1517 \$11082 \$10692 \$10714 VSS nfet_06v0 L=1U W=2.5U AS=1.1P AD=1.1P
+ PS=5.88U PD=5.88U
M$1518 \$12528 \$12469 VSS VSS nfet_06v0 L=1U W=5U AS=2.2P AD=1.25P PS=10.88U
+ PD=5.5U
M$1519 \$12485 \$12468 \$12528 VSS nfet_06v0 L=1U W=5U AS=1.25P AD=2.2P PS=5.5U
+ PD=10.88U
M$1520 \$10741 \$10692 \$10716 VSS nfet_06v0 L=1U W=2.5U AS=1.1P AD=1.1P
+ PS=5.88U PD=5.88U
M$1521 \$10756 \$10690 VSS VSS nfet_06v0 L=1U W=5U AS=2.2P AD=1.25P PS=10.88U
+ PD=5.5U
M$1522 \$10717 \$10691 \$10756 VSS nfet_06v0 L=1U W=5U AS=1.25P AD=2.2P PS=5.5U
+ PD=10.88U
M$1523 \$12529 \$12469 VSS VSS nfet_06v0 L=1U W=5U AS=2.2P AD=1.25P PS=10.88U
+ PD=5.5U
M$1524 \$12485 \$12468 \$12529 VSS nfet_06v0 L=1U W=5U AS=1.25P AD=2.2P PS=5.5U
+ PD=10.88U
M$1525 \$10692 \$10692 \$10718 VSS nfet_06v0 L=1U W=5U AS=2.2P AD=2.2P
+ PS=10.88U PD=10.88U
M$1526 \$12486 \$10730 \$12485 VSS nfet_06v0 L=1U W=5U AS=2.2P AD=1.3P
+ PS=10.88U PD=5.52U
M$1527 \$12485 \$10730 \$12486 VSS nfet_06v0 L=1U W=5U AS=1.3P AD=2.2P PS=5.52U
+ PD=10.88U
M$1528 \$10757 \$10718 VSS VSS nfet_06v0 L=1U W=5U AS=2.2P AD=1.25P PS=10.88U
+ PD=5.5U
M$1529 \$10718 \$10691 \$10757 VSS nfet_06v0 L=1U W=5U AS=1.25P AD=2.2P PS=5.5U
+ PD=10.88U
M$1530 \$12487 \$10708 \$12485 VSS nfet_06v0 L=1U W=5U AS=2.2P AD=1.3P
+ PS=10.88U PD=5.52U
M$1531 \$12485 \$10708 \$12487 VSS nfet_06v0 L=1U W=5U AS=1.3P AD=2.2P PS=5.52U
+ PD=10.88U
M$1532 \$10719 \$10716 VSS VSS nfet_06v0 L=1U W=1U AS=0.44P AD=0.44P PS=2.88U
+ PD=2.88U
M$1533 \$12489 \$12468 \$12488 VSS nfet_06v0 L=1U W=2.5U AS=1.1P AD=0.65P
+ PS=5.88U PD=3.02U
M$1534 \$12488 \$12468 \$12489 VSS nfet_06v0 L=1U W=2.5U AS=0.65P AD=1.1P
+ PS=3.02U PD=5.88U
M$1535 \$10691 \$10691 VSS VSS nfet_06v0 L=1U W=1U AS=0.44P AD=0.44P PS=2.88U
+ PD=2.88U
M$1536 \$10758 \$10690 VSS VSS nfet_06v0 L=1U W=5U AS=2.2P AD=1.25P PS=10.88U
+ PD=5.5U
M$1537 \$10690 \$10691 \$10758 VSS nfet_06v0 L=1U W=5U AS=1.25P AD=2.2P PS=5.5U
+ PD=10.88U
M$1538 \$12491 \$12468 \$12490 VSS nfet_06v0 L=1U W=2.5U AS=1.1P AD=0.65P
+ PS=5.88U PD=3.02U
M$1539 \$12490 \$12468 \$12491 VSS nfet_06v0 L=1U W=2.5U AS=0.65P AD=1.1P
+ PS=3.02U PD=5.88U
M$1540 \$10739 \$10768 VSS VSS nfet_06v0 L=1U W=1U AS=0.44P AD=0.25P PS=2.88U
+ PD=1.5U
M$1541 \$10775 \$10768 \$10739 VSS nfet_06v0 L=1U W=1U AS=0.25P AD=0.44P
+ PS=1.5U PD=2.88U
M$1542 \$12488 \$12489 VSS VSS nfet_06v0 L=1U W=2.5U AS=1.1P AD=0.65P PS=5.88U
+ PD=3.02U
M$1543 VSS \$12489 \$12488 VSS nfet_06v0 L=1U W=2.5U AS=0.65P AD=0.65P PS=3.02U
+ PD=3.02U
M$1544 \$12488 \$12489 VSS VSS nfet_06v0 L=1U W=2.5U AS=0.65P AD=0.65P PS=3.02U
+ PD=3.02U
M$1545 VSS \$12489 \$12488 VSS nfet_06v0 L=1U W=2.5U AS=0.65P AD=1.1P PS=3.02U
+ PD=5.88U
M$1546 \$10738 \$10768 VSS VSS nfet_06v0 L=1U W=1U AS=0.44P AD=0.25P PS=2.88U
+ PD=1.5U
M$1547 \$10768 \$10768 \$10738 VSS nfet_06v0 L=1U W=1U AS=0.25P AD=0.44P
+ PS=1.5U PD=2.88U
M$1548 \$12490 \$12489 VSS VSS nfet_06v0 L=1U W=2.5U AS=1.1P AD=0.65P PS=5.88U
+ PD=3.02U
M$1549 VSS \$12489 \$12490 VSS nfet_06v0 L=1U W=2.5U AS=0.65P AD=0.65P PS=3.02U
+ PD=3.02U
M$1550 \$12490 \$12489 VSS VSS nfet_06v0 L=1U W=2.5U AS=0.65P AD=0.65P PS=3.02U
+ PD=3.02U
M$1551 VSS \$12489 \$12490 VSS nfet_06v0 L=1U W=2.5U AS=0.65P AD=1.1P PS=3.02U
+ PD=5.88U
M$1552 \$12772 \$12470 \$12489 VSS nfet_06v0 L=1U W=2.5U AS=1.1P AD=1.1P
+ PS=5.88U PD=5.88U
M$1553 \$12492 \$12470 \$12491 VSS nfet_06v0 L=1U W=2.5U AS=1.1P AD=1.1P
+ PS=5.88U PD=5.88U
M$1554 \$12532 \$12469 VSS VSS nfet_06v0 L=1U W=5U AS=2.2P AD=1.25P PS=10.88U
+ PD=5.5U
M$1555 \$12493 \$12468 \$12532 VSS nfet_06v0 L=1U W=5U AS=1.25P AD=2.2P PS=5.5U
+ PD=10.88U
M$1556 \$12470 \$12470 \$12494 VSS nfet_06v0 L=1U W=5U AS=2.2P AD=2.2P
+ PS=10.88U PD=10.88U
M$1557 \$12533 \$12494 VSS VSS nfet_06v0 L=1U W=5U AS=2.2P AD=1.25P PS=10.88U
+ PD=5.5U
M$1558 \$12494 \$12468 \$12533 VSS nfet_06v0 L=1U W=5U AS=1.25P AD=2.2P PS=5.5U
+ PD=10.88U
M$1559 \$10760 \$10693 VSS VSS nfet_06v0 L=1U W=5U AS=2.2P AD=1.25P PS=10.88U
+ PD=5.5U
M$1560 \$10721 \$10694 \$10760 VSS nfet_06v0 L=1U W=5U AS=1.25P AD=2.2P PS=5.5U
+ PD=10.88U
M$1561 \$12495 \$12491 VSS VSS nfet_06v0 L=1U W=5U AS=2.2P AD=1.3P PS=10.88U
+ PD=5.52U
M$1562 VSS \$12491 \$12495 VSS nfet_06v0 L=1U W=5U AS=1.3P AD=1.3P PS=5.52U
+ PD=5.52U
M$1563 \$12495 \$12491 VSS VSS nfet_06v0 L=1U W=5U AS=1.3P AD=2.2P PS=5.52U
+ PD=10.88U
M$1564 \$10762 \$10693 VSS VSS nfet_06v0 L=1U W=5U AS=2.2P AD=1.25P PS=10.88U
+ PD=5.5U
M$1565 \$10721 \$10694 \$10762 VSS nfet_06v0 L=1U W=5U AS=1.25P AD=2.2P PS=5.5U
+ PD=10.88U
M$1566 \$10722 S2P \$10721 VSS nfet_06v0 L=1U W=5U AS=2.2P AD=2.2P PS=10.88U
+ PD=10.88U
M$1567 \$10723 S2N \$10721 VSS nfet_06v0 L=1U W=5U AS=2.2P AD=2.2P PS=10.88U
+ PD=10.88U
M$1568 \$10725 \$10694 \$10724 VSS nfet_06v0 L=1U W=2.5U AS=1.1P AD=1.1P
+ PS=5.88U PD=5.88U
M$1569 \$10727 \$10694 \$10726 VSS nfet_06v0 L=1U W=2.5U AS=1.1P AD=1.1P
+ PS=5.88U PD=5.88U
M$1570 \$10724 \$10725 VSS VSS nfet_06v0 L=1U W=2.5U AS=1.1P AD=1.1P PS=5.88U
+ PD=5.88U
M$1571 \$10726 \$10725 VSS VSS nfet_06v0 L=1U W=2.5U AS=1.1P AD=1.1P PS=5.88U
+ PD=5.88U
M$1572 \$11083 \$10695 \$10725 VSS nfet_06v0 L=1U W=2.5U AS=1.1P AD=1.1P
+ PS=5.88U PD=5.88U
M$1573 \$12471 \$12471 VSS VSS nfet_06v0 L=1U W=1U AS=0.44P AD=0.44P PS=2.88U
+ PD=2.88U
M$1574 \$10742 \$10695 \$10727 VSS nfet_06v0 L=1U W=2.5U AS=1.1P AD=1.1P
+ PS=5.88U PD=5.88U
M$1575 \$12531 \$12472 VSS VSS nfet_06v0 L=1U W=5U AS=2.2P AD=1.25P PS=10.88U
+ PD=5.5U
M$1576 \$12472 \$12471 \$12531 VSS nfet_06v0 L=1U W=5U AS=1.25P AD=2.2P PS=5.5U
+ PD=10.88U
M$1577 \$10763 \$10693 VSS VSS nfet_06v0 L=1U W=5U AS=2.2P AD=1.25P PS=10.88U
+ PD=5.5U
M$1578 \$10728 \$10694 \$10763 VSS nfet_06v0 L=1U W=5U AS=1.25P AD=2.2P PS=5.5U
+ PD=10.88U
M$1579 \$12510 \$13529 VSS VSS nfet_06v0 L=1U W=1U AS=0.44P AD=0.25P PS=2.88U
+ PD=1.5U
M$1580 \$13376 \$13529 \$12510 VSS nfet_06v0 L=1U W=1U AS=0.25P AD=0.44P
+ PS=1.5U PD=2.88U
M$1581 \$10695 \$10695 \$10729 VSS nfet_06v0 L=1U W=5U AS=2.2P AD=2.2P
+ PS=10.88U PD=10.88U
M$1582 \$12509 \$13529 VSS VSS nfet_06v0 L=1U W=1U AS=0.44P AD=0.25P PS=2.88U
+ PD=1.5U
M$1583 \$13529 \$13529 \$12509 VSS nfet_06v0 L=1U W=1U AS=0.25P AD=0.44P
+ PS=1.5U PD=2.88U
M$1584 \$10761 \$10729 VSS VSS nfet_06v0 L=1U W=5U AS=2.2P AD=1.25P PS=10.88U
+ PD=5.5U
M$1585 \$10729 \$10694 \$10761 VSS nfet_06v0 L=1U W=5U AS=1.25P AD=2.2P PS=5.5U
+ PD=10.88U
M$1586 \$12530 \$12472 VSS VSS nfet_06v0 L=1U W=5U AS=2.2P AD=1.25P PS=10.88U
+ PD=5.5U
M$1587 \$12496 \$12471 \$12530 VSS nfet_06v0 L=1U W=5U AS=1.25P AD=2.2P PS=5.5U
+ PD=10.88U
M$1588 \$10730 \$10727 VSS VSS nfet_06v0 L=1U W=1U AS=0.44P AD=0.44P PS=2.88U
+ PD=2.88U
M$1589 \$12527 \$12472 VSS VSS nfet_06v0 L=1U W=5U AS=2.2P AD=1.25P PS=10.88U
+ PD=5.5U
M$1590 \$12496 \$12471 \$12527 VSS nfet_06v0 L=1U W=5U AS=1.25P AD=2.2P PS=5.5U
+ PD=10.88U
M$1591 \$10694 \$10694 VSS VSS nfet_06v0 L=1U W=1U AS=0.44P AD=0.44P PS=2.88U
+ PD=2.88U
M$1592 \$10759 \$10693 VSS VSS nfet_06v0 L=1U W=5U AS=2.2P AD=1.25P PS=10.88U
+ PD=5.5U
M$1593 \$10693 \$10694 \$10759 VSS nfet_06v0 L=1U W=5U AS=1.25P AD=2.2P PS=5.5U
+ PD=10.88U
M$1594 \$12497 \$10730 \$12496 VSS nfet_06v0 L=1U W=5U AS=2.2P AD=1.3P
+ PS=10.88U PD=5.52U
M$1595 \$12496 \$10730 \$12497 VSS nfet_06v0 L=1U W=5U AS=1.3P AD=2.2P PS=5.52U
+ PD=10.88U
M$1596 \$10735 \$10771 VSS VSS nfet_06v0 L=1U W=1U AS=0.44P AD=0.25P PS=2.88U
+ PD=1.5U
M$1597 \$10776 \$10771 \$10735 VSS nfet_06v0 L=1U W=1U AS=0.25P AD=0.44P
+ PS=1.5U PD=2.88U
M$1598 \$12498 \$10719 \$12496 VSS nfet_06v0 L=1U W=5U AS=2.2P AD=1.3P
+ PS=10.88U PD=5.52U
M$1599 \$12496 \$10719 \$12498 VSS nfet_06v0 L=1U W=5U AS=1.3P AD=2.2P PS=5.52U
+ PD=10.88U
M$1600 \$10734 \$10771 VSS VSS nfet_06v0 L=1U W=1U AS=0.44P AD=0.25P PS=2.88U
+ PD=1.5U
M$1601 \$10771 \$10771 \$10734 VSS nfet_06v0 L=1U W=1U AS=0.25P AD=0.44P
+ PS=1.5U PD=2.88U
M$1602 \$12500 \$12471 \$12499 VSS nfet_06v0 L=1U W=2.5U AS=1.1P AD=0.65P
+ PS=5.88U PD=3.02U
M$1603 \$12499 \$12471 \$12500 VSS nfet_06v0 L=1U W=2.5U AS=0.65P AD=1.1P
+ PS=3.02U PD=5.88U
M$1604 \$12502 \$12471 \$12501 VSS nfet_06v0 L=1U W=2.5U AS=1.1P AD=0.65P
+ PS=5.88U PD=3.02U
M$1605 \$12501 \$12471 \$12502 VSS nfet_06v0 L=1U W=2.5U AS=0.65P AD=1.1P
+ PS=3.02U PD=5.88U
M$1606 \$12499 \$12500 VSS VSS nfet_06v0 L=1U W=2.5U AS=1.1P AD=0.65P PS=5.88U
+ PD=3.02U
M$1607 VSS \$12500 \$12499 VSS nfet_06v0 L=1U W=2.5U AS=0.65P AD=0.65P PS=3.02U
+ PD=3.02U
M$1608 \$12499 \$12500 VSS VSS nfet_06v0 L=1U W=2.5U AS=0.65P AD=0.65P PS=3.02U
+ PD=3.02U
M$1609 VSS \$12500 \$12499 VSS nfet_06v0 L=1U W=2.5U AS=0.65P AD=1.1P PS=3.02U
+ PD=5.88U
M$1610 \$12501 \$12500 VSS VSS nfet_06v0 L=1U W=2.5U AS=1.1P AD=0.65P PS=5.88U
+ PD=3.02U
M$1611 VSS \$12500 \$12501 VSS nfet_06v0 L=1U W=2.5U AS=0.65P AD=0.65P PS=3.02U
+ PD=3.02U
M$1612 \$12501 \$12500 VSS VSS nfet_06v0 L=1U W=2.5U AS=0.65P AD=0.65P PS=3.02U
+ PD=3.02U
M$1613 VSS \$12500 \$12501 VSS nfet_06v0 L=1U W=2.5U AS=0.65P AD=1.1P PS=3.02U
+ PD=5.88U
M$1614 \$12773 \$12473 \$12500 VSS nfet_06v0 L=1U W=2.5U AS=1.1P AD=1.1P
+ PS=5.88U PD=5.88U
M$1615 VSS \$1844 \$7227 VSS nfet_06v0 L=1U W=1U AS=0.44P AD=0.44P PS=2.88U
+ PD=2.88U
M$1616 \$12503 \$12473 \$12502 VSS nfet_06v0 L=1U W=2.5U AS=1.1P AD=1.1P
+ PS=5.88U PD=5.88U
M$1617 VSS \$1833 \$7227 VSS nfet_06v0 L=1U W=1U AS=0.44P AD=0.44P PS=2.88U
+ PD=2.88U
M$1618 \$12525 \$12472 VSS VSS nfet_06v0 L=1U W=5U AS=2.2P AD=1.25P PS=10.88U
+ PD=5.5U
M$1619 \$12504 \$12471 \$12525 VSS nfet_06v0 L=1U W=5U AS=1.25P AD=2.2P PS=5.5U
+ PD=10.88U
M$1620 VSS \$1822 \$10696 VSS nfet_06v0 L=1U W=1U AS=0.44P AD=0.44P PS=2.88U
+ PD=2.88U
M$1621 \$12473 \$12473 \$12505 VSS nfet_06v0 L=1U W=5U AS=2.2P AD=2.2P
+ PS=10.88U PD=10.88U
M$1622 VSS \$10697 \$3654 VSS nfet_06v0 L=1U W=1U AS=0.44P AD=0.44P PS=2.88U
+ PD=2.88U
M$1623 \$12522 \$12505 VSS VSS nfet_06v0 L=1U W=5U AS=2.2P AD=1.25P PS=10.88U
+ PD=5.5U
M$1624 \$12505 \$12471 \$12522 VSS nfet_06v0 L=1U W=5U AS=1.25P AD=2.2P PS=5.5U
+ PD=10.88U
M$1625 \$10733 \$10696 \$10697 VSS nfet_06v0 L=1U W=1U AS=0.44P AD=0.25P
+ PS=2.88U PD=1.5U
M$1626 VSS \$1844 \$10733 VSS nfet_06v0 L=1U W=1U AS=0.25P AD=0.44P PS=1.5U
+ PD=2.88U
M$1627 \$12506 \$12502 VSS VSS nfet_06v0 L=1U W=5U AS=2.2P AD=1.3P PS=10.88U
+ PD=5.52U
M$1628 VSS \$12502 \$12506 VSS nfet_06v0 L=1U W=5U AS=1.3P AD=1.3P PS=5.52U
+ PD=5.52U
M$1629 \$12506 \$12502 VSS VSS nfet_06v0 L=1U W=5U AS=1.3P AD=2.2P PS=5.52U
+ PD=10.88U
M$1630 VSS \$10698 \$99 VSS nfet_06v0 L=1U W=1U AS=0.44P AD=0.44P PS=2.88U
+ PD=2.88U
M$1631 \$10732 \$1833 \$10698 VSS nfet_06v0 L=1U W=1U AS=0.44P AD=0.25P
+ PS=2.88U PD=1.5U
M$1632 VSS \$1822 \$10732 VSS nfet_06v0 L=1U W=1U AS=0.25P AD=0.44P PS=1.5U
+ PD=2.88U
M$1633 VSS \$5403 \$7535 VSS nfet_06v0 L=1U W=1U AS=0.44P AD=0.44P PS=2.88U
+ PD=2.88U
M$1634 VSS \$5394 \$7535 VSS nfet_06v0 L=1U W=1U AS=0.44P AD=0.44P PS=2.88U
+ PD=2.88U
M$1635 VSS \$5385 \$14233 VSS nfet_06v0 L=1U W=1U AS=0.44P AD=0.44P PS=2.88U
+ PD=2.88U
M$1636 VSS \$14234 \$3653 VSS nfet_06v0 L=1U W=1U AS=0.44P AD=0.44P PS=2.88U
+ PD=2.88U
M$1637 \$14245 \$14233 \$14234 VSS nfet_06v0 L=1U W=1U AS=0.44P AD=0.25P
+ PS=2.88U PD=1.5U
M$1638 VSS \$5403 \$14245 VSS nfet_06v0 L=1U W=1U AS=0.25P AD=0.44P PS=1.5U
+ PD=2.88U
M$1639 VSS \$14235 \$419 VSS nfet_06v0 L=1U W=1U AS=0.44P AD=0.44P PS=2.88U
+ PD=2.88U
M$1640 \$14246 \$5394 \$14235 VSS nfet_06v0 L=1U W=1U AS=0.44P AD=0.25P
+ PS=2.88U PD=1.5U
M$1641 VSS \$5385 \$14246 VSS nfet_06v0 L=1U W=1U AS=0.25P AD=0.44P PS=1.5U
+ PD=2.88U
M$1642 VSS \$8959 \$14236 VSS nfet_06v0 L=1U W=1U AS=0.44P AD=0.44P PS=2.88U
+ PD=2.88U
M$1643 VSS \$8968 \$14236 VSS nfet_06v0 L=1U W=1U AS=0.44P AD=0.44P PS=2.88U
+ PD=2.88U
M$1644 VSS \$8938 \$14237 VSS nfet_06v0 L=1U W=1U AS=0.44P AD=0.44P PS=2.88U
+ PD=2.88U
M$1645 VSS \$14238 \$3580 VSS nfet_06v0 L=1U W=1U AS=0.44P AD=0.44P PS=2.88U
+ PD=2.88U
M$1646 \$14248 \$14237 \$14238 VSS nfet_06v0 L=1U W=1U AS=0.44P AD=0.25P
+ PS=2.88U PD=1.5U
M$1647 VSS \$8959 \$14248 VSS nfet_06v0 L=1U W=1U AS=0.25P AD=0.44P PS=1.5U
+ PD=2.88U
M$1648 VSS \$14239 \$19 VSS nfet_06v0 L=1U W=1U AS=0.44P AD=0.44P PS=2.88U
+ PD=2.88U
M$1649 \$14249 \$8968 \$14239 VSS nfet_06v0 L=1U W=1U AS=0.44P AD=0.25P
+ PS=2.88U PD=1.5U
M$1650 VSS \$8938 \$14249 VSS nfet_06v0 L=1U W=1U AS=0.25P AD=0.44P PS=1.5U
+ PD=2.88U
M$1651 VSS \$12506 \$14243 VSS nfet_06v0 L=1U W=1U AS=0.44P AD=0.44P PS=2.88U
+ PD=2.88U
M$1652 VSS \$12495 \$14243 VSS nfet_06v0 L=1U W=1U AS=0.44P AD=0.44P PS=2.88U
+ PD=2.88U
M$1653 VSS \$12484 \$14240 VSS nfet_06v0 L=1U W=1U AS=0.44P AD=0.44P PS=2.88U
+ PD=2.88U
M$1654 VSS \$14241 \$3652 VSS nfet_06v0 L=1U W=1U AS=0.44P AD=0.44P PS=2.88U
+ PD=2.88U
M$1655 \$14247 \$14240 \$14241 VSS nfet_06v0 L=1U W=1U AS=0.44P AD=0.25P
+ PS=2.88U PD=1.5U
M$1656 VSS \$12506 \$14247 VSS nfet_06v0 L=1U W=1U AS=0.25P AD=0.44P PS=1.5U
+ PD=2.88U
M$1657 VSS \$14242 \$95 VSS nfet_06v0 L=1U W=1U AS=0.44P AD=0.44P PS=2.88U
+ PD=2.88U
M$1658 \$14244 \$12495 \$14242 VSS nfet_06v0 L=1U W=1U AS=0.44P AD=0.25P
+ PS=2.88U PD=1.5U
M$1659 VSS \$12484 \$14244 VSS nfet_06v0 L=1U W=1U AS=0.25P AD=0.44P PS=1.5U
+ PD=2.88U
C$1660 \$12506 \$12501 4e-13 cap_mim_2f0fF A=200P P=60U
C$1661 \$7157 \$7152 4e-13 cap_mim_2f0fF A=200P P=60U
C$1662 \$10719 \$10715 4e-13 cap_mim_2f0fF A=200P P=60U
C$1663 \$1833 \$1828 4e-13 cap_mim_2f0fF A=200P P=60U
C$1664 \$10708 \$10704 4e-13 cap_mim_2f0fF A=200P P=60U
C$1665 \$12495 \$12490 4e-13 cap_mim_2f0fF A=200P P=60U
C$1666 \$8968 \$8944 4e-13 cap_mim_2f0fF A=200P P=60U
C$1667 \$12475 \$12484 4e-13 cap_mim_2f0fF A=200P P=60U
C$1668 \$52 \$48 4e-13 cap_mim_2f0fF A=200P P=60U
C$1669 \$12484 \$12479 4e-13 cap_mim_2f0fF A=200P P=60U
C$1670 \$8938 \$8933 4e-13 cap_mim_2f0fF A=200P P=60U
C$1671 \$44 \$52 4e-13 cap_mim_2f0fF A=200P P=60U
C$1672 \$10722 \$10730 4e-13 cap_mim_2f0fF A=200P P=60U
C$1673 \$8950 \$8959 4e-13 cap_mim_2f0fF A=200P P=60U
C$1674 \$7144 \$7139 4e-13 cap_mim_2f0fF A=200P P=60U
C$1675 \$1835 \$1844 4e-13 cap_mim_2f0fF A=200P P=60U
C$1676 \$7161 \$7170 4e-13 cap_mim_2f0fF A=200P P=60U
C$1677 \$7148 \$7157 4e-13 cap_mim_2f0fF A=200P P=60U
C$1678 \$5403 \$5375 4e-13 cap_mim_2f0fF A=200P P=60U
C$1679 \$5387 \$5394 4e-13 cap_mim_2f0fF A=200P P=60U
C$1680 \$1824 \$1833 4e-13 cap_mim_2f0fF A=200P P=60U
C$1681 \$12486 \$12495 4e-13 cap_mim_2f0fF A=200P P=60U
C$1682 \$8940 \$8968 4e-13 cap_mim_2f0fF A=200P P=60U
C$1683 \$1813 \$1822 4e-13 cap_mim_2f0fF A=200P P=60U
C$1684 \$12497 \$12506 4e-13 cap_mim_2f0fF A=200P P=60U
C$1685 \$7135 \$7144 4e-13 cap_mim_2f0fF A=200P P=60U
C$1686 \$3586 \$3594 4e-13 cap_mim_2f0fF A=200P P=60U
C$1687 \$1844 \$1839 4e-13 cap_mim_2f0fF A=200P P=60U
C$1688 \$41 \$37 4e-13 cap_mim_2f0fF A=200P P=60U
C$1689 \$7170 \$7165 4e-13 cap_mim_2f0fF A=200P P=60U
C$1690 \$5396 \$5403 4e-13 cap_mim_2f0fF A=200P P=60U
C$1691 \$30 \$26 4e-13 cap_mim_2f0fF A=200P P=60U
C$1692 \$22 \$30 4e-13 cap_mim_2f0fF A=200P P=60U
C$1693 \$3605 \$3601 4e-13 cap_mim_2f0fF A=200P P=60U
C$1694 \$1822 \$1817 4e-13 cap_mim_2f0fF A=200P P=60U
C$1695 \$5378 \$5385 4e-13 cap_mim_2f0fF A=200P P=60U
C$1696 \$8959 \$8954 4e-13 cap_mim_2f0fF A=200P P=60U
C$1697 \$3597 \$3605 4e-13 cap_mim_2f0fF A=200P P=60U
C$1698 \$10711 \$10719 4e-13 cap_mim_2f0fF A=200P P=60U
C$1699 \$5385 \$5365 4e-13 cap_mim_2f0fF A=200P P=60U
C$1700 \$10700 \$10708 4e-13 cap_mim_2f0fF A=200P P=60U
C$1701 \$10730 \$10726 4e-13 cap_mim_2f0fF A=200P P=60U
C$1702 \$3616 \$3612 4e-13 cap_mim_2f0fF A=200P P=60U
C$1703 \$8929 \$8938 4e-13 cap_mim_2f0fF A=200P P=60U
C$1704 \$33 \$41 4e-13 cap_mim_2f0fF A=200P P=60U
C$1705 \$3594 \$3590 4e-13 cap_mim_2f0fF A=200P P=60U
C$1706 \$5394 \$5370 4e-13 cap_mim_2f0fF A=200P P=60U
C$1707 \$3608 \$3616 4e-13 cap_mim_2f0fF A=200P P=60U
.ENDS GRADIENT_NAV
