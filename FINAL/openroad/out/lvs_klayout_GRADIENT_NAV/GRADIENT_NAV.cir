* Extracted by KLayout with GF180MCU LVS runset on : 09/08/2026 09:31

.SUBCKT GRADIENT_NAV S2N S1P S2P S1N S3P S3N S4P Z S4N SUB
M$1 \$10 \$68 \$507 \$507 pfet_05v0 L=0.5U W=1.83U AS=0.8052P AD=0.8052P
+ PS=4.54U PD=4.54U
M$2 \$13 \$10 \$507 \$507 pfet_05v0 L=0.5U W=1.83U AS=0.8052P AD=0.8052P
+ PS=4.54U PD=4.54U
M$3 \$14 \$13 \$507 \$507 pfet_05v0 L=0.5U W=1.83U AS=0.8052P AD=0.8052P
+ PS=4.54U PD=4.54U
M$4 \$3592 \$3653 \$4083 \$4083 pfet_05v0 L=0.5U W=1.83U AS=0.8052P AD=0.8052P
+ PS=4.54U PD=4.54U
M$5 \$3593 \$3592 \$4083 \$4083 pfet_05v0 L=0.5U W=1.83U AS=0.8052P AD=0.8052P
+ PS=4.54U PD=4.54U
M$6 \$3594 \$3593 \$4083 \$4083 pfet_05v0 L=0.5U W=1.83U AS=0.8052P AD=0.8052P
+ PS=4.54U PD=4.54U
M$7 \$7168 \$7228 \$7662 \$7662 pfet_05v0 L=0.5U W=1.83U AS=0.8052P AD=0.8052P
+ PS=4.54U PD=4.54U
M$8 Z \$7168 \$7662 \$7662 pfet_05v0 L=0.5U W=1.83U AS=0.8052P AD=0.8052P
+ PS=4.54U PD=4.54U
M$9 \$7169 Z \$7662 \$7662 pfet_05v0 L=0.5U W=1.83U AS=0.8052P AD=0.8052P
+ PS=4.54U PD=4.54U
M$10 \$100 \$55 SUB SUB pfet_06v0 L=20U W=0.7U AS=0.308P AD=0.308P PS=2.28U
+ PD=2.28U
M$11 \$105 \$57 SUB SUB pfet_06v0 L=20U W=0.7U AS=0.308P AD=0.308P PS=2.28U
+ PD=2.28U
M$12 \$109 \$59 SUB SUB pfet_06v0 L=20U W=0.7U AS=0.308P AD=0.308P PS=2.28U
+ PD=2.28U
M$13 \$68 \$68 \$507 \$507 pfet_06v0 L=1U W=2U AS=0.88P AD=0.52P PS=4.88U
+ PD=2.52U
M$14 \$507 \$68 \$68 \$507 pfet_06v0 L=1U W=2U AS=0.52P AD=0.52P PS=2.52U
+ PD=2.52U
M$15 \$68 \$68 \$507 \$507 pfet_06v0 L=1U W=2U AS=0.52P AD=0.52P PS=2.52U
+ PD=2.52U
M$16 \$507 \$68 \$68 \$507 pfet_06v0 L=1U W=2U AS=0.52P AD=0.52P PS=2.52U
+ PD=2.52U
M$17 \$68 \$68 \$507 \$507 pfet_06v0 L=1U W=2U AS=0.52P AD=0.52P PS=2.52U
+ PD=2.52U
M$18 \$507 \$68 \$68 \$507 pfet_06v0 L=1U W=2U AS=0.52P AD=0.88P PS=2.52U
+ PD=4.88U
M$19 \$12 \$12 \$507 \$507 pfet_06v0 L=1U W=2U AS=0.88P AD=0.88P PS=4.88U
+ PD=4.88U
M$20 \$1788 \$113 SUB SUB pfet_06v0 L=1U W=10U AS=4.4P AD=2.5P PS=20.88U
+ PD=10.5U
M$21 \$501 \$110 \$1788 SUB pfet_06v0 L=1U W=10U AS=2.5P AD=4.4P PS=10.5U
+ PD=20.88U
M$22 \$1790 \$113 SUB SUB pfet_06v0 L=1U W=10U AS=4.4P AD=2.5P PS=20.88U
+ PD=10.5U
M$23 \$501 \$110 \$1790 SUB pfet_06v0 L=1U W=10U AS=2.5P AD=4.4P PS=10.5U
+ PD=20.88U
M$24 \$97 S1P \$501 SUB pfet_06v0 L=1U W=10U AS=4.4P AD=4.4P PS=20.88U PD=20.88U
M$25 \$22 S1N \$501 SUB pfet_06v0 L=1U W=10U AS=4.4P AD=4.4P PS=20.88U PD=20.88U
M$26 \$502 \$110 \$21 SUB pfet_06v0 L=1U W=5U AS=2.2P AD=2.2P PS=10.88U
+ PD=10.88U
M$27 \$55 \$110 \$20 SUB pfet_06v0 L=1U W=5U AS=2.2P AD=2.2P PS=10.88U PD=10.88U
M$28 \$21 \$502 SUB SUB pfet_06v0 L=1U W=5U AS=2.2P AD=2.2P PS=10.88U PD=10.88U
M$29 \$20 \$502 SUB SUB pfet_06v0 L=1U W=5U AS=2.2P AD=2.2P PS=10.88U PD=10.88U
M$30 \$23 \$26 \$502 SUB pfet_06v0 L=1U W=5U AS=2.2P AD=2.2P PS=10.88U PD=10.88U
M$31 \$24 \$26 \$55 SUB pfet_06v0 L=1U W=5U AS=2.2P AD=2.2P PS=10.88U PD=10.88U
M$32 \$1793 \$269 SUB SUB pfet_06v0 L=1U W=10U AS=4.4P AD=2.5P PS=20.88U
+ PD=10.5U
M$33 \$269 \$110 \$1793 SUB pfet_06v0 L=1U W=10U AS=2.5P AD=4.4P PS=10.5U
+ PD=20.88U
M$34 \$26 \$26 \$269 SUB pfet_06v0 L=1U W=10U AS=4.4P AD=4.4P PS=20.88U
+ PD=20.88U
M$35 \$1795 \$113 SUB SUB pfet_06v0 L=1U W=10U AS=4.4P AD=2.5P PS=20.88U
+ PD=10.5U
M$36 \$25 \$110 \$1795 SUB pfet_06v0 L=1U W=10U AS=2.5P AD=4.4P PS=10.5U
+ PD=20.88U
M$37 \$1796 \$113 SUB SUB pfet_06v0 L=1U W=10U AS=4.4P AD=2.5P PS=20.88U
+ PD=10.5U
M$38 \$17 \$110 \$1796 SUB pfet_06v0 L=1U W=10U AS=2.5P AD=4.4P PS=10.5U
+ PD=20.88U
M$39 \$1797 \$113 SUB SUB pfet_06v0 L=1U W=10U AS=4.4P AD=2.5P PS=20.88U
+ PD=10.5U
M$40 \$16 \$110 \$1797 SUB pfet_06v0 L=1U W=10U AS=2.5P AD=4.4P PS=10.5U
+ PD=20.88U
M$41 \$110 \$110 SUB SUB pfet_06v0 L=1U W=2U AS=0.88P AD=0.88P PS=4.88U PD=4.88U
M$42 \$1799 \$113 SUB SUB pfet_06v0 L=1U W=10U AS=4.4P AD=2.5P PS=20.88U
+ PD=10.5U
M$43 \$113 \$110 \$1799 SUB pfet_06v0 L=1U W=10U AS=2.5P AD=4.4P PS=10.5U
+ PD=20.88U
M$44 \$1800 \$114 SUB SUB pfet_06v0 L=1U W=10U AS=4.4P AD=2.5P PS=20.88U
+ PD=10.5U
M$45 \$503 \$111 \$1800 SUB pfet_06v0 L=1U W=10U AS=2.5P AD=4.4P PS=10.5U
+ PD=20.88U
M$46 \$1801 \$114 SUB SUB pfet_06v0 L=1U W=10U AS=4.4P AD=2.5P PS=20.88U
+ PD=10.5U
M$47 \$503 \$111 \$1801 SUB pfet_06v0 L=1U W=10U AS=2.5P AD=4.4P PS=10.5U
+ PD=20.88U
M$48 \$102 S2P \$503 SUB pfet_06v0 L=1U W=10U AS=4.4P AD=4.4P PS=20.88U
+ PD=20.88U
M$49 \$34 \$347 \$503 SUB pfet_06v0 L=1U W=10U AS=4.4P AD=4.4P PS=20.88U
+ PD=20.88U
M$50 \$504 \$111 \$33 SUB pfet_06v0 L=1U W=5U AS=2.2P AD=2.2P PS=10.88U
+ PD=10.88U
M$51 \$57 \$111 \$32 SUB pfet_06v0 L=1U W=5U AS=2.2P AD=2.2P PS=10.88U PD=10.88U
M$52 \$33 \$504 SUB SUB pfet_06v0 L=1U W=5U AS=2.2P AD=2.2P PS=10.88U PD=10.88U
M$53 \$32 \$504 SUB SUB pfet_06v0 L=1U W=5U AS=2.2P AD=2.2P PS=10.88U PD=10.88U
M$54 \$35 \$38 \$504 SUB pfet_06v0 L=1U W=5U AS=2.2P AD=2.2P PS=10.88U PD=10.88U
M$55 \$36 \$38 \$57 SUB pfet_06v0 L=1U W=5U AS=2.2P AD=2.2P PS=10.88U PD=10.88U
M$56 \$1804 \$270 SUB SUB pfet_06v0 L=1U W=10U AS=4.4P AD=2.5P PS=20.88U
+ PD=10.5U
M$57 \$270 \$111 \$1804 SUB pfet_06v0 L=1U W=10U AS=2.5P AD=4.4P PS=10.5U
+ PD=20.88U
M$58 \$38 \$38 \$270 SUB pfet_06v0 L=1U W=10U AS=4.4P AD=4.4P PS=20.88U
+ PD=20.88U
M$59 \$1806 \$114 SUB SUB pfet_06v0 L=1U W=10U AS=4.4P AD=2.5P PS=20.88U
+ PD=10.5U
M$60 \$37 \$111 \$1806 SUB pfet_06v0 L=1U W=10U AS=2.5P AD=4.4P PS=10.5U
+ PD=20.88U
M$61 \$1808 \$114 SUB SUB pfet_06v0 L=1U W=10U AS=4.4P AD=2.5P PS=20.88U
+ PD=10.5U
M$62 \$29 \$111 \$1808 SUB pfet_06v0 L=1U W=10U AS=2.5P AD=4.4P PS=10.5U
+ PD=20.88U
M$63 \$1807 \$114 SUB SUB pfet_06v0 L=1U W=10U AS=4.4P AD=2.5P PS=20.88U
+ PD=10.5U
M$64 \$28 \$111 \$1807 SUB pfet_06v0 L=1U W=10U AS=2.5P AD=4.4P PS=10.5U
+ PD=20.88U
M$65 \$111 \$111 SUB SUB pfet_06v0 L=1U W=2U AS=0.88P AD=0.88P PS=4.88U PD=4.88U
M$66 \$1805 \$114 SUB SUB pfet_06v0 L=1U W=10U AS=4.4P AD=2.5P PS=20.88U
+ PD=10.5U
M$67 \$114 \$111 \$1805 SUB pfet_06v0 L=1U W=10U AS=2.5P AD=4.4P PS=10.5U
+ PD=20.88U
M$68 \$1803 \$115 SUB SUB pfet_06v0 L=1U W=10U AS=4.4P AD=2.5P PS=20.88U
+ PD=10.5U
M$69 \$505 \$112 \$1803 SUB pfet_06v0 L=1U W=10U AS=2.5P AD=4.4P PS=10.5U
+ PD=20.88U
M$70 \$1802 \$115 SUB SUB pfet_06v0 L=1U W=10U AS=4.4P AD=2.5P PS=20.88U
+ PD=10.5U
M$71 \$505 \$112 \$1802 SUB pfet_06v0 L=1U W=10U AS=2.5P AD=4.4P PS=10.5U
+ PD=20.88U
M$72 \$106 S3P \$505 SUB pfet_06v0 L=1U W=10U AS=4.4P AD=4.4P PS=20.88U
+ PD=20.88U
M$73 \$45 S3N \$505 SUB pfet_06v0 L=1U W=10U AS=4.4P AD=4.4P PS=20.88U PD=20.88U
M$74 \$506 \$112 \$44 SUB pfet_06v0 L=1U W=5U AS=2.2P AD=2.2P PS=10.88U
+ PD=10.88U
M$75 \$59 \$112 \$43 SUB pfet_06v0 L=1U W=5U AS=2.2P AD=2.2P PS=10.88U PD=10.88U
M$76 \$44 \$506 SUB SUB pfet_06v0 L=1U W=5U AS=2.2P AD=2.2P PS=10.88U PD=10.88U
M$77 \$43 \$506 SUB SUB pfet_06v0 L=1U W=5U AS=2.2P AD=2.2P PS=10.88U PD=10.88U
M$78 \$46 \$49 \$506 SUB pfet_06v0 L=1U W=5U AS=2.2P AD=2.2P PS=10.88U PD=10.88U
M$79 \$47 \$49 \$59 SUB pfet_06v0 L=1U W=5U AS=2.2P AD=2.2P PS=10.88U PD=10.88U
M$80 \$1798 \$271 SUB SUB pfet_06v0 L=1U W=10U AS=4.4P AD=2.5P PS=20.88U
+ PD=10.5U
M$81 \$271 \$112 \$1798 SUB pfet_06v0 L=1U W=10U AS=2.5P AD=4.4P PS=10.5U
+ PD=20.88U
M$82 \$49 \$49 \$271 SUB pfet_06v0 L=1U W=10U AS=4.4P AD=4.4P PS=20.88U
+ PD=20.88U
M$83 \$1794 \$115 SUB SUB pfet_06v0 L=1U W=10U AS=4.4P AD=2.5P PS=20.88U
+ PD=10.5U
M$84 \$48 \$112 \$1794 SUB pfet_06v0 L=1U W=10U AS=2.5P AD=4.4P PS=10.5U
+ PD=20.88U
M$85 \$1792 \$115 SUB SUB pfet_06v0 L=1U W=10U AS=4.4P AD=2.5P PS=20.88U
+ PD=10.5U
M$86 \$41 \$112 \$1792 SUB pfet_06v0 L=1U W=10U AS=2.5P AD=4.4P PS=10.5U
+ PD=20.88U
M$87 \$1791 \$115 SUB SUB pfet_06v0 L=1U W=10U AS=4.4P AD=2.5P PS=20.88U
+ PD=10.5U
M$88 \$40 \$112 \$1791 SUB pfet_06v0 L=1U W=10U AS=2.5P AD=4.4P PS=10.5U
+ PD=20.88U
M$89 \$112 \$112 SUB SUB pfet_06v0 L=1U W=2U AS=0.88P AD=0.88P PS=4.88U PD=4.88U
M$90 \$1789 \$115 SUB SUB pfet_06v0 L=1U W=10U AS=4.4P AD=2.5P PS=20.88U
+ PD=10.5U
M$91 \$115 \$112 \$1789 SUB pfet_06v0 L=1U W=10U AS=2.5P AD=4.4P PS=10.5U
+ PD=20.88U
M$92 \$3564 \$2730 SUB SUB pfet_06v0 L=1U W=10U AS=4.4P AD=2.5P PS=20.88U
+ PD=10.5U
M$93 \$1814 \$2883 \$3564 SUB pfet_06v0 L=1U W=10U AS=2.5P AD=4.4P PS=10.5U
+ PD=20.88U
M$94 \$3565 \$2730 SUB SUB pfet_06v0 L=1U W=10U AS=4.4P AD=2.5P PS=20.88U
+ PD=10.5U
M$95 \$1815 \$2883 \$3565 SUB pfet_06v0 L=1U W=10U AS=2.5P AD=4.4P PS=10.5U
+ PD=20.88U
M$96 \$2883 \$2883 SUB SUB pfet_06v0 L=1U W=2U AS=0.88P AD=0.88P PS=4.88U
+ PD=4.88U
M$97 \$3567 \$2730 SUB SUB pfet_06v0 L=1U W=10U AS=4.4P AD=2.5P PS=20.88U
+ PD=10.5U
M$98 \$2730 \$2883 \$3567 SUB pfet_06v0 L=1U W=10U AS=2.5P AD=4.4P PS=10.5U
+ PD=20.88U
M$99 \$3568 \$2730 SUB SUB pfet_06v0 L=1U W=10U AS=4.4P AD=2.5P PS=20.88U
+ PD=10.5U
M$100 \$1971 \$2883 \$3568 SUB pfet_06v0 L=1U W=10U AS=2.5P AD=4.4P PS=10.5U
+ PD=20.88U
M$101 \$3569 \$2730 SUB SUB pfet_06v0 L=1U W=10U AS=4.4P AD=2.5P PS=20.88U
+ PD=10.5U
M$102 \$1971 \$2883 \$3569 SUB pfet_06v0 L=1U W=10U AS=2.5P AD=4.4P PS=10.5U
+ PD=20.88U
M$103 \$1831 \$1891 \$1971 SUB pfet_06v0 L=1U W=10U AS=4.4P AD=2.6P PS=20.88U
+ PD=10.52U
M$104 \$1971 \$1891 \$1831 SUB pfet_06v0 L=1U W=10U AS=2.6P AD=4.4P PS=10.52U
+ PD=20.88U
M$105 \$1829 \$1816 \$1971 SUB pfet_06v0 L=1U W=10U AS=4.4P AD=2.6P PS=20.88U
+ PD=10.52U
M$106 \$1971 \$1816 \$1829 SUB pfet_06v0 L=1U W=10U AS=2.6P AD=4.4P PS=10.52U
+ PD=20.88U
M$107 \$2124 \$2883 \$1828 SUB pfet_06v0 L=1U W=5U AS=2.2P AD=1.3P PS=10.88U
+ PD=5.52U
M$108 \$1828 \$2883 \$2124 SUB pfet_06v0 L=1U W=5U AS=1.3P AD=2.2P PS=5.52U
+ PD=10.88U
M$109 \$2352 \$2883 \$1827 SUB pfet_06v0 L=1U W=5U AS=2.2P AD=1.3P PS=10.88U
+ PD=5.52U
M$110 \$1827 \$2883 \$2352 SUB pfet_06v0 L=1U W=5U AS=1.3P AD=2.2P PS=5.52U
+ PD=10.88U
M$111 \$1828 \$2124 SUB SUB pfet_06v0 L=1U W=5U AS=2.2P AD=1.3P PS=10.88U
+ PD=5.52U
M$112 SUB \$2124 \$1828 SUB pfet_06v0 L=1U W=5U AS=1.3P AD=1.3P PS=5.52U
+ PD=5.52U
M$113 \$1828 \$2124 SUB SUB pfet_06v0 L=1U W=5U AS=1.3P AD=1.3P PS=5.52U
+ PD=5.52U
M$114 SUB \$2124 \$1828 SUB pfet_06v0 L=1U W=5U AS=1.3P AD=2.2P PS=5.52U
+ PD=10.88U
M$115 \$1827 \$2124 SUB SUB pfet_06v0 L=1U W=5U AS=2.2P AD=1.3P PS=10.88U
+ PD=5.52U
M$116 SUB \$2124 \$1827 SUB pfet_06v0 L=1U W=5U AS=1.3P AD=1.3P PS=5.52U
+ PD=5.52U
M$117 \$1827 \$2124 SUB SUB pfet_06v0 L=1U W=5U AS=1.3P AD=1.3P PS=5.52U
+ PD=5.52U
M$118 SUB \$2124 \$1827 SUB pfet_06v0 L=1U W=5U AS=1.3P AD=2.2P PS=5.52U
+ PD=10.88U
M$119 \$1830 \$1833 \$2124 SUB pfet_06v0 L=1U W=5U AS=2.2P AD=2.2P PS=10.88U
+ PD=10.88U
M$120 \$1832 \$1833 \$2352 SUB pfet_06v0 L=1U W=5U AS=2.2P AD=2.2P PS=10.88U
+ PD=10.88U
M$121 \$3571 \$1892 SUB SUB pfet_06v0 L=1U W=10U AS=4.4P AD=2.5P PS=20.88U
+ PD=10.5U
M$122 \$1892 \$2883 \$3571 SUB pfet_06v0 L=1U W=10U AS=2.5P AD=4.4P PS=10.5U
+ PD=20.88U
M$123 \$1833 \$1833 \$1892 SUB pfet_06v0 L=1U W=10U AS=4.4P AD=4.4P PS=20.88U
+ PD=20.88U
M$124 \$3572 \$2730 SUB SUB pfet_06v0 L=1U W=10U AS=4.4P AD=2.5P PS=20.88U
+ PD=10.5U
M$125 \$1817 \$2883 \$3572 SUB pfet_06v0 L=1U W=10U AS=2.5P AD=4.4P PS=10.5U
+ PD=20.88U
M$126 \$1835 \$2352 SUB SUB pfet_06v0 L=1U W=10U AS=4.4P AD=2.6P PS=20.88U
+ PD=10.52U
M$127 SUB \$2352 \$1835 SUB pfet_06v0 L=1U W=10U AS=2.6P AD=2.6P PS=10.52U
+ PD=10.52U
M$128 \$1835 \$2352 SUB SUB pfet_06v0 L=1U W=10U AS=2.6P AD=4.4P PS=10.52U
+ PD=20.88U
M$129 \$3575 \$2731 SUB SUB pfet_06v0 L=1U W=10U AS=4.4P AD=2.5P PS=20.88U
+ PD=10.5U
M$130 \$1818 \$2884 \$3575 SUB pfet_06v0 L=1U W=10U AS=2.5P AD=4.4P PS=10.5U
+ PD=20.88U
M$131 \$3577 \$2731 SUB SUB pfet_06v0 L=1U W=10U AS=4.4P AD=2.5P PS=20.88U
+ PD=10.5U
M$132 \$1819 \$2884 \$3577 SUB pfet_06v0 L=1U W=10U AS=2.5P AD=4.4P PS=10.5U
+ PD=20.88U
M$133 \$2884 \$2884 SUB SUB pfet_06v0 L=1U W=2U AS=0.88P AD=0.88P PS=4.88U
+ PD=4.88U
M$134 \$3579 \$2731 SUB SUB pfet_06v0 L=1U W=10U AS=4.4P AD=2.5P PS=20.88U
+ PD=10.5U
M$135 \$2731 \$2884 \$3579 SUB pfet_06v0 L=1U W=10U AS=2.5P AD=4.4P PS=10.5U
+ PD=20.88U
M$136 \$3580 \$2731 SUB SUB pfet_06v0 L=1U W=10U AS=4.4P AD=2.5P PS=20.88U
+ PD=10.5U
M$137 \$1972 \$2884 \$3580 SUB pfet_06v0 L=1U W=10U AS=2.5P AD=4.4P PS=10.5U
+ PD=20.88U
M$138 \$3582 \$2731 SUB SUB pfet_06v0 L=1U W=10U AS=4.4P AD=2.5P PS=20.88U
+ PD=10.5U
M$139 \$1972 \$2884 \$3582 SUB pfet_06v0 L=1U W=10U AS=2.5P AD=4.4P PS=10.5U
+ PD=20.88U
M$140 \$1841 \$1893 \$1972 SUB pfet_06v0 L=1U W=10U AS=4.4P AD=2.6P PS=20.88U
+ PD=10.52U
M$141 \$1972 \$1893 \$1841 SUB pfet_06v0 L=1U W=10U AS=2.6P AD=4.4P PS=10.52U
+ PD=20.88U
M$142 \$1839 \$1820 \$1972 SUB pfet_06v0 L=1U W=10U AS=4.4P AD=2.6P PS=20.88U
+ PD=10.52U
M$143 \$1972 \$1820 \$1839 SUB pfet_06v0 L=1U W=10U AS=2.6P AD=4.4P PS=10.52U
+ PD=20.88U
M$144 \$2125 \$2884 \$1838 SUB pfet_06v0 L=1U W=5U AS=2.2P AD=1.3P PS=10.88U
+ PD=5.52U
M$145 \$1838 \$2884 \$2125 SUB pfet_06v0 L=1U W=5U AS=1.3P AD=2.2P PS=5.52U
+ PD=10.88U
M$146 \$2353 \$2884 \$1837 SUB pfet_06v0 L=1U W=5U AS=2.2P AD=1.3P PS=10.88U
+ PD=5.52U
M$147 \$1837 \$2884 \$2353 SUB pfet_06v0 L=1U W=5U AS=1.3P AD=2.2P PS=5.52U
+ PD=10.88U
M$148 \$1838 \$2125 SUB SUB pfet_06v0 L=1U W=5U AS=2.2P AD=1.3P PS=10.88U
+ PD=5.52U
M$149 SUB \$2125 \$1838 SUB pfet_06v0 L=1U W=5U AS=1.3P AD=1.3P PS=5.52U
+ PD=5.52U
M$150 \$1838 \$2125 SUB SUB pfet_06v0 L=1U W=5U AS=1.3P AD=1.3P PS=5.52U
+ PD=5.52U
M$151 SUB \$2125 \$1838 SUB pfet_06v0 L=1U W=5U AS=1.3P AD=2.2P PS=5.52U
+ PD=10.88U
M$152 \$1837 \$2125 SUB SUB pfet_06v0 L=1U W=5U AS=2.2P AD=1.3P PS=10.88U
+ PD=5.52U
M$153 SUB \$2125 \$1837 SUB pfet_06v0 L=1U W=5U AS=1.3P AD=1.3P PS=5.52U
+ PD=5.52U
M$154 \$1837 \$2125 SUB SUB pfet_06v0 L=1U W=5U AS=1.3P AD=1.3P PS=5.52U
+ PD=5.52U
M$155 SUB \$2125 \$1837 SUB pfet_06v0 L=1U W=5U AS=1.3P AD=2.2P PS=5.52U
+ PD=10.88U
M$156 \$1840 \$1843 \$2125 SUB pfet_06v0 L=1U W=5U AS=2.2P AD=2.2P PS=10.88U
+ PD=10.88U
M$157 \$1842 \$1843 \$2353 SUB pfet_06v0 L=1U W=5U AS=2.2P AD=2.2P PS=10.88U
+ PD=10.88U
M$158 \$3584 \$1894 SUB SUB pfet_06v0 L=1U W=10U AS=4.4P AD=2.5P PS=20.88U
+ PD=10.5U
M$159 \$1894 \$2884 \$3584 SUB pfet_06v0 L=1U W=10U AS=2.5P AD=4.4P PS=10.5U
+ PD=20.88U
M$160 \$1843 \$1843 \$1894 SUB pfet_06v0 L=1U W=10U AS=4.4P AD=4.4P PS=20.88U
+ PD=20.88U
M$161 \$3583 \$2731 SUB SUB pfet_06v0 L=1U W=10U AS=4.4P AD=2.5P PS=20.88U
+ PD=10.5U
M$162 \$1821 \$2884 \$3583 SUB pfet_06v0 L=1U W=10U AS=2.5P AD=4.4P PS=10.5U
+ PD=20.88U
M$163 \$1845 \$2353 SUB SUB pfet_06v0 L=1U W=10U AS=4.4P AD=2.6P PS=20.88U
+ PD=10.52U
M$164 SUB \$2353 \$1845 SUB pfet_06v0 L=1U W=10U AS=2.6P AD=2.6P PS=10.52U
+ PD=10.52U
M$165 \$1845 \$2353 SUB SUB pfet_06v0 L=1U W=10U AS=2.6P AD=4.4P PS=10.52U
+ PD=20.88U
M$166 \$3581 \$2732 SUB SUB pfet_06v0 L=1U W=10U AS=4.4P AD=2.5P PS=20.88U
+ PD=10.5U
M$167 \$1822 \$2885 \$3581 SUB pfet_06v0 L=1U W=10U AS=2.5P AD=4.4P PS=10.5U
+ PD=20.88U
M$168 \$3578 \$2732 SUB SUB pfet_06v0 L=1U W=10U AS=4.4P AD=2.5P PS=20.88U
+ PD=10.5U
M$169 \$1823 \$2885 \$3578 SUB pfet_06v0 L=1U W=10U AS=2.5P AD=4.4P PS=10.5U
+ PD=20.88U
M$170 \$2885 \$2885 SUB SUB pfet_06v0 L=1U W=2U AS=0.88P AD=0.88P PS=4.88U
+ PD=4.88U
M$171 \$3576 \$2732 SUB SUB pfet_06v0 L=1U W=10U AS=4.4P AD=2.5P PS=20.88U
+ PD=10.5U
M$172 \$2732 \$2885 \$3576 SUB pfet_06v0 L=1U W=10U AS=2.5P AD=4.4P PS=10.5U
+ PD=20.88U
M$173 \$3574 \$2732 SUB SUB pfet_06v0 L=1U W=10U AS=4.4P AD=2.5P PS=20.88U
+ PD=10.5U
M$174 \$1973 \$2885 \$3574 SUB pfet_06v0 L=1U W=10U AS=2.5P AD=4.4P PS=10.5U
+ PD=20.88U
M$175 \$3573 \$2732 SUB SUB pfet_06v0 L=1U W=10U AS=4.4P AD=2.5P PS=20.88U
+ PD=10.5U
M$176 \$1973 \$2885 \$3573 SUB pfet_06v0 L=1U W=10U AS=2.5P AD=4.4P PS=10.5U
+ PD=20.88U
M$177 \$1851 \$78 \$1973 SUB pfet_06v0 L=1U W=10U AS=4.4P AD=2.6P PS=20.88U
+ PD=10.52U
M$178 \$1973 \$78 \$1851 SUB pfet_06v0 L=1U W=10U AS=2.6P AD=4.4P PS=10.52U
+ PD=20.88U
M$179 \$1849 \$1824 \$1973 SUB pfet_06v0 L=1U W=10U AS=4.4P AD=2.6P PS=20.88U
+ PD=10.52U
M$180 \$1973 \$1824 \$1849 SUB pfet_06v0 L=1U W=10U AS=2.6P AD=4.4P PS=10.52U
+ PD=20.88U
M$181 \$2126 \$2885 \$1848 SUB pfet_06v0 L=1U W=5U AS=2.2P AD=1.3P PS=10.88U
+ PD=5.52U
M$182 \$1848 \$2885 \$2126 SUB pfet_06v0 L=1U W=5U AS=1.3P AD=2.2P PS=5.52U
+ PD=10.88U
M$183 \$2354 \$2885 \$1847 SUB pfet_06v0 L=1U W=5U AS=2.2P AD=1.3P PS=10.88U
+ PD=5.52U
M$184 \$1847 \$2885 \$2354 SUB pfet_06v0 L=1U W=5U AS=1.3P AD=2.2P PS=5.52U
+ PD=10.88U
M$185 \$1848 \$2126 SUB SUB pfet_06v0 L=1U W=5U AS=2.2P AD=1.3P PS=10.88U
+ PD=5.52U
M$186 SUB \$2126 \$1848 SUB pfet_06v0 L=1U W=5U AS=1.3P AD=1.3P PS=5.52U
+ PD=5.52U
M$187 \$1848 \$2126 SUB SUB pfet_06v0 L=1U W=5U AS=1.3P AD=1.3P PS=5.52U
+ PD=5.52U
M$188 SUB \$2126 \$1848 SUB pfet_06v0 L=1U W=5U AS=1.3P AD=2.2P PS=5.52U
+ PD=10.88U
M$189 \$1847 \$2126 SUB SUB pfet_06v0 L=1U W=5U AS=2.2P AD=1.3P PS=10.88U
+ PD=5.52U
M$190 SUB \$2126 \$1847 SUB pfet_06v0 L=1U W=5U AS=1.3P AD=1.3P PS=5.52U
+ PD=5.52U
M$191 \$1847 \$2126 SUB SUB pfet_06v0 L=1U W=5U AS=1.3P AD=1.3P PS=5.52U
+ PD=5.52U
M$192 SUB \$2126 \$1847 SUB pfet_06v0 L=1U W=5U AS=1.3P AD=2.2P PS=5.52U
+ PD=10.88U
M$193 \$1850 \$1853 \$2126 SUB pfet_06v0 L=1U W=5U AS=2.2P AD=2.2P PS=10.88U
+ PD=10.88U
M$194 \$1852 \$1853 \$2354 SUB pfet_06v0 L=1U W=5U AS=2.2P AD=2.2P PS=10.88U
+ PD=10.88U
M$195 \$3570 \$1895 SUB SUB pfet_06v0 L=1U W=10U AS=4.4P AD=2.5P PS=20.88U
+ PD=10.5U
M$196 \$1895 \$2885 \$3570 SUB pfet_06v0 L=1U W=10U AS=2.5P AD=4.4P PS=10.5U
+ PD=20.88U
M$197 \$1853 \$1853 \$1895 SUB pfet_06v0 L=1U W=10U AS=4.4P AD=4.4P PS=20.88U
+ PD=20.88U
M$198 \$3566 \$2732 SUB SUB pfet_06v0 L=1U W=10U AS=4.4P AD=2.5P PS=20.88U
+ PD=10.5U
M$199 \$1825 \$2885 \$3566 SUB pfet_06v0 L=1U W=10U AS=2.5P AD=4.4P PS=10.5U
+ PD=20.88U
M$200 \$1855 \$2354 SUB SUB pfet_06v0 L=1U W=10U AS=4.4P AD=2.6P PS=20.88U
+ PD=10.52U
M$201 SUB \$2354 \$1855 SUB pfet_06v0 L=1U W=10U AS=2.6P AD=2.6P PS=10.52U
+ PD=10.52U
M$202 \$1855 \$2354 SUB SUB pfet_06v0 L=1U W=10U AS=2.6P AD=4.4P PS=10.52U
+ PD=20.88U
M$203 \$5367 \$3693 SUB SUB pfet_06v0 L=1U W=10U AS=4.4P AD=2.5P PS=20.88U
+ PD=10.5U
M$204 \$4235 \$3690 \$5367 SUB pfet_06v0 L=1U W=10U AS=2.5P AD=4.4P PS=10.5U
+ PD=20.88U
M$205 \$7140 \$6156 SUB SUB pfet_06v0 L=1U W=10U AS=4.4P AD=2.5P PS=20.88U
+ PD=10.5U
M$206 \$5393 \$6384 \$7140 SUB pfet_06v0 L=1U W=10U AS=2.5P AD=4.4P PS=10.5U
+ PD=20.88U
M$207 \$7141 \$6156 SUB SUB pfet_06v0 L=1U W=10U AS=4.4P AD=2.5P PS=20.88U
+ PD=10.5U
M$208 \$5394 \$6384 \$7141 SUB pfet_06v0 L=1U W=10U AS=2.5P AD=4.4P PS=10.5U
+ PD=20.88U
M$209 \$5369 \$3693 SUB SUB pfet_06v0 L=1U W=10U AS=4.4P AD=2.5P PS=20.88U
+ PD=10.5U
M$210 \$4235 \$3690 \$5369 SUB pfet_06v0 L=1U W=10U AS=2.5P AD=4.4P PS=10.5U
+ PD=20.88U
M$211 \$3602 S1P \$4235 SUB pfet_06v0 L=1U W=10U AS=4.4P AD=4.4P PS=20.88U
+ PD=20.88U
M$212 \$6384 \$6384 SUB SUB pfet_06v0 L=1U W=2U AS=0.88P AD=0.88P PS=4.88U
+ PD=4.88U
M$213 \$3600 S1N \$4235 SUB pfet_06v0 L=1U W=10U AS=4.4P AD=4.4P PS=20.88U
+ PD=20.88U
M$214 \$7142 \$6156 SUB SUB pfet_06v0 L=1U W=10U AS=4.4P AD=2.5P PS=20.88U
+ PD=10.5U
M$215 \$6156 \$6384 \$7142 SUB pfet_06v0 L=1U W=10U AS=2.5P AD=4.4P PS=10.5U
+ PD=20.88U
M$216 \$4077 \$3690 \$3599 SUB pfet_06v0 L=1U W=5U AS=2.2P AD=2.2P PS=10.88U
+ PD=10.88U
M$217 \$7144 \$6156 SUB SUB pfet_06v0 L=1U W=10U AS=4.4P AD=2.5P PS=20.88U
+ PD=10.5U
M$218 \$5625 \$6384 \$7144 SUB pfet_06v0 L=1U W=10U AS=2.5P AD=4.4P PS=10.5U
+ PD=20.88U
M$219 \$3640 \$3690 \$3598 SUB pfet_06v0 L=1U W=5U AS=2.2P AD=2.2P PS=10.88U
+ PD=10.88U
M$220 \$7145 \$6156 SUB SUB pfet_06v0 L=1U W=10U AS=4.4P AD=2.5P PS=20.88U
+ PD=10.5U
M$221 \$5625 \$6384 \$7145 SUB pfet_06v0 L=1U W=10U AS=2.5P AD=4.4P PS=10.5U
+ PD=20.88U
M$222 \$3599 \$4077 SUB SUB pfet_06v0 L=1U W=5U AS=2.2P AD=2.2P PS=10.88U
+ PD=10.88U
M$223 \$3598 \$4077 SUB SUB pfet_06v0 L=1U W=5U AS=2.2P AD=2.2P PS=10.88U
+ PD=10.88U
M$224 \$5397 \$5473 \$5625 SUB pfet_06v0 L=1U W=10U AS=4.4P AD=2.6P PS=20.88U
+ PD=10.52U
M$225 \$5625 \$5473 \$5397 SUB pfet_06v0 L=1U W=10U AS=2.6P AD=4.4P PS=10.52U
+ PD=20.88U
M$226 \$3601 \$3605 \$4077 SUB pfet_06v0 L=1U W=5U AS=2.2P AD=2.2P PS=10.88U
+ PD=10.88U
M$227 \$5396 \$5395 \$5625 SUB pfet_06v0 L=1U W=10U AS=4.4P AD=2.6P PS=20.88U
+ PD=10.52U
M$228 \$5625 \$5395 \$5396 SUB pfet_06v0 L=1U W=10U AS=2.6P AD=4.4P PS=10.52U
+ PD=20.88U
M$229 \$3603 \$3605 \$3640 SUB pfet_06v0 L=1U W=5U AS=2.2P AD=2.2P PS=10.88U
+ PD=10.88U
M$230 \$5778 \$6384 \$5412 SUB pfet_06v0 L=1U W=5U AS=2.2P AD=1.3P PS=10.88U
+ PD=5.52U
M$231 \$5412 \$6384 \$5778 SUB pfet_06v0 L=1U W=5U AS=1.3P AD=2.2P PS=5.52U
+ PD=10.88U
M$232 \$5371 \$3847 SUB SUB pfet_06v0 L=1U W=10U AS=4.4P AD=2.5P PS=20.88U
+ PD=10.5U
M$233 \$3847 \$3690 \$5371 SUB pfet_06v0 L=1U W=10U AS=2.5P AD=4.4P PS=10.5U
+ PD=20.88U
M$234 \$5415 \$6384 \$5411 SUB pfet_06v0 L=1U W=5U AS=2.2P AD=1.3P PS=10.88U
+ PD=5.52U
M$235 \$5411 \$6384 \$5415 SUB pfet_06v0 L=1U W=5U AS=1.3P AD=2.2P PS=5.52U
+ PD=10.88U
M$236 \$3605 \$3605 \$3847 SUB pfet_06v0 L=1U W=10U AS=4.4P AD=4.4P PS=20.88U
+ PD=20.88U
M$237 \$5373 \$3693 SUB SUB pfet_06v0 L=1U W=10U AS=4.4P AD=2.5P PS=20.88U
+ PD=10.5U
M$238 \$3604 \$3690 \$5373 SUB pfet_06v0 L=1U W=10U AS=2.5P AD=4.4P PS=10.5U
+ PD=20.88U
M$239 \$5412 \$5778 SUB SUB pfet_06v0 L=1U W=5U AS=2.2P AD=1.3P PS=10.88U
+ PD=5.52U
M$240 SUB \$5778 \$5412 SUB pfet_06v0 L=1U W=5U AS=1.3P AD=1.3P PS=5.52U
+ PD=5.52U
M$241 \$5412 \$5778 SUB SUB pfet_06v0 L=1U W=5U AS=1.3P AD=1.3P PS=5.52U
+ PD=5.52U
M$242 SUB \$5778 \$5412 SUB pfet_06v0 L=1U W=5U AS=1.3P AD=2.2P PS=5.52U
+ PD=10.88U
M$243 \$5374 \$3693 SUB SUB pfet_06v0 L=1U W=10U AS=4.4P AD=2.5P PS=20.88U
+ PD=10.5U
M$244 \$3596 \$3690 \$5374 SUB pfet_06v0 L=1U W=10U AS=2.5P AD=4.4P PS=10.5U
+ PD=20.88U
M$245 \$5411 \$5778 SUB SUB pfet_06v0 L=1U W=5U AS=2.2P AD=1.3P PS=10.88U
+ PD=5.52U
M$246 SUB \$5778 \$5411 SUB pfet_06v0 L=1U W=5U AS=1.3P AD=1.3P PS=5.52U
+ PD=5.52U
M$247 \$5411 \$5778 SUB SUB pfet_06v0 L=1U W=5U AS=1.3P AD=1.3P PS=5.52U
+ PD=5.52U
M$248 SUB \$5778 \$5411 SUB pfet_06v0 L=1U W=5U AS=1.3P AD=2.2P PS=5.52U
+ PD=10.88U
M$249 \$5376 \$3693 SUB SUB pfet_06v0 L=1U W=10U AS=4.4P AD=2.5P PS=20.88U
+ PD=10.5U
M$250 \$3595 \$3690 \$5376 SUB pfet_06v0 L=1U W=10U AS=2.5P AD=4.4P PS=10.5U
+ PD=20.88U
M$251 \$3690 \$3690 SUB SUB pfet_06v0 L=1U W=2U AS=0.88P AD=0.88P PS=4.88U
+ PD=4.88U
M$252 \$5413 \$5416 \$5778 SUB pfet_06v0 L=1U W=5U AS=2.2P AD=2.2P PS=10.88U
+ PD=10.88U
M$253 \$5377 \$3693 SUB SUB pfet_06v0 L=1U W=10U AS=4.4P AD=2.5P PS=20.88U
+ PD=10.5U
M$254 \$3693 \$3690 \$5377 SUB pfet_06v0 L=1U W=10U AS=2.5P AD=4.4P PS=10.5U
+ PD=20.88U
M$255 \$5414 \$5416 \$5415 SUB pfet_06v0 L=1U W=5U AS=2.2P AD=2.2P PS=10.88U
+ PD=10.88U
M$256 \$7147 \$5470 SUB SUB pfet_06v0 L=1U W=10U AS=4.4P AD=2.5P PS=20.88U
+ PD=10.5U
M$257 \$5470 \$6384 \$7147 SUB pfet_06v0 L=1U W=10U AS=2.5P AD=4.4P PS=10.5U
+ PD=20.88U
M$258 \$3607 \$3640 SUB SUB pfet_06v0 L=20U W=0.7U AS=0.308P AD=0.308P PS=2.28U
+ PD=2.28U
M$259 \$5416 \$5416 \$5470 SUB pfet_06v0 L=1U W=10U AS=4.4P AD=4.4P PS=20.88U
+ PD=20.88U
M$260 \$7148 \$6156 SUB SUB pfet_06v0 L=1U W=10U AS=4.4P AD=2.5P PS=20.88U
+ PD=10.5U
M$261 \$5398 \$6384 \$7148 SUB pfet_06v0 L=1U W=10U AS=2.5P AD=4.4P PS=10.5U
+ PD=20.88U
M$262 \$5418 \$5415 SUB SUB pfet_06v0 L=1U W=10U AS=4.4P AD=2.6P PS=20.88U
+ PD=10.52U
M$263 SUB \$5415 \$5418 SUB pfet_06v0 L=1U W=10U AS=2.6P AD=2.6P PS=10.52U
+ PD=10.52U
M$264 \$5418 \$5415 SUB SUB pfet_06v0 L=1U W=10U AS=2.6P AD=4.4P PS=10.52U
+ PD=20.88U
M$265 \$5378 \$3694 SUB SUB pfet_06v0 L=1U W=10U AS=4.4P AD=2.5P PS=20.88U
+ PD=10.5U
M$266 \$4236 \$3691 \$5378 SUB pfet_06v0 L=1U W=10U AS=2.5P AD=4.4P PS=10.5U
+ PD=20.88U
M$267 \$5380 \$3694 SUB SUB pfet_06v0 L=1U W=10U AS=4.4P AD=2.5P PS=20.88U
+ PD=10.5U
M$268 \$4236 \$3691 \$5380 SUB pfet_06v0 L=1U W=10U AS=2.5P AD=4.4P PS=10.5U
+ PD=20.88U
M$269 \$3615 S2P \$4236 SUB pfet_06v0 L=1U W=10U AS=4.4P AD=4.4P PS=20.88U
+ PD=20.88U
M$270 \$3613 \$4078 \$4236 SUB pfet_06v0 L=1U W=10U AS=4.4P AD=4.4P PS=20.88U
+ PD=20.88U
M$271 \$7149 \$6157 SUB SUB pfet_06v0 L=1U W=10U AS=4.4P AD=2.5P PS=20.88U
+ PD=10.5U
M$272 \$5399 \$6385 \$7149 SUB pfet_06v0 L=1U W=10U AS=2.5P AD=4.4P PS=10.5U
+ PD=20.88U
M$273 \$4079 \$3691 \$3612 SUB pfet_06v0 L=1U W=5U AS=2.2P AD=2.2P PS=10.88U
+ PD=10.88U
M$274 \$7150 \$6157 SUB SUB pfet_06v0 L=1U W=10U AS=4.4P AD=2.5P PS=20.88U
+ PD=10.5U
M$275 \$5400 \$6385 \$7150 SUB pfet_06v0 L=1U W=10U AS=2.5P AD=4.4P PS=10.5U
+ PD=20.88U
M$276 \$3642 \$3691 \$3611 SUB pfet_06v0 L=1U W=5U AS=2.2P AD=2.2P PS=10.88U
+ PD=10.88U
M$277 \$6385 \$6385 SUB SUB pfet_06v0 L=1U W=2U AS=0.88P AD=0.88P PS=4.88U
+ PD=4.88U
M$278 \$3612 \$4079 SUB SUB pfet_06v0 L=1U W=5U AS=2.2P AD=2.2P PS=10.88U
+ PD=10.88U
M$279 \$7151 \$6157 SUB SUB pfet_06v0 L=1U W=10U AS=4.4P AD=2.5P PS=20.88U
+ PD=10.5U
M$280 \$6157 \$6385 \$7151 SUB pfet_06v0 L=1U W=10U AS=2.5P AD=4.4P PS=10.5U
+ PD=20.88U
M$281 \$3611 \$4079 SUB SUB pfet_06v0 L=1U W=5U AS=2.2P AD=2.2P PS=10.88U
+ PD=10.88U
M$282 \$3614 \$3618 \$4079 SUB pfet_06v0 L=1U W=5U AS=2.2P AD=2.2P PS=10.88U
+ PD=10.88U
M$283 \$7152 \$6157 SUB SUB pfet_06v0 L=1U W=10U AS=4.4P AD=2.5P PS=20.88U
+ PD=10.5U
M$284 \$5626 \$6385 \$7152 SUB pfet_06v0 L=1U W=10U AS=2.5P AD=4.4P PS=10.5U
+ PD=20.88U
M$285 \$3616 \$3618 \$3642 SUB pfet_06v0 L=1U W=5U AS=2.2P AD=2.2P PS=10.88U
+ PD=10.88U
M$286 \$7153 \$6157 SUB SUB pfet_06v0 L=1U W=10U AS=4.4P AD=2.5P PS=20.88U
+ PD=10.5U
M$287 \$5626 \$6385 \$7153 SUB pfet_06v0 L=1U W=10U AS=2.5P AD=4.4P PS=10.5U
+ PD=20.88U
M$288 \$5383 \$3848 SUB SUB pfet_06v0 L=1U W=10U AS=4.4P AD=2.5P PS=20.88U
+ PD=10.5U
M$289 \$3848 \$3691 \$5383 SUB pfet_06v0 L=1U W=10U AS=2.5P AD=4.4P PS=10.5U
+ PD=20.88U
M$290 \$5402 \$5474 \$5626 SUB pfet_06v0 L=1U W=10U AS=4.4P AD=2.6P PS=20.88U
+ PD=10.52U
M$291 \$5626 \$5474 \$5402 SUB pfet_06v0 L=1U W=10U AS=2.6P AD=4.4P PS=10.52U
+ PD=20.88U
M$292 \$3618 \$3618 \$3848 SUB pfet_06v0 L=1U W=10U AS=4.4P AD=4.4P PS=20.88U
+ PD=20.88U
M$293 \$5385 \$3694 SUB SUB pfet_06v0 L=1U W=10U AS=4.4P AD=2.5P PS=20.88U
+ PD=10.5U
M$294 \$3617 \$3691 \$5385 SUB pfet_06v0 L=1U W=10U AS=2.5P AD=4.4P PS=10.5U
+ PD=20.88U
M$295 \$5401 \$5391 \$5626 SUB pfet_06v0 L=1U W=10U AS=4.4P AD=2.6P PS=20.88U
+ PD=10.52U
M$296 \$5626 \$5391 \$5401 SUB pfet_06v0 L=1U W=10U AS=2.6P AD=4.4P PS=10.52U
+ PD=20.88U
M$297 \$5386 \$3694 SUB SUB pfet_06v0 L=1U W=10U AS=4.4P AD=2.5P PS=20.88U
+ PD=10.5U
M$298 \$3609 \$3691 \$5386 SUB pfet_06v0 L=1U W=10U AS=2.5P AD=4.4P PS=10.5U
+ PD=20.88U
M$299 \$5779 \$6385 \$5421 SUB pfet_06v0 L=1U W=5U AS=2.2P AD=1.3P PS=10.88U
+ PD=5.52U
M$300 \$5421 \$6385 \$5779 SUB pfet_06v0 L=1U W=5U AS=1.3P AD=2.2P PS=5.52U
+ PD=10.88U
M$301 \$5384 \$3694 SUB SUB pfet_06v0 L=1U W=10U AS=4.4P AD=2.5P PS=20.88U
+ PD=10.5U
M$302 \$3608 \$3691 \$5384 SUB pfet_06v0 L=1U W=10U AS=2.5P AD=4.4P PS=10.5U
+ PD=20.88U
M$303 \$5424 \$6385 \$5420 SUB pfet_06v0 L=1U W=5U AS=2.2P AD=1.3P PS=10.88U
+ PD=5.52U
M$304 \$5420 \$6385 \$5424 SUB pfet_06v0 L=1U W=5U AS=1.3P AD=2.2P PS=5.52U
+ PD=10.88U
M$305 \$3691 \$3691 SUB SUB pfet_06v0 L=1U W=2U AS=0.88P AD=0.88P PS=4.88U
+ PD=4.88U
M$306 \$5421 \$5779 SUB SUB pfet_06v0 L=1U W=5U AS=2.2P AD=1.3P PS=10.88U
+ PD=5.52U
M$307 SUB \$5779 \$5421 SUB pfet_06v0 L=1U W=5U AS=1.3P AD=1.3P PS=5.52U
+ PD=5.52U
M$308 \$5421 \$5779 SUB SUB pfet_06v0 L=1U W=5U AS=1.3P AD=1.3P PS=5.52U
+ PD=5.52U
M$309 SUB \$5779 \$5421 SUB pfet_06v0 L=1U W=5U AS=1.3P AD=2.2P PS=5.52U
+ PD=10.88U
M$310 \$5382 \$3694 SUB SUB pfet_06v0 L=1U W=10U AS=4.4P AD=2.5P PS=20.88U
+ PD=10.5U
M$311 \$3694 \$3691 \$5382 SUB pfet_06v0 L=1U W=10U AS=2.5P AD=4.4P PS=10.5U
+ PD=20.88U
M$312 \$5420 \$5779 SUB SUB pfet_06v0 L=1U W=5U AS=2.2P AD=1.3P PS=10.88U
+ PD=5.52U
M$313 SUB \$5779 \$5420 SUB pfet_06v0 L=1U W=5U AS=1.3P AD=1.3P PS=5.52U
+ PD=5.52U
M$314 \$5420 \$5779 SUB SUB pfet_06v0 L=1U W=5U AS=1.3P AD=1.3P PS=5.52U
+ PD=5.52U
M$315 SUB \$5779 \$5420 SUB pfet_06v0 L=1U W=5U AS=1.3P AD=2.2P PS=5.52U
+ PD=10.88U
M$316 \$3620 \$3642 SUB SUB pfet_06v0 L=20U W=0.7U AS=0.308P AD=0.308P PS=2.28U
+ PD=2.28U
M$317 \$5422 \$5425 \$5779 SUB pfet_06v0 L=1U W=5U AS=2.2P AD=2.2P PS=10.88U
+ PD=10.88U
M$318 \$5423 \$5425 \$5424 SUB pfet_06v0 L=1U W=5U AS=2.2P AD=2.2P PS=10.88U
+ PD=10.88U
M$319 \$7154 \$5471 SUB SUB pfet_06v0 L=1U W=10U AS=4.4P AD=2.5P PS=20.88U
+ PD=10.5U
M$320 \$5471 \$6385 \$7154 SUB pfet_06v0 L=1U W=10U AS=2.5P AD=4.4P PS=10.5U
+ PD=20.88U
M$321 \$5425 \$5425 \$5471 SUB pfet_06v0 L=1U W=10U AS=4.4P AD=4.4P PS=20.88U
+ PD=20.88U
M$322 \$5381 \$3695 SUB SUB pfet_06v0 L=1U W=10U AS=4.4P AD=2.5P PS=20.88U
+ PD=10.5U
M$323 \$4237 \$3692 \$5381 SUB pfet_06v0 L=1U W=10U AS=2.5P AD=4.4P PS=10.5U
+ PD=20.88U
M$324 \$7155 \$6157 SUB SUB pfet_06v0 L=1U W=10U AS=4.4P AD=2.5P PS=20.88U
+ PD=10.5U
M$325 \$5403 \$6385 \$7155 SUB pfet_06v0 L=1U W=10U AS=2.5P AD=4.4P PS=10.5U
+ PD=20.88U
M$326 \$5379 \$3695 SUB SUB pfet_06v0 L=1U W=10U AS=4.4P AD=2.5P PS=20.88U
+ PD=10.5U
M$327 \$4237 \$3692 \$5379 SUB pfet_06v0 L=1U W=10U AS=2.5P AD=4.4P PS=10.5U
+ PD=20.88U
M$328 \$5427 \$5424 SUB SUB pfet_06v0 L=1U W=10U AS=4.4P AD=2.6P PS=20.88U
+ PD=10.52U
M$329 SUB \$5424 \$5427 SUB pfet_06v0 L=1U W=10U AS=2.6P AD=2.6P PS=10.52U
+ PD=10.52U
M$330 \$5427 \$5424 SUB SUB pfet_06v0 L=1U W=10U AS=2.6P AD=4.4P PS=10.52U
+ PD=20.88U
M$331 \$3629 S4P \$4237 SUB pfet_06v0 L=1U W=10U AS=4.4P AD=4.4P PS=20.88U
+ PD=20.88U
M$332 \$3627 \$4080 \$4237 SUB pfet_06v0 L=1U W=10U AS=4.4P AD=4.4P PS=20.88U
+ PD=20.88U
M$333 \$4081 \$3692 \$3626 SUB pfet_06v0 L=1U W=5U AS=2.2P AD=2.2P PS=10.88U
+ PD=10.88U
M$334 \$3644 \$3692 \$3625 SUB pfet_06v0 L=1U W=5U AS=2.2P AD=2.2P PS=10.88U
+ PD=10.88U
M$335 \$3626 \$4081 SUB SUB pfet_06v0 L=1U W=5U AS=2.2P AD=2.2P PS=10.88U
+ PD=10.88U
M$336 \$3625 \$4081 SUB SUB pfet_06v0 L=1U W=5U AS=2.2P AD=2.2P PS=10.88U
+ PD=10.88U
M$337 \$7156 \$6158 SUB SUB pfet_06v0 L=1U W=10U AS=4.4P AD=2.5P PS=20.88U
+ PD=10.5U
M$338 \$5404 \$6386 \$7156 SUB pfet_06v0 L=1U W=10U AS=2.5P AD=4.4P PS=10.5U
+ PD=20.88U
M$339 \$3628 \$3632 \$4081 SUB pfet_06v0 L=1U W=5U AS=2.2P AD=2.2P PS=10.88U
+ PD=10.88U
M$340 \$7158 \$6158 SUB SUB pfet_06v0 L=1U W=10U AS=4.4P AD=2.5P PS=20.88U
+ PD=10.5U
M$341 \$5405 \$6386 \$7158 SUB pfet_06v0 L=1U W=10U AS=2.5P AD=4.4P PS=10.5U
+ PD=20.88U
M$342 \$3630 \$3632 \$3644 SUB pfet_06v0 L=1U W=5U AS=2.2P AD=2.2P PS=10.88U
+ PD=10.88U
M$343 \$5375 \$3849 SUB SUB pfet_06v0 L=1U W=10U AS=4.4P AD=2.5P PS=20.88U
+ PD=10.5U
M$344 \$3849 \$3692 \$5375 SUB pfet_06v0 L=1U W=10U AS=2.5P AD=4.4P PS=10.5U
+ PD=20.88U
M$345 \$6386 \$6386 SUB SUB pfet_06v0 L=1U W=2U AS=0.88P AD=0.88P PS=4.88U
+ PD=4.88U
M$346 \$7159 \$6158 SUB SUB pfet_06v0 L=1U W=10U AS=4.4P AD=2.5P PS=20.88U
+ PD=10.5U
M$347 \$6158 \$6386 \$7159 SUB pfet_06v0 L=1U W=10U AS=2.5P AD=4.4P PS=10.5U
+ PD=20.88U
M$348 \$3632 \$3632 \$3849 SUB pfet_06v0 L=1U W=10U AS=4.4P AD=4.4P PS=20.88U
+ PD=20.88U
M$349 \$7160 \$6158 SUB SUB pfet_06v0 L=1U W=10U AS=4.4P AD=2.5P PS=20.88U
+ PD=10.5U
M$350 \$5627 \$6386 \$7160 SUB pfet_06v0 L=1U W=10U AS=2.5P AD=4.4P PS=10.5U
+ PD=20.88U
M$351 \$5372 \$3695 SUB SUB pfet_06v0 L=1U W=10U AS=4.4P AD=2.5P PS=20.88U
+ PD=10.5U
M$352 \$3631 \$3692 \$5372 SUB pfet_06v0 L=1U W=10U AS=2.5P AD=4.4P PS=10.5U
+ PD=20.88U
M$353 \$7157 \$6158 SUB SUB pfet_06v0 L=1U W=10U AS=4.4P AD=2.5P PS=20.88U
+ PD=10.5U
M$354 \$5627 \$6386 \$7157 SUB pfet_06v0 L=1U W=10U AS=2.5P AD=4.4P PS=10.5U
+ PD=20.88U
M$355 \$5370 \$3695 SUB SUB pfet_06v0 L=1U W=10U AS=4.4P AD=2.5P PS=20.88U
+ PD=10.5U
M$356 \$3622 \$3692 \$5370 SUB pfet_06v0 L=1U W=10U AS=2.5P AD=4.4P PS=10.5U
+ PD=20.88U
M$357 \$5408 \$3678 \$5627 SUB pfet_06v0 L=1U W=10U AS=4.4P AD=2.6P PS=20.88U
+ PD=10.52U
M$358 \$5627 \$3678 \$5408 SUB pfet_06v0 L=1U W=10U AS=2.6P AD=4.4P PS=10.52U
+ PD=20.88U
M$359 \$5368 \$3695 SUB SUB pfet_06v0 L=1U W=10U AS=4.4P AD=2.5P PS=20.88U
+ PD=10.5U
M$360 \$3621 \$3692 \$5368 SUB pfet_06v0 L=1U W=10U AS=2.5P AD=4.4P PS=10.5U
+ PD=20.88U
M$361 \$3692 \$3692 SUB SUB pfet_06v0 L=1U W=2U AS=0.88P AD=0.88P PS=4.88U
+ PD=4.88U
M$362 \$5407 \$5406 \$5627 SUB pfet_06v0 L=1U W=10U AS=4.4P AD=2.6P PS=20.88U
+ PD=10.52U
M$363 \$5627 \$5406 \$5407 SUB pfet_06v0 L=1U W=10U AS=2.6P AD=4.4P PS=10.52U
+ PD=20.88U
M$364 \$5366 \$3695 SUB SUB pfet_06v0 L=1U W=10U AS=4.4P AD=2.5P PS=20.88U
+ PD=10.5U
M$365 \$3695 \$3692 \$5366 SUB pfet_06v0 L=1U W=10U AS=2.5P AD=4.4P PS=10.5U
+ PD=20.88U
M$366 \$5780 \$6386 \$5430 SUB pfet_06v0 L=1U W=5U AS=2.2P AD=1.3P PS=10.88U
+ PD=5.52U
M$367 \$5430 \$6386 \$5780 SUB pfet_06v0 L=1U W=5U AS=1.3P AD=2.2P PS=5.52U
+ PD=10.88U
M$368 \$5433 \$6386 \$5429 SUB pfet_06v0 L=1U W=5U AS=2.2P AD=1.3P PS=10.88U
+ PD=5.52U
M$369 \$5429 \$6386 \$5433 SUB pfet_06v0 L=1U W=5U AS=1.3P AD=2.2P PS=5.52U
+ PD=10.88U
M$370 \$3634 \$3644 SUB SUB pfet_06v0 L=20U W=0.7U AS=0.308P AD=0.308P PS=2.28U
+ PD=2.28U
M$371 \$5430 \$5780 SUB SUB pfet_06v0 L=1U W=5U AS=2.2P AD=1.3P PS=10.88U
+ PD=5.52U
M$372 SUB \$5780 \$5430 SUB pfet_06v0 L=1U W=5U AS=1.3P AD=1.3P PS=5.52U
+ PD=5.52U
M$373 \$5430 \$5780 SUB SUB pfet_06v0 L=1U W=5U AS=1.3P AD=1.3P PS=5.52U
+ PD=5.52U
M$374 SUB \$5780 \$5430 SUB pfet_06v0 L=1U W=5U AS=1.3P AD=2.2P PS=5.52U
+ PD=10.88U
M$375 \$5429 \$5780 SUB SUB pfet_06v0 L=1U W=5U AS=2.2P AD=1.3P PS=10.88U
+ PD=5.52U
M$376 SUB \$5780 \$5429 SUB pfet_06v0 L=1U W=5U AS=1.3P AD=1.3P PS=5.52U
+ PD=5.52U
M$377 \$5429 \$5780 SUB SUB pfet_06v0 L=1U W=5U AS=1.3P AD=1.3P PS=5.52U
+ PD=5.52U
M$378 SUB \$5780 \$5429 SUB pfet_06v0 L=1U W=5U AS=1.3P AD=2.2P PS=5.52U
+ PD=10.88U
M$379 \$5431 \$5434 \$5780 SUB pfet_06v0 L=1U W=5U AS=2.2P AD=2.2P PS=10.88U
+ PD=10.88U
M$380 \$3653 \$3653 \$4083 \$4083 pfet_06v0 L=1U W=2U AS=0.88P AD=0.52P
+ PS=4.88U PD=2.52U
M$381 \$4083 \$3653 \$3653 \$4083 pfet_06v0 L=1U W=2U AS=0.52P AD=0.52P
+ PS=2.52U PD=2.52U
M$382 \$3653 \$3653 \$4083 \$4083 pfet_06v0 L=1U W=2U AS=0.52P AD=0.52P
+ PS=2.52U PD=2.52U
M$383 \$4083 \$3653 \$3653 \$4083 pfet_06v0 L=1U W=2U AS=0.52P AD=0.52P
+ PS=2.52U PD=2.52U
M$384 \$3653 \$3653 \$4083 \$4083 pfet_06v0 L=1U W=2U AS=0.52P AD=0.52P
+ PS=2.52U PD=2.52U
M$385 \$4083 \$3653 \$3653 \$4083 pfet_06v0 L=1U W=2U AS=0.52P AD=0.88P
+ PS=2.52U PD=4.88U
M$386 \$5432 \$5434 \$5433 SUB pfet_06v0 L=1U W=5U AS=2.2P AD=2.2P PS=10.88U
+ PD=10.88U
M$387 \$7146 \$5472 SUB SUB pfet_06v0 L=1U W=10U AS=4.4P AD=2.5P PS=20.88U
+ PD=10.5U
M$388 \$5472 \$6386 \$7146 SUB pfet_06v0 L=1U W=10U AS=2.5P AD=4.4P PS=10.5U
+ PD=20.88U
M$389 \$3591 \$3591 \$4083 \$4083 pfet_06v0 L=1U W=2U AS=0.88P AD=0.88P
+ PS=4.88U PD=4.88U
M$390 \$5434 \$5434 \$5472 SUB pfet_06v0 L=1U W=10U AS=4.4P AD=4.4P PS=20.88U
+ PD=20.88U
M$391 \$7143 \$6158 SUB SUB pfet_06v0 L=1U W=10U AS=4.4P AD=2.5P PS=20.88U
+ PD=10.5U
M$392 \$5409 \$6386 \$7143 SUB pfet_06v0 L=1U W=10U AS=2.5P AD=4.4P PS=10.5U
+ PD=20.88U
M$393 \$5436 \$5433 SUB SUB pfet_06v0 L=1U W=10U AS=4.4P AD=2.6P PS=20.88U
+ PD=10.52U
M$394 SUB \$5433 \$5436 SUB pfet_06v0 L=1U W=10U AS=2.6P AD=2.6P PS=10.52U
+ PD=10.52U
M$395 \$5436 \$5433 SUB SUB pfet_06v0 L=1U W=10U AS=2.6P AD=4.4P PS=10.52U
+ PD=20.88U
M$396 \$10716 \$9807 SUB SUB pfet_06v0 L=1U W=10U AS=4.4P AD=2.5P PS=20.88U
+ PD=10.5U
M$397 \$8968 \$10035 \$10716 SUB pfet_06v0 L=1U W=10U AS=2.5P AD=4.4P PS=10.5U
+ PD=20.88U
M$398 \$8943 \$7265 SUB SUB pfet_06v0 L=1U W=10U AS=4.4P AD=2.5P PS=20.88U
+ PD=10.5U
M$399 \$7656 \$7266 \$8943 SUB pfet_06v0 L=1U W=10U AS=2.5P AD=4.4P PS=10.5U
+ PD=20.88U
M$400 \$8944 \$7265 SUB SUB pfet_06v0 L=1U W=10U AS=4.4P AD=2.5P PS=20.88U
+ PD=10.5U
M$401 \$7656 \$7266 \$8944 SUB pfet_06v0 L=1U W=10U AS=2.5P AD=4.4P PS=10.5U
+ PD=20.88U
M$402 \$10717 \$9807 SUB SUB pfet_06v0 L=1U W=10U AS=4.4P AD=2.5P PS=20.88U
+ PD=10.5U
M$403 \$8969 \$10035 \$10717 SUB pfet_06v0 L=1U W=10U AS=2.5P AD=4.4P PS=10.5U
+ PD=20.88U
M$404 \$10035 \$10035 SUB SUB pfet_06v0 L=1U W=2U AS=0.88P AD=0.88P PS=4.88U
+ PD=4.88U
M$405 \$7177 S3P \$7656 SUB pfet_06v0 L=1U W=10U AS=4.4P AD=4.4P PS=20.88U
+ PD=20.88U
M$406 \$10719 \$9807 SUB SUB pfet_06v0 L=1U W=10U AS=4.4P AD=2.5P PS=20.88U
+ PD=10.5U
M$407 \$9807 \$10035 \$10719 SUB pfet_06v0 L=1U W=10U AS=2.5P AD=4.4P PS=10.5U
+ PD=20.88U
M$408 \$7175 \$7501 \$7656 SUB pfet_06v0 L=1U W=10U AS=4.4P AD=4.4P PS=20.88U
+ PD=20.88U
M$409 \$7657 \$7266 \$7174 SUB pfet_06v0 L=1U W=5U AS=2.2P AD=2.2P PS=10.88U
+ PD=10.88U
M$410 \$10721 \$9807 SUB SUB pfet_06v0 L=1U W=10U AS=4.4P AD=2.5P PS=20.88U
+ PD=10.5U
M$411 \$9201 \$10035 \$10721 SUB pfet_06v0 L=1U W=10U AS=2.5P AD=4.4P PS=10.5U
+ PD=20.88U
M$412 \$7215 \$7266 \$7173 SUB pfet_06v0 L=1U W=5U AS=2.2P AD=2.2P PS=10.88U
+ PD=10.88U
M$413 \$10722 \$9807 SUB SUB pfet_06v0 L=1U W=10U AS=4.4P AD=2.5P PS=20.88U
+ PD=10.5U
M$414 \$9201 \$10035 \$10722 SUB pfet_06v0 L=1U W=10U AS=2.5P AD=4.4P PS=10.5U
+ PD=20.88U
M$415 \$7174 \$7657 SUB SUB pfet_06v0 L=1U W=5U AS=2.2P AD=2.2P PS=10.88U
+ PD=10.88U
M$416 \$7173 \$7657 SUB SUB pfet_06v0 L=1U W=5U AS=2.2P AD=2.2P PS=10.88U
+ PD=10.88U
M$417 \$8984 \$9049 \$9201 SUB pfet_06v0 L=1U W=10U AS=4.4P AD=2.6P PS=20.88U
+ PD=10.52U
M$418 \$9201 \$9049 \$8984 SUB pfet_06v0 L=1U W=10U AS=2.6P AD=4.4P PS=10.52U
+ PD=20.88U
M$419 \$7176 \$7180 \$7657 SUB pfet_06v0 L=1U W=5U AS=2.2P AD=2.2P PS=10.88U
+ PD=10.88U
M$420 \$8982 \$8970 \$9201 SUB pfet_06v0 L=1U W=10U AS=4.4P AD=2.6P PS=20.88U
+ PD=10.52U
M$421 \$9201 \$8970 \$8982 SUB pfet_06v0 L=1U W=10U AS=2.6P AD=4.4P PS=10.52U
+ PD=20.88U
M$422 \$7178 \$7180 \$7215 SUB pfet_06v0 L=1U W=5U AS=2.2P AD=2.2P PS=10.88U
+ PD=10.88U
M$423 \$9354 \$10035 \$8981 SUB pfet_06v0 L=1U W=5U AS=2.2P AD=1.3P PS=10.88U
+ PD=5.52U
M$424 \$8981 \$10035 \$9354 SUB pfet_06v0 L=1U W=5U AS=1.3P AD=2.2P PS=5.52U
+ PD=10.88U
M$425 \$8946 \$7423 SUB SUB pfet_06v0 L=1U W=10U AS=4.4P AD=2.5P PS=20.88U
+ PD=10.5U
M$426 \$7423 \$7266 \$8946 SUB pfet_06v0 L=1U W=10U AS=2.5P AD=4.4P PS=10.5U
+ PD=20.88U
M$427 \$8986 \$10035 \$8980 SUB pfet_06v0 L=1U W=5U AS=2.2P AD=1.3P PS=10.88U
+ PD=5.52U
M$428 \$8980 \$10035 \$8986 SUB pfet_06v0 L=1U W=5U AS=1.3P AD=2.2P PS=5.52U
+ PD=10.88U
M$429 \$7180 \$7180 \$7423 SUB pfet_06v0 L=1U W=10U AS=4.4P AD=4.4P PS=20.88U
+ PD=20.88U
M$430 \$8947 \$7265 SUB SUB pfet_06v0 L=1U W=10U AS=4.4P AD=2.5P PS=20.88U
+ PD=10.5U
M$431 \$7179 \$7266 \$8947 SUB pfet_06v0 L=1U W=10U AS=2.5P AD=4.4P PS=10.5U
+ PD=20.88U
M$432 \$8981 \$9354 SUB SUB pfet_06v0 L=1U W=5U AS=2.2P AD=1.3P PS=10.88U
+ PD=5.52U
M$433 SUB \$9354 \$8981 SUB pfet_06v0 L=1U W=5U AS=1.3P AD=1.3P PS=5.52U
+ PD=5.52U
M$434 \$8981 \$9354 SUB SUB pfet_06v0 L=1U W=5U AS=1.3P AD=1.3P PS=5.52U
+ PD=5.52U
M$435 SUB \$9354 \$8981 SUB pfet_06v0 L=1U W=5U AS=1.3P AD=2.2P PS=5.52U
+ PD=10.88U
M$436 \$8949 \$7265 SUB SUB pfet_06v0 L=1U W=10U AS=4.4P AD=2.5P PS=20.88U
+ PD=10.5U
M$437 \$7171 \$7266 \$8949 SUB pfet_06v0 L=1U W=10U AS=2.5P AD=4.4P PS=10.5U
+ PD=20.88U
M$438 \$8980 \$9354 SUB SUB pfet_06v0 L=1U W=5U AS=2.2P AD=1.3P PS=10.88U
+ PD=5.52U
M$439 SUB \$9354 \$8980 SUB pfet_06v0 L=1U W=5U AS=1.3P AD=1.3P PS=5.52U
+ PD=5.52U
M$440 \$8980 \$9354 SUB SUB pfet_06v0 L=1U W=5U AS=1.3P AD=1.3P PS=5.52U
+ PD=5.52U
M$441 SUB \$9354 \$8980 SUB pfet_06v0 L=1U W=5U AS=1.3P AD=2.2P PS=5.52U
+ PD=10.88U
M$442 \$8950 \$7265 SUB SUB pfet_06v0 L=1U W=10U AS=4.4P AD=2.5P PS=20.88U
+ PD=10.5U
M$443 \$7170 \$7266 \$8950 SUB pfet_06v0 L=1U W=10U AS=2.5P AD=4.4P PS=10.5U
+ PD=20.88U
M$444 \$7266 \$7266 SUB SUB pfet_06v0 L=1U W=2U AS=0.88P AD=0.88P PS=4.88U
+ PD=4.88U
M$445 \$8983 \$8987 \$9354 SUB pfet_06v0 L=1U W=5U AS=2.2P AD=2.2P PS=10.88U
+ PD=10.88U
M$446 \$8951 \$7265 SUB SUB pfet_06v0 L=1U W=10U AS=4.4P AD=2.5P PS=20.88U
+ PD=10.5U
M$447 \$7265 \$7266 \$8951 SUB pfet_06v0 L=1U W=10U AS=2.5P AD=4.4P PS=10.5U
+ PD=20.88U
M$448 \$8985 \$8987 \$8986 SUB pfet_06v0 L=1U W=5U AS=2.2P AD=2.2P PS=10.88U
+ PD=10.88U
M$449 \$10727 \$9042 SUB SUB pfet_06v0 L=1U W=10U AS=4.4P AD=2.5P PS=20.88U
+ PD=10.5U
M$450 \$9042 \$10035 \$10727 SUB pfet_06v0 L=1U W=10U AS=2.5P AD=4.4P PS=10.5U
+ PD=20.88U
M$451 \$7182 \$7215 SUB SUB pfet_06v0 L=20U W=0.7U AS=0.308P AD=0.308P PS=2.28U
+ PD=2.28U
M$452 \$8987 \$8987 \$9042 SUB pfet_06v0 L=1U W=10U AS=4.4P AD=4.4P PS=20.88U
+ PD=20.88U
M$453 \$10728 \$9807 SUB SUB pfet_06v0 L=1U W=10U AS=4.4P AD=2.5P PS=20.88U
+ PD=10.5U
M$454 \$8971 \$10035 \$10728 SUB pfet_06v0 L=1U W=10U AS=2.5P AD=4.4P PS=10.5U
+ PD=20.88U
M$455 \$8989 \$8986 SUB SUB pfet_06v0 L=1U W=10U AS=4.4P AD=2.6P PS=20.88U
+ PD=10.52U
M$456 SUB \$8986 \$8989 SUB pfet_06v0 L=1U W=10U AS=2.6P AD=2.6P PS=10.52U
+ PD=10.52U
M$457 \$8989 \$8986 SUB SUB pfet_06v0 L=1U W=10U AS=2.6P AD=4.4P PS=10.52U
+ PD=20.88U
M$458 \$8952 \$7267 SUB SUB pfet_06v0 L=1U W=10U AS=4.4P AD=2.5P PS=20.88U
+ PD=10.5U
M$459 \$7658 \$7268 \$8952 SUB pfet_06v0 L=1U W=10U AS=2.5P AD=4.4P PS=10.5U
+ PD=20.88U
M$460 \$8954 \$7267 SUB SUB pfet_06v0 L=1U W=10U AS=4.4P AD=2.5P PS=20.88U
+ PD=10.5U
M$461 \$7658 \$7268 \$8954 SUB pfet_06v0 L=1U W=10U AS=2.5P AD=4.4P PS=10.5U
+ PD=20.88U
M$462 \$7191 \$7186 \$7658 SUB pfet_06v0 L=1U W=10U AS=4.4P AD=4.4P PS=20.88U
+ PD=20.88U
M$463 \$7189 \$7502 \$7658 SUB pfet_06v0 L=1U W=10U AS=4.4P AD=4.4P PS=20.88U
+ PD=20.88U
M$464 \$10730 \$9808 SUB SUB pfet_06v0 L=1U W=10U AS=4.4P AD=2.5P PS=20.88U
+ PD=10.5U
M$465 \$8972 \$10036 \$10730 SUB pfet_06v0 L=1U W=10U AS=2.5P AD=4.4P PS=10.5U
+ PD=20.88U
M$466 \$7659 \$7268 \$7188 SUB pfet_06v0 L=1U W=5U AS=2.2P AD=2.2P PS=10.88U
+ PD=10.88U
M$467 \$10732 \$9808 SUB SUB pfet_06v0 L=1U W=10U AS=4.4P AD=2.5P PS=20.88U
+ PD=10.5U
M$468 \$8973 \$10036 \$10732 SUB pfet_06v0 L=1U W=10U AS=2.5P AD=4.4P PS=10.5U
+ PD=20.88U
M$469 \$7217 \$7268 \$7187 SUB pfet_06v0 L=1U W=5U AS=2.2P AD=2.2P PS=10.88U
+ PD=10.88U
M$470 \$10036 \$10036 SUB SUB pfet_06v0 L=1U W=2U AS=0.88P AD=0.88P PS=4.88U
+ PD=4.88U
M$471 \$7188 \$7659 SUB SUB pfet_06v0 L=1U W=5U AS=2.2P AD=2.2P PS=10.88U
+ PD=10.88U
M$472 \$7187 \$7659 SUB SUB pfet_06v0 L=1U W=5U AS=2.2P AD=2.2P PS=10.88U
+ PD=10.88U
M$473 \$10733 \$9808 SUB SUB pfet_06v0 L=1U W=10U AS=4.4P AD=2.5P PS=20.88U
+ PD=10.5U
M$474 \$9808 \$10036 \$10733 SUB pfet_06v0 L=1U W=10U AS=2.5P AD=4.4P PS=10.5U
+ PD=20.88U
M$475 \$7190 \$7194 \$7659 SUB pfet_06v0 L=1U W=5U AS=2.2P AD=2.2P PS=10.88U
+ PD=10.88U
M$476 \$10735 \$9808 SUB SUB pfet_06v0 L=1U W=10U AS=4.4P AD=2.5P PS=20.88U
+ PD=10.5U
M$477 \$9202 \$10036 \$10735 SUB pfet_06v0 L=1U W=10U AS=2.5P AD=4.4P PS=10.5U
+ PD=20.88U
M$478 \$7192 \$7194 \$7217 SUB pfet_06v0 L=1U W=5U AS=2.2P AD=2.2P PS=10.88U
+ PD=10.88U
M$479 \$10736 \$9808 SUB SUB pfet_06v0 L=1U W=10U AS=4.4P AD=2.5P PS=20.88U
+ PD=10.5U
M$480 \$9202 \$10036 \$10736 SUB pfet_06v0 L=1U W=10U AS=2.5P AD=4.4P PS=10.5U
+ PD=20.88U
M$481 \$8956 \$7424 SUB SUB pfet_06v0 L=1U W=10U AS=4.4P AD=2.5P PS=20.88U
+ PD=10.5U
M$482 \$7424 \$7268 \$8956 SUB pfet_06v0 L=1U W=10U AS=2.5P AD=4.4P PS=10.5U
+ PD=20.88U
M$483 \$8995 \$9050 \$9202 SUB pfet_06v0 L=1U W=10U AS=4.4P AD=2.6P PS=20.88U
+ PD=10.52U
M$484 \$9202 \$9050 \$8995 SUB pfet_06v0 L=1U W=10U AS=2.6P AD=4.4P PS=10.52U
+ PD=20.88U
M$485 \$7194 \$7194 \$7424 SUB pfet_06v0 L=1U W=10U AS=4.4P AD=4.4P PS=20.88U
+ PD=20.88U
M$486 \$8957 \$7267 SUB SUB pfet_06v0 L=1U W=10U AS=4.4P AD=2.5P PS=20.88U
+ PD=10.5U
M$487 \$7193 \$7268 \$8957 SUB pfet_06v0 L=1U W=10U AS=2.5P AD=4.4P PS=10.5U
+ PD=20.88U
M$488 \$8993 \$7259 \$9202 SUB pfet_06v0 L=1U W=10U AS=4.4P AD=2.6P PS=20.88U
+ PD=10.52U
M$489 \$9202 \$7259 \$8993 SUB pfet_06v0 L=1U W=10U AS=2.6P AD=4.4P PS=10.52U
+ PD=20.88U
M$490 \$8958 \$7267 SUB SUB pfet_06v0 L=1U W=10U AS=4.4P AD=2.5P PS=20.88U
+ PD=10.5U
M$491 \$7184 \$7268 \$8958 SUB pfet_06v0 L=1U W=10U AS=2.5P AD=4.4P PS=10.5U
+ PD=20.88U
M$492 \$9355 \$10036 \$8992 SUB pfet_06v0 L=1U W=5U AS=2.2P AD=1.3P PS=10.88U
+ PD=5.52U
M$493 \$8992 \$10036 \$9355 SUB pfet_06v0 L=1U W=5U AS=1.3P AD=2.2P PS=5.52U
+ PD=10.88U
M$494 \$8959 \$7267 SUB SUB pfet_06v0 L=1U W=10U AS=4.4P AD=2.5P PS=20.88U
+ PD=10.5U
M$495 \$7183 \$7268 \$8959 SUB pfet_06v0 L=1U W=10U AS=2.5P AD=4.4P PS=10.5U
+ PD=20.88U
M$496 \$8997 \$10036 \$8991 SUB pfet_06v0 L=1U W=5U AS=2.2P AD=1.3P PS=10.88U
+ PD=5.52U
M$497 \$8991 \$10036 \$8997 SUB pfet_06v0 L=1U W=5U AS=1.3P AD=2.2P PS=5.52U
+ PD=10.88U
M$498 \$7268 \$7268 SUB SUB pfet_06v0 L=1U W=2U AS=0.88P AD=0.88P PS=4.88U
+ PD=4.88U
M$499 \$8992 \$9355 SUB SUB pfet_06v0 L=1U W=5U AS=2.2P AD=1.3P PS=10.88U
+ PD=5.52U
M$500 SUB \$9355 \$8992 SUB pfet_06v0 L=1U W=5U AS=1.3P AD=1.3P PS=5.52U
+ PD=5.52U
M$501 \$8992 \$9355 SUB SUB pfet_06v0 L=1U W=5U AS=1.3P AD=1.3P PS=5.52U
+ PD=5.52U
M$502 SUB \$9355 \$8992 SUB pfet_06v0 L=1U W=5U AS=1.3P AD=2.2P PS=5.52U
+ PD=10.88U
M$503 \$8960 \$7267 SUB SUB pfet_06v0 L=1U W=10U AS=4.4P AD=2.5P PS=20.88U
+ PD=10.5U
M$504 \$7267 \$7268 \$8960 SUB pfet_06v0 L=1U W=10U AS=2.5P AD=4.4P PS=10.5U
+ PD=20.88U
M$505 \$8991 \$9355 SUB SUB pfet_06v0 L=1U W=5U AS=2.2P AD=1.3P PS=10.88U
+ PD=5.52U
M$506 SUB \$9355 \$8991 SUB pfet_06v0 L=1U W=5U AS=1.3P AD=1.3P PS=5.52U
+ PD=5.52U
M$507 \$8991 \$9355 SUB SUB pfet_06v0 L=1U W=5U AS=1.3P AD=1.3P PS=5.52U
+ PD=5.52U
M$508 SUB \$9355 \$8991 SUB pfet_06v0 L=1U W=5U AS=1.3P AD=2.2P PS=5.52U
+ PD=10.88U
M$509 \$7196 \$7217 SUB SUB pfet_06v0 L=20U W=0.7U AS=0.308P AD=0.308P PS=2.28U
+ PD=2.28U
M$510 \$8994 \$8998 \$9355 SUB pfet_06v0 L=1U W=5U AS=2.2P AD=2.2P PS=10.88U
+ PD=10.88U
M$511 \$8996 \$8998 \$8997 SUB pfet_06v0 L=1U W=5U AS=2.2P AD=2.2P PS=10.88U
+ PD=10.88U
M$512 \$10734 \$9045 SUB SUB pfet_06v0 L=1U W=10U AS=4.4P AD=2.5P PS=20.88U
+ PD=10.5U
M$513 \$9045 \$10036 \$10734 SUB pfet_06v0 L=1U W=10U AS=2.5P AD=4.4P PS=10.5U
+ PD=20.88U
M$514 \$8998 \$8998 \$9045 SUB pfet_06v0 L=1U W=10U AS=4.4P AD=4.4P PS=20.88U
+ PD=20.88U
M$515 \$8961 \$7269 SUB SUB pfet_06v0 L=1U W=10U AS=4.4P AD=2.5P PS=20.88U
+ PD=10.5U
M$516 \$7660 \$7270 \$8961 SUB pfet_06v0 L=1U W=10U AS=2.5P AD=4.4P PS=10.5U
+ PD=20.88U
M$517 \$10731 \$9808 SUB SUB pfet_06v0 L=1U W=10U AS=4.4P AD=2.5P PS=20.88U
+ PD=10.5U
M$518 \$8974 \$10036 \$10731 SUB pfet_06v0 L=1U W=10U AS=2.5P AD=4.4P PS=10.5U
+ PD=20.88U
M$519 \$8962 \$7269 SUB SUB pfet_06v0 L=1U W=10U AS=4.4P AD=2.5P PS=20.88U
+ PD=10.5U
M$520 \$7660 \$7270 \$8962 SUB pfet_06v0 L=1U W=10U AS=2.5P AD=4.4P PS=10.5U
+ PD=20.88U
M$521 \$9020 \$8997 SUB SUB pfet_06v0 L=1U W=10U AS=4.4P AD=2.6P PS=20.88U
+ PD=10.52U
M$522 SUB \$8997 \$9020 SUB pfet_06v0 L=1U W=10U AS=2.6P AD=2.6P PS=10.52U
+ PD=10.52U
M$523 \$9020 \$8997 SUB SUB pfet_06v0 L=1U W=10U AS=2.6P AD=4.4P PS=10.52U
+ PD=20.88U
M$524 \$7204 S1P \$7660 SUB pfet_06v0 L=1U W=10U AS=4.4P AD=4.4P PS=20.88U
+ PD=20.88U
M$525 \$7202 S1N \$7660 SUB pfet_06v0 L=1U W=10U AS=4.4P AD=4.4P PS=20.88U
+ PD=20.88U
M$526 \$7661 \$7270 \$7201 SUB pfet_06v0 L=1U W=5U AS=2.2P AD=2.2P PS=10.88U
+ PD=10.88U
M$527 \$7219 \$7270 \$7200 SUB pfet_06v0 L=1U W=5U AS=2.2P AD=2.2P PS=10.88U
+ PD=10.88U
M$528 \$7201 \$7661 SUB SUB pfet_06v0 L=1U W=5U AS=2.2P AD=2.2P PS=10.88U
+ PD=10.88U
M$529 \$7200 \$7661 SUB SUB pfet_06v0 L=1U W=5U AS=2.2P AD=2.2P PS=10.88U
+ PD=10.88U
M$530 \$10729 \$9809 SUB SUB pfet_06v0 L=1U W=10U AS=4.4P AD=2.5P PS=20.88U
+ PD=10.5U
M$531 \$8975 \$10037 \$10729 SUB pfet_06v0 L=1U W=10U AS=2.5P AD=4.4P PS=10.5U
+ PD=20.88U
M$532 \$7203 \$7207 \$7661 SUB pfet_06v0 L=1U W=5U AS=2.2P AD=2.2P PS=10.88U
+ PD=10.88U
M$533 \$10726 \$9809 SUB SUB pfet_06v0 L=1U W=10U AS=4.4P AD=2.5P PS=20.88U
+ PD=10.5U
M$534 \$8976 \$10037 \$10726 SUB pfet_06v0 L=1U W=10U AS=2.5P AD=4.4P PS=10.5U
+ PD=20.88U
M$535 \$7205 \$7207 \$7219 SUB pfet_06v0 L=1U W=5U AS=2.2P AD=2.2P PS=10.88U
+ PD=10.88U
M$536 \$8963 \$7425 SUB SUB pfet_06v0 L=1U W=10U AS=4.4P AD=2.5P PS=20.88U
+ PD=10.5U
M$537 \$7425 \$7270 \$8963 SUB pfet_06v0 L=1U W=10U AS=2.5P AD=4.4P PS=10.5U
+ PD=20.88U
M$538 \$10037 \$10037 SUB SUB pfet_06v0 L=1U W=2U AS=0.88P AD=0.88P PS=4.88U
+ PD=4.88U
M$539 \$10725 \$9809 SUB SUB pfet_06v0 L=1U W=10U AS=4.4P AD=2.5P PS=20.88U
+ PD=10.5U
M$540 \$9809 \$10037 \$10725 SUB pfet_06v0 L=1U W=10U AS=2.5P AD=4.4P PS=10.5U
+ PD=20.88U
M$541 \$7207 \$7207 \$7425 SUB pfet_06v0 L=1U W=10U AS=4.4P AD=4.4P PS=20.88U
+ PD=20.88U
M$542 \$10724 \$9809 SUB SUB pfet_06v0 L=1U W=10U AS=4.4P AD=2.5P PS=20.88U
+ PD=10.5U
M$543 \$9203 \$10037 \$10724 SUB pfet_06v0 L=1U W=10U AS=2.5P AD=4.4P PS=10.5U
+ PD=20.88U
M$544 \$8955 \$7269 SUB SUB pfet_06v0 L=1U W=10U AS=4.4P AD=2.5P PS=20.88U
+ PD=10.5U
M$545 \$7206 \$7270 \$8955 SUB pfet_06v0 L=1U W=10U AS=2.5P AD=4.4P PS=10.5U
+ PD=20.88U
M$546 \$8953 \$7269 SUB SUB pfet_06v0 L=1U W=10U AS=4.4P AD=2.5P PS=20.88U
+ PD=10.5U
M$547 \$7198 \$7270 \$8953 SUB pfet_06v0 L=1U W=10U AS=2.5P AD=4.4P PS=10.5U
+ PD=20.88U
M$548 \$10723 \$9809 SUB SUB pfet_06v0 L=1U W=10U AS=4.4P AD=2.5P PS=20.88U
+ PD=10.5U
M$549 \$9203 \$10037 \$10723 SUB pfet_06v0 L=1U W=10U AS=2.5P AD=4.4P PS=10.5U
+ PD=20.88U
M$550 \$8948 \$7269 SUB SUB pfet_06v0 L=1U W=10U AS=4.4P AD=2.5P PS=20.88U
+ PD=10.5U
M$551 \$7197 \$7270 \$8948 SUB pfet_06v0 L=1U W=10U AS=2.5P AD=4.4P PS=10.5U
+ PD=20.88U
M$552 \$9005 \$7209 \$9203 SUB pfet_06v0 L=1U W=10U AS=4.4P AD=2.6P PS=20.88U
+ PD=10.52U
M$553 \$9203 \$7209 \$9005 SUB pfet_06v0 L=1U W=10U AS=2.6P AD=4.4P PS=10.52U
+ PD=20.88U
M$554 \$7270 \$7270 SUB SUB pfet_06v0 L=1U W=2U AS=0.88P AD=0.88P PS=4.88U
+ PD=4.88U
M$555 \$9003 \$8977 \$9203 SUB pfet_06v0 L=1U W=10U AS=4.4P AD=2.6P PS=20.88U
+ PD=10.52U
M$556 \$9203 \$8977 \$9003 SUB pfet_06v0 L=1U W=10U AS=2.6P AD=4.4P PS=10.52U
+ PD=20.88U
M$557 \$8945 \$7269 SUB SUB pfet_06v0 L=1U W=10U AS=4.4P AD=2.5P PS=20.88U
+ PD=10.5U
M$558 \$7269 \$7270 \$8945 SUB pfet_06v0 L=1U W=10U AS=2.5P AD=4.4P PS=10.5U
+ PD=20.88U
M$559 \$9356 \$10037 \$9002 SUB pfet_06v0 L=1U W=5U AS=2.2P AD=1.3P PS=10.88U
+ PD=5.52U
M$560 \$9002 \$10037 \$9356 SUB pfet_06v0 L=1U W=5U AS=1.3P AD=2.2P PS=5.52U
+ PD=10.88U
M$561 \$9007 \$10037 \$9001 SUB pfet_06v0 L=1U W=5U AS=2.2P AD=1.3P PS=10.88U
+ PD=5.52U
M$562 \$9001 \$10037 \$9007 SUB pfet_06v0 L=1U W=5U AS=1.3P AD=2.2P PS=5.52U
+ PD=10.88U
M$563 \$7209 \$7219 SUB SUB pfet_06v0 L=20U W=0.7U AS=0.308P AD=0.308P PS=2.28U
+ PD=2.28U
M$564 \$9002 \$9356 SUB SUB pfet_06v0 L=1U W=5U AS=2.2P AD=1.3P PS=10.88U
+ PD=5.52U
M$565 SUB \$9356 \$9002 SUB pfet_06v0 L=1U W=5U AS=1.3P AD=1.3P PS=5.52U
+ PD=5.52U
M$566 \$9002 \$9356 SUB SUB pfet_06v0 L=1U W=5U AS=1.3P AD=1.3P PS=5.52U
+ PD=5.52U
M$567 SUB \$9356 \$9002 SUB pfet_06v0 L=1U W=5U AS=1.3P AD=2.2P PS=5.52U
+ PD=10.88U
M$568 \$9001 \$9356 SUB SUB pfet_06v0 L=1U W=5U AS=2.2P AD=1.3P PS=10.88U
+ PD=5.52U
M$569 SUB \$9356 \$9001 SUB pfet_06v0 L=1U W=5U AS=1.3P AD=1.3P PS=5.52U
+ PD=5.52U
M$570 \$9001 \$9356 SUB SUB pfet_06v0 L=1U W=5U AS=1.3P AD=1.3P PS=5.52U
+ PD=5.52U
M$571 SUB \$9356 \$9001 SUB pfet_06v0 L=1U W=5U AS=1.3P AD=2.2P PS=5.52U
+ PD=10.88U
M$572 \$9004 \$9008 \$9356 SUB pfet_06v0 L=1U W=5U AS=2.2P AD=2.2P PS=10.88U
+ PD=10.88U
M$573 \$7228 \$7228 \$7662 \$7662 pfet_06v0 L=1U W=2U AS=0.88P AD=0.52P
+ PS=4.88U PD=2.52U
M$574 \$7662 \$7228 \$7228 \$7662 pfet_06v0 L=1U W=2U AS=0.52P AD=0.52P
+ PS=2.52U PD=2.52U
M$575 \$7228 \$7228 \$7662 \$7662 pfet_06v0 L=1U W=2U AS=0.52P AD=0.52P
+ PS=2.52U PD=2.52U
M$576 \$7662 \$7228 \$7228 \$7662 pfet_06v0 L=1U W=2U AS=0.52P AD=0.52P
+ PS=2.52U PD=2.52U
M$577 \$7228 \$7228 \$7662 \$7662 pfet_06v0 L=1U W=2U AS=0.52P AD=0.52P
+ PS=2.52U PD=2.52U
M$578 \$7662 \$7228 \$7228 \$7662 pfet_06v0 L=1U W=2U AS=0.52P AD=0.88P
+ PS=2.52U PD=4.88U
M$579 \$9006 \$9008 \$9007 SUB pfet_06v0 L=1U W=5U AS=2.2P AD=2.2P PS=10.88U
+ PD=10.88U
M$580 \$10720 \$9048 SUB SUB pfet_06v0 L=1U W=10U AS=4.4P AD=2.5P PS=20.88U
+ PD=10.5U
M$581 \$9048 \$10037 \$10720 SUB pfet_06v0 L=1U W=10U AS=2.5P AD=4.4P PS=10.5U
+ PD=20.88U
M$582 \$7167 \$7167 \$7662 \$7662 pfet_06v0 L=1U W=2U AS=0.88P AD=0.88P
+ PS=4.88U PD=4.88U
M$583 \$9008 \$9008 \$9048 SUB pfet_06v0 L=1U W=10U AS=4.4P AD=4.4P PS=20.88U
+ PD=20.88U
M$584 \$10718 \$9809 SUB SUB pfet_06v0 L=1U W=10U AS=4.4P AD=2.5P PS=20.88U
+ PD=10.5U
M$585 \$8978 \$10037 \$10718 SUB pfet_06v0 L=1U W=10U AS=2.5P AD=4.4P PS=10.5U
+ PD=20.88U
M$586 \$9010 \$9007 SUB SUB pfet_06v0 L=1U W=10U AS=4.4P AD=2.6P PS=20.88U
+ PD=10.52U
M$587 SUB \$9007 \$9010 SUB pfet_06v0 L=1U W=10U AS=2.6P AD=2.6P PS=10.52U
+ PD=10.52U
M$588 \$9010 \$9007 SUB SUB pfet_06v0 L=1U W=10U AS=2.6P AD=4.4P PS=10.52U
+ PD=20.88U
M$589 \$14275 \$13441 SUB SUB pfet_06v0 L=1U W=10U AS=4.4P AD=2.5P PS=20.88U
+ PD=10.5U
M$590 \$12527 \$13594 \$14275 SUB pfet_06v0 L=1U W=10U AS=2.5P AD=4.4P PS=10.5U
+ PD=20.88U
M$591 \$12427 \$10833 SUB SUB pfet_06v0 L=1U W=10U AS=4.4P AD=2.5P PS=20.88U
+ PD=10.5U
M$592 \$11371 \$10822 \$12427 SUB pfet_06v0 L=1U W=10U AS=2.5P AD=4.4P PS=10.5U
+ PD=20.88U
M$593 \$14276 \$13441 SUB SUB pfet_06v0 L=1U W=10U AS=4.4P AD=2.5P PS=20.88U
+ PD=10.5U
M$594 \$12528 \$13594 \$14276 SUB pfet_06v0 L=1U W=10U AS=2.5P AD=4.4P PS=10.5U
+ PD=20.88U
M$595 \$12428 \$10833 SUB SUB pfet_06v0 L=1U W=10U AS=4.4P AD=2.5P PS=20.88U
+ PD=10.5U
M$596 \$11371 \$10822 \$12428 SUB pfet_06v0 L=1U W=10U AS=2.5P AD=4.4P PS=10.5U
+ PD=20.88U
M$597 \$10761 S3P \$11371 SUB pfet_06v0 L=1U W=10U AS=4.4P AD=4.4P PS=20.88U
+ PD=20.88U
M$598 \$13594 \$13594 SUB SUB pfet_06v0 L=1U W=2U AS=0.88P AD=0.88P PS=4.88U
+ PD=4.88U
M$599 \$14278 \$13441 SUB SUB pfet_06v0 L=1U W=10U AS=4.4P AD=2.5P PS=20.88U
+ PD=10.5U
M$600 \$13441 \$13594 \$14278 SUB pfet_06v0 L=1U W=10U AS=2.5P AD=4.4P PS=10.5U
+ PD=20.88U
M$601 \$10759 S3N \$11371 SUB pfet_06v0 L=1U W=10U AS=4.4P AD=4.4P PS=20.88U
+ PD=20.88U
M$602 \$11142 \$10822 \$10758 SUB pfet_06v0 L=1U W=5U AS=2.2P AD=2.2P PS=10.88U
+ PD=10.88U
M$603 \$14279 \$13441 SUB SUB pfet_06v0 L=1U W=10U AS=4.4P AD=2.5P PS=20.88U
+ PD=10.5U
M$604 \$12760 \$13594 \$14279 SUB pfet_06v0 L=1U W=10U AS=2.5P AD=4.4P PS=10.5U
+ PD=20.88U
M$605 \$10797 \$10822 \$10757 SUB pfet_06v0 L=1U W=5U AS=2.2P AD=2.2P PS=10.88U
+ PD=10.88U
M$606 \$14280 \$13441 SUB SUB pfet_06v0 L=1U W=10U AS=4.4P AD=2.5P PS=20.88U
+ PD=10.5U
M$607 \$12760 \$13594 \$14280 SUB pfet_06v0 L=1U W=10U AS=2.5P AD=4.4P PS=10.5U
+ PD=20.88U
M$608 \$10758 \$11142 SUB SUB pfet_06v0 L=1U W=5U AS=2.2P AD=2.2P PS=10.88U
+ PD=10.88U
M$609 \$10757 \$11142 SUB SUB pfet_06v0 L=1U W=5U AS=2.2P AD=2.2P PS=10.88U
+ PD=10.88U
M$610 \$12544 \$12608 \$12760 SUB pfet_06v0 L=1U W=10U AS=4.4P AD=2.6P
+ PS=20.88U PD=10.52U
M$611 \$12760 \$12608 \$12544 SUB pfet_06v0 L=1U W=10U AS=2.6P AD=4.4P
+ PS=10.52U PD=20.88U
M$612 \$10760 \$10763 \$11142 SUB pfet_06v0 L=1U W=5U AS=2.2P AD=2.2P PS=10.88U
+ PD=10.88U
M$613 \$12542 \$12529 \$12760 SUB pfet_06v0 L=1U W=10U AS=4.4P AD=2.6P
+ PS=20.88U PD=10.52U
M$614 \$12760 \$12529 \$12542 SUB pfet_06v0 L=1U W=10U AS=2.6P AD=4.4P
+ PS=10.52U PD=20.88U
M$615 \$10762 \$10763 \$10797 SUB pfet_06v0 L=1U W=5U AS=2.2P AD=2.2P PS=10.88U
+ PD=10.88U
M$616 \$12913 \$13594 \$12541 SUB pfet_06v0 L=1U W=5U AS=2.2P AD=1.3P PS=10.88U
+ PD=5.52U
M$617 \$12541 \$13594 \$12913 SUB pfet_06v0 L=1U W=5U AS=1.3P AD=2.2P PS=5.52U
+ PD=10.88U
M$618 \$12446 \$11064 SUB SUB pfet_06v0 L=1U W=10U AS=4.4P AD=2.5P PS=20.88U
+ PD=10.5U
M$619 \$11064 \$10822 \$12446 SUB pfet_06v0 L=1U W=10U AS=2.5P AD=4.4P PS=10.5U
+ PD=20.88U
M$620 \$12546 \$13594 \$12540 SUB pfet_06v0 L=1U W=5U AS=2.2P AD=1.3P PS=10.88U
+ PD=5.52U
M$621 \$12540 \$13594 \$12546 SUB pfet_06v0 L=1U W=5U AS=1.3P AD=2.2P PS=5.52U
+ PD=10.88U
M$622 \$10763 \$10763 \$11064 SUB pfet_06v0 L=1U W=10U AS=4.4P AD=4.4P
+ PS=20.88U PD=20.88U
M$623 \$12457 \$10833 SUB SUB pfet_06v0 L=1U W=10U AS=4.4P AD=2.5P PS=20.88U
+ PD=10.5U
M$624 \$10743 \$10822 \$12457 SUB pfet_06v0 L=1U W=10U AS=2.5P AD=4.4P PS=10.5U
+ PD=20.88U
M$625 \$12541 \$12913 SUB SUB pfet_06v0 L=1U W=5U AS=2.2P AD=1.3P PS=10.88U
+ PD=5.52U
M$626 SUB \$12913 \$12541 SUB pfet_06v0 L=1U W=5U AS=1.3P AD=1.3P PS=5.52U
+ PD=5.52U
M$627 \$12541 \$12913 SUB SUB pfet_06v0 L=1U W=5U AS=1.3P AD=1.3P PS=5.52U
+ PD=5.52U
M$628 SUB \$12913 \$12541 SUB pfet_06v0 L=1U W=5U AS=1.3P AD=2.2P PS=5.52U
+ PD=10.88U
M$629 \$12458 \$10833 SUB SUB pfet_06v0 L=1U W=10U AS=4.4P AD=2.5P PS=20.88U
+ PD=10.5U
M$630 \$10742 \$10822 \$12458 SUB pfet_06v0 L=1U W=10U AS=2.5P AD=4.4P PS=10.5U
+ PD=20.88U
M$631 \$12540 \$12913 SUB SUB pfet_06v0 L=1U W=5U AS=2.2P AD=1.3P PS=10.88U
+ PD=5.52U
M$632 SUB \$12913 \$12540 SUB pfet_06v0 L=1U W=5U AS=1.3P AD=1.3P PS=5.52U
+ PD=5.52U
M$633 \$12540 \$12913 SUB SUB pfet_06v0 L=1U W=5U AS=1.3P AD=1.3P PS=5.52U
+ PD=5.52U
M$634 SUB \$12913 \$12540 SUB pfet_06v0 L=1U W=5U AS=1.3P AD=2.2P PS=5.52U
+ PD=10.88U
M$635 \$12459 \$10833 SUB SUB pfet_06v0 L=1U W=10U AS=4.4P AD=2.5P PS=20.88U
+ PD=10.5U
M$636 \$10741 \$10822 \$12459 SUB pfet_06v0 L=1U W=10U AS=2.5P AD=4.4P PS=10.5U
+ PD=20.88U
M$637 \$10822 \$10822 SUB SUB pfet_06v0 L=1U W=2U AS=0.88P AD=0.88P PS=4.88U
+ PD=4.88U
M$638 \$12543 \$12547 \$12913 SUB pfet_06v0 L=1U W=5U AS=2.2P AD=2.2P PS=10.88U
+ PD=10.88U
M$639 \$12461 \$10833 SUB SUB pfet_06v0 L=1U W=10U AS=4.4P AD=2.5P PS=20.88U
+ PD=10.5U
M$640 \$10833 \$10822 \$12461 SUB pfet_06v0 L=1U W=10U AS=2.5P AD=4.4P PS=10.5U
+ PD=20.88U
M$641 \$12545 \$12547 \$12546 SUB pfet_06v0 L=1U W=5U AS=2.2P AD=2.2P PS=10.88U
+ PD=10.88U
M$642 \$14282 \$12605 SUB SUB pfet_06v0 L=1U W=10U AS=4.4P AD=2.5P PS=20.88U
+ PD=10.5U
M$643 \$12605 \$13594 \$14282 SUB pfet_06v0 L=1U W=10U AS=2.5P AD=4.4P PS=10.5U
+ PD=20.88U
M$644 \$10765 \$10797 SUB SUB pfet_06v0 L=20U W=0.7U AS=0.308P AD=0.308P
+ PS=2.28U PD=2.28U
M$645 \$12547 \$12547 \$12605 SUB pfet_06v0 L=1U W=10U AS=4.4P AD=4.4P
+ PS=20.88U PD=20.88U
M$646 \$14283 \$13441 SUB SUB pfet_06v0 L=1U W=10U AS=4.4P AD=2.5P PS=20.88U
+ PD=10.5U
M$647 \$12530 \$13594 \$14283 SUB pfet_06v0 L=1U W=10U AS=2.5P AD=4.4P PS=10.5U
+ PD=20.88U
M$648 \$12549 \$12546 SUB SUB pfet_06v0 L=1U W=10U AS=4.4P AD=2.6P PS=20.88U
+ PD=10.52U
M$649 SUB \$12546 \$12549 SUB pfet_06v0 L=1U W=10U AS=2.6P AD=2.6P PS=10.52U
+ PD=10.52U
M$650 \$12549 \$12546 SUB SUB pfet_06v0 L=1U W=10U AS=2.6P AD=4.4P PS=10.52U
+ PD=20.88U
M$651 \$12463 \$10834 SUB SUB pfet_06v0 L=1U W=10U AS=4.4P AD=2.5P PS=20.88U
+ PD=10.5U
M$652 \$11372 \$10826 \$12463 SUB pfet_06v0 L=1U W=10U AS=2.5P AD=4.4P PS=10.5U
+ PD=20.88U
M$653 \$12465 \$10834 SUB SUB pfet_06v0 L=1U W=10U AS=4.4P AD=2.5P PS=20.88U
+ PD=10.5U
M$654 \$11372 \$10826 \$12465 SUB pfet_06v0 L=1U W=10U AS=2.5P AD=4.4P PS=10.5U
+ PD=20.88U
M$655 \$10772 \$10913 \$11372 SUB pfet_06v0 L=1U W=10U AS=4.4P AD=4.4P
+ PS=20.88U PD=20.88U
M$656 \$10770 S4N \$11372 SUB pfet_06v0 L=1U W=10U AS=4.4P AD=4.4P PS=20.88U
+ PD=20.88U
M$657 \$14286 \$13442 SUB SUB pfet_06v0 L=1U W=10U AS=4.4P AD=2.5P PS=20.88U
+ PD=10.5U
M$658 \$12531 \$13595 \$14286 SUB pfet_06v0 L=1U W=10U AS=2.5P AD=4.4P PS=10.5U
+ PD=20.88U
M$659 \$11144 \$10826 \$10769 SUB pfet_06v0 L=1U W=5U AS=2.2P AD=2.2P PS=10.88U
+ PD=10.88U
M$660 \$14288 \$13442 SUB SUB pfet_06v0 L=1U W=10U AS=4.4P AD=2.5P PS=20.88U
+ PD=10.5U
M$661 \$12532 \$13595 \$14288 SUB pfet_06v0 L=1U W=10U AS=2.5P AD=4.4P PS=10.5U
+ PD=20.88U
M$662 \$10798 \$10826 \$10768 SUB pfet_06v0 L=1U W=5U AS=2.2P AD=2.2P PS=10.88U
+ PD=10.88U
M$663 \$10769 \$11144 SUB SUB pfet_06v0 L=1U W=5U AS=2.2P AD=2.2P PS=10.88U
+ PD=10.88U
M$664 \$13595 \$13595 SUB SUB pfet_06v0 L=1U W=2U AS=0.88P AD=0.88P PS=4.88U
+ PD=4.88U
M$665 \$14290 \$13442 SUB SUB pfet_06v0 L=1U W=10U AS=4.4P AD=2.5P PS=20.88U
+ PD=10.5U
M$666 \$13442 \$13595 \$14290 SUB pfet_06v0 L=1U W=10U AS=2.5P AD=4.4P PS=10.5U
+ PD=20.88U
M$667 \$10768 \$11144 SUB SUB pfet_06v0 L=1U W=5U AS=2.2P AD=2.2P PS=10.88U
+ PD=10.88U
M$668 \$10771 \$10774 \$11144 SUB pfet_06v0 L=1U W=5U AS=2.2P AD=2.2P PS=10.88U
+ PD=10.88U
M$669 \$14292 \$13442 SUB SUB pfet_06v0 L=1U W=10U AS=4.4P AD=2.5P PS=20.88U
+ PD=10.5U
M$670 \$12761 \$13595 \$14292 SUB pfet_06v0 L=1U W=10U AS=2.5P AD=4.4P PS=10.5U
+ PD=20.88U
M$671 \$10773 \$10774 \$10798 SUB pfet_06v0 L=1U W=5U AS=2.2P AD=2.2P PS=10.88U
+ PD=10.88U
M$672 \$14293 \$13442 SUB SUB pfet_06v0 L=1U W=10U AS=4.4P AD=2.5P PS=20.88U
+ PD=10.5U
M$673 \$12761 \$13595 \$14293 SUB pfet_06v0 L=1U W=10U AS=2.5P AD=4.4P PS=10.5U
+ PD=20.88U
M$674 \$12484 \$11065 SUB SUB pfet_06v0 L=1U W=10U AS=4.4P AD=2.5P PS=20.88U
+ PD=10.5U
M$675 \$11065 \$10826 \$12484 SUB pfet_06v0 L=1U W=10U AS=2.5P AD=4.4P PS=10.5U
+ PD=20.88U
M$676 \$12555 \$12609 \$12761 SUB pfet_06v0 L=1U W=10U AS=4.4P AD=2.6P
+ PS=20.88U PD=10.52U
M$677 \$12761 \$12609 \$12555 SUB pfet_06v0 L=1U W=10U AS=2.6P AD=4.4P
+ PS=10.52U PD=20.88U
M$678 \$10774 \$10774 \$11065 SUB pfet_06v0 L=1U W=10U AS=4.4P AD=4.4P
+ PS=20.88U PD=20.88U
M$679 \$12498 \$10834 SUB SUB pfet_06v0 L=1U W=10U AS=4.4P AD=2.5P PS=20.88U
+ PD=10.5U
M$680 \$10746 \$10826 \$12498 SUB pfet_06v0 L=1U W=10U AS=2.5P AD=4.4P PS=10.5U
+ PD=20.88U
M$681 \$12553 \$12533 \$12761 SUB pfet_06v0 L=1U W=10U AS=4.4P AD=2.6P
+ PS=20.88U PD=10.52U
M$682 \$12761 \$12533 \$12553 SUB pfet_06v0 L=1U W=10U AS=2.6P AD=4.4P
+ PS=10.52U PD=20.88U
M$683 \$12499 \$10834 SUB SUB pfet_06v0 L=1U W=10U AS=4.4P AD=2.5P PS=20.88U
+ PD=10.5U
M$684 \$10745 \$10826 \$12499 SUB pfet_06v0 L=1U W=10U AS=2.5P AD=4.4P PS=10.5U
+ PD=20.88U
M$685 \$12914 \$13595 \$12552 SUB pfet_06v0 L=1U W=5U AS=2.2P AD=1.3P PS=10.88U
+ PD=5.52U
M$686 \$12552 \$13595 \$12914 SUB pfet_06v0 L=1U W=5U AS=1.3P AD=2.2P PS=5.52U
+ PD=10.88U
M$687 \$12501 \$10834 SUB SUB pfet_06v0 L=1U W=10U AS=4.4P AD=2.5P PS=20.88U
+ PD=10.5U
M$688 \$10744 \$10826 \$12501 SUB pfet_06v0 L=1U W=10U AS=2.5P AD=4.4P PS=10.5U
+ PD=20.88U
M$689 \$12557 \$13595 \$12551 SUB pfet_06v0 L=1U W=5U AS=2.2P AD=1.3P PS=10.88U
+ PD=5.52U
M$690 \$12551 \$13595 \$12557 SUB pfet_06v0 L=1U W=5U AS=1.3P AD=2.2P PS=5.52U
+ PD=10.88U
M$691 \$10826 \$10826 SUB SUB pfet_06v0 L=1U W=2U AS=0.88P AD=0.88P PS=4.88U
+ PD=4.88U
M$692 \$12552 \$12914 SUB SUB pfet_06v0 L=1U W=5U AS=2.2P AD=1.3P PS=10.88U
+ PD=5.52U
M$693 SUB \$12914 \$12552 SUB pfet_06v0 L=1U W=5U AS=1.3P AD=1.3P PS=5.52U
+ PD=5.52U
M$694 \$12552 \$12914 SUB SUB pfet_06v0 L=1U W=5U AS=1.3P AD=1.3P PS=5.52U
+ PD=5.52U
M$695 SUB \$12914 \$12552 SUB pfet_06v0 L=1U W=5U AS=1.3P AD=2.2P PS=5.52U
+ PD=10.88U
M$696 \$12506 \$10834 SUB SUB pfet_06v0 L=1U W=10U AS=4.4P AD=2.5P PS=20.88U
+ PD=10.5U
M$697 \$10834 \$10826 \$12506 SUB pfet_06v0 L=1U W=10U AS=2.5P AD=4.4P PS=10.5U
+ PD=20.88U
M$698 \$12551 \$12914 SUB SUB pfet_06v0 L=1U W=5U AS=2.2P AD=1.3P PS=10.88U
+ PD=5.52U
M$699 SUB \$12914 \$12551 SUB pfet_06v0 L=1U W=5U AS=1.3P AD=1.3P PS=5.52U
+ PD=5.52U
M$700 \$12551 \$12914 SUB SUB pfet_06v0 L=1U W=5U AS=1.3P AD=1.3P PS=5.52U
+ PD=5.52U
M$701 SUB \$12914 \$12551 SUB pfet_06v0 L=1U W=5U AS=1.3P AD=2.2P PS=5.52U
+ PD=10.88U
M$702 \$10776 \$10798 SUB SUB pfet_06v0 L=20U W=0.7U AS=0.308P AD=0.308P
+ PS=2.28U PD=2.28U
M$703 \$12554 \$12558 \$12914 SUB pfet_06v0 L=1U W=5U AS=2.2P AD=2.2P PS=10.88U
+ PD=10.88U
M$704 \$12556 \$12558 \$12557 SUB pfet_06v0 L=1U W=5U AS=2.2P AD=2.2P PS=10.88U
+ PD=10.88U
M$705 \$14295 \$12606 SUB SUB pfet_06v0 L=1U W=10U AS=4.4P AD=2.5P PS=20.88U
+ PD=10.5U
M$706 \$12606 \$13595 \$14295 SUB pfet_06v0 L=1U W=10U AS=2.5P AD=4.4P PS=10.5U
+ PD=20.88U
M$707 \$12558 \$12558 \$12606 SUB pfet_06v0 L=1U W=10U AS=4.4P AD=4.4P
+ PS=20.88U PD=20.88U
M$708 \$12511 \$10835 SUB SUB pfet_06v0 L=1U W=10U AS=4.4P AD=2.5P PS=20.88U
+ PD=10.5U
M$709 \$11373 \$10830 \$12511 SUB pfet_06v0 L=1U W=10U AS=2.5P AD=4.4P PS=10.5U
+ PD=20.88U
M$710 \$14294 \$13442 SUB SUB pfet_06v0 L=1U W=10U AS=4.4P AD=2.5P PS=20.88U
+ PD=10.5U
M$711 \$12534 \$13595 \$14294 SUB pfet_06v0 L=1U W=10U AS=2.5P AD=4.4P PS=10.5U
+ PD=20.88U
M$712 \$12514 \$10835 SUB SUB pfet_06v0 L=1U W=10U AS=4.4P AD=2.5P PS=20.88U
+ PD=10.5U
M$713 \$11373 \$10830 \$12514 SUB pfet_06v0 L=1U W=10U AS=2.5P AD=4.4P PS=10.5U
+ PD=20.88U
M$714 \$12560 \$12557 SUB SUB pfet_06v0 L=1U W=10U AS=4.4P AD=2.6P PS=20.88U
+ PD=10.52U
M$715 SUB \$12557 \$12560 SUB pfet_06v0 L=1U W=10U AS=2.6P AD=2.6P PS=10.52U
+ PD=10.52U
M$716 \$12560 \$12557 SUB SUB pfet_06v0 L=1U W=10U AS=2.6P AD=4.4P PS=10.52U
+ PD=20.88U
M$717 \$10783 SUB \$11373 SUB pfet_06v0 L=1U W=10U AS=4.4P AD=4.4P PS=20.88U
+ PD=20.88U
M$718 \$10781 S2N \$11373 SUB pfet_06v0 L=1U W=10U AS=4.4P AD=4.4P PS=20.88U
+ PD=20.88U
M$719 \$11145 \$10830 \$10780 SUB pfet_06v0 L=1U W=5U AS=2.2P AD=2.2P PS=10.88U
+ PD=10.88U
M$720 \$10799 \$10830 \$10779 SUB pfet_06v0 L=1U W=5U AS=2.2P AD=2.2P PS=10.88U
+ PD=10.88U
M$721 \$10780 \$11145 SUB SUB pfet_06v0 L=1U W=5U AS=2.2P AD=2.2P PS=10.88U
+ PD=10.88U
M$722 \$10779 \$11145 SUB SUB pfet_06v0 L=1U W=5U AS=2.2P AD=2.2P PS=10.88U
+ PD=10.88U
M$723 \$14291 \$13443 SUB SUB pfet_06v0 L=1U W=10U AS=4.4P AD=2.5P PS=20.88U
+ PD=10.5U
M$724 \$12535 \$13596 \$14291 SUB pfet_06v0 L=1U W=10U AS=2.5P AD=4.4P PS=10.5U
+ PD=20.88U
M$725 \$10782 \$10785 \$11145 SUB pfet_06v0 L=1U W=5U AS=2.2P AD=2.2P PS=10.88U
+ PD=10.88U
M$726 \$14289 \$13443 SUB SUB pfet_06v0 L=1U W=10U AS=4.4P AD=2.5P PS=20.88U
+ PD=10.5U
M$727 \$12536 \$13596 \$14289 SUB pfet_06v0 L=1U W=10U AS=2.5P AD=4.4P PS=10.5U
+ PD=20.88U
M$728 \$10784 \$10785 \$10799 SUB pfet_06v0 L=1U W=5U AS=2.2P AD=2.2P PS=10.88U
+ PD=10.88U
M$729 \$13596 \$13596 SUB SUB pfet_06v0 L=1U W=2U AS=0.88P AD=0.88P PS=4.88U
+ PD=4.88U
M$730 \$12503 \$11066 SUB SUB pfet_06v0 L=1U W=10U AS=4.4P AD=2.5P PS=20.88U
+ PD=10.5U
M$731 \$11066 \$10830 \$12503 SUB pfet_06v0 L=1U W=10U AS=2.5P AD=4.4P PS=10.5U
+ PD=20.88U
M$732 \$14287 \$13443 SUB SUB pfet_06v0 L=1U W=10U AS=4.4P AD=2.5P PS=20.88U
+ PD=10.5U
M$733 \$13443 \$13596 \$14287 SUB pfet_06v0 L=1U W=10U AS=2.5P AD=4.4P PS=10.5U
+ PD=20.88U
M$734 \$10785 \$10785 \$11066 SUB pfet_06v0 L=1U W=10U AS=4.4P AD=4.4P
+ PS=20.88U PD=20.88U
M$735 \$12462 \$10835 SUB SUB pfet_06v0 L=1U W=10U AS=4.4P AD=2.5P PS=20.88U
+ PD=10.5U
M$736 \$10749 \$10830 \$12462 SUB pfet_06v0 L=1U W=10U AS=2.5P AD=4.4P PS=10.5U
+ PD=20.88U
M$737 \$14285 \$13443 SUB SUB pfet_06v0 L=1U W=10U AS=4.4P AD=2.5P PS=20.88U
+ PD=10.5U
M$738 \$12762 \$13596 \$14285 SUB pfet_06v0 L=1U W=10U AS=2.5P AD=4.4P PS=10.5U
+ PD=20.88U
M$739 \$12460 \$10835 SUB SUB pfet_06v0 L=1U W=10U AS=4.4P AD=2.5P PS=20.88U
+ PD=10.5U
M$740 \$10748 \$10830 \$12460 SUB pfet_06v0 L=1U W=10U AS=2.5P AD=4.4P PS=10.5U
+ PD=20.88U
M$741 \$14284 \$13443 SUB SUB pfet_06v0 L=1U W=10U AS=4.4P AD=2.5P PS=20.88U
+ PD=10.5U
M$742 \$12762 \$13596 \$14284 SUB pfet_06v0 L=1U W=10U AS=2.5P AD=4.4P PS=10.5U
+ PD=20.88U
M$743 \$12566 \$10836 \$12762 SUB pfet_06v0 L=1U W=10U AS=4.4P AD=2.6P
+ PS=20.88U PD=10.52U
M$744 \$12762 \$10836 \$12566 SUB pfet_06v0 L=1U W=10U AS=2.6P AD=4.4P
+ PS=10.52U PD=20.88U
M$745 \$12456 \$10835 SUB SUB pfet_06v0 L=1U W=10U AS=4.4P AD=2.5P PS=20.88U
+ PD=10.5U
M$746 \$10747 \$10830 \$12456 SUB pfet_06v0 L=1U W=10U AS=2.5P AD=4.4P PS=10.5U
+ PD=20.88U
M$747 \$10830 \$10830 SUB SUB pfet_06v0 L=1U W=2U AS=0.88P AD=0.88P PS=4.88U
+ PD=4.88U
M$748 \$12564 \$12537 \$12762 SUB pfet_06v0 L=1U W=10U AS=4.4P AD=2.6P
+ PS=20.88U PD=10.52U
M$749 \$12762 \$12537 \$12564 SUB pfet_06v0 L=1U W=10U AS=2.6P AD=4.4P
+ PS=10.52U PD=20.88U
M$750 \$12429 \$10835 SUB SUB pfet_06v0 L=1U W=10U AS=4.4P AD=2.5P PS=20.88U
+ PD=10.5U
M$751 \$10835 \$10830 \$12429 SUB pfet_06v0 L=1U W=10U AS=2.5P AD=4.4P PS=10.5U
+ PD=20.88U
M$752 \$12915 \$13596 \$12563 SUB pfet_06v0 L=1U W=5U AS=2.2P AD=1.3P PS=10.88U
+ PD=5.52U
M$753 \$12563 \$13596 \$12915 SUB pfet_06v0 L=1U W=5U AS=1.3P AD=2.2P PS=5.52U
+ PD=10.88U
M$754 \$12568 \$13596 \$12562 SUB pfet_06v0 L=1U W=5U AS=2.2P AD=1.3P PS=10.88U
+ PD=5.52U
M$755 \$12562 \$13596 \$12568 SUB pfet_06v0 L=1U W=5U AS=1.3P AD=2.2P PS=5.52U
+ PD=10.88U
M$756 \$10787 \$10799 SUB SUB pfet_06v0 L=20U W=0.7U AS=0.308P AD=0.308P
+ PS=2.28U PD=2.28U
M$757 \$12563 \$12915 SUB SUB pfet_06v0 L=1U W=5U AS=2.2P AD=1.3P PS=10.88U
+ PD=5.52U
M$758 SUB \$12915 \$12563 SUB pfet_06v0 L=1U W=5U AS=1.3P AD=1.3P PS=5.52U
+ PD=5.52U
M$759 \$12563 \$12915 SUB SUB pfet_06v0 L=1U W=5U AS=1.3P AD=1.3P PS=5.52U
+ PD=5.52U
M$760 SUB \$12915 \$12563 SUB pfet_06v0 L=1U W=5U AS=1.3P AD=2.2P PS=5.52U
+ PD=10.88U
M$761 \$12562 \$12915 SUB SUB pfet_06v0 L=1U W=5U AS=2.2P AD=1.3P PS=10.88U
+ PD=5.52U
M$762 SUB \$12915 \$12562 SUB pfet_06v0 L=1U W=5U AS=1.3P AD=1.3P PS=5.52U
+ PD=5.52U
M$763 \$12562 \$12915 SUB SUB pfet_06v0 L=1U W=5U AS=1.3P AD=1.3P PS=5.52U
+ PD=5.52U
M$764 SUB \$12915 \$12562 SUB pfet_06v0 L=1U W=5U AS=1.3P AD=2.2P PS=5.52U
+ PD=10.88U
M$765 \$12565 \$12569 \$12915 SUB pfet_06v0 L=1U W=5U AS=2.2P AD=2.2P PS=10.88U
+ PD=10.88U
M$766 \$10862 \$1884 \$7889 SUB pfet_06v0 L=1U W=3U AS=1.32P AD=0.75P PS=6.88U
+ PD=3.5U
M$767 SUB \$1862 \$10862 SUB pfet_06v0 L=1U W=3U AS=0.75P AD=1.32P PS=3.5U
+ PD=6.88U
M$768 \$12567 \$12569 \$12568 SUB pfet_06v0 L=1U W=5U AS=2.2P AD=2.2P PS=10.88U
+ PD=10.88U
M$769 \$10750 \$10751 SUB SUB pfet_06v0 L=1U W=3U AS=1.32P AD=1.32P PS=6.88U
+ PD=6.88U
M$770 \$14281 \$12607 SUB SUB pfet_06v0 L=1U W=10U AS=4.4P AD=2.5P PS=20.88U
+ PD=10.5U
M$771 \$12607 \$13596 \$14281 SUB pfet_06v0 L=1U W=10U AS=2.5P AD=4.4P PS=10.5U
+ PD=20.88U
M$772 \$10752 \$10753 SUB SUB pfet_06v0 L=1U W=3U AS=1.32P AD=1.32P PS=6.88U
+ PD=6.88U
M$773 \$12569 \$12569 \$12607 SUB pfet_06v0 L=1U W=10U AS=4.4P AD=4.4P
+ PS=20.88U PD=20.88U
M$774 SUB \$1884 \$10753 SUB pfet_06v0 L=1U W=3U AS=1.32P AD=1.32P PS=6.88U
+ PD=6.88U
M$775 \$14277 \$13443 SUB SUB pfet_06v0 L=1U W=10U AS=4.4P AD=2.5P PS=20.88U
+ PD=10.5U
M$776 \$12538 \$13596 \$14277 SUB pfet_06v0 L=1U W=10U AS=2.5P AD=4.4P PS=10.5U
+ PD=20.88U
M$777 SUB \$10750 \$10753 SUB pfet_06v0 L=1U W=3U AS=1.32P AD=1.32P PS=6.88U
+ PD=6.88U
M$778 \$12571 \$12568 SUB SUB pfet_06v0 L=1U W=10U AS=4.4P AD=2.6P PS=20.88U
+ PD=10.52U
M$779 SUB \$12568 \$12571 SUB pfet_06v0 L=1U W=10U AS=2.6P AD=2.6P PS=10.52U
+ PD=10.52U
M$780 \$12571 \$12568 SUB SUB pfet_06v0 L=1U W=10U AS=2.6P AD=4.4P PS=10.52U
+ PD=20.88U
M$781 \$10754 \$10755 SUB SUB pfet_06v0 L=1U W=3U AS=1.32P AD=1.32P PS=6.88U
+ PD=6.88U
M$782 SUB \$10751 \$10755 SUB pfet_06v0 L=1U W=3U AS=1.32P AD=1.32P PS=6.88U
+ PD=6.88U
M$783 SUB \$1862 \$10755 SUB pfet_06v0 L=1U W=3U AS=1.32P AD=1.32P PS=6.88U
+ PD=6.88U
M$784 \$14331 \$14300 \$7663 SUB pfet_06v0 L=1U W=3U AS=1.32P AD=0.75P PS=6.88U
+ PD=3.5U
M$785 SUB \$14301 \$14331 SUB pfet_06v0 L=1U W=3U AS=0.75P AD=1.32P PS=3.5U
+ PD=6.88U
M$786 \$14314 \$14302 SUB SUB pfet_06v0 L=1U W=3U AS=1.32P AD=1.32P PS=6.88U
+ PD=6.88U
M$787 \$4234 \$14303 SUB SUB pfet_06v0 L=1U W=3U AS=1.32P AD=1.32P PS=6.88U
+ PD=6.88U
M$788 SUB \$14300 \$14303 SUB pfet_06v0 L=1U W=3U AS=1.32P AD=1.32P PS=6.88U
+ PD=6.88U
M$789 SUB \$14314 \$14303 SUB pfet_06v0 L=1U W=3U AS=1.32P AD=1.32P PS=6.88U
+ PD=6.88U
M$790 \$1787 \$14304 SUB SUB pfet_06v0 L=1U W=3U AS=1.32P AD=1.32P PS=6.88U
+ PD=6.88U
M$791 SUB \$14302 \$14304 SUB pfet_06v0 L=1U W=3U AS=1.32P AD=1.32P PS=6.88U
+ PD=6.88U
M$792 SUB \$14301 \$14304 SUB pfet_06v0 L=1U W=3U AS=1.32P AD=1.32P PS=6.88U
+ PD=6.88U
M$793 \$14333 \$9010 \$7210 SUB pfet_06v0 L=1U W=3U AS=1.32P AD=0.75P PS=6.88U
+ PD=3.5U
M$794 SUB \$14305 \$14333 SUB pfet_06v0 L=1U W=3U AS=0.75P AD=1.32P PS=3.5U
+ PD=6.88U
M$795 \$14315 \$14306 SUB SUB pfet_06v0 L=1U W=3U AS=1.32P AD=1.32P PS=6.88U
+ PD=6.88U
M$796 \$14316 \$14307 SUB SUB pfet_06v0 L=1U W=3U AS=1.32P AD=1.32P PS=6.88U
+ PD=6.88U
M$797 SUB \$9010 \$14307 SUB pfet_06v0 L=1U W=3U AS=1.32P AD=1.32P PS=6.88U
+ PD=6.88U
M$798 SUB \$14315 \$14307 SUB pfet_06v0 L=1U W=3U AS=1.32P AD=1.32P PS=6.88U
+ PD=6.88U
M$799 \$14317 \$14308 SUB SUB pfet_06v0 L=1U W=3U AS=1.32P AD=1.32P PS=6.88U
+ PD=6.88U
M$800 SUB \$14306 \$14308 SUB pfet_06v0 L=1U W=3U AS=1.32P AD=1.32P PS=6.88U
+ PD=6.88U
M$801 SUB \$14305 \$14308 SUB pfet_06v0 L=1U W=3U AS=1.32P AD=1.32P PS=6.88U
+ PD=6.88U
M$802 \$14332 \$14309 \$7504 SUB pfet_06v0 L=1U W=3U AS=1.32P AD=0.75P PS=6.88U
+ PD=3.5U
M$803 SUB \$14310 \$14332 SUB pfet_06v0 L=1U W=3U AS=0.75P AD=1.32P PS=3.5U
+ PD=6.88U
M$804 \$14318 \$14311 SUB SUB pfet_06v0 L=1U W=3U AS=1.32P AD=1.32P PS=6.88U
+ PD=6.88U
M$805 \$14319 \$14312 SUB SUB pfet_06v0 L=1U W=3U AS=1.32P AD=1.32P PS=6.88U
+ PD=6.88U
M$806 SUB \$14309 \$14312 SUB pfet_06v0 L=1U W=3U AS=1.32P AD=1.32P PS=6.88U
+ PD=6.88U
M$807 SUB \$14318 \$14312 SUB pfet_06v0 L=1U W=3U AS=1.32P AD=1.32P PS=6.88U
+ PD=6.88U
M$808 \$14320 \$14313 SUB SUB pfet_06v0 L=1U W=3U AS=1.32P AD=1.32P PS=6.88U
+ PD=6.88U
M$809 SUB \$14311 \$14313 SUB pfet_06v0 L=1U W=3U AS=1.32P AD=1.32P PS=6.88U
+ PD=6.88U
M$810 SUB \$14310 \$14313 SUB pfet_06v0 L=1U W=3U AS=1.32P AD=1.32P PS=6.88U
+ PD=6.88U
M$811 \$10 \$68 SUB SUB nfet_05v0 L=0.6U W=1.32U AS=0.5808P AD=0.5808P PS=3.52U
+ PD=3.52U
M$812 \$13 \$10 SUB SUB nfet_05v0 L=0.6U W=1.32U AS=0.5808P AD=0.5808P PS=3.52U
+ PD=3.52U
M$813 \$14 \$13 SUB SUB nfet_05v0 L=0.6U W=1.32U AS=0.5808P AD=0.5808P PS=3.52U
+ PD=3.52U
M$814 \$3592 \$3653 SUB SUB nfet_05v0 L=0.6U W=1.32U AS=0.5808P AD=0.5808P
+ PS=3.52U PD=3.52U
M$815 \$3593 \$3592 SUB SUB nfet_05v0 L=0.6U W=1.32U AS=0.5808P AD=0.5808P
+ PS=3.52U PD=3.52U
M$816 \$3594 \$3593 SUB SUB nfet_05v0 L=0.6U W=1.32U AS=0.5808P AD=0.5808P
+ PS=3.52U PD=3.52U
M$817 \$7168 \$7228 SUB SUB nfet_05v0 L=0.6U W=1.32U AS=0.5808P AD=0.5808P
+ PS=3.52U PD=3.52U
M$818 Z \$7168 SUB SUB nfet_05v0 L=0.6U W=1.32U AS=0.5808P AD=0.5808P PS=3.52U
+ PD=3.52U
M$819 \$7169 Z SUB SUB nfet_05v0 L=0.6U W=1.32U AS=0.5808P AD=0.5808P PS=3.52U
+ PD=3.52U
M$820 \$68 \$11 \$9 SUB nfet_06v0 L=1U W=2.48U AS=1.0912P AD=0.6448P PS=5.84U
+ PD=3U
M$821 \$9 \$11 \$68 SUB nfet_06v0 L=1U W=2.48U AS=0.6448P AD=1.0912P PS=3U
+ PD=5.84U
M$822 \$9 \$12 SUB SUB nfet_06v0 L=1U W=1.24U AS=0.5456P AD=0.5456P PS=3.36U
+ PD=3.36U
M$823 \$66 \$12 SUB SUB nfet_06v0 L=1U W=1.24U AS=0.5456P AD=0.5456P PS=3.36U
+ PD=3.36U
M$824 \$53 \$12 SUB SUB nfet_06v0 L=1U W=0.7U AS=0.308P AD=0.175P PS=2.28U
+ PD=1.2U
M$825 \$52 \$12 \$53 SUB nfet_06v0 L=1U W=0.7U AS=0.175P AD=0.175P PS=1.2U
+ PD=1.2U
M$826 \$51 \$12 \$52 SUB nfet_06v0 L=1U W=0.7U AS=0.175P AD=0.175P PS=1.2U
+ PD=1.2U
M$827 \$12 \$12 \$51 SUB nfet_06v0 L=1U W=0.7U AS=0.175P AD=0.308P PS=1.2U
+ PD=2.28U
M$828 \$81 \$16 SUB SUB nfet_06v0 L=1U W=5U AS=2.2P AD=1.25P PS=10.88U PD=5.5U
M$829 \$18 \$17 \$81 SUB nfet_06v0 L=1U W=5U AS=1.25P AD=2.2P PS=5.5U PD=10.88U
M$830 \$82 \$16 SUB SUB nfet_06v0 L=1U W=5U AS=2.2P AD=1.25P PS=10.88U PD=5.5U
M$831 \$18 \$17 \$82 SUB nfet_06v0 L=1U W=5U AS=1.25P AD=2.2P PS=5.5U PD=10.88U
M$832 \$20 S1P \$18 SUB nfet_06v0 L=1U W=5U AS=2.2P AD=2.2P PS=10.88U PD=10.88U
M$833 \$21 S1N \$18 SUB nfet_06v0 L=1U W=5U AS=2.2P AD=2.2P PS=10.88U PD=10.88U
M$834 \$23 \$17 \$22 SUB nfet_06v0 L=1U W=2.5U AS=1.1P AD=1.1P PS=5.88U PD=5.88U
M$835 \$24 \$17 \$97 SUB nfet_06v0 L=1U W=2.5U AS=1.1P AD=1.1P PS=5.88U PD=5.88U
M$836 \$22 \$23 SUB SUB nfet_06v0 L=1U W=2.5U AS=1.1P AD=1.1P PS=5.88U PD=5.88U
M$837 \$97 \$23 SUB SUB nfet_06v0 L=1U W=2.5U AS=1.1P AD=1.1P PS=5.88U PD=5.88U
M$838 \$502 \$25 \$23 SUB nfet_06v0 L=1U W=2.5U AS=1.1P AD=1.1P PS=5.88U
+ PD=5.88U
M$839 \$55 \$25 \$24 SUB nfet_06v0 L=1U W=2.5U AS=1.1P AD=1.1P PS=5.88U PD=5.88U
M$840 \$84 \$16 SUB SUB nfet_06v0 L=1U W=5U AS=2.2P AD=1.25P PS=10.88U PD=5.5U
M$841 \$26 \$17 \$84 SUB nfet_06v0 L=1U W=5U AS=1.25P AD=2.2P PS=5.5U PD=10.88U
M$842 \$25 \$25 \$27 SUB nfet_06v0 L=1U W=5U AS=2.2P AD=2.2P PS=10.88U PD=10.88U
M$843 \$85 \$27 SUB SUB nfet_06v0 L=1U W=5U AS=2.2P AD=1.25P PS=10.88U PD=5.5U
M$844 \$27 \$17 \$85 SUB nfet_06v0 L=1U W=5U AS=1.25P AD=2.2P PS=5.5U PD=10.88U
M$845 \$100 \$24 SUB SUB nfet_06v0 L=1U W=1U AS=0.44P AD=0.44P PS=2.88U PD=2.88U
M$846 \$17 \$17 SUB SUB nfet_06v0 L=1U W=1U AS=0.44P AD=0.44P PS=2.88U PD=2.88U
M$847 \$86 \$16 SUB SUB nfet_06v0 L=1U W=5U AS=2.2P AD=1.25P PS=10.88U PD=5.5U
M$848 \$16 \$17 \$86 SUB nfet_06v0 L=1U W=5U AS=1.25P AD=2.2P PS=5.5U PD=10.88U
M$849 \$62 \$110 SUB SUB nfet_06v0 L=1U W=1U AS=0.44P AD=0.25P PS=2.88U PD=1.5U
M$850 \$113 \$110 \$62 SUB nfet_06v0 L=1U W=1U AS=0.25P AD=0.44P PS=1.5U
+ PD=2.88U
M$851 \$63 \$110 SUB SUB nfet_06v0 L=1U W=1U AS=0.44P AD=0.25P PS=2.88U PD=1.5U
M$852 \$110 \$110 \$63 SUB nfet_06v0 L=1U W=1U AS=0.25P AD=0.44P PS=1.5U
+ PD=2.88U
M$853 \$87 \$28 SUB SUB nfet_06v0 L=1U W=5U AS=2.2P AD=1.25P PS=10.88U PD=5.5U
M$854 \$30 \$29 \$87 SUB nfet_06v0 L=1U W=5U AS=1.25P AD=2.2P PS=5.5U PD=10.88U
M$855 \$88 \$28 SUB SUB nfet_06v0 L=1U W=5U AS=2.2P AD=1.25P PS=10.88U PD=5.5U
M$856 \$30 \$29 \$88 SUB nfet_06v0 L=1U W=5U AS=1.25P AD=2.2P PS=5.5U PD=10.88U
M$857 \$32 S2P \$30 SUB nfet_06v0 L=1U W=5U AS=2.2P AD=2.2P PS=10.88U PD=10.88U
M$858 \$33 \$347 \$30 SUB nfet_06v0 L=1U W=5U AS=2.2P AD=2.2P PS=10.88U
+ PD=10.88U
M$859 \$35 \$29 \$34 SUB nfet_06v0 L=1U W=2.5U AS=1.1P AD=1.1P PS=5.88U PD=5.88U
M$860 \$36 \$29 \$102 SUB nfet_06v0 L=1U W=2.5U AS=1.1P AD=1.1P PS=5.88U
+ PD=5.88U
M$861 \$34 \$35 SUB SUB nfet_06v0 L=1U W=2.5U AS=1.1P AD=1.1P PS=5.88U PD=5.88U
M$862 \$102 \$35 SUB SUB nfet_06v0 L=1U W=2.5U AS=1.1P AD=1.1P PS=5.88U PD=5.88U
M$863 \$504 \$37 \$35 SUB nfet_06v0 L=1U W=2.5U AS=1.1P AD=1.1P PS=5.88U
+ PD=5.88U
M$864 \$57 \$37 \$36 SUB nfet_06v0 L=1U W=2.5U AS=1.1P AD=1.1P PS=5.88U PD=5.88U
M$865 \$89 \$28 SUB SUB nfet_06v0 L=1U W=5U AS=2.2P AD=1.25P PS=10.88U PD=5.5U
M$866 \$38 \$29 \$89 SUB nfet_06v0 L=1U W=5U AS=1.25P AD=2.2P PS=5.5U PD=10.88U
M$867 \$37 \$37 \$39 SUB nfet_06v0 L=1U W=5U AS=2.2P AD=2.2P PS=10.88U PD=10.88U
M$868 \$90 \$39 SUB SUB nfet_06v0 L=1U W=5U AS=2.2P AD=1.25P PS=10.88U PD=5.5U
M$869 \$39 \$29 \$90 SUB nfet_06v0 L=1U W=5U AS=1.25P AD=2.2P PS=5.5U PD=10.88U
M$870 \$105 \$36 SUB SUB nfet_06v0 L=1U W=1U AS=0.44P AD=0.44P PS=2.88U PD=2.88U
M$871 \$29 \$29 SUB SUB nfet_06v0 L=1U W=1U AS=0.44P AD=0.44P PS=2.88U PD=2.88U
M$872 \$91 \$28 SUB SUB nfet_06v0 L=1U W=5U AS=2.2P AD=1.25P PS=10.88U PD=5.5U
M$873 \$28 \$29 \$91 SUB nfet_06v0 L=1U W=5U AS=1.25P AD=2.2P PS=5.5U PD=10.88U
M$874 \$65 \$111 SUB SUB nfet_06v0 L=1U W=1U AS=0.44P AD=0.25P PS=2.88U PD=1.5U
M$875 \$114 \$111 \$65 SUB nfet_06v0 L=1U W=1U AS=0.25P AD=0.44P PS=1.5U
+ PD=2.88U
M$876 \$64 \$111 SUB SUB nfet_06v0 L=1U W=1U AS=0.44P AD=0.25P PS=2.88U PD=1.5U
M$877 \$111 \$111 \$64 SUB nfet_06v0 L=1U W=1U AS=0.25P AD=0.44P PS=1.5U
+ PD=2.88U
M$878 \$93 \$40 SUB SUB nfet_06v0 L=1U W=5U AS=2.2P AD=1.25P PS=10.88U PD=5.5U
M$879 \$42 \$41 \$93 SUB nfet_06v0 L=1U W=5U AS=1.25P AD=2.2P PS=5.5U PD=10.88U
M$880 \$94 \$40 SUB SUB nfet_06v0 L=1U W=5U AS=2.2P AD=1.25P PS=10.88U PD=5.5U
M$881 \$42 \$41 \$94 SUB nfet_06v0 L=1U W=5U AS=1.25P AD=2.2P PS=5.5U PD=10.88U
M$882 \$43 S3P \$42 SUB nfet_06v0 L=1U W=5U AS=2.2P AD=2.2P PS=10.88U PD=10.88U
M$883 \$44 S3N \$42 SUB nfet_06v0 L=1U W=5U AS=2.2P AD=2.2P PS=10.88U PD=10.88U
M$884 \$46 \$41 \$45 SUB nfet_06v0 L=1U W=2.5U AS=1.1P AD=1.1P PS=5.88U PD=5.88U
M$885 \$47 \$41 \$106 SUB nfet_06v0 L=1U W=2.5U AS=1.1P AD=1.1P PS=5.88U
+ PD=5.88U
M$886 \$45 \$46 SUB SUB nfet_06v0 L=1U W=2.5U AS=1.1P AD=1.1P PS=5.88U PD=5.88U
M$887 \$106 \$46 SUB SUB nfet_06v0 L=1U W=2.5U AS=1.1P AD=1.1P PS=5.88U PD=5.88U
M$888 \$506 \$48 \$46 SUB nfet_06v0 L=1U W=2.5U AS=1.1P AD=1.1P PS=5.88U
+ PD=5.88U
M$889 \$59 \$48 \$47 SUB nfet_06v0 L=1U W=2.5U AS=1.1P AD=1.1P PS=5.88U PD=5.88U
M$890 \$96 \$40 SUB SUB nfet_06v0 L=1U W=5U AS=2.2P AD=1.25P PS=10.88U PD=5.5U
M$891 \$49 \$41 \$96 SUB nfet_06v0 L=1U W=5U AS=1.25P AD=2.2P PS=5.5U PD=10.88U
M$892 \$48 \$48 \$50 SUB nfet_06v0 L=1U W=5U AS=2.2P AD=2.2P PS=10.88U PD=10.88U
M$893 \$95 \$50 SUB SUB nfet_06v0 L=1U W=5U AS=2.2P AD=1.25P PS=10.88U PD=5.5U
M$894 \$50 \$41 \$95 SUB nfet_06v0 L=1U W=5U AS=1.25P AD=2.2P PS=5.5U PD=10.88U
M$895 \$109 \$47 SUB SUB nfet_06v0 L=1U W=1U AS=0.44P AD=0.44P PS=2.88U PD=2.88U
M$896 \$41 \$41 SUB SUB nfet_06v0 L=1U W=1U AS=0.44P AD=0.44P PS=2.88U PD=2.88U
M$897 \$92 \$40 SUB SUB nfet_06v0 L=1U W=5U AS=2.2P AD=1.25P PS=10.88U PD=5.5U
M$898 \$40 \$41 \$92 SUB nfet_06v0 L=1U W=5U AS=1.25P AD=2.2P PS=5.5U PD=10.88U
M$899 \$61 \$112 SUB SUB nfet_06v0 L=1U W=1U AS=0.44P AD=0.25P PS=2.88U PD=1.5U
M$900 \$115 \$112 \$61 SUB nfet_06v0 L=1U W=1U AS=0.25P AD=0.44P PS=1.5U
+ PD=2.88U
M$901 \$60 \$112 SUB SUB nfet_06v0 L=1U W=1U AS=0.44P AD=0.25P PS=2.88U PD=1.5U
M$902 \$112 \$112 \$60 SUB nfet_06v0 L=1U W=1U AS=0.25P AD=0.44P PS=1.5U
+ PD=2.88U
M$903 \$1814 \$1814 SUB SUB nfet_06v0 L=1U W=1U AS=0.44P AD=0.44P PS=2.88U
+ PD=2.88U
M$904 \$1863 \$1815 SUB SUB nfet_06v0 L=1U W=5U AS=2.2P AD=1.25P PS=10.88U
+ PD=5.5U
M$905 \$1815 \$1814 \$1863 SUB nfet_06v0 L=1U W=5U AS=1.25P AD=2.2P PS=5.5U
+ PD=10.88U
M$906 \$1856 \$2883 SUB SUB nfet_06v0 L=1U W=1U AS=0.44P AD=0.25P PS=2.88U
+ PD=1.5U
M$907 \$2730 \$2883 \$1856 SUB nfet_06v0 L=1U W=1U AS=0.25P AD=0.44P PS=1.5U
+ PD=2.88U
M$908 \$1857 \$2883 SUB SUB nfet_06v0 L=1U W=1U AS=0.44P AD=0.25P PS=2.88U
+ PD=1.5U
M$909 \$2883 \$2883 \$1857 SUB nfet_06v0 L=1U W=1U AS=0.25P AD=0.44P PS=1.5U
+ PD=2.88U
M$910 \$1864 \$1815 SUB SUB nfet_06v0 L=1U W=5U AS=2.2P AD=1.25P PS=10.88U
+ PD=5.5U
M$911 \$1826 \$1814 \$1864 SUB nfet_06v0 L=1U W=5U AS=1.25P AD=2.2P PS=5.5U
+ PD=10.88U
M$912 \$1865 \$1815 SUB SUB nfet_06v0 L=1U W=5U AS=2.2P AD=1.25P PS=10.88U
+ PD=5.5U
M$913 \$1826 \$1814 \$1865 SUB nfet_06v0 L=1U W=5U AS=1.25P AD=2.2P PS=5.5U
+ PD=10.88U
M$914 \$1827 \$1891 \$1826 SUB nfet_06v0 L=1U W=5U AS=2.2P AD=1.3P PS=10.88U
+ PD=5.52U
M$915 \$1826 \$1891 \$1827 SUB nfet_06v0 L=1U W=5U AS=1.3P AD=2.2P PS=5.52U
+ PD=10.88U
M$916 \$1828 \$1816 \$1826 SUB nfet_06v0 L=1U W=5U AS=2.2P AD=1.3P PS=10.88U
+ PD=5.52U
M$917 \$1826 \$1816 \$1828 SUB nfet_06v0 L=1U W=5U AS=1.3P AD=2.2P PS=5.52U
+ PD=10.88U
M$918 \$1830 \$1814 \$1829 SUB nfet_06v0 L=1U W=2.5U AS=1.1P AD=0.65P PS=5.88U
+ PD=3.02U
M$919 \$1829 \$1814 \$1830 SUB nfet_06v0 L=1U W=2.5U AS=0.65P AD=1.1P PS=3.02U
+ PD=5.88U
M$920 \$1832 \$1814 \$1831 SUB nfet_06v0 L=1U W=2.5U AS=1.1P AD=0.65P PS=5.88U
+ PD=3.02U
M$921 \$1831 \$1814 \$1832 SUB nfet_06v0 L=1U W=2.5U AS=0.65P AD=1.1P PS=3.02U
+ PD=5.88U
M$922 \$1829 \$1830 SUB SUB nfet_06v0 L=1U W=2.5U AS=1.1P AD=0.65P PS=5.88U
+ PD=3.02U
M$923 SUB \$1830 \$1829 SUB nfet_06v0 L=1U W=2.5U AS=0.65P AD=0.65P PS=3.02U
+ PD=3.02U
M$924 \$1829 \$1830 SUB SUB nfet_06v0 L=1U W=2.5U AS=0.65P AD=0.65P PS=3.02U
+ PD=3.02U
M$925 SUB \$1830 \$1829 SUB nfet_06v0 L=1U W=2.5U AS=0.65P AD=1.1P PS=3.02U
+ PD=5.88U
M$926 \$1831 \$1830 SUB SUB nfet_06v0 L=1U W=2.5U AS=1.1P AD=0.65P PS=5.88U
+ PD=3.02U
M$927 SUB \$1830 \$1831 SUB nfet_06v0 L=1U W=2.5U AS=0.65P AD=0.65P PS=3.02U
+ PD=3.02U
M$928 \$1831 \$1830 SUB SUB nfet_06v0 L=1U W=2.5U AS=0.65P AD=0.65P PS=3.02U
+ PD=3.02U
M$929 SUB \$1830 \$1831 SUB nfet_06v0 L=1U W=2.5U AS=0.65P AD=1.1P PS=3.02U
+ PD=5.88U
M$930 \$2124 \$1817 \$1830 SUB nfet_06v0 L=1U W=2.5U AS=1.1P AD=1.1P PS=5.88U
+ PD=5.88U
M$931 \$2352 \$1817 \$1832 SUB nfet_06v0 L=1U W=2.5U AS=1.1P AD=1.1P PS=5.88U
+ PD=5.88U
M$932 \$1867 \$1815 SUB SUB nfet_06v0 L=1U W=5U AS=2.2P AD=1.25P PS=10.88U
+ PD=5.5U
M$933 \$1833 \$1814 \$1867 SUB nfet_06v0 L=1U W=5U AS=1.25P AD=2.2P PS=5.5U
+ PD=10.88U
M$934 \$1817 \$1817 \$1834 SUB nfet_06v0 L=1U W=5U AS=2.2P AD=2.2P PS=10.88U
+ PD=10.88U
M$935 \$1868 \$1834 SUB SUB nfet_06v0 L=1U W=5U AS=2.2P AD=1.25P PS=10.88U
+ PD=5.5U
M$936 \$1834 \$1814 \$1868 SUB nfet_06v0 L=1U W=5U AS=1.25P AD=2.2P PS=5.5U
+ PD=10.88U
M$937 \$1835 \$1832 SUB SUB nfet_06v0 L=1U W=5U AS=2.2P AD=1.3P PS=10.88U
+ PD=5.52U
M$938 SUB \$1832 \$1835 SUB nfet_06v0 L=1U W=5U AS=1.3P AD=1.3P PS=5.52U
+ PD=5.52U
M$939 \$1835 \$1832 SUB SUB nfet_06v0 L=1U W=5U AS=1.3P AD=2.2P PS=5.52U
+ PD=10.88U
M$940 \$1818 \$1818 SUB SUB nfet_06v0 L=1U W=1U AS=0.44P AD=0.44P PS=2.88U
+ PD=2.88U
M$941 \$1870 \$1819 SUB SUB nfet_06v0 L=1U W=5U AS=2.2P AD=1.25P PS=10.88U
+ PD=5.5U
M$942 \$1819 \$1818 \$1870 SUB nfet_06v0 L=1U W=5U AS=1.25P AD=2.2P PS=5.5U
+ PD=10.88U
M$943 \$1860 \$2884 SUB SUB nfet_06v0 L=1U W=1U AS=0.44P AD=0.25P PS=2.88U
+ PD=1.5U
M$944 \$2731 \$2884 \$1860 SUB nfet_06v0 L=1U W=1U AS=0.25P AD=0.44P PS=1.5U
+ PD=2.88U
M$945 \$1861 \$2884 SUB SUB nfet_06v0 L=1U W=1U AS=0.44P AD=0.25P PS=2.88U
+ PD=1.5U
M$946 \$2884 \$2884 \$1861 SUB nfet_06v0 L=1U W=1U AS=0.25P AD=0.44P PS=1.5U
+ PD=2.88U
M$947 \$1871 \$1819 SUB SUB nfet_06v0 L=1U W=5U AS=2.2P AD=1.25P PS=10.88U
+ PD=5.5U
M$948 \$1836 \$1818 \$1871 SUB nfet_06v0 L=1U W=5U AS=1.25P AD=2.2P PS=5.5U
+ PD=10.88U
M$949 \$1872 \$1819 SUB SUB nfet_06v0 L=1U W=5U AS=2.2P AD=1.25P PS=10.88U
+ PD=5.5U
M$950 \$1836 \$1818 \$1872 SUB nfet_06v0 L=1U W=5U AS=1.25P AD=2.2P PS=5.5U
+ PD=10.88U
M$951 \$1837 \$1893 \$1836 SUB nfet_06v0 L=1U W=5U AS=2.2P AD=1.3P PS=10.88U
+ PD=5.52U
M$952 \$1836 \$1893 \$1837 SUB nfet_06v0 L=1U W=5U AS=1.3P AD=2.2P PS=5.52U
+ PD=10.88U
M$953 \$1838 \$1820 \$1836 SUB nfet_06v0 L=1U W=5U AS=2.2P AD=1.3P PS=10.88U
+ PD=5.52U
M$954 \$1836 \$1820 \$1838 SUB nfet_06v0 L=1U W=5U AS=1.3P AD=2.2P PS=5.52U
+ PD=10.88U
M$955 \$1840 \$1818 \$1839 SUB nfet_06v0 L=1U W=2.5U AS=1.1P AD=0.65P PS=5.88U
+ PD=3.02U
M$956 \$1839 \$1818 \$1840 SUB nfet_06v0 L=1U W=2.5U AS=0.65P AD=1.1P PS=3.02U
+ PD=5.88U
M$957 \$1842 \$1818 \$1841 SUB nfet_06v0 L=1U W=2.5U AS=1.1P AD=0.65P PS=5.88U
+ PD=3.02U
M$958 \$1841 \$1818 \$1842 SUB nfet_06v0 L=1U W=2.5U AS=0.65P AD=1.1P PS=3.02U
+ PD=5.88U
M$959 \$1839 \$1840 SUB SUB nfet_06v0 L=1U W=2.5U AS=1.1P AD=0.65P PS=5.88U
+ PD=3.02U
M$960 SUB \$1840 \$1839 SUB nfet_06v0 L=1U W=2.5U AS=0.65P AD=0.65P PS=3.02U
+ PD=3.02U
M$961 \$1839 \$1840 SUB SUB nfet_06v0 L=1U W=2.5U AS=0.65P AD=0.65P PS=3.02U
+ PD=3.02U
M$962 SUB \$1840 \$1839 SUB nfet_06v0 L=1U W=2.5U AS=0.65P AD=1.1P PS=3.02U
+ PD=5.88U
M$963 \$1841 \$1840 SUB SUB nfet_06v0 L=1U W=2.5U AS=1.1P AD=0.65P PS=5.88U
+ PD=3.02U
M$964 SUB \$1840 \$1841 SUB nfet_06v0 L=1U W=2.5U AS=0.65P AD=0.65P PS=3.02U
+ PD=3.02U
M$965 \$1841 \$1840 SUB SUB nfet_06v0 L=1U W=2.5U AS=0.65P AD=0.65P PS=3.02U
+ PD=3.02U
M$966 SUB \$1840 \$1841 SUB nfet_06v0 L=1U W=2.5U AS=0.65P AD=1.1P PS=3.02U
+ PD=5.88U
M$967 \$2125 \$1821 \$1840 SUB nfet_06v0 L=1U W=2.5U AS=1.1P AD=1.1P PS=5.88U
+ PD=5.88U
M$968 \$2353 \$1821 \$1842 SUB nfet_06v0 L=1U W=2.5U AS=1.1P AD=1.1P PS=5.88U
+ PD=5.88U
M$969 \$1873 \$1819 SUB SUB nfet_06v0 L=1U W=5U AS=2.2P AD=1.25P PS=10.88U
+ PD=5.5U
M$970 \$1843 \$1818 \$1873 SUB nfet_06v0 L=1U W=5U AS=1.25P AD=2.2P PS=5.5U
+ PD=10.88U
M$971 \$1821 \$1821 \$1844 SUB nfet_06v0 L=1U W=5U AS=2.2P AD=2.2P PS=10.88U
+ PD=10.88U
M$972 \$1874 \$1844 SUB SUB nfet_06v0 L=1U W=5U AS=2.2P AD=1.25P PS=10.88U
+ PD=5.5U
M$973 \$1844 \$1818 \$1874 SUB nfet_06v0 L=1U W=5U AS=1.25P AD=2.2P PS=5.5U
+ PD=10.88U
M$974 \$1845 \$1842 SUB SUB nfet_06v0 L=1U W=5U AS=2.2P AD=1.3P PS=10.88U
+ PD=5.52U
M$975 SUB \$1842 \$1845 SUB nfet_06v0 L=1U W=5U AS=1.3P AD=1.3P PS=5.52U
+ PD=5.52U
M$976 \$1845 \$1842 SUB SUB nfet_06v0 L=1U W=5U AS=1.3P AD=2.2P PS=5.52U
+ PD=10.88U
M$977 \$1822 \$1822 SUB SUB nfet_06v0 L=1U W=1U AS=0.44P AD=0.44P PS=2.88U
+ PD=2.88U
M$978 \$1875 \$1823 SUB SUB nfet_06v0 L=1U W=5U AS=2.2P AD=1.25P PS=10.88U
+ PD=5.5U
M$979 \$1823 \$1822 \$1875 SUB nfet_06v0 L=1U W=5U AS=1.25P AD=2.2P PS=5.5U
+ PD=10.88U
M$980 \$1859 \$2885 SUB SUB nfet_06v0 L=1U W=1U AS=0.44P AD=0.25P PS=2.88U
+ PD=1.5U
M$981 \$2732 \$2885 \$1859 SUB nfet_06v0 L=1U W=1U AS=0.25P AD=0.44P PS=1.5U
+ PD=2.88U
M$982 \$1858 \$2885 SUB SUB nfet_06v0 L=1U W=1U AS=0.44P AD=0.25P PS=2.88U
+ PD=1.5U
M$983 \$2885 \$2885 \$1858 SUB nfet_06v0 L=1U W=1U AS=0.25P AD=0.44P PS=1.5U
+ PD=2.88U
M$984 \$1876 \$1823 SUB SUB nfet_06v0 L=1U W=5U AS=2.2P AD=1.25P PS=10.88U
+ PD=5.5U
M$985 \$1846 \$1822 \$1876 SUB nfet_06v0 L=1U W=5U AS=1.25P AD=2.2P PS=5.5U
+ PD=10.88U
M$986 \$1877 \$1823 SUB SUB nfet_06v0 L=1U W=5U AS=2.2P AD=1.25P PS=10.88U
+ PD=5.5U
M$987 \$1846 \$1822 \$1877 SUB nfet_06v0 L=1U W=5U AS=1.25P AD=2.2P PS=5.5U
+ PD=10.88U
M$988 \$1847 \$78 \$1846 SUB nfet_06v0 L=1U W=5U AS=2.2P AD=1.3P PS=10.88U
+ PD=5.52U
M$989 \$1846 \$78 \$1847 SUB nfet_06v0 L=1U W=5U AS=1.3P AD=2.2P PS=5.52U
+ PD=10.88U
M$990 \$1848 \$1824 \$1846 SUB nfet_06v0 L=1U W=5U AS=2.2P AD=1.3P PS=10.88U
+ PD=5.52U
M$991 \$1846 \$1824 \$1848 SUB nfet_06v0 L=1U W=5U AS=1.3P AD=2.2P PS=5.52U
+ PD=10.88U
M$992 \$1850 \$1822 \$1849 SUB nfet_06v0 L=1U W=2.5U AS=1.1P AD=0.65P PS=5.88U
+ PD=3.02U
M$993 \$1849 \$1822 \$1850 SUB nfet_06v0 L=1U W=2.5U AS=0.65P AD=1.1P PS=3.02U
+ PD=5.88U
M$994 \$1852 \$1822 \$1851 SUB nfet_06v0 L=1U W=2.5U AS=1.1P AD=0.65P PS=5.88U
+ PD=3.02U
M$995 \$1851 \$1822 \$1852 SUB nfet_06v0 L=1U W=2.5U AS=0.65P AD=1.1P PS=3.02U
+ PD=5.88U
M$996 \$1849 \$1850 SUB SUB nfet_06v0 L=1U W=2.5U AS=1.1P AD=0.65P PS=5.88U
+ PD=3.02U
M$997 SUB \$1850 \$1849 SUB nfet_06v0 L=1U W=2.5U AS=0.65P AD=0.65P PS=3.02U
+ PD=3.02U
M$998 \$1849 \$1850 SUB SUB nfet_06v0 L=1U W=2.5U AS=0.65P AD=0.65P PS=3.02U
+ PD=3.02U
M$999 SUB \$1850 \$1849 SUB nfet_06v0 L=1U W=2.5U AS=0.65P AD=1.1P PS=3.02U
+ PD=5.88U
M$1000 \$1851 \$1850 SUB SUB nfet_06v0 L=1U W=2.5U AS=1.1P AD=0.65P PS=5.88U
+ PD=3.02U
M$1001 SUB \$1850 \$1851 SUB nfet_06v0 L=1U W=2.5U AS=0.65P AD=0.65P PS=3.02U
+ PD=3.02U
M$1002 \$1851 \$1850 SUB SUB nfet_06v0 L=1U W=2.5U AS=0.65P AD=0.65P PS=3.02U
+ PD=3.02U
M$1003 SUB \$1850 \$1851 SUB nfet_06v0 L=1U W=2.5U AS=0.65P AD=1.1P PS=3.02U
+ PD=5.88U
M$1004 \$2126 \$1825 \$1850 SUB nfet_06v0 L=1U W=2.5U AS=1.1P AD=1.1P PS=5.88U
+ PD=5.88U
M$1005 \$68 \$67 \$66 SUB nfet_06v0 L=1U W=2.48U AS=1.0912P AD=0.6448P PS=5.84U
+ PD=3U
M$1006 \$66 \$67 \$68 SUB nfet_06v0 L=1U W=2.48U AS=0.6448P AD=1.0912P PS=3U
+ PD=5.84U
M$1007 \$2354 \$1825 \$1852 SUB nfet_06v0 L=1U W=2.5U AS=1.1P AD=1.1P PS=5.88U
+ PD=5.88U
M$1008 \$1869 \$1823 SUB SUB nfet_06v0 L=1U W=5U AS=2.2P AD=1.25P PS=10.88U
+ PD=5.5U
M$1009 \$1853 \$1822 \$1869 SUB nfet_06v0 L=1U W=5U AS=1.25P AD=2.2P PS=5.5U
+ PD=10.88U
M$1010 \$68 \$70 \$69 SUB nfet_06v0 L=1U W=2.48U AS=1.0912P AD=0.6448P PS=5.84U
+ PD=3U
M$1011 \$69 \$70 \$68 SUB nfet_06v0 L=1U W=2.48U AS=0.6448P AD=1.0912P PS=3U
+ PD=5.84U
M$1012 \$1825 \$1825 \$1854 SUB nfet_06v0 L=1U W=5U AS=2.2P AD=2.2P PS=10.88U
+ PD=10.88U
M$1013 \$69 \$12 SUB SUB nfet_06v0 L=1U W=1.24U AS=0.5456P AD=0.5456P PS=3.36U
+ PD=3.36U
M$1014 \$1866 \$1854 SUB SUB nfet_06v0 L=1U W=5U AS=2.2P AD=1.25P PS=10.88U
+ PD=5.5U
M$1015 \$1854 \$1822 \$1866 SUB nfet_06v0 L=1U W=5U AS=1.25P AD=2.2P PS=5.5U
+ PD=10.88U
M$1016 \$68 \$68 \$71 SUB nfet_06v0 L=1U W=2U AS=0.88P AD=0.52P PS=4.88U
+ PD=2.52U
M$1017 \$71 \$68 \$68 SUB nfet_06v0 L=1U W=2U AS=0.52P AD=0.88P PS=2.52U
+ PD=4.88U
M$1018 \$1855 \$1852 SUB SUB nfet_06v0 L=1U W=5U AS=2.2P AD=1.3P PS=10.88U
+ PD=5.52U
M$1019 SUB \$1852 \$1855 SUB nfet_06v0 L=1U W=5U AS=1.3P AD=1.3P PS=5.52U
+ PD=5.52U
M$1020 \$1855 \$1852 SUB SUB nfet_06v0 L=1U W=5U AS=1.3P AD=2.2P PS=5.52U
+ PD=10.88U
M$1021 \$83 \$68 SUB SUB nfet_06v0 L=1U W=2U AS=0.88P AD=0.5P PS=4.88U PD=2.5U
M$1022 \$71 \$68 \$83 SUB nfet_06v0 L=1U W=2U AS=0.5P AD=0.88P PS=2.5U PD=4.88U
M$1023 \$68 \$73 \$72 SUB nfet_06v0 L=1U W=2.48U AS=1.0912P AD=0.6448P PS=5.84U
+ PD=3U
M$1024 \$72 \$73 \$68 SUB nfet_06v0 L=1U W=2.48U AS=0.6448P AD=1.0912P PS=3U
+ PD=5.84U
M$1025 \$72 \$12 SUB SUB nfet_06v0 L=1U W=1.24U AS=0.5456P AD=0.5456P PS=3.36U
+ PD=3.36U
M$1026 \$3659 \$3595 SUB SUB nfet_06v0 L=1U W=5U AS=2.2P AD=1.25P PS=10.88U
+ PD=5.5U
M$1027 \$3597 \$3596 \$3659 SUB nfet_06v0 L=1U W=5U AS=1.25P AD=2.2P PS=5.5U
+ PD=10.88U
M$1028 \$5393 \$5393 SUB SUB nfet_06v0 L=1U W=1U AS=0.44P AD=0.44P PS=2.88U
+ PD=2.88U
M$1029 \$5449 \$5394 SUB SUB nfet_06v0 L=1U W=5U AS=2.2P AD=1.25P PS=10.88U
+ PD=5.5U
M$1030 \$5394 \$5393 \$5449 SUB nfet_06v0 L=1U W=5U AS=1.25P AD=2.2P PS=5.5U
+ PD=10.88U
M$1031 \$3660 \$3595 SUB SUB nfet_06v0 L=1U W=5U AS=2.2P AD=1.25P PS=10.88U
+ PD=5.5U
M$1032 \$3597 \$3596 \$3660 SUB nfet_06v0 L=1U W=5U AS=1.25P AD=2.2P PS=5.5U
+ PD=10.88U
M$1033 \$5437 \$6384 SUB SUB nfet_06v0 L=1U W=1U AS=0.44P AD=0.25P PS=2.88U
+ PD=1.5U
M$1034 \$6156 \$6384 \$5437 SUB nfet_06v0 L=1U W=1U AS=0.25P AD=0.44P PS=1.5U
+ PD=2.88U
M$1035 \$3598 S1P \$3597 SUB nfet_06v0 L=1U W=5U AS=2.2P AD=2.2P PS=10.88U
+ PD=10.88U
M$1036 \$3599 S1N \$3597 SUB nfet_06v0 L=1U W=5U AS=2.2P AD=2.2P PS=10.88U
+ PD=10.88U
M$1037 \$5438 \$6384 SUB SUB nfet_06v0 L=1U W=1U AS=0.44P AD=0.25P PS=2.88U
+ PD=1.5U
M$1038 \$6384 \$6384 \$5438 SUB nfet_06v0 L=1U W=1U AS=0.25P AD=0.44P PS=1.5U
+ PD=2.88U
M$1039 \$3601 \$3596 \$3600 SUB nfet_06v0 L=1U W=2.5U AS=1.1P AD=1.1P PS=5.88U
+ PD=5.88U
M$1040 \$5450 \$5394 SUB SUB nfet_06v0 L=1U W=5U AS=2.2P AD=1.25P PS=10.88U
+ PD=5.5U
M$1041 \$5410 \$5393 \$5450 SUB nfet_06v0 L=1U W=5U AS=1.25P AD=2.2P PS=5.5U
+ PD=10.88U
M$1042 \$3603 \$3596 \$3602 SUB nfet_06v0 L=1U W=2.5U AS=1.1P AD=1.1P PS=5.88U
+ PD=5.88U
M$1043 \$5451 \$5394 SUB SUB nfet_06v0 L=1U W=5U AS=2.2P AD=1.25P PS=10.88U
+ PD=5.5U
M$1044 \$5410 \$5393 \$5451 SUB nfet_06v0 L=1U W=5U AS=1.25P AD=2.2P PS=5.5U
+ PD=10.88U
M$1045 \$3600 \$3601 SUB SUB nfet_06v0 L=1U W=2.5U AS=1.1P AD=1.1P PS=5.88U
+ PD=5.88U
M$1046 \$3602 \$3601 SUB SUB nfet_06v0 L=1U W=2.5U AS=1.1P AD=1.1P PS=5.88U
+ PD=5.88U
M$1047 \$5411 \$5473 \$5410 SUB nfet_06v0 L=1U W=5U AS=2.2P AD=1.3P PS=10.88U
+ PD=5.52U
M$1048 \$5410 \$5473 \$5411 SUB nfet_06v0 L=1U W=5U AS=1.3P AD=2.2P PS=5.52U
+ PD=10.88U
M$1049 \$4077 \$3604 \$3601 SUB nfet_06v0 L=1U W=2.5U AS=1.1P AD=1.1P PS=5.88U
+ PD=5.88U
M$1050 \$5412 \$5395 \$5410 SUB nfet_06v0 L=1U W=5U AS=2.2P AD=1.3P PS=10.88U
+ PD=5.52U
M$1051 \$5410 \$5395 \$5412 SUB nfet_06v0 L=1U W=5U AS=1.3P AD=2.2P PS=5.52U
+ PD=10.88U
M$1052 \$3640 \$3604 \$3603 SUB nfet_06v0 L=1U W=2.5U AS=1.1P AD=1.1P PS=5.88U
+ PD=5.88U
M$1053 \$3661 \$3595 SUB SUB nfet_06v0 L=1U W=5U AS=2.2P AD=1.25P PS=10.88U
+ PD=5.5U
M$1054 \$3605 \$3596 \$3661 SUB nfet_06v0 L=1U W=5U AS=1.25P AD=2.2P PS=5.5U
+ PD=10.88U
M$1055 \$5413 \$5393 \$5396 SUB nfet_06v0 L=1U W=2.5U AS=1.1P AD=0.65P PS=5.88U
+ PD=3.02U
M$1056 \$5396 \$5393 \$5413 SUB nfet_06v0 L=1U W=2.5U AS=0.65P AD=1.1P PS=3.02U
+ PD=5.88U
M$1057 \$3604 \$3604 \$3606 SUB nfet_06v0 L=1U W=5U AS=2.2P AD=2.2P PS=10.88U
+ PD=10.88U
M$1058 \$5414 \$5393 \$5397 SUB nfet_06v0 L=1U W=2.5U AS=1.1P AD=0.65P PS=5.88U
+ PD=3.02U
M$1059 \$5397 \$5393 \$5414 SUB nfet_06v0 L=1U W=2.5U AS=0.65P AD=1.1P PS=3.02U
+ PD=5.88U
M$1060 \$3662 \$3606 SUB SUB nfet_06v0 L=1U W=5U AS=2.2P AD=1.25P PS=10.88U
+ PD=5.5U
M$1061 \$3606 \$3596 \$3662 SUB nfet_06v0 L=1U W=5U AS=1.25P AD=2.2P PS=5.5U
+ PD=10.88U
M$1062 \$5396 \$5413 SUB SUB nfet_06v0 L=1U W=2.5U AS=1.1P AD=0.65P PS=5.88U
+ PD=3.02U
M$1063 SUB \$5413 \$5396 SUB nfet_06v0 L=1U W=2.5U AS=0.65P AD=0.65P PS=3.02U
+ PD=3.02U
M$1064 \$5396 \$5413 SUB SUB nfet_06v0 L=1U W=2.5U AS=0.65P AD=0.65P PS=3.02U
+ PD=3.02U
M$1065 SUB \$5413 \$5396 SUB nfet_06v0 L=1U W=2.5U AS=0.65P AD=1.1P PS=3.02U
+ PD=5.88U
M$1066 \$3607 \$3603 SUB SUB nfet_06v0 L=1U W=1U AS=0.44P AD=0.44P PS=2.88U
+ PD=2.88U
M$1067 \$3596 \$3596 SUB SUB nfet_06v0 L=1U W=1U AS=0.44P AD=0.44P PS=2.88U
+ PD=2.88U
M$1068 \$5397 \$5413 SUB SUB nfet_06v0 L=1U W=2.5U AS=1.1P AD=0.65P PS=5.88U
+ PD=3.02U
M$1069 SUB \$5413 \$5397 SUB nfet_06v0 L=1U W=2.5U AS=0.65P AD=0.65P PS=3.02U
+ PD=3.02U
M$1070 \$5397 \$5413 SUB SUB nfet_06v0 L=1U W=2.5U AS=0.65P AD=0.65P PS=3.02U
+ PD=3.02U
M$1071 SUB \$5413 \$5397 SUB nfet_06v0 L=1U W=2.5U AS=0.65P AD=1.1P PS=3.02U
+ PD=5.88U
M$1072 \$3663 \$3595 SUB SUB nfet_06v0 L=1U W=5U AS=2.2P AD=1.25P PS=10.88U
+ PD=5.5U
M$1073 \$3595 \$3596 \$3663 SUB nfet_06v0 L=1U W=5U AS=1.25P AD=2.2P PS=5.5U
+ PD=10.88U
M$1074 \$3647 \$3690 SUB SUB nfet_06v0 L=1U W=1U AS=0.44P AD=0.25P PS=2.88U
+ PD=1.5U
M$1075 \$3693 \$3690 \$3647 SUB nfet_06v0 L=1U W=1U AS=0.25P AD=0.44P PS=1.5U
+ PD=2.88U
M$1076 \$5778 \$5398 \$5413 SUB nfet_06v0 L=1U W=2.5U AS=1.1P AD=1.1P PS=5.88U
+ PD=5.88U
M$1077 \$3648 \$3690 SUB SUB nfet_06v0 L=1U W=1U AS=0.44P AD=0.25P PS=2.88U
+ PD=1.5U
M$1078 \$3690 \$3690 \$3648 SUB nfet_06v0 L=1U W=1U AS=0.25P AD=0.44P PS=1.5U
+ PD=2.88U
M$1079 \$5415 \$5398 \$5414 SUB nfet_06v0 L=1U W=2.5U AS=1.1P AD=1.1P PS=5.88U
+ PD=5.88U
M$1080 \$5452 \$5394 SUB SUB nfet_06v0 L=1U W=5U AS=2.2P AD=1.25P PS=10.88U
+ PD=5.5U
M$1081 \$5416 \$5393 \$5452 SUB nfet_06v0 L=1U W=5U AS=1.25P AD=2.2P PS=5.5U
+ PD=10.88U
M$1082 \$5398 \$5398 \$5417 SUB nfet_06v0 L=1U W=5U AS=2.2P AD=2.2P PS=10.88U
+ PD=10.88U
M$1083 \$5454 \$5417 SUB SUB nfet_06v0 L=1U W=5U AS=2.2P AD=1.25P PS=10.88U
+ PD=5.5U
M$1084 \$5417 \$5393 \$5454 SUB nfet_06v0 L=1U W=5U AS=1.25P AD=2.2P PS=5.5U
+ PD=10.88U
M$1085 \$5418 \$5414 SUB SUB nfet_06v0 L=1U W=5U AS=2.2P AD=1.3P PS=10.88U
+ PD=5.52U
M$1086 SUB \$5414 \$5418 SUB nfet_06v0 L=1U W=5U AS=1.3P AD=1.3P PS=5.52U
+ PD=5.52U
M$1087 \$5418 \$5414 SUB SUB nfet_06v0 L=1U W=5U AS=1.3P AD=2.2P PS=5.52U
+ PD=10.88U
M$1088 \$3664 \$3608 SUB SUB nfet_06v0 L=1U W=5U AS=2.2P AD=1.25P PS=10.88U
+ PD=5.5U
M$1089 \$3610 \$3609 \$3664 SUB nfet_06v0 L=1U W=5U AS=1.25P AD=2.2P PS=5.5U
+ PD=10.88U
M$1090 \$3665 \$3608 SUB SUB nfet_06v0 L=1U W=5U AS=2.2P AD=1.25P PS=10.88U
+ PD=5.5U
M$1091 \$3610 \$3609 \$3665 SUB nfet_06v0 L=1U W=5U AS=1.25P AD=2.2P PS=5.5U
+ PD=10.88U
M$1092 \$3611 S2P \$3610 SUB nfet_06v0 L=1U W=5U AS=2.2P AD=2.2P PS=10.88U
+ PD=10.88U
M$1093 \$3612 \$4078 \$3610 SUB nfet_06v0 L=1U W=5U AS=2.2P AD=2.2P PS=10.88U
+ PD=10.88U
M$1094 \$5399 \$5399 SUB SUB nfet_06v0 L=1U W=1U AS=0.44P AD=0.44P PS=2.88U
+ PD=2.88U
M$1095 \$3614 \$3609 \$3613 SUB nfet_06v0 L=1U W=2.5U AS=1.1P AD=1.1P PS=5.88U
+ PD=5.88U
M$1096 \$5456 \$5400 SUB SUB nfet_06v0 L=1U W=5U AS=2.2P AD=1.25P PS=10.88U
+ PD=5.5U
M$1097 \$5400 \$5399 \$5456 SUB nfet_06v0 L=1U W=5U AS=1.25P AD=2.2P PS=5.5U
+ PD=10.88U
M$1098 \$3616 \$3609 \$3615 SUB nfet_06v0 L=1U W=2.5U AS=1.1P AD=1.1P PS=5.88U
+ PD=5.88U
M$1099 \$3613 \$3614 SUB SUB nfet_06v0 L=1U W=2.5U AS=1.1P AD=1.1P PS=5.88U
+ PD=5.88U
M$1100 \$5441 \$6385 SUB SUB nfet_06v0 L=1U W=1U AS=0.44P AD=0.25P PS=2.88U
+ PD=1.5U
M$1101 \$6157 \$6385 \$5441 SUB nfet_06v0 L=1U W=1U AS=0.25P AD=0.44P PS=1.5U
+ PD=2.88U
M$1102 \$3615 \$3614 SUB SUB nfet_06v0 L=1U W=2.5U AS=1.1P AD=1.1P PS=5.88U
+ PD=5.88U
M$1103 \$5442 \$6385 SUB SUB nfet_06v0 L=1U W=1U AS=0.44P AD=0.25P PS=2.88U
+ PD=1.5U
M$1104 \$6385 \$6385 \$5442 SUB nfet_06v0 L=1U W=1U AS=0.25P AD=0.44P PS=1.5U
+ PD=2.88U
M$1105 \$4079 \$3617 \$3614 SUB nfet_06v0 L=1U W=2.5U AS=1.1P AD=1.1P PS=5.88U
+ PD=5.88U
M$1106 \$5457 \$5400 SUB SUB nfet_06v0 L=1U W=5U AS=2.2P AD=1.25P PS=10.88U
+ PD=5.5U
M$1107 \$5419 \$5399 \$5457 SUB nfet_06v0 L=1U W=5U AS=1.25P AD=2.2P PS=5.5U
+ PD=10.88U
M$1108 \$3642 \$3617 \$3616 SUB nfet_06v0 L=1U W=2.5U AS=1.1P AD=1.1P PS=5.88U
+ PD=5.88U
M$1109 \$3666 \$3608 SUB SUB nfet_06v0 L=1U W=5U AS=2.2P AD=1.25P PS=10.88U
+ PD=5.5U
M$1110 \$3618 \$3609 \$3666 SUB nfet_06v0 L=1U W=5U AS=1.25P AD=2.2P PS=5.5U
+ PD=10.88U
M$1111 \$5458 \$5400 SUB SUB nfet_06v0 L=1U W=5U AS=2.2P AD=1.25P PS=10.88U
+ PD=5.5U
M$1112 \$5419 \$5399 \$5458 SUB nfet_06v0 L=1U W=5U AS=1.25P AD=2.2P PS=5.5U
+ PD=10.88U
M$1113 \$3617 \$3617 \$3619 SUB nfet_06v0 L=1U W=5U AS=2.2P AD=2.2P PS=10.88U
+ PD=10.88U
M$1114 \$5420 \$5474 \$5419 SUB nfet_06v0 L=1U W=5U AS=2.2P AD=1.3P PS=10.88U
+ PD=5.52U
M$1115 \$5419 \$5474 \$5420 SUB nfet_06v0 L=1U W=5U AS=1.3P AD=2.2P PS=5.52U
+ PD=10.88U
M$1116 \$3668 \$3619 SUB SUB nfet_06v0 L=1U W=5U AS=2.2P AD=1.25P PS=10.88U
+ PD=5.5U
M$1117 \$3619 \$3609 \$3668 SUB nfet_06v0 L=1U W=5U AS=1.25P AD=2.2P PS=5.5U
+ PD=10.88U
M$1118 \$5421 \$5391 \$5419 SUB nfet_06v0 L=1U W=5U AS=2.2P AD=1.3P PS=10.88U
+ PD=5.52U
M$1119 \$5419 \$5391 \$5421 SUB nfet_06v0 L=1U W=5U AS=1.3P AD=2.2P PS=5.52U
+ PD=10.88U
M$1120 \$3620 \$3616 SUB SUB nfet_06v0 L=1U W=1U AS=0.44P AD=0.44P PS=2.88U
+ PD=2.88U
M$1121 \$5422 \$5399 \$5401 SUB nfet_06v0 L=1U W=2.5U AS=1.1P AD=0.65P PS=5.88U
+ PD=3.02U
M$1122 \$5401 \$5399 \$5422 SUB nfet_06v0 L=1U W=2.5U AS=0.65P AD=1.1P PS=3.02U
+ PD=5.88U
M$1123 \$3609 \$3609 SUB SUB nfet_06v0 L=1U W=1U AS=0.44P AD=0.44P PS=2.88U
+ PD=2.88U
M$1124 \$3669 \$3608 SUB SUB nfet_06v0 L=1U W=5U AS=2.2P AD=1.25P PS=10.88U
+ PD=5.5U
M$1125 \$3608 \$3609 \$3669 SUB nfet_06v0 L=1U W=5U AS=1.25P AD=2.2P PS=5.5U
+ PD=10.88U
M$1126 \$5423 \$5399 \$5402 SUB nfet_06v0 L=1U W=2.5U AS=1.1P AD=0.65P PS=5.88U
+ PD=3.02U
M$1127 \$5402 \$5399 \$5423 SUB nfet_06v0 L=1U W=2.5U AS=0.65P AD=1.1P PS=3.02U
+ PD=5.88U
M$1128 \$3650 \$3691 SUB SUB nfet_06v0 L=1U W=1U AS=0.44P AD=0.25P PS=2.88U
+ PD=1.5U
M$1129 \$3694 \$3691 \$3650 SUB nfet_06v0 L=1U W=1U AS=0.25P AD=0.44P PS=1.5U
+ PD=2.88U
M$1130 \$5401 \$5422 SUB SUB nfet_06v0 L=1U W=2.5U AS=1.1P AD=0.65P PS=5.88U
+ PD=3.02U
M$1131 SUB \$5422 \$5401 SUB nfet_06v0 L=1U W=2.5U AS=0.65P AD=0.65P PS=3.02U
+ PD=3.02U
M$1132 \$5401 \$5422 SUB SUB nfet_06v0 L=1U W=2.5U AS=0.65P AD=0.65P PS=3.02U
+ PD=3.02U
M$1133 SUB \$5422 \$5401 SUB nfet_06v0 L=1U W=2.5U AS=0.65P AD=1.1P PS=3.02U
+ PD=5.88U
M$1134 \$3649 \$3691 SUB SUB nfet_06v0 L=1U W=1U AS=0.44P AD=0.25P PS=2.88U
+ PD=1.5U
M$1135 \$3691 \$3691 \$3649 SUB nfet_06v0 L=1U W=1U AS=0.25P AD=0.44P PS=1.5U
+ PD=2.88U
M$1136 \$5402 \$5422 SUB SUB nfet_06v0 L=1U W=2.5U AS=1.1P AD=0.65P PS=5.88U
+ PD=3.02U
M$1137 SUB \$5422 \$5402 SUB nfet_06v0 L=1U W=2.5U AS=0.65P AD=0.65P PS=3.02U
+ PD=3.02U
M$1138 \$5402 \$5422 SUB SUB nfet_06v0 L=1U W=2.5U AS=0.65P AD=0.65P PS=3.02U
+ PD=3.02U
M$1139 SUB \$5422 \$5402 SUB nfet_06v0 L=1U W=2.5U AS=0.65P AD=1.1P PS=3.02U
+ PD=5.88U
M$1140 \$5779 \$5403 \$5422 SUB nfet_06v0 L=1U W=2.5U AS=1.1P AD=1.1P PS=5.88U
+ PD=5.88U
M$1141 \$5424 \$5403 \$5423 SUB nfet_06v0 L=1U W=2.5U AS=1.1P AD=1.1P PS=5.88U
+ PD=5.88U
M$1142 \$5459 \$5400 SUB SUB nfet_06v0 L=1U W=5U AS=2.2P AD=1.25P PS=10.88U
+ PD=5.5U
M$1143 \$5425 \$5399 \$5459 SUB nfet_06v0 L=1U W=5U AS=1.25P AD=2.2P PS=5.5U
+ PD=10.88U
M$1144 \$5403 \$5403 \$5426 SUB nfet_06v0 L=1U W=5U AS=2.2P AD=2.2P PS=10.88U
+ PD=10.88U
M$1145 \$5460 \$5426 SUB SUB nfet_06v0 L=1U W=5U AS=2.2P AD=1.25P PS=10.88U
+ PD=5.5U
M$1146 \$5426 \$5399 \$5460 SUB nfet_06v0 L=1U W=5U AS=1.25P AD=2.2P PS=5.5U
+ PD=10.88U
M$1147 \$3671 \$3621 SUB SUB nfet_06v0 L=1U W=5U AS=2.2P AD=1.25P PS=10.88U
+ PD=5.5U
M$1148 \$3623 \$3622 \$3671 SUB nfet_06v0 L=1U W=5U AS=1.25P AD=2.2P PS=5.5U
+ PD=10.88U
M$1149 \$5427 \$5423 SUB SUB nfet_06v0 L=1U W=5U AS=2.2P AD=1.3P PS=10.88U
+ PD=5.52U
M$1150 SUB \$5423 \$5427 SUB nfet_06v0 L=1U W=5U AS=1.3P AD=1.3P PS=5.52U
+ PD=5.52U
M$1151 \$5427 \$5423 SUB SUB nfet_06v0 L=1U W=5U AS=1.3P AD=2.2P PS=5.52U
+ PD=10.88U
M$1152 \$3672 \$3621 SUB SUB nfet_06v0 L=1U W=5U AS=2.2P AD=1.25P PS=10.88U
+ PD=5.5U
M$1153 \$3623 \$3622 \$3672 SUB nfet_06v0 L=1U W=5U AS=1.25P AD=2.2P PS=5.5U
+ PD=10.88U
M$1154 \$3625 S4P \$3623 SUB nfet_06v0 L=1U W=5U AS=2.2P AD=2.2P PS=10.88U
+ PD=10.88U
M$1155 \$3626 \$4080 \$3623 SUB nfet_06v0 L=1U W=5U AS=2.2P AD=2.2P PS=10.88U
+ PD=10.88U
M$1156 \$3628 \$3622 \$3627 SUB nfet_06v0 L=1U W=2.5U AS=1.1P AD=1.1P PS=5.88U
+ PD=5.88U
M$1157 \$3630 \$3622 \$3629 SUB nfet_06v0 L=1U W=2.5U AS=1.1P AD=1.1P PS=5.88U
+ PD=5.88U
M$1158 \$3627 \$3628 SUB SUB nfet_06v0 L=1U W=2.5U AS=1.1P AD=1.1P PS=5.88U
+ PD=5.88U
M$1159 \$3629 \$3628 SUB SUB nfet_06v0 L=1U W=2.5U AS=1.1P AD=1.1P PS=5.88U
+ PD=5.88U
M$1160 \$4081 \$3631 \$3628 SUB nfet_06v0 L=1U W=2.5U AS=1.1P AD=1.1P PS=5.88U
+ PD=5.88U
M$1161 \$5404 \$5404 SUB SUB nfet_06v0 L=1U W=1U AS=0.44P AD=0.44P PS=2.88U
+ PD=2.88U
M$1162 \$3644 \$3631 \$3630 SUB nfet_06v0 L=1U W=2.5U AS=1.1P AD=1.1P PS=5.88U
+ PD=5.88U
M$1163 \$5461 \$5405 SUB SUB nfet_06v0 L=1U W=5U AS=2.2P AD=1.25P PS=10.88U
+ PD=5.5U
M$1164 \$5405 \$5404 \$5461 SUB nfet_06v0 L=1U W=5U AS=1.25P AD=2.2P PS=5.5U
+ PD=10.88U
M$1165 \$3673 \$3621 SUB SUB nfet_06v0 L=1U W=5U AS=2.2P AD=1.25P PS=10.88U
+ PD=5.5U
M$1166 \$3632 \$3622 \$3673 SUB nfet_06v0 L=1U W=5U AS=1.25P AD=2.2P PS=5.5U
+ PD=10.88U
M$1167 \$5440 \$6386 SUB SUB nfet_06v0 L=1U W=1U AS=0.44P AD=0.25P PS=2.88U
+ PD=1.5U
M$1168 \$6158 \$6386 \$5440 SUB nfet_06v0 L=1U W=1U AS=0.25P AD=0.44P PS=1.5U
+ PD=2.88U
M$1169 \$3631 \$3631 \$3633 SUB nfet_06v0 L=1U W=5U AS=2.2P AD=2.2P PS=10.88U
+ PD=10.88U
M$1170 \$5439 \$6386 SUB SUB nfet_06v0 L=1U W=1U AS=0.44P AD=0.25P PS=2.88U
+ PD=1.5U
M$1171 \$6386 \$6386 \$5439 SUB nfet_06v0 L=1U W=1U AS=0.25P AD=0.44P PS=1.5U
+ PD=2.88U
M$1172 \$3670 \$3633 SUB SUB nfet_06v0 L=1U W=5U AS=2.2P AD=1.25P PS=10.88U
+ PD=5.5U
M$1173 \$3633 \$3622 \$3670 SUB nfet_06v0 L=1U W=5U AS=1.25P AD=2.2P PS=5.5U
+ PD=10.88U
M$1174 \$5462 \$5405 SUB SUB nfet_06v0 L=1U W=5U AS=2.2P AD=1.25P PS=10.88U
+ PD=5.5U
M$1175 \$5428 \$5404 \$5462 SUB nfet_06v0 L=1U W=5U AS=1.25P AD=2.2P PS=5.5U
+ PD=10.88U
M$1176 \$3634 \$3630 SUB SUB nfet_06v0 L=1U W=1U AS=0.44P AD=0.44P PS=2.88U
+ PD=2.88U
M$1177 \$5463 \$5405 SUB SUB nfet_06v0 L=1U W=5U AS=2.2P AD=1.25P PS=10.88U
+ PD=5.5U
M$1178 \$5428 \$5404 \$5463 SUB nfet_06v0 L=1U W=5U AS=1.25P AD=2.2P PS=5.5U
+ PD=10.88U
M$1179 \$3622 \$3622 SUB SUB nfet_06v0 L=1U W=1U AS=0.44P AD=0.44P PS=2.88U
+ PD=2.88U
M$1180 \$3667 \$3621 SUB SUB nfet_06v0 L=1U W=5U AS=2.2P AD=1.25P PS=10.88U
+ PD=5.5U
M$1181 \$3621 \$3622 \$3667 SUB nfet_06v0 L=1U W=5U AS=1.25P AD=2.2P PS=5.5U
+ PD=10.88U
M$1182 \$5429 \$3678 \$5428 SUB nfet_06v0 L=1U W=5U AS=2.2P AD=1.3P PS=10.88U
+ PD=5.52U
M$1183 \$5428 \$3678 \$5429 SUB nfet_06v0 L=1U W=5U AS=1.3P AD=2.2P PS=5.52U
+ PD=10.88U
M$1184 \$3646 \$3692 SUB SUB nfet_06v0 L=1U W=1U AS=0.44P AD=0.25P PS=2.88U
+ PD=1.5U
M$1185 \$3695 \$3692 \$3646 SUB nfet_06v0 L=1U W=1U AS=0.25P AD=0.44P PS=1.5U
+ PD=2.88U
M$1186 \$5430 \$5406 \$5428 SUB nfet_06v0 L=1U W=5U AS=2.2P AD=1.3P PS=10.88U
+ PD=5.52U
M$1187 \$5428 \$5406 \$5430 SUB nfet_06v0 L=1U W=5U AS=1.3P AD=2.2P PS=5.52U
+ PD=10.88U
M$1188 \$3645 \$3692 SUB SUB nfet_06v0 L=1U W=1U AS=0.44P AD=0.25P PS=2.88U
+ PD=1.5U
M$1189 \$3692 \$3692 \$3645 SUB nfet_06v0 L=1U W=1U AS=0.25P AD=0.44P PS=1.5U
+ PD=2.88U
M$1190 \$5431 \$5404 \$5407 SUB nfet_06v0 L=1U W=2.5U AS=1.1P AD=0.65P PS=5.88U
+ PD=3.02U
M$1191 \$5407 \$5404 \$5431 SUB nfet_06v0 L=1U W=2.5U AS=0.65P AD=1.1P PS=3.02U
+ PD=5.88U
M$1192 \$5432 \$5404 \$5408 SUB nfet_06v0 L=1U W=2.5U AS=1.1P AD=0.65P PS=5.88U
+ PD=3.02U
M$1193 \$5408 \$5404 \$5432 SUB nfet_06v0 L=1U W=2.5U AS=0.65P AD=1.1P PS=3.02U
+ PD=5.88U
M$1194 \$5407 \$5431 SUB SUB nfet_06v0 L=1U W=2.5U AS=1.1P AD=0.65P PS=5.88U
+ PD=3.02U
M$1195 SUB \$5431 \$5407 SUB nfet_06v0 L=1U W=2.5U AS=0.65P AD=0.65P PS=3.02U
+ PD=3.02U
M$1196 \$5407 \$5431 SUB SUB nfet_06v0 L=1U W=2.5U AS=0.65P AD=0.65P PS=3.02U
+ PD=3.02U
M$1197 SUB \$5431 \$5407 SUB nfet_06v0 L=1U W=2.5U AS=0.65P AD=1.1P PS=3.02U
+ PD=5.88U
M$1198 \$5408 \$5431 SUB SUB nfet_06v0 L=1U W=2.5U AS=1.1P AD=0.65P PS=5.88U
+ PD=3.02U
M$1199 SUB \$5431 \$5408 SUB nfet_06v0 L=1U W=2.5U AS=0.65P AD=0.65P PS=3.02U
+ PD=3.02U
M$1200 \$5408 \$5431 SUB SUB nfet_06v0 L=1U W=2.5U AS=0.65P AD=0.65P PS=3.02U
+ PD=3.02U
M$1201 SUB \$5431 \$5408 SUB nfet_06v0 L=1U W=2.5U AS=0.65P AD=1.1P PS=3.02U
+ PD=5.88U
M$1202 \$5780 \$5409 \$5431 SUB nfet_06v0 L=1U W=2.5U AS=1.1P AD=1.1P PS=5.88U
+ PD=5.88U
M$1203 \$3653 \$3652 \$3651 SUB nfet_06v0 L=1U W=2.48U AS=1.0912P AD=0.6448P
+ PS=5.84U PD=3U
M$1204 \$3651 \$3652 \$3653 SUB nfet_06v0 L=1U W=2.48U AS=0.6448P AD=1.0912P
+ PS=3U PD=5.84U
M$1205 \$3653 \$3590 \$3589 SUB nfet_06v0 L=1U W=2.48U AS=1.0912P AD=0.6448P
+ PS=5.84U PD=3U
M$1206 \$3589 \$3590 \$3653 SUB nfet_06v0 L=1U W=2.48U AS=0.6448P AD=1.0912P
+ PS=3U PD=5.84U
M$1207 \$5433 \$5409 \$5432 SUB nfet_06v0 L=1U W=2.5U AS=1.1P AD=1.1P PS=5.88U
+ PD=5.88U
M$1208 \$5455 \$5405 SUB SUB nfet_06v0 L=1U W=5U AS=2.2P AD=1.25P PS=10.88U
+ PD=5.5U
M$1209 \$5434 \$5404 \$5455 SUB nfet_06v0 L=1U W=5U AS=1.25P AD=2.2P PS=5.5U
+ PD=10.88U
M$1210 \$3653 \$3655 \$3654 SUB nfet_06v0 L=1U W=2.48U AS=1.0912P AD=0.6448P
+ PS=5.84U PD=3U
M$1211 \$3654 \$3655 \$3653 SUB nfet_06v0 L=1U W=2.48U AS=0.6448P AD=1.0912P
+ PS=3U PD=5.84U
M$1212 \$3589 \$3591 SUB SUB nfet_06v0 L=1U W=1.24U AS=0.5456P AD=0.5456P
+ PS=3.36U PD=3.36U
M$1213 \$5409 \$5409 \$5435 SUB nfet_06v0 L=1U W=5U AS=2.2P AD=2.2P PS=10.88U
+ PD=10.88U
M$1214 \$3651 \$3591 SUB SUB nfet_06v0 L=1U W=1.24U AS=0.5456P AD=0.5456P
+ PS=3.36U PD=3.36U
M$1215 \$3654 \$3591 SUB SUB nfet_06v0 L=1U W=1.24U AS=0.5456P AD=0.5456P
+ PS=3.36U PD=3.36U
M$1216 \$5453 \$5435 SUB SUB nfet_06v0 L=1U W=5U AS=2.2P AD=1.25P PS=10.88U
+ PD=5.5U
M$1217 \$5435 \$5404 \$5453 SUB nfet_06v0 L=1U W=5U AS=1.25P AD=2.2P PS=5.5U
+ PD=10.88U
M$1218 \$3638 \$3591 SUB SUB nfet_06v0 L=1U W=0.7U AS=0.308P AD=0.175P PS=2.28U
+ PD=1.2U
M$1219 \$3637 \$3591 \$3638 SUB nfet_06v0 L=1U W=0.7U AS=0.175P AD=0.175P
+ PS=1.2U PD=1.2U
M$1220 \$3636 \$3591 \$3637 SUB nfet_06v0 L=1U W=0.7U AS=0.175P AD=0.175P
+ PS=1.2U PD=1.2U
M$1221 \$3591 \$3591 \$3636 SUB nfet_06v0 L=1U W=0.7U AS=0.175P AD=0.308P
+ PS=1.2U PD=2.28U
M$1222 \$3653 \$3653 \$3656 SUB nfet_06v0 L=1U W=2U AS=0.88P AD=0.52P PS=4.88U
+ PD=2.52U
M$1223 \$3656 \$3653 \$3653 SUB nfet_06v0 L=1U W=2U AS=0.52P AD=0.88P PS=2.52U
+ PD=4.88U
M$1224 \$5436 \$5432 SUB SUB nfet_06v0 L=1U W=5U AS=2.2P AD=1.3P PS=10.88U
+ PD=5.52U
M$1225 SUB \$5432 \$5436 SUB nfet_06v0 L=1U W=5U AS=1.3P AD=1.3P PS=5.52U
+ PD=5.52U
M$1226 \$5436 \$5432 SUB SUB nfet_06v0 L=1U W=5U AS=1.3P AD=2.2P PS=5.52U
+ PD=10.88U
M$1227 \$3682 \$3653 SUB SUB nfet_06v0 L=1U W=2U AS=0.88P AD=0.5P PS=4.88U
+ PD=2.5U
M$1228 \$3656 \$3653 \$3682 SUB nfet_06v0 L=1U W=2U AS=0.5P AD=0.88P PS=2.5U
+ PD=4.88U
M$1229 \$3653 \$3658 \$3657 SUB nfet_06v0 L=1U W=2.48U AS=1.0912P AD=0.6448P
+ PS=5.84U PD=3U
M$1230 \$3657 \$3658 \$3653 SUB nfet_06v0 L=1U W=2.48U AS=0.6448P AD=1.0912P
+ PS=3U PD=5.84U
M$1231 \$3657 \$3591 SUB SUB nfet_06v0 L=1U W=1.24U AS=0.5456P AD=0.5456P
+ PS=3.36U PD=3.36U
M$1232 \$7234 \$7170 SUB SUB nfet_06v0 L=1U W=5U AS=2.2P AD=1.25P PS=10.88U
+ PD=5.5U
M$1233 \$7172 \$7171 \$7234 SUB nfet_06v0 L=1U W=5U AS=1.25P AD=2.2P PS=5.5U
+ PD=10.88U
M$1234 \$8968 \$8968 SUB SUB nfet_06v0 L=1U W=1U AS=0.44P AD=0.44P PS=2.88U
+ PD=2.88U
M$1235 \$9025 \$8969 SUB SUB nfet_06v0 L=1U W=5U AS=2.2P AD=1.25P PS=10.88U
+ PD=5.5U
M$1236 \$8969 \$8968 \$9025 SUB nfet_06v0 L=1U W=5U AS=1.25P AD=2.2P PS=5.5U
+ PD=10.88U
M$1237 \$7235 \$7170 SUB SUB nfet_06v0 L=1U W=5U AS=2.2P AD=1.25P PS=10.88U
+ PD=5.5U
M$1238 \$7172 \$7171 \$7235 SUB nfet_06v0 L=1U W=5U AS=1.25P AD=2.2P PS=5.5U
+ PD=10.88U
M$1239 \$9011 \$10035 SUB SUB nfet_06v0 L=1U W=1U AS=0.44P AD=0.25P PS=2.88U
+ PD=1.5U
M$1240 \$9807 \$10035 \$9011 SUB nfet_06v0 L=1U W=1U AS=0.25P AD=0.44P PS=1.5U
+ PD=2.88U
M$1241 \$7173 S3P \$7172 SUB nfet_06v0 L=1U W=5U AS=2.2P AD=2.2P PS=10.88U
+ PD=10.88U
M$1242 \$7174 \$7501 \$7172 SUB nfet_06v0 L=1U W=5U AS=2.2P AD=2.2P PS=10.88U
+ PD=10.88U
M$1243 \$9012 \$10035 SUB SUB nfet_06v0 L=1U W=1U AS=0.44P AD=0.25P PS=2.88U
+ PD=1.5U
M$1244 \$10035 \$10035 \$9012 SUB nfet_06v0 L=1U W=1U AS=0.25P AD=0.44P PS=1.5U
+ PD=2.88U
M$1245 \$7176 \$7171 \$7175 SUB nfet_06v0 L=1U W=2.5U AS=1.1P AD=1.1P PS=5.88U
+ PD=5.88U
M$1246 \$9026 \$8969 SUB SUB nfet_06v0 L=1U W=5U AS=2.2P AD=1.25P PS=10.88U
+ PD=5.5U
M$1247 \$8979 \$8968 \$9026 SUB nfet_06v0 L=1U W=5U AS=1.25P AD=2.2P PS=5.5U
+ PD=10.88U
M$1248 \$7178 \$7171 \$7177 SUB nfet_06v0 L=1U W=2.5U AS=1.1P AD=1.1P PS=5.88U
+ PD=5.88U
M$1249 \$9028 \$8969 SUB SUB nfet_06v0 L=1U W=5U AS=2.2P AD=1.25P PS=10.88U
+ PD=5.5U
M$1250 \$8979 \$8968 \$9028 SUB nfet_06v0 L=1U W=5U AS=1.25P AD=2.2P PS=5.5U
+ PD=10.88U
M$1251 \$7175 \$7176 SUB SUB nfet_06v0 L=1U W=2.5U AS=1.1P AD=1.1P PS=5.88U
+ PD=5.88U
M$1252 \$7177 \$7176 SUB SUB nfet_06v0 L=1U W=2.5U AS=1.1P AD=1.1P PS=5.88U
+ PD=5.88U
M$1253 \$8980 \$9049 \$8979 SUB nfet_06v0 L=1U W=5U AS=2.2P AD=1.3P PS=10.88U
+ PD=5.52U
M$1254 \$8979 \$9049 \$8980 SUB nfet_06v0 L=1U W=5U AS=1.3P AD=2.2P PS=5.52U
+ PD=10.88U
M$1255 \$7657 \$7179 \$7176 SUB nfet_06v0 L=1U W=2.5U AS=1.1P AD=1.1P PS=5.88U
+ PD=5.88U
M$1256 \$8981 \$8970 \$8979 SUB nfet_06v0 L=1U W=5U AS=2.2P AD=1.3P PS=10.88U
+ PD=5.52U
M$1257 \$8979 \$8970 \$8981 SUB nfet_06v0 L=1U W=5U AS=1.3P AD=2.2P PS=5.52U
+ PD=10.88U
M$1258 \$7215 \$7179 \$7178 SUB nfet_06v0 L=1U W=2.5U AS=1.1P AD=1.1P PS=5.88U
+ PD=5.88U
M$1259 \$7236 \$7170 SUB SUB nfet_06v0 L=1U W=5U AS=2.2P AD=1.25P PS=10.88U
+ PD=5.5U
M$1260 \$7180 \$7171 \$7236 SUB nfet_06v0 L=1U W=5U AS=1.25P AD=2.2P PS=5.5U
+ PD=10.88U
M$1261 \$8983 \$8968 \$8982 SUB nfet_06v0 L=1U W=2.5U AS=1.1P AD=0.65P PS=5.88U
+ PD=3.02U
M$1262 \$8982 \$8968 \$8983 SUB nfet_06v0 L=1U W=2.5U AS=0.65P AD=1.1P PS=3.02U
+ PD=5.88U
M$1263 \$7179 \$7179 \$7181 SUB nfet_06v0 L=1U W=5U AS=2.2P AD=2.2P PS=10.88U
+ PD=10.88U
M$1264 \$8985 \$8968 \$8984 SUB nfet_06v0 L=1U W=2.5U AS=1.1P AD=0.65P PS=5.88U
+ PD=3.02U
M$1265 \$8984 \$8968 \$8985 SUB nfet_06v0 L=1U W=2.5U AS=0.65P AD=1.1P PS=3.02U
+ PD=5.88U
M$1266 \$7237 \$7181 SUB SUB nfet_06v0 L=1U W=5U AS=2.2P AD=1.25P PS=10.88U
+ PD=5.5U
M$1267 \$7181 \$7171 \$7237 SUB nfet_06v0 L=1U W=5U AS=1.25P AD=2.2P PS=5.5U
+ PD=10.88U
M$1268 \$8982 \$8983 SUB SUB nfet_06v0 L=1U W=2.5U AS=1.1P AD=0.65P PS=5.88U
+ PD=3.02U
M$1269 SUB \$8983 \$8982 SUB nfet_06v0 L=1U W=2.5U AS=0.65P AD=0.65P PS=3.02U
+ PD=3.02U
M$1270 \$8982 \$8983 SUB SUB nfet_06v0 L=1U W=2.5U AS=0.65P AD=0.65P PS=3.02U
+ PD=3.02U
M$1271 SUB \$8983 \$8982 SUB nfet_06v0 L=1U W=2.5U AS=0.65P AD=1.1P PS=3.02U
+ PD=5.88U
M$1272 \$7182 \$7178 SUB SUB nfet_06v0 L=1U W=1U AS=0.44P AD=0.44P PS=2.88U
+ PD=2.88U
M$1273 \$7171 \$7171 SUB SUB nfet_06v0 L=1U W=1U AS=0.44P AD=0.44P PS=2.88U
+ PD=2.88U
M$1274 \$8984 \$8983 SUB SUB nfet_06v0 L=1U W=2.5U AS=1.1P AD=0.65P PS=5.88U
+ PD=3.02U
M$1275 SUB \$8983 \$8984 SUB nfet_06v0 L=1U W=2.5U AS=0.65P AD=0.65P PS=3.02U
+ PD=3.02U
M$1276 \$8984 \$8983 SUB SUB nfet_06v0 L=1U W=2.5U AS=0.65P AD=0.65P PS=3.02U
+ PD=3.02U
M$1277 SUB \$8983 \$8984 SUB nfet_06v0 L=1U W=2.5U AS=0.65P AD=1.1P PS=3.02U
+ PD=5.88U
M$1278 \$7238 \$7170 SUB SUB nfet_06v0 L=1U W=5U AS=2.2P AD=1.25P PS=10.88U
+ PD=5.5U
M$1279 \$7170 \$7171 \$7238 SUB nfet_06v0 L=1U W=5U AS=1.25P AD=2.2P PS=5.5U
+ PD=10.88U
M$1280 \$7222 \$7266 SUB SUB nfet_06v0 L=1U W=1U AS=0.44P AD=0.25P PS=2.88U
+ PD=1.5U
M$1281 \$7265 \$7266 \$7222 SUB nfet_06v0 L=1U W=1U AS=0.25P AD=0.44P PS=1.5U
+ PD=2.88U
M$1282 \$9354 \$8971 \$8983 SUB nfet_06v0 L=1U W=2.5U AS=1.1P AD=1.1P PS=5.88U
+ PD=5.88U
M$1283 \$7223 \$7266 SUB SUB nfet_06v0 L=1U W=1U AS=0.44P AD=0.25P PS=2.88U
+ PD=1.5U
M$1284 \$7266 \$7266 \$7223 SUB nfet_06v0 L=1U W=1U AS=0.25P AD=0.44P PS=1.5U
+ PD=2.88U
M$1285 \$8986 \$8971 \$8985 SUB nfet_06v0 L=1U W=2.5U AS=1.1P AD=1.1P PS=5.88U
+ PD=5.88U
M$1286 \$9030 \$8969 SUB SUB nfet_06v0 L=1U W=5U AS=2.2P AD=1.25P PS=10.88U
+ PD=5.5U
M$1287 \$8987 \$8968 \$9030 SUB nfet_06v0 L=1U W=5U AS=1.25P AD=2.2P PS=5.5U
+ PD=10.88U
M$1288 \$8971 \$8971 \$8988 SUB nfet_06v0 L=1U W=5U AS=2.2P AD=2.2P PS=10.88U
+ PD=10.88U
M$1289 \$9031 \$8988 SUB SUB nfet_06v0 L=1U W=5U AS=2.2P AD=1.25P PS=10.88U
+ PD=5.5U
M$1290 \$8988 \$8968 \$9031 SUB nfet_06v0 L=1U W=5U AS=1.25P AD=2.2P PS=5.5U
+ PD=10.88U
M$1291 \$8989 \$8985 SUB SUB nfet_06v0 L=1U W=5U AS=2.2P AD=1.3P PS=10.88U
+ PD=5.52U
M$1292 SUB \$8985 \$8989 SUB nfet_06v0 L=1U W=5U AS=1.3P AD=1.3P PS=5.52U
+ PD=5.52U
M$1293 \$8989 \$8985 SUB SUB nfet_06v0 L=1U W=5U AS=1.3P AD=2.2P PS=5.52U
+ PD=10.88U
M$1294 \$7239 \$7183 SUB SUB nfet_06v0 L=1U W=5U AS=2.2P AD=1.25P PS=10.88U
+ PD=5.5U
M$1295 \$7185 \$7184 \$7239 SUB nfet_06v0 L=1U W=5U AS=1.25P AD=2.2P PS=5.5U
+ PD=10.88U
M$1296 \$7240 \$7183 SUB SUB nfet_06v0 L=1U W=5U AS=2.2P AD=1.25P PS=10.88U
+ PD=5.5U
M$1297 \$7185 \$7184 \$7240 SUB nfet_06v0 L=1U W=5U AS=1.25P AD=2.2P PS=5.5U
+ PD=10.88U
M$1298 \$7187 \$7186 \$7185 SUB nfet_06v0 L=1U W=5U AS=2.2P AD=2.2P PS=10.88U
+ PD=10.88U
M$1299 \$7188 \$7502 \$7185 SUB nfet_06v0 L=1U W=5U AS=2.2P AD=2.2P PS=10.88U
+ PD=10.88U
M$1300 \$8972 \$8972 SUB SUB nfet_06v0 L=1U W=1U AS=0.44P AD=0.44P PS=2.88U
+ PD=2.88U
M$1301 \$7190 \$7184 \$7189 SUB nfet_06v0 L=1U W=2.5U AS=1.1P AD=1.1P PS=5.88U
+ PD=5.88U
M$1302 \$9035 \$8973 SUB SUB nfet_06v0 L=1U W=5U AS=2.2P AD=1.25P PS=10.88U
+ PD=5.5U
M$1303 \$8973 \$8972 \$9035 SUB nfet_06v0 L=1U W=5U AS=1.25P AD=2.2P PS=5.5U
+ PD=10.88U
M$1304 \$7192 \$7184 \$7191 SUB nfet_06v0 L=1U W=2.5U AS=1.1P AD=1.1P PS=5.88U
+ PD=5.88U
M$1305 \$7189 \$7190 SUB SUB nfet_06v0 L=1U W=2.5U AS=1.1P AD=1.1P PS=5.88U
+ PD=5.88U
M$1306 \$9016 \$10036 SUB SUB nfet_06v0 L=1U W=1U AS=0.44P AD=0.25P PS=2.88U
+ PD=1.5U
M$1307 \$9808 \$10036 \$9016 SUB nfet_06v0 L=1U W=1U AS=0.25P AD=0.44P PS=1.5U
+ PD=2.88U
M$1308 \$7191 \$7190 SUB SUB nfet_06v0 L=1U W=2.5U AS=1.1P AD=1.1P PS=5.88U
+ PD=5.88U
M$1309 \$9015 \$10036 SUB SUB nfet_06v0 L=1U W=1U AS=0.44P AD=0.25P PS=2.88U
+ PD=1.5U
M$1310 \$10036 \$10036 \$9015 SUB nfet_06v0 L=1U W=1U AS=0.25P AD=0.44P PS=1.5U
+ PD=2.88U
M$1311 \$7659 \$7193 \$7190 SUB nfet_06v0 L=1U W=2.5U AS=1.1P AD=1.1P PS=5.88U
+ PD=5.88U
M$1312 \$9036 \$8973 SUB SUB nfet_06v0 L=1U W=5U AS=2.2P AD=1.25P PS=10.88U
+ PD=5.5U
M$1313 \$8990 \$8972 \$9036 SUB nfet_06v0 L=1U W=5U AS=1.25P AD=2.2P PS=5.5U
+ PD=10.88U
M$1314 \$7217 \$7193 \$7192 SUB nfet_06v0 L=1U W=2.5U AS=1.1P AD=1.1P PS=5.88U
+ PD=5.88U
M$1315 \$7243 \$7183 SUB SUB nfet_06v0 L=1U W=5U AS=2.2P AD=1.25P PS=10.88U
+ PD=5.5U
M$1316 \$7194 \$7184 \$7243 SUB nfet_06v0 L=1U W=5U AS=1.25P AD=2.2P PS=5.5U
+ PD=10.88U
M$1317 \$9037 \$8973 SUB SUB nfet_06v0 L=1U W=5U AS=2.2P AD=1.25P PS=10.88U
+ PD=5.5U
M$1318 \$8990 \$8972 \$9037 SUB nfet_06v0 L=1U W=5U AS=1.25P AD=2.2P PS=5.5U
+ PD=10.88U
M$1319 \$7193 \$7193 \$7195 SUB nfet_06v0 L=1U W=5U AS=2.2P AD=2.2P PS=10.88U
+ PD=10.88U
M$1320 \$8991 \$9050 \$8990 SUB nfet_06v0 L=1U W=5U AS=2.2P AD=1.3P PS=10.88U
+ PD=5.52U
M$1321 \$8990 \$9050 \$8991 SUB nfet_06v0 L=1U W=5U AS=1.3P AD=2.2P PS=5.52U
+ PD=10.88U
M$1322 \$7244 \$7195 SUB SUB nfet_06v0 L=1U W=5U AS=2.2P AD=1.25P PS=10.88U
+ PD=5.5U
M$1323 \$7195 \$7184 \$7244 SUB nfet_06v0 L=1U W=5U AS=1.25P AD=2.2P PS=5.5U
+ PD=10.88U
M$1324 \$8992 \$7259 \$8990 SUB nfet_06v0 L=1U W=5U AS=2.2P AD=1.3P PS=10.88U
+ PD=5.52U
M$1325 \$8990 \$7259 \$8992 SUB nfet_06v0 L=1U W=5U AS=1.3P AD=2.2P PS=5.52U
+ PD=10.88U
M$1326 \$7196 \$7192 SUB SUB nfet_06v0 L=1U W=1U AS=0.44P AD=0.44P PS=2.88U
+ PD=2.88U
M$1327 \$8994 \$8972 \$8993 SUB nfet_06v0 L=1U W=2.5U AS=1.1P AD=0.65P PS=5.88U
+ PD=3.02U
M$1328 \$8993 \$8972 \$8994 SUB nfet_06v0 L=1U W=2.5U AS=0.65P AD=1.1P PS=3.02U
+ PD=5.88U
M$1329 \$7184 \$7184 SUB SUB nfet_06v0 L=1U W=1U AS=0.44P AD=0.44P PS=2.88U
+ PD=2.88U
M$1330 \$7246 \$7183 SUB SUB nfet_06v0 L=1U W=5U AS=2.2P AD=1.25P PS=10.88U
+ PD=5.5U
M$1331 \$7183 \$7184 \$7246 SUB nfet_06v0 L=1U W=5U AS=1.25P AD=2.2P PS=5.5U
+ PD=10.88U
M$1332 \$8996 \$8972 \$8995 SUB nfet_06v0 L=1U W=2.5U AS=1.1P AD=0.65P PS=5.88U
+ PD=3.02U
M$1333 \$8995 \$8972 \$8996 SUB nfet_06v0 L=1U W=2.5U AS=0.65P AD=1.1P PS=3.02U
+ PD=5.88U
M$1334 \$7225 \$7268 SUB SUB nfet_06v0 L=1U W=1U AS=0.44P AD=0.25P PS=2.88U
+ PD=1.5U
M$1335 \$7267 \$7268 \$7225 SUB nfet_06v0 L=1U W=1U AS=0.25P AD=0.44P PS=1.5U
+ PD=2.88U
M$1336 \$8993 \$8994 SUB SUB nfet_06v0 L=1U W=2.5U AS=1.1P AD=0.65P PS=5.88U
+ PD=3.02U
M$1337 SUB \$8994 \$8993 SUB nfet_06v0 L=1U W=2.5U AS=0.65P AD=0.65P PS=3.02U
+ PD=3.02U
M$1338 \$8993 \$8994 SUB SUB nfet_06v0 L=1U W=2.5U AS=0.65P AD=0.65P PS=3.02U
+ PD=3.02U
M$1339 SUB \$8994 \$8993 SUB nfet_06v0 L=1U W=2.5U AS=0.65P AD=1.1P PS=3.02U
+ PD=5.88U
M$1340 \$7224 \$7268 SUB SUB nfet_06v0 L=1U W=1U AS=0.44P AD=0.25P PS=2.88U
+ PD=1.5U
M$1341 \$7268 \$7268 \$7224 SUB nfet_06v0 L=1U W=1U AS=0.25P AD=0.44P PS=1.5U
+ PD=2.88U
M$1342 \$8995 \$8994 SUB SUB nfet_06v0 L=1U W=2.5U AS=1.1P AD=0.65P PS=5.88U
+ PD=3.02U
M$1343 SUB \$8994 \$8995 SUB nfet_06v0 L=1U W=2.5U AS=0.65P AD=0.65P PS=3.02U
+ PD=3.02U
M$1344 \$8995 \$8994 SUB SUB nfet_06v0 L=1U W=2.5U AS=0.65P AD=0.65P PS=3.02U
+ PD=3.02U
M$1345 SUB \$8994 \$8995 SUB nfet_06v0 L=1U W=2.5U AS=0.65P AD=1.1P PS=3.02U
+ PD=5.88U
M$1346 \$9355 \$8974 \$8994 SUB nfet_06v0 L=1U W=2.5U AS=1.1P AD=1.1P PS=5.88U
+ PD=5.88U
M$1347 \$8997 \$8974 \$8996 SUB nfet_06v0 L=1U W=2.5U AS=1.1P AD=1.1P PS=5.88U
+ PD=5.88U
M$1348 \$9039 \$8973 SUB SUB nfet_06v0 L=1U W=5U AS=2.2P AD=1.25P PS=10.88U
+ PD=5.5U
M$1349 \$8998 \$8972 \$9039 SUB nfet_06v0 L=1U W=5U AS=1.25P AD=2.2P PS=5.5U
+ PD=10.88U
M$1350 \$8974 \$8974 \$8999 SUB nfet_06v0 L=1U W=5U AS=2.2P AD=2.2P PS=10.88U
+ PD=10.88U
M$1351 \$9038 \$8999 SUB SUB nfet_06v0 L=1U W=5U AS=2.2P AD=1.25P PS=10.88U
+ PD=5.5U
M$1352 \$8999 \$8972 \$9038 SUB nfet_06v0 L=1U W=5U AS=1.25P AD=2.2P PS=5.5U
+ PD=10.88U
M$1353 \$7247 \$7197 SUB SUB nfet_06v0 L=1U W=5U AS=2.2P AD=1.25P PS=10.88U
+ PD=5.5U
M$1354 \$7199 \$7198 \$7247 SUB nfet_06v0 L=1U W=5U AS=1.25P AD=2.2P PS=5.5U
+ PD=10.88U
M$1355 \$9020 \$8996 SUB SUB nfet_06v0 L=1U W=5U AS=2.2P AD=1.3P PS=10.88U
+ PD=5.52U
M$1356 SUB \$8996 \$9020 SUB nfet_06v0 L=1U W=5U AS=1.3P AD=1.3P PS=5.52U
+ PD=5.52U
M$1357 \$9020 \$8996 SUB SUB nfet_06v0 L=1U W=5U AS=1.3P AD=2.2P PS=5.52U
+ PD=10.88U
M$1358 \$7248 \$7197 SUB SUB nfet_06v0 L=1U W=5U AS=2.2P AD=1.25P PS=10.88U
+ PD=5.5U
M$1359 \$7199 \$7198 \$7248 SUB nfet_06v0 L=1U W=5U AS=1.25P AD=2.2P PS=5.5U
+ PD=10.88U
M$1360 \$7200 S1P \$7199 SUB nfet_06v0 L=1U W=5U AS=2.2P AD=2.2P PS=10.88U
+ PD=10.88U
M$1361 \$7201 S1N \$7199 SUB nfet_06v0 L=1U W=5U AS=2.2P AD=2.2P PS=10.88U
+ PD=10.88U
M$1362 \$7203 \$7198 \$7202 SUB nfet_06v0 L=1U W=2.5U AS=1.1P AD=1.1P PS=5.88U
+ PD=5.88U
M$1363 \$7205 \$7198 \$7204 SUB nfet_06v0 L=1U W=2.5U AS=1.1P AD=1.1P PS=5.88U
+ PD=5.88U
M$1364 \$7202 \$7203 SUB SUB nfet_06v0 L=1U W=2.5U AS=1.1P AD=1.1P PS=5.88U
+ PD=5.88U
M$1365 \$7204 \$7203 SUB SUB nfet_06v0 L=1U W=2.5U AS=1.1P AD=1.1P PS=5.88U
+ PD=5.88U
M$1366 \$7661 \$7206 \$7203 SUB nfet_06v0 L=1U W=2.5U AS=1.1P AD=1.1P PS=5.88U
+ PD=5.88U
M$1367 \$8975 \$8975 SUB SUB nfet_06v0 L=1U W=1U AS=0.44P AD=0.44P PS=2.88U
+ PD=2.88U
M$1368 \$7219 \$7206 \$7205 SUB nfet_06v0 L=1U W=2.5U AS=1.1P AD=1.1P PS=5.88U
+ PD=5.88U
M$1369 \$9034 \$8976 SUB SUB nfet_06v0 L=1U W=5U AS=2.2P AD=1.25P PS=10.88U
+ PD=5.5U
M$1370 \$8976 \$8975 \$9034 SUB nfet_06v0 L=1U W=5U AS=1.25P AD=2.2P PS=5.5U
+ PD=10.88U
M$1371 \$7245 \$7197 SUB SUB nfet_06v0 L=1U W=5U AS=2.2P AD=1.25P PS=10.88U
+ PD=5.5U
M$1372 \$7207 \$7198 \$7245 SUB nfet_06v0 L=1U W=5U AS=1.25P AD=2.2P PS=5.5U
+ PD=10.88U
M$1373 \$9014 \$10037 SUB SUB nfet_06v0 L=1U W=1U AS=0.44P AD=0.25P PS=2.88U
+ PD=1.5U
M$1374 \$9809 \$10037 \$9014 SUB nfet_06v0 L=1U W=1U AS=0.25P AD=0.44P PS=1.5U
+ PD=2.88U
M$1375 \$7206 \$7206 \$7208 SUB nfet_06v0 L=1U W=5U AS=2.2P AD=2.2P PS=10.88U
+ PD=10.88U
M$1376 \$9013 \$10037 SUB SUB nfet_06v0 L=1U W=1U AS=0.44P AD=0.25P PS=2.88U
+ PD=1.5U
M$1377 \$10037 \$10037 \$9013 SUB nfet_06v0 L=1U W=1U AS=0.25P AD=0.44P PS=1.5U
+ PD=2.88U
M$1378 \$7242 \$7208 SUB SUB nfet_06v0 L=1U W=5U AS=2.2P AD=1.25P PS=10.88U
+ PD=5.5U
M$1379 \$7208 \$7198 \$7242 SUB nfet_06v0 L=1U W=5U AS=1.25P AD=2.2P PS=5.5U
+ PD=10.88U
M$1380 \$9033 \$8976 SUB SUB nfet_06v0 L=1U W=5U AS=2.2P AD=1.25P PS=10.88U
+ PD=5.5U
M$1381 \$9000 \$8975 \$9033 SUB nfet_06v0 L=1U W=5U AS=1.25P AD=2.2P PS=5.5U
+ PD=10.88U
M$1382 \$7209 \$7205 SUB SUB nfet_06v0 L=1U W=1U AS=0.44P AD=0.44P PS=2.88U
+ PD=2.88U
M$1383 \$9032 \$8976 SUB SUB nfet_06v0 L=1U W=5U AS=2.2P AD=1.25P PS=10.88U
+ PD=5.5U
M$1384 \$9000 \$8975 \$9032 SUB nfet_06v0 L=1U W=5U AS=1.25P AD=2.2P PS=5.5U
+ PD=10.88U
M$1385 \$7198 \$7198 SUB SUB nfet_06v0 L=1U W=1U AS=0.44P AD=0.44P PS=2.88U
+ PD=2.88U
M$1386 \$7241 \$7197 SUB SUB nfet_06v0 L=1U W=5U AS=2.2P AD=1.25P PS=10.88U
+ PD=5.5U
M$1387 \$7197 \$7198 \$7241 SUB nfet_06v0 L=1U W=5U AS=1.25P AD=2.2P PS=5.5U
+ PD=10.88U
M$1388 \$9001 \$7209 \$9000 SUB nfet_06v0 L=1U W=5U AS=2.2P AD=1.3P PS=10.88U
+ PD=5.52U
M$1389 \$9000 \$7209 \$9001 SUB nfet_06v0 L=1U W=5U AS=1.3P AD=2.2P PS=5.52U
+ PD=10.88U
M$1390 \$7221 \$7270 SUB SUB nfet_06v0 L=1U W=1U AS=0.44P AD=0.25P PS=2.88U
+ PD=1.5U
M$1391 \$7269 \$7270 \$7221 SUB nfet_06v0 L=1U W=1U AS=0.25P AD=0.44P PS=1.5U
+ PD=2.88U
M$1392 \$9002 \$8977 \$9000 SUB nfet_06v0 L=1U W=5U AS=2.2P AD=1.3P PS=10.88U
+ PD=5.52U
M$1393 \$9000 \$8977 \$9002 SUB nfet_06v0 L=1U W=5U AS=1.3P AD=2.2P PS=5.52U
+ PD=10.88U
M$1394 \$7220 \$7270 SUB SUB nfet_06v0 L=1U W=1U AS=0.44P AD=0.25P PS=2.88U
+ PD=1.5U
M$1395 \$7270 \$7270 \$7220 SUB nfet_06v0 L=1U W=1U AS=0.25P AD=0.44P PS=1.5U
+ PD=2.88U
M$1396 \$9004 \$8975 \$9003 SUB nfet_06v0 L=1U W=2.5U AS=1.1P AD=0.65P PS=5.88U
+ PD=3.02U
M$1397 \$9003 \$8975 \$9004 SUB nfet_06v0 L=1U W=2.5U AS=0.65P AD=1.1P PS=3.02U
+ PD=5.88U
M$1398 \$9006 \$8975 \$9005 SUB nfet_06v0 L=1U W=2.5U AS=1.1P AD=0.65P PS=5.88U
+ PD=3.02U
M$1399 \$9005 \$8975 \$9006 SUB nfet_06v0 L=1U W=2.5U AS=0.65P AD=1.1P PS=3.02U
+ PD=5.88U
M$1400 \$9003 \$9004 SUB SUB nfet_06v0 L=1U W=2.5U AS=1.1P AD=0.65P PS=5.88U
+ PD=3.02U
M$1401 SUB \$9004 \$9003 SUB nfet_06v0 L=1U W=2.5U AS=0.65P AD=0.65P PS=3.02U
+ PD=3.02U
M$1402 \$9003 \$9004 SUB SUB nfet_06v0 L=1U W=2.5U AS=0.65P AD=0.65P PS=3.02U
+ PD=3.02U
M$1403 SUB \$9004 \$9003 SUB nfet_06v0 L=1U W=2.5U AS=0.65P AD=1.1P PS=3.02U
+ PD=5.88U
M$1404 \$9005 \$9004 SUB SUB nfet_06v0 L=1U W=2.5U AS=1.1P AD=0.65P PS=5.88U
+ PD=3.02U
M$1405 SUB \$9004 \$9005 SUB nfet_06v0 L=1U W=2.5U AS=0.65P AD=0.65P PS=3.02U
+ PD=3.02U
M$1406 \$9005 \$9004 SUB SUB nfet_06v0 L=1U W=2.5U AS=0.65P AD=0.65P PS=3.02U
+ PD=3.02U
M$1407 SUB \$9004 \$9005 SUB nfet_06v0 L=1U W=2.5U AS=0.65P AD=1.1P PS=3.02U
+ PD=5.88U
M$1408 \$9356 \$8978 \$9004 SUB nfet_06v0 L=1U W=2.5U AS=1.1P AD=1.1P PS=5.88U
+ PD=5.88U
M$1409 \$7228 \$7227 \$7226 SUB nfet_06v0 L=1U W=2.48U AS=1.0912P AD=0.6448P
+ PS=5.84U PD=3U
M$1410 \$7226 \$7227 \$7228 SUB nfet_06v0 L=1U W=2.48U AS=0.6448P AD=1.0912P
+ PS=3U PD=5.84U
M$1411 \$7228 \$7166 \$7165 SUB nfet_06v0 L=1U W=2.48U AS=1.0912P AD=0.6448P
+ PS=5.84U PD=3U
M$1412 \$7165 \$7166 \$7228 SUB nfet_06v0 L=1U W=2.48U AS=0.6448P AD=1.0912P
+ PS=3U PD=5.84U
M$1413 \$9007 \$8978 \$9006 SUB nfet_06v0 L=1U W=2.5U AS=1.1P AD=1.1P PS=5.88U
+ PD=5.88U
M$1414 \$9029 \$8976 SUB SUB nfet_06v0 L=1U W=5U AS=2.2P AD=1.25P PS=10.88U
+ PD=5.5U
M$1415 \$9008 \$8975 \$9029 SUB nfet_06v0 L=1U W=5U AS=1.25P AD=2.2P PS=5.5U
+ PD=10.88U
M$1416 \$7228 \$7230 \$7229 SUB nfet_06v0 L=1U W=2.48U AS=1.0912P AD=0.6448P
+ PS=5.84U PD=3U
M$1417 \$7229 \$7230 \$7228 SUB nfet_06v0 L=1U W=2.48U AS=0.6448P AD=1.0912P
+ PS=3U PD=5.84U
M$1418 \$7165 \$7167 SUB SUB nfet_06v0 L=1U W=1.24U AS=0.5456P AD=0.5456P
+ PS=3.36U PD=3.36U
M$1419 \$8978 \$8978 \$9009 SUB nfet_06v0 L=1U W=5U AS=2.2P AD=2.2P PS=10.88U
+ PD=10.88U
M$1420 \$7226 \$7167 SUB SUB nfet_06v0 L=1U W=1.24U AS=0.5456P AD=0.5456P
+ PS=3.36U PD=3.36U
M$1421 \$7229 \$7167 SUB SUB nfet_06v0 L=1U W=1.24U AS=0.5456P AD=0.5456P
+ PS=3.36U PD=3.36U
M$1422 \$9027 \$9009 SUB SUB nfet_06v0 L=1U W=5U AS=2.2P AD=1.25P PS=10.88U
+ PD=5.5U
M$1423 \$9009 \$8975 \$9027 SUB nfet_06v0 L=1U W=5U AS=1.25P AD=2.2P PS=5.5U
+ PD=10.88U
M$1424 \$7213 \$7167 SUB SUB nfet_06v0 L=1U W=0.7U AS=0.308P AD=0.175P PS=2.28U
+ PD=1.2U
M$1425 \$7212 \$7167 \$7213 SUB nfet_06v0 L=1U W=0.7U AS=0.175P AD=0.175P
+ PS=1.2U PD=1.2U
M$1426 \$7211 \$7167 \$7212 SUB nfet_06v0 L=1U W=0.7U AS=0.175P AD=0.175P
+ PS=1.2U PD=1.2U
M$1427 \$7167 \$7167 \$7211 SUB nfet_06v0 L=1U W=0.7U AS=0.175P AD=0.308P
+ PS=1.2U PD=2.28U
M$1428 \$7228 \$7228 \$7231 SUB nfet_06v0 L=1U W=2U AS=0.88P AD=0.52P PS=4.88U
+ PD=2.52U
M$1429 \$7231 \$7228 \$7228 SUB nfet_06v0 L=1U W=2U AS=0.52P AD=0.88P PS=2.52U
+ PD=4.88U
M$1430 \$9010 \$9006 SUB SUB nfet_06v0 L=1U W=5U AS=2.2P AD=1.3P PS=10.88U
+ PD=5.52U
M$1431 SUB \$9006 \$9010 SUB nfet_06v0 L=1U W=5U AS=1.3P AD=1.3P PS=5.52U
+ PD=5.52U
M$1432 \$9010 \$9006 SUB SUB nfet_06v0 L=1U W=5U AS=1.3P AD=2.2P PS=5.52U
+ PD=10.88U
M$1433 \$7256 \$7228 SUB SUB nfet_06v0 L=1U W=2U AS=0.88P AD=0.5P PS=4.88U
+ PD=2.5U
M$1434 \$7231 \$7228 \$7256 SUB nfet_06v0 L=1U W=2U AS=0.5P AD=0.88P PS=2.5U
+ PD=4.88U
M$1435 \$7228 \$7233 \$7232 SUB nfet_06v0 L=1U W=2.48U AS=1.0912P AD=0.6448P
+ PS=5.84U PD=3U
M$1436 \$7232 \$7233 \$7228 SUB nfet_06v0 L=1U W=2.48U AS=0.6448P AD=1.0912P
+ PS=3U PD=5.84U
M$1437 \$7232 \$7167 SUB SUB nfet_06v0 L=1U W=1.24U AS=0.5456P AD=0.5456P
+ PS=3.36U PD=3.36U
M$1438 \$12527 \$12527 SUB SUB nfet_06v0 L=1U W=1U AS=0.44P AD=0.44P PS=2.88U
+ PD=2.88U
M$1439 \$10806 \$10741 SUB SUB nfet_06v0 L=1U W=5U AS=2.2P AD=1.25P PS=10.88U
+ PD=5.5U
M$1440 \$10756 \$10742 \$10806 SUB nfet_06v0 L=1U W=5U AS=1.25P AD=2.2P PS=5.5U
+ PD=10.88U
M$1441 \$12584 \$12528 SUB SUB nfet_06v0 L=1U W=5U AS=2.2P AD=1.25P PS=10.88U
+ PD=5.5U
M$1442 \$12528 \$12527 \$12584 SUB nfet_06v0 L=1U W=5U AS=1.25P AD=2.2P PS=5.5U
+ PD=10.88U
M$1443 \$10807 \$10741 SUB SUB nfet_06v0 L=1U W=5U AS=2.2P AD=1.25P PS=10.88U
+ PD=5.5U
M$1444 \$10756 \$10742 \$10807 SUB nfet_06v0 L=1U W=5U AS=1.25P AD=2.2P PS=5.5U
+ PD=10.88U
M$1445 \$12572 \$13594 SUB SUB nfet_06v0 L=1U W=1U AS=0.44P AD=0.25P PS=2.88U
+ PD=1.5U
M$1446 \$13441 \$13594 \$12572 SUB nfet_06v0 L=1U W=1U AS=0.25P AD=0.44P
+ PS=1.5U PD=2.88U
M$1447 \$10757 S3P \$10756 SUB nfet_06v0 L=1U W=5U AS=2.2P AD=2.2P PS=10.88U
+ PD=10.88U
M$1448 \$12573 \$13594 SUB SUB nfet_06v0 L=1U W=1U AS=0.44P AD=0.25P PS=2.88U
+ PD=1.5U
M$1449 \$13594 \$13594 \$12573 SUB nfet_06v0 L=1U W=1U AS=0.25P AD=0.44P
+ PS=1.5U PD=2.88U
M$1450 \$10758 S3N \$10756 SUB nfet_06v0 L=1U W=5U AS=2.2P AD=2.2P PS=10.88U
+ PD=10.88U
M$1451 \$10760 \$10742 \$10759 SUB nfet_06v0 L=1U W=2.5U AS=1.1P AD=1.1P
+ PS=5.88U PD=5.88U
M$1452 \$12586 \$12528 SUB SUB nfet_06v0 L=1U W=5U AS=2.2P AD=1.25P PS=10.88U
+ PD=5.5U
M$1453 \$12539 \$12527 \$12586 SUB nfet_06v0 L=1U W=5U AS=1.25P AD=2.2P PS=5.5U
+ PD=10.88U
M$1454 \$10762 \$10742 \$10761 SUB nfet_06v0 L=1U W=2.5U AS=1.1P AD=1.1P
+ PS=5.88U PD=5.88U
M$1455 \$12587 \$12528 SUB SUB nfet_06v0 L=1U W=5U AS=2.2P AD=1.25P PS=10.88U
+ PD=5.5U
M$1456 \$12539 \$12527 \$12587 SUB nfet_06v0 L=1U W=5U AS=1.25P AD=2.2P PS=5.5U
+ PD=10.88U
M$1457 \$10759 \$10760 SUB SUB nfet_06v0 L=1U W=2.5U AS=1.1P AD=1.1P PS=5.88U
+ PD=5.88U
M$1458 \$10761 \$10760 SUB SUB nfet_06v0 L=1U W=2.5U AS=1.1P AD=1.1P PS=5.88U
+ PD=5.88U
M$1459 \$12540 \$12608 \$12539 SUB nfet_06v0 L=1U W=5U AS=2.2P AD=1.3P
+ PS=10.88U PD=5.52U
M$1460 \$12539 \$12608 \$12540 SUB nfet_06v0 L=1U W=5U AS=1.3P AD=2.2P PS=5.52U
+ PD=10.88U
M$1461 \$11142 \$10743 \$10760 SUB nfet_06v0 L=1U W=2.5U AS=1.1P AD=1.1P
+ PS=5.88U PD=5.88U
M$1462 \$12541 \$12529 \$12539 SUB nfet_06v0 L=1U W=5U AS=2.2P AD=1.3P
+ PS=10.88U PD=5.52U
M$1463 \$12539 \$12529 \$12541 SUB nfet_06v0 L=1U W=5U AS=1.3P AD=2.2P PS=5.52U
+ PD=10.88U
M$1464 \$10797 \$10743 \$10762 SUB nfet_06v0 L=1U W=2.5U AS=1.1P AD=1.1P
+ PS=5.88U PD=5.88U
M$1465 \$10808 \$10741 SUB SUB nfet_06v0 L=1U W=5U AS=2.2P AD=1.25P PS=10.88U
+ PD=5.5U
M$1466 \$10763 \$10742 \$10808 SUB nfet_06v0 L=1U W=5U AS=1.25P AD=2.2P PS=5.5U
+ PD=10.88U
M$1467 \$12543 \$12527 \$12542 SUB nfet_06v0 L=1U W=2.5U AS=1.1P AD=0.65P
+ PS=5.88U PD=3.02U
M$1468 \$12542 \$12527 \$12543 SUB nfet_06v0 L=1U W=2.5U AS=0.65P AD=1.1P
+ PS=3.02U PD=5.88U
M$1469 \$10743 \$10743 \$10764 SUB nfet_06v0 L=1U W=5U AS=2.2P AD=2.2P
+ PS=10.88U PD=10.88U
M$1470 \$12545 \$12527 \$12544 SUB nfet_06v0 L=1U W=2.5U AS=1.1P AD=0.65P
+ PS=5.88U PD=3.02U
M$1471 \$12544 \$12527 \$12545 SUB nfet_06v0 L=1U W=2.5U AS=0.65P AD=1.1P
+ PS=3.02U PD=5.88U
M$1472 \$10809 \$10764 SUB SUB nfet_06v0 L=1U W=5U AS=2.2P AD=1.25P PS=10.88U
+ PD=5.5U
M$1473 \$10764 \$10742 \$10809 SUB nfet_06v0 L=1U W=5U AS=1.25P AD=2.2P PS=5.5U
+ PD=10.88U
M$1474 \$12542 \$12543 SUB SUB nfet_06v0 L=1U W=2.5U AS=1.1P AD=0.65P PS=5.88U
+ PD=3.02U
M$1475 SUB \$12543 \$12542 SUB nfet_06v0 L=1U W=2.5U AS=0.65P AD=0.65P PS=3.02U
+ PD=3.02U
M$1476 \$12542 \$12543 SUB SUB nfet_06v0 L=1U W=2.5U AS=0.65P AD=0.65P PS=3.02U
+ PD=3.02U
M$1477 SUB \$12543 \$12542 SUB nfet_06v0 L=1U W=2.5U AS=0.65P AD=1.1P PS=3.02U
+ PD=5.88U
M$1478 \$10765 \$10762 SUB SUB nfet_06v0 L=1U W=1U AS=0.44P AD=0.44P PS=2.88U
+ PD=2.88U
M$1479 \$10742 \$10742 SUB SUB nfet_06v0 L=1U W=1U AS=0.44P AD=0.44P PS=2.88U
+ PD=2.88U
M$1480 \$12544 \$12543 SUB SUB nfet_06v0 L=1U W=2.5U AS=1.1P AD=0.65P PS=5.88U
+ PD=3.02U
M$1481 SUB \$12543 \$12544 SUB nfet_06v0 L=1U W=2.5U AS=0.65P AD=0.65P PS=3.02U
+ PD=3.02U
M$1482 \$12544 \$12543 SUB SUB nfet_06v0 L=1U W=2.5U AS=0.65P AD=0.65P PS=3.02U
+ PD=3.02U
M$1483 SUB \$12543 \$12544 SUB nfet_06v0 L=1U W=2.5U AS=0.65P AD=1.1P PS=3.02U
+ PD=5.88U
M$1484 \$10810 \$10741 SUB SUB nfet_06v0 L=1U W=5U AS=2.2P AD=1.25P PS=10.88U
+ PD=5.5U
M$1485 \$10741 \$10742 \$10810 SUB nfet_06v0 L=1U W=5U AS=1.25P AD=2.2P PS=5.5U
+ PD=10.88U
M$1486 \$10792 \$10822 SUB SUB nfet_06v0 L=1U W=1U AS=0.44P AD=0.25P PS=2.88U
+ PD=1.5U
M$1487 \$10833 \$10822 \$10792 SUB nfet_06v0 L=1U W=1U AS=0.25P AD=0.44P
+ PS=1.5U PD=2.88U
M$1488 \$12913 \$12530 \$12543 SUB nfet_06v0 L=1U W=2.5U AS=1.1P AD=1.1P
+ PS=5.88U PD=5.88U
M$1489 \$10794 \$10822 SUB SUB nfet_06v0 L=1U W=1U AS=0.44P AD=0.25P PS=2.88U
+ PD=1.5U
M$1490 \$10822 \$10822 \$10794 SUB nfet_06v0 L=1U W=1U AS=0.25P AD=0.44P
+ PS=1.5U PD=2.88U
M$1491 \$12546 \$12530 \$12545 SUB nfet_06v0 L=1U W=2.5U AS=1.1P AD=1.1P
+ PS=5.88U PD=5.88U
M$1492 \$12589 \$12528 SUB SUB nfet_06v0 L=1U W=5U AS=2.2P AD=1.25P PS=10.88U
+ PD=5.5U
M$1493 \$12547 \$12527 \$12589 SUB nfet_06v0 L=1U W=5U AS=1.25P AD=2.2P PS=5.5U
+ PD=10.88U
M$1494 \$12530 \$12530 \$12548 SUB nfet_06v0 L=1U W=5U AS=2.2P AD=2.2P
+ PS=10.88U PD=10.88U
M$1495 \$12591 \$12548 SUB SUB nfet_06v0 L=1U W=5U AS=2.2P AD=1.25P PS=10.88U
+ PD=5.5U
M$1496 \$12548 \$12527 \$12591 SUB nfet_06v0 L=1U W=5U AS=1.25P AD=2.2P PS=5.5U
+ PD=10.88U
M$1497 \$12549 \$12545 SUB SUB nfet_06v0 L=1U W=5U AS=2.2P AD=1.3P PS=10.88U
+ PD=5.52U
M$1498 SUB \$12545 \$12549 SUB nfet_06v0 L=1U W=5U AS=1.3P AD=1.3P PS=5.52U
+ PD=5.52U
M$1499 \$12549 \$12545 SUB SUB nfet_06v0 L=1U W=5U AS=1.3P AD=2.2P PS=5.52U
+ PD=10.88U
M$1500 \$10811 \$10744 SUB SUB nfet_06v0 L=1U W=5U AS=2.2P AD=1.25P PS=10.88U
+ PD=5.5U
M$1501 \$10767 \$10745 \$10811 SUB nfet_06v0 L=1U W=5U AS=1.25P AD=2.2P PS=5.5U
+ PD=10.88U
M$1502 \$10812 \$10744 SUB SUB nfet_06v0 L=1U W=5U AS=2.2P AD=1.25P PS=10.88U
+ PD=5.5U
M$1503 \$10767 \$10745 \$10812 SUB nfet_06v0 L=1U W=5U AS=1.25P AD=2.2P PS=5.5U
+ PD=10.88U
M$1504 \$10768 \$10913 \$10767 SUB nfet_06v0 L=1U W=5U AS=2.2P AD=2.2P
+ PS=10.88U PD=10.88U
M$1505 \$10769 S4N \$10767 SUB nfet_06v0 L=1U W=5U AS=2.2P AD=2.2P PS=10.88U
+ PD=10.88U
M$1506 \$12531 \$12531 SUB SUB nfet_06v0 L=1U W=1U AS=0.44P AD=0.44P PS=2.88U
+ PD=2.88U
M$1507 \$10771 \$10745 \$10770 SUB nfet_06v0 L=1U W=2.5U AS=1.1P AD=1.1P
+ PS=5.88U PD=5.88U
M$1508 \$12594 \$12532 SUB SUB nfet_06v0 L=1U W=5U AS=2.2P AD=1.25P PS=10.88U
+ PD=5.5U
M$1509 \$12532 \$12531 \$12594 SUB nfet_06v0 L=1U W=5U AS=1.25P AD=2.2P PS=5.5U
+ PD=10.88U
M$1510 \$10773 \$10745 \$10772 SUB nfet_06v0 L=1U W=2.5U AS=1.1P AD=1.1P
+ PS=5.88U PD=5.88U
M$1511 \$10770 \$10771 SUB SUB nfet_06v0 L=1U W=2.5U AS=1.1P AD=1.1P PS=5.88U
+ PD=5.88U
M$1512 \$12576 \$13595 SUB SUB nfet_06v0 L=1U W=1U AS=0.44P AD=0.25P PS=2.88U
+ PD=1.5U
M$1513 \$13442 \$13595 \$12576 SUB nfet_06v0 L=1U W=1U AS=0.25P AD=0.44P
+ PS=1.5U PD=2.88U
M$1514 \$10772 \$10771 SUB SUB nfet_06v0 L=1U W=2.5U AS=1.1P AD=1.1P PS=5.88U
+ PD=5.88U
M$1515 \$12577 \$13595 SUB SUB nfet_06v0 L=1U W=1U AS=0.44P AD=0.25P PS=2.88U
+ PD=1.5U
M$1516 \$13595 \$13595 \$12577 SUB nfet_06v0 L=1U W=1U AS=0.25P AD=0.44P
+ PS=1.5U PD=2.88U
M$1517 \$11144 \$10746 \$10771 SUB nfet_06v0 L=1U W=2.5U AS=1.1P AD=1.1P
+ PS=5.88U PD=5.88U
M$1518 \$12596 \$12532 SUB SUB nfet_06v0 L=1U W=5U AS=2.2P AD=1.25P PS=10.88U
+ PD=5.5U
M$1519 \$12550 \$12531 \$12596 SUB nfet_06v0 L=1U W=5U AS=1.25P AD=2.2P PS=5.5U
+ PD=10.88U
M$1520 \$10798 \$10746 \$10773 SUB nfet_06v0 L=1U W=2.5U AS=1.1P AD=1.1P
+ PS=5.88U PD=5.88U
M$1521 \$10813 \$10744 SUB SUB nfet_06v0 L=1U W=5U AS=2.2P AD=1.25P PS=10.88U
+ PD=5.5U
M$1522 \$10774 \$10745 \$10813 SUB nfet_06v0 L=1U W=5U AS=1.25P AD=2.2P PS=5.5U
+ PD=10.88U
M$1523 \$12597 \$12532 SUB SUB nfet_06v0 L=1U W=5U AS=2.2P AD=1.25P PS=10.88U
+ PD=5.5U
M$1524 \$12550 \$12531 \$12597 SUB nfet_06v0 L=1U W=5U AS=1.25P AD=2.2P PS=5.5U
+ PD=10.88U
M$1525 \$10746 \$10746 \$10775 SUB nfet_06v0 L=1U W=5U AS=2.2P AD=2.2P
+ PS=10.88U PD=10.88U
M$1526 \$12551 \$12609 \$12550 SUB nfet_06v0 L=1U W=5U AS=2.2P AD=1.3P
+ PS=10.88U PD=5.52U
M$1527 \$12550 \$12609 \$12551 SUB nfet_06v0 L=1U W=5U AS=1.3P AD=2.2P PS=5.52U
+ PD=10.88U
M$1528 \$10814 \$10775 SUB SUB nfet_06v0 L=1U W=5U AS=2.2P AD=1.25P PS=10.88U
+ PD=5.5U
M$1529 \$10775 \$10745 \$10814 SUB nfet_06v0 L=1U W=5U AS=1.25P AD=2.2P PS=5.5U
+ PD=10.88U
M$1530 \$12552 \$12533 \$12550 SUB nfet_06v0 L=1U W=5U AS=2.2P AD=1.3P
+ PS=10.88U PD=5.52U
M$1531 \$12550 \$12533 \$12552 SUB nfet_06v0 L=1U W=5U AS=1.3P AD=2.2P PS=5.52U
+ PD=10.88U
M$1532 \$10776 \$10773 SUB SUB nfet_06v0 L=1U W=1U AS=0.44P AD=0.44P PS=2.88U
+ PD=2.88U
M$1533 \$12554 \$12531 \$12553 SUB nfet_06v0 L=1U W=2.5U AS=1.1P AD=0.65P
+ PS=5.88U PD=3.02U
M$1534 \$12553 \$12531 \$12554 SUB nfet_06v0 L=1U W=2.5U AS=0.65P AD=1.1P
+ PS=3.02U PD=5.88U
M$1535 \$10745 \$10745 SUB SUB nfet_06v0 L=1U W=1U AS=0.44P AD=0.44P PS=2.88U
+ PD=2.88U
M$1536 \$10815 \$10744 SUB SUB nfet_06v0 L=1U W=5U AS=2.2P AD=1.25P PS=10.88U
+ PD=5.5U
M$1537 \$10744 \$10745 \$10815 SUB nfet_06v0 L=1U W=5U AS=1.25P AD=2.2P PS=5.5U
+ PD=10.88U
M$1538 \$12556 \$12531 \$12555 SUB nfet_06v0 L=1U W=2.5U AS=1.1P AD=0.65P
+ PS=5.88U PD=3.02U
M$1539 \$12555 \$12531 \$12556 SUB nfet_06v0 L=1U W=2.5U AS=0.65P AD=1.1P
+ PS=3.02U PD=5.88U
M$1540 \$10796 \$10826 SUB SUB nfet_06v0 L=1U W=1U AS=0.44P AD=0.25P PS=2.88U
+ PD=1.5U
M$1541 \$10834 \$10826 \$10796 SUB nfet_06v0 L=1U W=1U AS=0.25P AD=0.44P
+ PS=1.5U PD=2.88U
M$1542 \$12553 \$12554 SUB SUB nfet_06v0 L=1U W=2.5U AS=1.1P AD=0.65P PS=5.88U
+ PD=3.02U
M$1543 SUB \$12554 \$12553 SUB nfet_06v0 L=1U W=2.5U AS=0.65P AD=0.65P PS=3.02U
+ PD=3.02U
M$1544 \$12553 \$12554 SUB SUB nfet_06v0 L=1U W=2.5U AS=0.65P AD=0.65P PS=3.02U
+ PD=3.02U
M$1545 SUB \$12554 \$12553 SUB nfet_06v0 L=1U W=2.5U AS=0.65P AD=1.1P PS=3.02U
+ PD=5.88U
M$1546 \$10795 \$10826 SUB SUB nfet_06v0 L=1U W=1U AS=0.44P AD=0.25P PS=2.88U
+ PD=1.5U
M$1547 \$10826 \$10826 \$10795 SUB nfet_06v0 L=1U W=1U AS=0.25P AD=0.44P
+ PS=1.5U PD=2.88U
M$1548 \$12555 \$12554 SUB SUB nfet_06v0 L=1U W=2.5U AS=1.1P AD=0.65P PS=5.88U
+ PD=3.02U
M$1549 SUB \$12554 \$12555 SUB nfet_06v0 L=1U W=2.5U AS=0.65P AD=0.65P PS=3.02U
+ PD=3.02U
M$1550 \$12555 \$12554 SUB SUB nfet_06v0 L=1U W=2.5U AS=0.65P AD=0.65P PS=3.02U
+ PD=3.02U
M$1551 SUB \$12554 \$12555 SUB nfet_06v0 L=1U W=2.5U AS=0.65P AD=1.1P PS=3.02U
+ PD=5.88U
M$1552 \$12914 \$12534 \$12554 SUB nfet_06v0 L=1U W=2.5U AS=1.1P AD=1.1P
+ PS=5.88U PD=5.88U
M$1553 \$12557 \$12534 \$12556 SUB nfet_06v0 L=1U W=2.5U AS=1.1P AD=1.1P
+ PS=5.88U PD=5.88U
M$1554 \$12598 \$12532 SUB SUB nfet_06v0 L=1U W=5U AS=2.2P AD=1.25P PS=10.88U
+ PD=5.5U
M$1555 \$12558 \$12531 \$12598 SUB nfet_06v0 L=1U W=5U AS=1.25P AD=2.2P PS=5.5U
+ PD=10.88U
M$1556 \$12534 \$12534 \$12559 SUB nfet_06v0 L=1U W=5U AS=2.2P AD=2.2P
+ PS=10.88U PD=10.88U
M$1557 \$12595 \$12559 SUB SUB nfet_06v0 L=1U W=5U AS=2.2P AD=1.25P PS=10.88U
+ PD=5.5U
M$1558 \$12559 \$12531 \$12595 SUB nfet_06v0 L=1U W=5U AS=1.25P AD=2.2P PS=5.5U
+ PD=10.88U
M$1559 \$10818 \$10747 SUB SUB nfet_06v0 L=1U W=5U AS=2.2P AD=1.25P PS=10.88U
+ PD=5.5U
M$1560 \$10778 \$10748 \$10818 SUB nfet_06v0 L=1U W=5U AS=1.25P AD=2.2P PS=5.5U
+ PD=10.88U
M$1561 \$12560 \$12556 SUB SUB nfet_06v0 L=1U W=5U AS=2.2P AD=1.3P PS=10.88U
+ PD=5.52U
M$1562 SUB \$12556 \$12560 SUB nfet_06v0 L=1U W=5U AS=1.3P AD=1.3P PS=5.52U
+ PD=5.52U
M$1563 \$12560 \$12556 SUB SUB nfet_06v0 L=1U W=5U AS=1.3P AD=2.2P PS=5.52U
+ PD=10.88U
M$1564 \$10819 \$10747 SUB SUB nfet_06v0 L=1U W=5U AS=2.2P AD=1.25P PS=10.88U
+ PD=5.5U
M$1565 \$10778 \$10748 \$10819 SUB nfet_06v0 L=1U W=5U AS=1.25P AD=2.2P PS=5.5U
+ PD=10.88U
M$1566 \$10779 SUB \$10778 SUB nfet_06v0 L=1U W=5U AS=2.2P AD=2.2P PS=10.88U
+ PD=10.88U
M$1567 \$10780 S2N \$10778 SUB nfet_06v0 L=1U W=5U AS=2.2P AD=2.2P PS=10.88U
+ PD=10.88U
M$1568 \$10782 \$10748 \$10781 SUB nfet_06v0 L=1U W=2.5U AS=1.1P AD=1.1P
+ PS=5.88U PD=5.88U
M$1569 \$10784 \$10748 \$10783 SUB nfet_06v0 L=1U W=2.5U AS=1.1P AD=1.1P
+ PS=5.88U PD=5.88U
M$1570 \$10781 \$10782 SUB SUB nfet_06v0 L=1U W=2.5U AS=1.1P AD=1.1P PS=5.88U
+ PD=5.88U
M$1571 \$10783 \$10782 SUB SUB nfet_06v0 L=1U W=2.5U AS=1.1P AD=1.1P PS=5.88U
+ PD=5.88U
M$1572 \$11145 \$10749 \$10782 SUB nfet_06v0 L=1U W=2.5U AS=1.1P AD=1.1P
+ PS=5.88U PD=5.88U
M$1573 \$12535 \$12535 SUB SUB nfet_06v0 L=1U W=1U AS=0.44P AD=0.44P PS=2.88U
+ PD=2.88U
M$1574 \$10799 \$10749 \$10784 SUB nfet_06v0 L=1U W=2.5U AS=1.1P AD=1.1P
+ PS=5.88U PD=5.88U
M$1575 \$12593 \$12536 SUB SUB nfet_06v0 L=1U W=5U AS=2.2P AD=1.25P PS=10.88U
+ PD=5.5U
M$1576 \$12536 \$12535 \$12593 SUB nfet_06v0 L=1U W=5U AS=1.25P AD=2.2P PS=5.5U
+ PD=10.88U
M$1577 \$10820 \$10747 SUB SUB nfet_06v0 L=1U W=5U AS=2.2P AD=1.25P PS=10.88U
+ PD=5.5U
M$1578 \$10785 \$10748 \$10820 SUB nfet_06v0 L=1U W=5U AS=1.25P AD=2.2P PS=5.5U
+ PD=10.88U
M$1579 \$12575 \$13596 SUB SUB nfet_06v0 L=1U W=1U AS=0.44P AD=0.25P PS=2.88U
+ PD=1.5U
M$1580 \$13443 \$13596 \$12575 SUB nfet_06v0 L=1U W=1U AS=0.25P AD=0.44P
+ PS=1.5U PD=2.88U
M$1581 \$10749 \$10749 \$10786 SUB nfet_06v0 L=1U W=5U AS=2.2P AD=2.2P
+ PS=10.88U PD=10.88U
M$1582 \$12574 \$13596 SUB SUB nfet_06v0 L=1U W=1U AS=0.44P AD=0.25P PS=2.88U
+ PD=1.5U
M$1583 \$13596 \$13596 \$12574 SUB nfet_06v0 L=1U W=1U AS=0.25P AD=0.44P
+ PS=1.5U PD=2.88U
M$1584 \$10817 \$10786 SUB SUB nfet_06v0 L=1U W=5U AS=2.2P AD=1.25P PS=10.88U
+ PD=5.5U
M$1585 \$10786 \$10748 \$10817 SUB nfet_06v0 L=1U W=5U AS=1.25P AD=2.2P PS=5.5U
+ PD=10.88U
M$1586 \$12592 \$12536 SUB SUB nfet_06v0 L=1U W=5U AS=2.2P AD=1.25P PS=10.88U
+ PD=5.5U
M$1587 \$12561 \$12535 \$12592 SUB nfet_06v0 L=1U W=5U AS=1.25P AD=2.2P PS=5.5U
+ PD=10.88U
M$1588 \$10787 \$10784 SUB SUB nfet_06v0 L=1U W=1U AS=0.44P AD=0.44P PS=2.88U
+ PD=2.88U
M$1589 \$12590 \$12536 SUB SUB nfet_06v0 L=1U W=5U AS=2.2P AD=1.25P PS=10.88U
+ PD=5.5U
M$1590 \$12561 \$12535 \$12590 SUB nfet_06v0 L=1U W=5U AS=1.25P AD=2.2P PS=5.5U
+ PD=10.88U
M$1591 \$10748 \$10748 SUB SUB nfet_06v0 L=1U W=1U AS=0.44P AD=0.44P PS=2.88U
+ PD=2.88U
M$1592 \$10816 \$10747 SUB SUB nfet_06v0 L=1U W=5U AS=2.2P AD=1.25P PS=10.88U
+ PD=5.5U
M$1593 \$10747 \$10748 \$10816 SUB nfet_06v0 L=1U W=5U AS=1.25P AD=2.2P PS=5.5U
+ PD=10.88U
M$1594 \$12562 \$10836 \$12561 SUB nfet_06v0 L=1U W=5U AS=2.2P AD=1.3P
+ PS=10.88U PD=5.52U
M$1595 \$12561 \$10836 \$12562 SUB nfet_06v0 L=1U W=5U AS=1.3P AD=2.2P PS=5.52U
+ PD=10.88U
M$1596 \$10793 \$10830 SUB SUB nfet_06v0 L=1U W=1U AS=0.44P AD=0.25P PS=2.88U
+ PD=1.5U
M$1597 \$10835 \$10830 \$10793 SUB nfet_06v0 L=1U W=1U AS=0.25P AD=0.44P
+ PS=1.5U PD=2.88U
M$1598 \$12563 \$12537 \$12561 SUB nfet_06v0 L=1U W=5U AS=2.2P AD=1.3P
+ PS=10.88U PD=5.52U
M$1599 \$12561 \$12537 \$12563 SUB nfet_06v0 L=1U W=5U AS=1.3P AD=2.2P PS=5.52U
+ PD=10.88U
M$1600 \$10791 \$10830 SUB SUB nfet_06v0 L=1U W=1U AS=0.44P AD=0.25P PS=2.88U
+ PD=1.5U
M$1601 \$10830 \$10830 \$10791 SUB nfet_06v0 L=1U W=1U AS=0.25P AD=0.44P
+ PS=1.5U PD=2.88U
M$1602 \$12565 \$12535 \$12564 SUB nfet_06v0 L=1U W=2.5U AS=1.1P AD=0.65P
+ PS=5.88U PD=3.02U
M$1603 \$12564 \$12535 \$12565 SUB nfet_06v0 L=1U W=2.5U AS=0.65P AD=1.1P
+ PS=3.02U PD=5.88U
M$1604 \$12567 \$12535 \$12566 SUB nfet_06v0 L=1U W=2.5U AS=1.1P AD=0.65P
+ PS=5.88U PD=3.02U
M$1605 \$12566 \$12535 \$12567 SUB nfet_06v0 L=1U W=2.5U AS=0.65P AD=1.1P
+ PS=3.02U PD=5.88U
M$1606 \$12564 \$12565 SUB SUB nfet_06v0 L=1U W=2.5U AS=1.1P AD=0.65P PS=5.88U
+ PD=3.02U
M$1607 SUB \$12565 \$12564 SUB nfet_06v0 L=1U W=2.5U AS=0.65P AD=0.65P PS=3.02U
+ PD=3.02U
M$1608 \$12564 \$12565 SUB SUB nfet_06v0 L=1U W=2.5U AS=0.65P AD=0.65P PS=3.02U
+ PD=3.02U
M$1609 SUB \$12565 \$12564 SUB nfet_06v0 L=1U W=2.5U AS=0.65P AD=1.1P PS=3.02U
+ PD=5.88U
M$1610 \$12566 \$12565 SUB SUB nfet_06v0 L=1U W=2.5U AS=1.1P AD=0.65P PS=5.88U
+ PD=3.02U
M$1611 SUB \$12565 \$12566 SUB nfet_06v0 L=1U W=2.5U AS=0.65P AD=0.65P PS=3.02U
+ PD=3.02U
M$1612 \$12566 \$12565 SUB SUB nfet_06v0 L=1U W=2.5U AS=0.65P AD=0.65P PS=3.02U
+ PD=3.02U
M$1613 SUB \$12565 \$12566 SUB nfet_06v0 L=1U W=2.5U AS=0.65P AD=1.1P PS=3.02U
+ PD=5.88U
M$1614 \$12915 \$12538 \$12565 SUB nfet_06v0 L=1U W=2.5U AS=1.1P AD=1.1P
+ PS=5.88U PD=5.88U
M$1615 SUB \$1884 \$7889 SUB nfet_06v0 L=1U W=1U AS=0.44P AD=0.44P PS=2.88U
+ PD=2.88U
M$1616 \$12568 \$12538 \$12567 SUB nfet_06v0 L=1U W=2.5U AS=1.1P AD=1.1P
+ PS=5.88U PD=5.88U
M$1617 SUB \$1862 \$7889 SUB nfet_06v0 L=1U W=1U AS=0.44P AD=0.44P PS=2.88U
+ PD=2.88U
M$1618 \$12588 \$12536 SUB SUB nfet_06v0 L=1U W=5U AS=2.2P AD=1.25P PS=10.88U
+ PD=5.5U
M$1619 \$12569 \$12535 \$12588 SUB nfet_06v0 L=1U W=5U AS=1.25P AD=2.2P PS=5.5U
+ PD=10.88U
M$1620 SUB \$10751 \$10750 SUB nfet_06v0 L=1U W=1U AS=0.44P AD=0.44P PS=2.88U
+ PD=2.88U
M$1621 \$12538 \$12538 \$12570 SUB nfet_06v0 L=1U W=5U AS=2.2P AD=2.2P
+ PS=10.88U PD=10.88U
M$1622 SUB \$10753 \$10752 SUB nfet_06v0 L=1U W=1U AS=0.44P AD=0.44P PS=2.88U
+ PD=2.88U
M$1623 \$12585 \$12570 SUB SUB nfet_06v0 L=1U W=5U AS=2.2P AD=1.25P PS=10.88U
+ PD=5.5U
M$1624 \$12570 \$12535 \$12585 SUB nfet_06v0 L=1U W=5U AS=1.25P AD=2.2P PS=5.5U
+ PD=10.88U
M$1625 \$10790 \$10750 \$10753 SUB nfet_06v0 L=1U W=1U AS=0.44P AD=0.25P
+ PS=2.88U PD=1.5U
M$1626 SUB \$1884 \$10790 SUB nfet_06v0 L=1U W=1U AS=0.25P AD=0.44P PS=1.5U
+ PD=2.88U
M$1627 \$12571 \$12567 SUB SUB nfet_06v0 L=1U W=5U AS=2.2P AD=1.3P PS=10.88U
+ PD=5.52U
M$1628 SUB \$12567 \$12571 SUB nfet_06v0 L=1U W=5U AS=1.3P AD=1.3P PS=5.52U
+ PD=5.52U
M$1629 \$12571 \$12567 SUB SUB nfet_06v0 L=1U W=5U AS=1.3P AD=2.2P PS=5.52U
+ PD=10.88U
M$1630 SUB \$10755 \$10754 SUB nfet_06v0 L=1U W=1U AS=0.44P AD=0.44P PS=2.88U
+ PD=2.88U
M$1631 \$10789 \$1862 \$10755 SUB nfet_06v0 L=1U W=1U AS=0.44P AD=0.25P
+ PS=2.88U PD=1.5U
M$1632 SUB \$10751 \$10789 SUB nfet_06v0 L=1U W=1U AS=0.25P AD=0.44P PS=1.5U
+ PD=2.88U
M$1633 SUB \$14300 \$7663 SUB nfet_06v0 L=1U W=1U AS=0.44P AD=0.44P PS=2.88U
+ PD=2.88U
M$1634 SUB \$14301 \$7663 SUB nfet_06v0 L=1U W=1U AS=0.44P AD=0.44P PS=2.88U
+ PD=2.88U
M$1635 SUB \$14302 \$14314 SUB nfet_06v0 L=1U W=1U AS=0.44P AD=0.44P PS=2.88U
+ PD=2.88U
M$1636 SUB \$14303 \$4234 SUB nfet_06v0 L=1U W=1U AS=0.44P AD=0.44P PS=2.88U
+ PD=2.88U
M$1637 \$14322 \$14314 \$14303 SUB nfet_06v0 L=1U W=1U AS=0.44P AD=0.25P
+ PS=2.88U PD=1.5U
M$1638 SUB \$14300 \$14322 SUB nfet_06v0 L=1U W=1U AS=0.25P AD=0.44P PS=1.5U
+ PD=2.88U
M$1639 SUB \$14304 \$1787 SUB nfet_06v0 L=1U W=1U AS=0.44P AD=0.44P PS=2.88U
+ PD=2.88U
M$1640 \$14324 \$14301 \$14304 SUB nfet_06v0 L=1U W=1U AS=0.44P AD=0.25P
+ PS=2.88U PD=1.5U
M$1641 SUB \$14302 \$14324 SUB nfet_06v0 L=1U W=1U AS=0.25P AD=0.44P PS=1.5U
+ PD=2.88U
M$1642 SUB \$9010 \$7210 SUB nfet_06v0 L=1U W=1U AS=0.44P AD=0.44P PS=2.88U
+ PD=2.88U
M$1643 SUB \$14305 \$7210 SUB nfet_06v0 L=1U W=1U AS=0.44P AD=0.44P PS=2.88U
+ PD=2.88U
M$1644 SUB \$14306 \$14315 SUB nfet_06v0 L=1U W=1U AS=0.44P AD=0.44P PS=2.88U
+ PD=2.88U
M$1645 SUB \$14307 \$14316 SUB nfet_06v0 L=1U W=1U AS=0.44P AD=0.44P PS=2.88U
+ PD=2.88U
M$1646 \$14325 \$14315 \$14307 SUB nfet_06v0 L=1U W=1U AS=0.44P AD=0.25P
+ PS=2.88U PD=1.5U
M$1647 SUB \$9010 \$14325 SUB nfet_06v0 L=1U W=1U AS=0.25P AD=0.44P PS=1.5U
+ PD=2.88U
M$1648 SUB \$14308 \$14317 SUB nfet_06v0 L=1U W=1U AS=0.44P AD=0.44P PS=2.88U
+ PD=2.88U
M$1649 \$14326 \$14305 \$14308 SUB nfet_06v0 L=1U W=1U AS=0.44P AD=0.25P
+ PS=2.88U PD=1.5U
M$1650 SUB \$14306 \$14326 SUB nfet_06v0 L=1U W=1U AS=0.25P AD=0.44P PS=1.5U
+ PD=2.88U
M$1651 SUB \$14309 \$7504 SUB nfet_06v0 L=1U W=1U AS=0.44P AD=0.44P PS=2.88U
+ PD=2.88U
M$1652 SUB \$14310 \$7504 SUB nfet_06v0 L=1U W=1U AS=0.44P AD=0.44P PS=2.88U
+ PD=2.88U
M$1653 SUB \$14311 \$14318 SUB nfet_06v0 L=1U W=1U AS=0.44P AD=0.44P PS=2.88U
+ PD=2.88U
M$1654 SUB \$14312 \$14319 SUB nfet_06v0 L=1U W=1U AS=0.44P AD=0.44P PS=2.88U
+ PD=2.88U
M$1655 \$14323 \$14318 \$14312 SUB nfet_06v0 L=1U W=1U AS=0.44P AD=0.25P
+ PS=2.88U PD=1.5U
M$1656 SUB \$14309 \$14323 SUB nfet_06v0 L=1U W=1U AS=0.25P AD=0.44P PS=1.5U
+ PD=2.88U
M$1657 SUB \$14313 \$14320 SUB nfet_06v0 L=1U W=1U AS=0.44P AD=0.44P PS=2.88U
+ PD=2.88U
M$1658 \$14321 \$14310 \$14313 SUB nfet_06v0 L=1U W=1U AS=0.44P AD=0.25P
+ PS=2.88U PD=1.5U
M$1659 SUB \$14311 \$14321 SUB nfet_06v0 L=1U W=1U AS=0.25P AD=0.44P PS=1.5U
+ PD=2.88U
C$1660 \$12540 \$12549 4e-13 cap_mim_2f0fF A=200P P=60U
C$1661 \$3607 \$3602 4e-13 cap_mim_2f0fF A=200P P=60U
C$1662 \$12551 \$12560 4e-13 cap_mim_2f0fF A=200P P=60U
C$1663 \$8991 \$9020 4e-13 cap_mim_2f0fF A=200P P=60U
C$1664 \$7196 \$7191 4e-13 cap_mim_2f0fF A=200P P=60U
C$1665 \$9001 \$9010 4e-13 cap_mim_2f0fF A=200P P=60U
C$1666 \$109 \$106 4e-13 cap_mim_2f0fF A=200P P=60U
C$1667 \$3634 \$3629 4e-13 cap_mim_2f0fF A=200P P=60U
C$1668 \$12560 \$12555 4e-13 cap_mim_2f0fF A=200P P=60U
C$1669 \$7209 \$7204 4e-13 cap_mim_2f0fF A=200P P=60U
C$1670 \$12549 \$12544 4e-13 cap_mim_2f0fF A=200P P=60U
C$1671 \$10787 \$10783 4e-13 cap_mim_2f0fF A=200P P=60U
C$1672 \$5429 \$5436 4e-13 cap_mim_2f0fF A=200P P=60U
C$1673 \$7200 \$7209 4e-13 cap_mim_2f0fF A=200P P=60U
C$1674 \$7187 \$7196 4e-13 cap_mim_2f0fF A=200P P=60U
C$1675 \$5427 \$5402 4e-13 cap_mim_2f0fF A=200P P=60U
C$1676 \$1837 \$1845 4e-13 cap_mim_2f0fF A=200P P=60U
C$1677 \$10776 \$10772 4e-13 cap_mim_2f0fF A=200P P=60U
C$1678 \$1835 \$1831 4e-13 cap_mim_2f0fF A=200P P=60U
C$1679 \$10757 \$10765 4e-13 cap_mim_2f0fF A=200P P=60U
C$1680 \$1827 \$1835 4e-13 cap_mim_2f0fF A=200P P=60U
C$1681 \$3598 \$3607 4e-13 cap_mim_2f0fF A=200P P=60U
C$1682 \$8989 \$8984 4e-13 cap_mim_2f0fF A=200P P=60U
C$1683 \$10768 \$10776 4e-13 cap_mim_2f0fF A=200P P=60U
C$1684 \$12571 \$12566 4e-13 cap_mim_2f0fF A=200P P=60U
C$1685 \$20 \$100 4e-13 cap_mim_2f0fF A=200P P=60U
C$1686 \$7182 \$7177 4e-13 cap_mim_2f0fF A=200P P=60U
C$1687 \$1855 \$1851 4e-13 cap_mim_2f0fF A=200P P=60U
C$1688 \$5411 \$5418 4e-13 cap_mim_2f0fF A=200P P=60U
C$1689 \$1845 \$1841 4e-13 cap_mim_2f0fF A=200P P=60U
C$1690 \$43 \$109 4e-13 cap_mim_2f0fF A=200P P=60U
C$1691 \$5436 \$5408 4e-13 cap_mim_2f0fF A=200P P=60U
C$1692 \$105 \$102 4e-13 cap_mim_2f0fF A=200P P=60U
C$1693 \$1847 \$1855 4e-13 cap_mim_2f0fF A=200P P=60U
C$1694 \$9020 \$8995 4e-13 cap_mim_2f0fF A=200P P=60U
C$1695 \$7173 \$7182 4e-13 cap_mim_2f0fF A=200P P=60U
C$1696 \$9010 \$9005 4e-13 cap_mim_2f0fF A=200P P=60U
C$1697 \$8980 \$8989 4e-13 cap_mim_2f0fF A=200P P=60U
C$1698 \$100 \$97 4e-13 cap_mim_2f0fF A=200P P=60U
C$1699 \$5420 \$5427 4e-13 cap_mim_2f0fF A=200P P=60U
C$1700 \$12562 \$12571 4e-13 cap_mim_2f0fF A=200P P=60U
C$1701 \$10779 \$10787 4e-13 cap_mim_2f0fF A=200P P=60U
C$1702 \$3625 \$3634 4e-13 cap_mim_2f0fF A=200P P=60U
C$1703 \$10765 \$10761 4e-13 cap_mim_2f0fF A=200P P=60U
C$1704 \$32 \$105 4e-13 cap_mim_2f0fF A=200P P=60U
C$1705 \$3611 \$3620 4e-13 cap_mim_2f0fF A=200P P=60U
C$1706 \$3620 \$3615 4e-13 cap_mim_2f0fF A=200P P=60U
C$1707 \$5418 \$5397 4e-13 cap_mim_2f0fF A=200P P=60U
.ENDS GRADIENT_NAV
