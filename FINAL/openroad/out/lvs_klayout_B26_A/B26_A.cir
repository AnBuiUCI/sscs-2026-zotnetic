* Extracted by KLayout with GF180MCU LVS runset on : 29/08/2026 19:36

.SUBCKT B26_A S4P S4N Z ZP_OUT VDD|XN_OE|XP_OE|YN_OE|YP_OE|ZN_OE|ZP_OE Y XN_OUT
+ XP_OUT YN_OUT YP_OUT ZN_OUT X S1N S1P S3P S3N S2N S2P
+ VSS|XN_CS|XN_IE|XN_PD|XN_PDRV0|XN_PDRV1|XN_PU|XN_SL|XP_CS|XP_IE|XP_PD|XP_PDRV0|XP_PDRV1|XP_PU|XP_SL|YN_CS|YN_IE|YN_PD|YN_PDRV0|YN_PDRV1|YN_PU|YN_SL|YP_CS|YP_IE|YP_PD|YP_PDRV0|YP_PDRV1|YP_PU|YP_SL|ZN_CS|ZN_IE|ZN_PD|ZN_PDRV0|ZN_PDRV1|ZN_PU|ZN_SL|ZP_CS|ZP_IE|ZP_PD|ZP_PDRV0|ZP_PDRV1|ZP_PU|ZP_SL
M$1 \$7260 X VDD|XN_OE|XP_OE|YN_OE|YP_OE|ZN_OE|ZP_OE
+ VDD|XN_OE|XP_OE|YN_OE|YP_OE|ZN_OE|ZP_OE pfet_05v0 L=0.5U W=1.83U AS=0.8052P
+ AD=0.8052P PS=4.54U PD=4.54U
M$2 XN_OUT \$7260 VDD|XN_OE|XP_OE|YN_OE|YP_OE|ZN_OE|ZP_OE
+ VDD|XN_OE|XP_OE|YN_OE|YP_OE|ZN_OE|ZP_OE pfet_05v0 L=0.5U W=1.83U AS=0.8052P
+ AD=0.8052P PS=4.54U PD=4.54U
M$3 XP_OUT XN_OUT VDD|XN_OE|XP_OE|YN_OE|YP_OE|ZN_OE|ZP_OE
+ VDD|XN_OE|XP_OE|YN_OE|YP_OE|ZN_OE|ZP_OE pfet_05v0 L=0.5U W=1.83U AS=0.8052P
+ AD=0.8052P PS=4.54U PD=4.54U
M$4 \$9063 Y VDD|XN_OE|XP_OE|YN_OE|YP_OE|ZN_OE|ZP_OE
+ VDD|XN_OE|XP_OE|YN_OE|YP_OE|ZN_OE|ZP_OE pfet_05v0 L=0.5U W=1.83U AS=0.8052P
+ AD=0.8052P PS=4.54U PD=4.54U
M$5 YN_OUT \$9063 VDD|XN_OE|XP_OE|YN_OE|YP_OE|ZN_OE|ZP_OE
+ VDD|XN_OE|XP_OE|YN_OE|YP_OE|ZN_OE|ZP_OE pfet_05v0 L=0.5U W=1.83U AS=0.8052P
+ AD=0.8052P PS=4.54U PD=4.54U
M$6 YP_OUT YN_OUT VDD|XN_OE|XP_OE|YN_OE|YP_OE|ZN_OE|ZP_OE
+ VDD|XN_OE|XP_OE|YN_OE|YP_OE|ZN_OE|ZP_OE pfet_05v0 L=0.5U W=1.83U AS=0.8052P
+ AD=0.8052P PS=4.54U PD=4.54U
M$7 \$10864 Z VDD|XN_OE|XP_OE|YN_OE|YP_OE|ZN_OE|ZP_OE
+ VDD|XN_OE|XP_OE|YN_OE|YP_OE|ZN_OE|ZP_OE pfet_05v0 L=0.5U W=1.83U AS=0.8052P
+ AD=0.8052P PS=4.54U PD=4.54U
M$8 ZN_OUT \$10864 VDD|XN_OE|XP_OE|YN_OE|YP_OE|ZN_OE|ZP_OE
+ VDD|XN_OE|XP_OE|YN_OE|YP_OE|ZN_OE|ZP_OE pfet_05v0 L=0.5U W=1.83U AS=0.8052P
+ AD=0.8052P PS=4.54U PD=4.54U
M$9 ZP_OUT ZN_OUT VDD|XN_OE|XP_OE|YN_OE|YP_OE|ZN_OE|ZP_OE
+ VDD|XN_OE|XP_OE|YN_OE|YP_OE|ZN_OE|ZP_OE pfet_05v0 L=0.5U W=1.83U AS=0.8052P
+ AD=0.8052P PS=4.54U PD=4.54U
M$10 VDD|XN_OE|XP_OE|YN_OE|YP_OE|ZN_OE|ZP_OE
+ VSS|XN_CS|XN_IE|XN_PD|XN_PDRV0|XN_PDRV1|XN_PU|XN_SL|XP_CS|XP_IE|XP_PD|XP_PDRV0|XP_PDRV1|XP_PU|XP_SL|YN_CS|YN_IE|YN_PD|YN_PDRV0|YN_PDRV1|YN_PU|YN_SL|YP_CS|YP_IE|YP_PD|YP_PDRV0|YP_PDRV1|YP_PU|YP_SL|ZN_CS|ZN_IE|ZN_PD|ZN_PDRV0|ZN_PDRV1|ZN_PU|ZN_SL|ZP_CS|ZP_IE|ZP_PD|ZP_PDRV0|ZP_PDRV1|ZP_PU|ZP_SL
+ VDD|XN_OE|XP_OE|YN_OE|YP_OE|ZN_OE|ZP_OE
+ VDD|XN_OE|XP_OE|YN_OE|YP_OE|ZN_OE|ZP_OE pfet_06v0 L=2U W=18U AS=7.92P
+ AD=7.92P PS=36.88U PD=36.88U
M$11 VDD|XN_OE|XP_OE|YN_OE|YP_OE|ZN_OE|ZP_OE
+ VSS|XN_CS|XN_IE|XN_PD|XN_PDRV0|XN_PDRV1|XN_PU|XN_SL|XP_CS|XP_IE|XP_PD|XP_PDRV0|XP_PDRV1|XP_PU|XP_SL|YN_CS|YN_IE|YN_PD|YN_PDRV0|YN_PDRV1|YN_PU|YN_SL|YP_CS|YP_IE|YP_PD|YP_PDRV0|YP_PDRV1|YP_PU|YP_SL|ZN_CS|ZN_IE|ZN_PD|ZN_PDRV0|ZN_PDRV1|ZN_PU|ZN_SL|ZP_CS|ZP_IE|ZP_PD|ZP_PDRV0|ZP_PDRV1|ZP_PU|ZP_SL
+ VDD|XN_OE|XP_OE|YN_OE|YP_OE|ZN_OE|ZP_OE
+ VDD|XN_OE|XP_OE|YN_OE|YP_OE|ZN_OE|ZP_OE pfet_06v0 L=2U W=18U AS=7.92P
+ AD=7.92P PS=36.88U PD=36.88U
M$12 VDD|XN_OE|XP_OE|YN_OE|YP_OE|ZN_OE|ZP_OE
+ VSS|XN_CS|XN_IE|XN_PD|XN_PDRV0|XN_PDRV1|XN_PU|XN_SL|XP_CS|XP_IE|XP_PD|XP_PDRV0|XP_PDRV1|XP_PU|XP_SL|YN_CS|YN_IE|YN_PD|YN_PDRV0|YN_PDRV1|YN_PU|YN_SL|YP_CS|YP_IE|YP_PD|YP_PDRV0|YP_PDRV1|YP_PU|YP_SL|ZN_CS|ZN_IE|ZN_PD|ZN_PDRV0|ZN_PDRV1|ZN_PU|ZN_SL|ZP_CS|ZP_IE|ZP_PD|ZP_PDRV0|ZP_PDRV1|ZP_PU|ZP_SL
+ VDD|XN_OE|XP_OE|YN_OE|YP_OE|ZN_OE|ZP_OE
+ VDD|XN_OE|XP_OE|YN_OE|YP_OE|ZN_OE|ZP_OE pfet_06v0 L=2U W=18U AS=7.92P
+ AD=7.92P PS=36.88U PD=36.88U
M$13 VDD|XN_OE|XP_OE|YN_OE|YP_OE|ZN_OE|ZP_OE
+ VSS|XN_CS|XN_IE|XN_PD|XN_PDRV0|XN_PDRV1|XN_PU|XN_SL|XP_CS|XP_IE|XP_PD|XP_PDRV0|XP_PDRV1|XP_PU|XP_SL|YN_CS|YN_IE|YN_PD|YN_PDRV0|YN_PDRV1|YN_PU|YN_SL|YP_CS|YP_IE|YP_PD|YP_PDRV0|YP_PDRV1|YP_PU|YP_SL|ZN_CS|ZN_IE|ZN_PD|ZN_PDRV0|ZN_PDRV1|ZN_PU|ZN_SL|ZP_CS|ZP_IE|ZP_PD|ZP_PDRV0|ZP_PDRV1|ZP_PU|ZP_SL
+ VDD|XN_OE|XP_OE|YN_OE|YP_OE|ZN_OE|ZP_OE
+ VDD|XN_OE|XP_OE|YN_OE|YP_OE|ZN_OE|ZP_OE pfet_06v0 L=2U W=18U AS=7.92P
+ AD=7.92P PS=36.88U PD=36.88U
M$14 VDD|XN_OE|XP_OE|YN_OE|YP_OE|ZN_OE|ZP_OE
+ VSS|XN_CS|XN_IE|XN_PD|XN_PDRV0|XN_PDRV1|XN_PU|XN_SL|XP_CS|XP_IE|XP_PD|XP_PDRV0|XP_PDRV1|XP_PU|XP_SL|YN_CS|YN_IE|YN_PD|YN_PDRV0|YN_PDRV1|YN_PU|YN_SL|YP_CS|YP_IE|YP_PD|YP_PDRV0|YP_PDRV1|YP_PU|YP_SL|ZN_CS|ZN_IE|ZN_PD|ZN_PDRV0|ZN_PDRV1|ZN_PU|ZN_SL|ZP_CS|ZP_IE|ZP_PD|ZP_PDRV0|ZP_PDRV1|ZP_PU|ZP_SL
+ VDD|XN_OE|XP_OE|YN_OE|YP_OE|ZN_OE|ZP_OE
+ VDD|XN_OE|XP_OE|YN_OE|YP_OE|ZN_OE|ZP_OE pfet_06v0 L=2U W=18U AS=7.92P
+ AD=7.92P PS=36.88U PD=36.88U
M$15 VDD|XN_OE|XP_OE|YN_OE|YP_OE|ZN_OE|ZP_OE
+ VSS|XN_CS|XN_IE|XN_PD|XN_PDRV0|XN_PDRV1|XN_PU|XN_SL|XP_CS|XP_IE|XP_PD|XP_PDRV0|XP_PDRV1|XP_PU|XP_SL|YN_CS|YN_IE|YN_PD|YN_PDRV0|YN_PDRV1|YN_PU|YN_SL|YP_CS|YP_IE|YP_PD|YP_PDRV0|YP_PDRV1|YP_PU|YP_SL|ZN_CS|ZN_IE|ZN_PD|ZN_PDRV0|ZN_PDRV1|ZN_PU|ZN_SL|ZP_CS|ZP_IE|ZP_PD|ZP_PDRV0|ZP_PDRV1|ZP_PU|ZP_SL
+ VDD|XN_OE|XP_OE|YN_OE|YP_OE|ZN_OE|ZP_OE
+ VDD|XN_OE|XP_OE|YN_OE|YP_OE|ZN_OE|ZP_OE pfet_06v0 L=2U W=18U AS=7.92P
+ AD=7.92P PS=36.88U PD=36.88U
M$16 VDD|XN_OE|XP_OE|YN_OE|YP_OE|ZN_OE|ZP_OE
+ VSS|XN_CS|XN_IE|XN_PD|XN_PDRV0|XN_PDRV1|XN_PU|XN_SL|XP_CS|XP_IE|XP_PD|XP_PDRV0|XP_PDRV1|XP_PU|XP_SL|YN_CS|YN_IE|YN_PD|YN_PDRV0|YN_PDRV1|YN_PU|YN_SL|YP_CS|YP_IE|YP_PD|YP_PDRV0|YP_PDRV1|YP_PU|YP_SL|ZN_CS|ZN_IE|ZN_PD|ZN_PDRV0|ZN_PDRV1|ZN_PU|ZN_SL|ZP_CS|ZP_IE|ZP_PD|ZP_PDRV0|ZP_PDRV1|ZP_PU|ZP_SL
+ VDD|XN_OE|XP_OE|YN_OE|YP_OE|ZN_OE|ZP_OE
+ VDD|XN_OE|XP_OE|YN_OE|YP_OE|ZN_OE|ZP_OE pfet_06v0 L=2U W=18U AS=7.92P
+ AD=7.92P PS=36.88U PD=36.88U
M$17 VDD|XN_OE|XP_OE|YN_OE|YP_OE|ZN_OE|ZP_OE
+ VSS|XN_CS|XN_IE|XN_PD|XN_PDRV0|XN_PDRV1|XN_PU|XN_SL|XP_CS|XP_IE|XP_PD|XP_PDRV0|XP_PDRV1|XP_PU|XP_SL|YN_CS|YN_IE|YN_PD|YN_PDRV0|YN_PDRV1|YN_PU|YN_SL|YP_CS|YP_IE|YP_PD|YP_PDRV0|YP_PDRV1|YP_PU|YP_SL|ZN_CS|ZN_IE|ZN_PD|ZN_PDRV0|ZN_PDRV1|ZN_PU|ZN_SL|ZP_CS|ZP_IE|ZP_PD|ZP_PDRV0|ZP_PDRV1|ZP_PU|ZP_SL
+ VDD|XN_OE|XP_OE|YN_OE|YP_OE|ZN_OE|ZP_OE
+ VDD|XN_OE|XP_OE|YN_OE|YP_OE|ZN_OE|ZP_OE pfet_06v0 L=2U W=18U AS=7.92P
+ AD=7.92P PS=36.88U PD=36.88U
M$18 VDD|XN_OE|XP_OE|YN_OE|YP_OE|ZN_OE|ZP_OE
+ VSS|XN_CS|XN_IE|XN_PD|XN_PDRV0|XN_PDRV1|XN_PU|XN_SL|XP_CS|XP_IE|XP_PD|XP_PDRV0|XP_PDRV1|XP_PU|XP_SL|YN_CS|YN_IE|YN_PD|YN_PDRV0|YN_PDRV1|YN_PU|YN_SL|YP_CS|YP_IE|YP_PD|YP_PDRV0|YP_PDRV1|YP_PU|YP_SL|ZN_CS|ZN_IE|ZN_PD|ZN_PDRV0|ZN_PDRV1|ZN_PU|ZN_SL|ZP_CS|ZP_IE|ZP_PD|ZP_PDRV0|ZP_PDRV1|ZP_PU|ZP_SL
+ VDD|XN_OE|XP_OE|YN_OE|YP_OE|ZN_OE|ZP_OE
+ VDD|XN_OE|XP_OE|YN_OE|YP_OE|ZN_OE|ZP_OE pfet_06v0 L=2U W=18U AS=7.92P
+ AD=7.92P PS=36.88U PD=36.88U
M$19 \$2403 \$99 VDD|XN_OE|XP_OE|YN_OE|YP_OE|ZN_OE|ZP_OE
+ VDD|XN_OE|XP_OE|YN_OE|YP_OE|ZN_OE|ZP_OE pfet_06v0 L=1U W=10U AS=4.4P AD=2.5P
+ PS=20.88U PD=10.5U
M$20 \$135 \$119 \$2403 VDD|XN_OE|XP_OE|YN_OE|YP_OE|ZN_OE|ZP_OE pfet_06v0 L=1U
+ W=10U AS=2.5P AD=4.4P PS=10.5U PD=20.88U
M$21 \$2405 \$99 VDD|XN_OE|XP_OE|YN_OE|YP_OE|ZN_OE|ZP_OE
+ VDD|XN_OE|XP_OE|YN_OE|YP_OE|ZN_OE|ZP_OE pfet_06v0 L=1U W=10U AS=4.4P AD=2.5P
+ PS=20.88U PD=10.5U
M$22 \$135 \$119 \$2405 VDD|XN_OE|XP_OE|YN_OE|YP_OE|ZN_OE|ZP_OE pfet_06v0 L=1U
+ W=10U AS=2.5P AD=4.4P PS=10.5U PD=20.88U
M$23 \$136 \$119 \$25 VDD|XN_OE|XP_OE|YN_OE|YP_OE|ZN_OE|ZP_OE pfet_06v0 L=1U
+ W=10U AS=4.4P AD=4.4P PS=20.88U PD=20.88U
M$24 \$120 \$119 \$24 VDD|XN_OE|XP_OE|YN_OE|YP_OE|ZN_OE|ZP_OE pfet_06v0 L=1U
+ W=10U AS=4.4P AD=4.4P PS=20.88U PD=20.88U
M$25 \$2407 \$106 VDD|XN_OE|XP_OE|YN_OE|YP_OE|ZN_OE|ZP_OE
+ VDD|XN_OE|XP_OE|YN_OE|YP_OE|ZN_OE|ZP_OE pfet_06v0 L=1U W=10U AS=4.4P AD=2.5P
+ PS=20.88U PD=10.5U
M$26 \$106 \$119 \$2407 VDD|XN_OE|XP_OE|YN_OE|YP_OE|ZN_OE|ZP_OE pfet_06v0 L=1U
+ W=10U AS=2.5P AD=3.3P PS=10.5U PD=10.66U
M$27 \$28 \$28 \$106 VDD|XN_OE|XP_OE|YN_OE|YP_OE|ZN_OE|ZP_OE pfet_06v0 L=1U
+ W=10U AS=3.3P AD=4.4P PS=10.66U PD=20.88U
M$28 \$2408 \$99 VDD|XN_OE|XP_OE|YN_OE|YP_OE|ZN_OE|ZP_OE
+ VDD|XN_OE|XP_OE|YN_OE|YP_OE|ZN_OE|ZP_OE pfet_06v0 L=1U W=10U AS=4.4P AD=2.5P
+ PS=20.88U PD=10.5U
M$29 \$64 \$119 \$2408 VDD|XN_OE|XP_OE|YN_OE|YP_OE|ZN_OE|ZP_OE pfet_06v0 L=1U
+ W=10U AS=2.5P AD=4.4P PS=10.5U PD=20.88U
M$30 \$2411 \$99 VDD|XN_OE|XP_OE|YN_OE|YP_OE|ZN_OE|ZP_OE
+ VDD|XN_OE|XP_OE|YN_OE|YP_OE|ZN_OE|ZP_OE pfet_06v0 L=1U W=10U AS=4.4P AD=2.5P
+ PS=20.88U PD=10.5U
M$31 \$92 \$119 \$2411 VDD|XN_OE|XP_OE|YN_OE|YP_OE|ZN_OE|ZP_OE pfet_06v0 L=1U
+ W=10U AS=2.5P AD=4.4P PS=10.5U PD=20.88U
M$32 \$2412 \$99 VDD|XN_OE|XP_OE|YN_OE|YP_OE|ZN_OE|ZP_OE
+ VDD|XN_OE|XP_OE|YN_OE|YP_OE|ZN_OE|ZP_OE pfet_06v0 L=1U W=10U AS=4.4P AD=2.5P
+ PS=20.88U PD=10.5U
M$33 \$91 \$119 \$2412 VDD|XN_OE|XP_OE|YN_OE|YP_OE|ZN_OE|ZP_OE pfet_06v0 L=1U
+ W=10U AS=2.5P AD=4.4P PS=10.5U PD=20.88U
M$34 \$2413 \$99 VDD|XN_OE|XP_OE|YN_OE|YP_OE|ZN_OE|ZP_OE
+ VDD|XN_OE|XP_OE|YN_OE|YP_OE|ZN_OE|ZP_OE pfet_06v0 L=1U W=10U AS=4.4P AD=2.5P
+ PS=20.88U PD=10.5U
M$35 \$99 \$119 \$2413 VDD|XN_OE|XP_OE|YN_OE|YP_OE|ZN_OE|ZP_OE pfet_06v0 L=1U
+ W=10U AS=2.5P AD=4.4P PS=10.5U PD=20.88U
M$36 \$2414 \$100 VDD|XN_OE|XP_OE|YN_OE|YP_OE|ZN_OE|ZP_OE
+ VDD|XN_OE|XP_OE|YN_OE|YP_OE|ZN_OE|ZP_OE pfet_06v0 L=1U W=10U AS=4.4P AD=2.5P
+ PS=20.88U PD=10.5U
M$37 \$137 \$121 \$2414 VDD|XN_OE|XP_OE|YN_OE|YP_OE|ZN_OE|ZP_OE pfet_06v0 L=1U
+ W=10U AS=2.5P AD=4.4P PS=10.5U PD=20.88U
M$38 \$2415 \$100 VDD|XN_OE|XP_OE|YN_OE|YP_OE|ZN_OE|ZP_OE
+ VDD|XN_OE|XP_OE|YN_OE|YP_OE|ZN_OE|ZP_OE pfet_06v0 L=1U W=10U AS=4.4P AD=2.5P
+ PS=20.88U PD=10.5U
M$39 \$137 \$121 \$2415 VDD|XN_OE|XP_OE|YN_OE|YP_OE|ZN_OE|ZP_OE pfet_06v0 L=1U
+ W=10U AS=2.5P AD=4.4P PS=10.5U PD=20.88U
M$40 \$138 \$121 \$33 VDD|XN_OE|XP_OE|YN_OE|YP_OE|ZN_OE|ZP_OE pfet_06v0 L=1U
+ W=10U AS=4.4P AD=4.4P PS=20.88U PD=20.88U
M$41 \$122 \$121 \$32 VDD|XN_OE|XP_OE|YN_OE|YP_OE|ZN_OE|ZP_OE pfet_06v0 L=1U
+ W=10U AS=4.4P AD=4.4P PS=20.88U PD=20.88U
M$42 \$2419 \$110 VDD|XN_OE|XP_OE|YN_OE|YP_OE|ZN_OE|ZP_OE
+ VDD|XN_OE|XP_OE|YN_OE|YP_OE|ZN_OE|ZP_OE pfet_06v0 L=1U W=10U AS=4.4P AD=2.5P
+ PS=20.88U PD=10.5U
M$43 \$110 \$121 \$2419 VDD|XN_OE|XP_OE|YN_OE|YP_OE|ZN_OE|ZP_OE pfet_06v0 L=1U
+ W=10U AS=2.5P AD=3.3P PS=10.5U PD=10.66U
M$44 \$36 \$36 \$110 VDD|XN_OE|XP_OE|YN_OE|YP_OE|ZN_OE|ZP_OE pfet_06v0 L=1U
+ W=10U AS=3.3P AD=4.4P PS=10.66U PD=20.88U
M$45 \$2420 \$100 VDD|XN_OE|XP_OE|YN_OE|YP_OE|ZN_OE|ZP_OE
+ VDD|XN_OE|XP_OE|YN_OE|YP_OE|ZN_OE|ZP_OE pfet_06v0 L=1U W=10U AS=4.4P AD=2.5P
+ PS=20.88U PD=10.5U
M$46 \$66 \$121 \$2420 VDD|XN_OE|XP_OE|YN_OE|YP_OE|ZN_OE|ZP_OE pfet_06v0 L=1U
+ W=10U AS=2.5P AD=4.4P PS=10.5U PD=20.88U
M$47 \$2423 \$100 VDD|XN_OE|XP_OE|YN_OE|YP_OE|ZN_OE|ZP_OE
+ VDD|XN_OE|XP_OE|YN_OE|YP_OE|ZN_OE|ZP_OE pfet_06v0 L=1U W=10U AS=4.4P AD=2.5P
+ PS=20.88U PD=10.5U
M$48 \$94 \$121 \$2423 VDD|XN_OE|XP_OE|YN_OE|YP_OE|ZN_OE|ZP_OE pfet_06v0 L=1U
+ W=10U AS=2.5P AD=4.4P PS=10.5U PD=20.88U
M$49 \$2424 \$100 VDD|XN_OE|XP_OE|YN_OE|YP_OE|ZN_OE|ZP_OE
+ VDD|XN_OE|XP_OE|YN_OE|YP_OE|ZN_OE|ZP_OE pfet_06v0 L=1U W=10U AS=4.4P AD=2.5P
+ PS=20.88U PD=10.5U
M$50 \$93 \$121 \$2424 VDD|XN_OE|XP_OE|YN_OE|YP_OE|ZN_OE|ZP_OE pfet_06v0 L=1U
+ W=10U AS=2.5P AD=4.4P PS=10.5U PD=20.88U
M$51 \$2425 \$100 VDD|XN_OE|XP_OE|YN_OE|YP_OE|ZN_OE|ZP_OE
+ VDD|XN_OE|XP_OE|YN_OE|YP_OE|ZN_OE|ZP_OE pfet_06v0 L=1U W=10U AS=4.4P AD=2.5P
+ PS=20.88U PD=10.5U
M$52 \$100 \$121 \$2425 VDD|XN_OE|XP_OE|YN_OE|YP_OE|ZN_OE|ZP_OE pfet_06v0 L=1U
+ W=10U AS=2.5P AD=4.4P PS=10.5U PD=20.88U
M$53 \$2426 \$101 VDD|XN_OE|XP_OE|YN_OE|YP_OE|ZN_OE|ZP_OE
+ VDD|XN_OE|XP_OE|YN_OE|YP_OE|ZN_OE|ZP_OE pfet_06v0 L=1U W=10U AS=4.4P AD=2.5P
+ PS=20.88U PD=10.5U
M$54 \$139 \$123 \$2426 VDD|XN_OE|XP_OE|YN_OE|YP_OE|ZN_OE|ZP_OE pfet_06v0 L=1U
+ W=10U AS=2.5P AD=4.4P PS=10.5U PD=20.88U
M$55 \$2428 \$101 VDD|XN_OE|XP_OE|YN_OE|YP_OE|ZN_OE|ZP_OE
+ VDD|XN_OE|XP_OE|YN_OE|YP_OE|ZN_OE|ZP_OE pfet_06v0 L=1U W=10U AS=4.4P AD=2.5P
+ PS=20.88U PD=10.5U
M$56 \$139 \$123 \$2428 VDD|XN_OE|XP_OE|YN_OE|YP_OE|ZN_OE|ZP_OE pfet_06v0 L=1U
+ W=10U AS=2.5P AD=4.4P PS=10.5U PD=20.88U
M$57 \$140 \$123 \$41 VDD|XN_OE|XP_OE|YN_OE|YP_OE|ZN_OE|ZP_OE pfet_06v0 L=1U
+ W=10U AS=4.4P AD=4.4P PS=20.88U PD=20.88U
M$58 \$124 \$123 \$40 VDD|XN_OE|XP_OE|YN_OE|YP_OE|ZN_OE|ZP_OE pfet_06v0 L=1U
+ W=10U AS=4.4P AD=4.4P PS=20.88U PD=20.88U
M$59 \$2429 \$114 VDD|XN_OE|XP_OE|YN_OE|YP_OE|ZN_OE|ZP_OE
+ VDD|XN_OE|XP_OE|YN_OE|YP_OE|ZN_OE|ZP_OE pfet_06v0 L=1U W=10U AS=4.4P AD=2.5P
+ PS=20.88U PD=10.5U
M$60 \$114 \$123 \$2429 VDD|XN_OE|XP_OE|YN_OE|YP_OE|ZN_OE|ZP_OE pfet_06v0 L=1U
+ W=10U AS=2.5P AD=3.3P PS=10.5U PD=10.66U
M$61 \$44 \$44 \$114 VDD|XN_OE|XP_OE|YN_OE|YP_OE|ZN_OE|ZP_OE pfet_06v0 L=1U
+ W=10U AS=3.3P AD=4.4P PS=10.66U PD=20.88U
M$62 \$2427 \$101 VDD|XN_OE|XP_OE|YN_OE|YP_OE|ZN_OE|ZP_OE
+ VDD|XN_OE|XP_OE|YN_OE|YP_OE|ZN_OE|ZP_OE pfet_06v0 L=1U W=10U AS=4.4P AD=2.5P
+ PS=20.88U PD=10.5U
M$63 \$68 \$123 \$2427 VDD|XN_OE|XP_OE|YN_OE|YP_OE|ZN_OE|ZP_OE pfet_06v0 L=1U
+ W=10U AS=2.5P AD=4.4P PS=10.5U PD=20.88U
M$64 \$2422 \$101 VDD|XN_OE|XP_OE|YN_OE|YP_OE|ZN_OE|ZP_OE
+ VDD|XN_OE|XP_OE|YN_OE|YP_OE|ZN_OE|ZP_OE pfet_06v0 L=1U W=10U AS=4.4P AD=2.5P
+ PS=20.88U PD=10.5U
M$65 \$96 \$123 \$2422 VDD|XN_OE|XP_OE|YN_OE|YP_OE|ZN_OE|ZP_OE pfet_06v0 L=1U
+ W=10U AS=2.5P AD=4.4P PS=10.5U PD=20.88U
M$66 \$2421 \$101 VDD|XN_OE|XP_OE|YN_OE|YP_OE|ZN_OE|ZP_OE
+ VDD|XN_OE|XP_OE|YN_OE|YP_OE|ZN_OE|ZP_OE pfet_06v0 L=1U W=10U AS=4.4P AD=2.5P
+ PS=20.88U PD=10.5U
M$67 \$95 \$123 \$2421 VDD|XN_OE|XP_OE|YN_OE|YP_OE|ZN_OE|ZP_OE pfet_06v0 L=1U
+ W=10U AS=2.5P AD=4.4P PS=10.5U PD=20.88U
M$68 \$2418 \$101 VDD|XN_OE|XP_OE|YN_OE|YP_OE|ZN_OE|ZP_OE
+ VDD|XN_OE|XP_OE|YN_OE|YP_OE|ZN_OE|ZP_OE pfet_06v0 L=1U W=10U AS=4.4P AD=2.5P
+ PS=20.88U PD=10.5U
M$69 \$101 \$123 \$2418 VDD|XN_OE|XP_OE|YN_OE|YP_OE|ZN_OE|ZP_OE pfet_06v0 L=1U
+ W=10U AS=2.5P AD=4.4P PS=10.5U PD=20.88U
M$70 \$2417 \$102 VDD|XN_OE|XP_OE|YN_OE|YP_OE|ZN_OE|ZP_OE
+ VDD|XN_OE|XP_OE|YN_OE|YP_OE|ZN_OE|ZP_OE pfet_06v0 L=1U W=10U AS=4.4P AD=2.5P
+ PS=20.88U PD=10.5U
M$71 \$141 \$125 \$2417 VDD|XN_OE|XP_OE|YN_OE|YP_OE|ZN_OE|ZP_OE pfet_06v0 L=1U
+ W=10U AS=2.5P AD=4.4P PS=10.5U PD=20.88U
M$72 \$2416 \$102 VDD|XN_OE|XP_OE|YN_OE|YP_OE|ZN_OE|ZP_OE
+ VDD|XN_OE|XP_OE|YN_OE|YP_OE|ZN_OE|ZP_OE pfet_06v0 L=1U W=10U AS=4.4P AD=2.5P
+ PS=20.88U PD=10.5U
M$73 \$141 \$125 \$2416 VDD|XN_OE|XP_OE|YN_OE|YP_OE|ZN_OE|ZP_OE pfet_06v0 L=1U
+ W=10U AS=2.5P AD=4.4P PS=10.5U PD=20.88U
M$74 \$142 \$125 \$49 VDD|XN_OE|XP_OE|YN_OE|YP_OE|ZN_OE|ZP_OE pfet_06v0 L=1U
+ W=10U AS=4.4P AD=4.4P PS=20.88U PD=20.88U
M$75 \$126 \$125 \$48 VDD|XN_OE|XP_OE|YN_OE|YP_OE|ZN_OE|ZP_OE pfet_06v0 L=1U
+ W=10U AS=4.4P AD=4.4P PS=20.88U PD=20.88U
M$76 \$2410 \$118 VDD|XN_OE|XP_OE|YN_OE|YP_OE|ZN_OE|ZP_OE
+ VDD|XN_OE|XP_OE|YN_OE|YP_OE|ZN_OE|ZP_OE pfet_06v0 L=1U W=10U AS=4.4P AD=2.5P
+ PS=20.88U PD=10.5U
M$77 \$118 \$125 \$2410 VDD|XN_OE|XP_OE|YN_OE|YP_OE|ZN_OE|ZP_OE pfet_06v0 L=1U
+ W=10U AS=2.5P AD=3.3P PS=10.5U PD=10.66U
M$78 \$52 \$52 \$118 VDD|XN_OE|XP_OE|YN_OE|YP_OE|ZN_OE|ZP_OE pfet_06v0 L=1U
+ W=10U AS=3.3P AD=4.4P PS=10.66U PD=20.88U
M$79 \$2409 \$102 VDD|XN_OE|XP_OE|YN_OE|YP_OE|ZN_OE|ZP_OE
+ VDD|XN_OE|XP_OE|YN_OE|YP_OE|ZN_OE|ZP_OE pfet_06v0 L=1U W=10U AS=4.4P AD=2.5P
+ PS=20.88U PD=10.5U
M$80 \$70 \$125 \$2409 VDD|XN_OE|XP_OE|YN_OE|YP_OE|ZN_OE|ZP_OE pfet_06v0 L=1U
+ W=10U AS=2.5P AD=4.4P PS=10.5U PD=20.88U
M$81 \$2406 \$102 VDD|XN_OE|XP_OE|YN_OE|YP_OE|ZN_OE|ZP_OE
+ VDD|XN_OE|XP_OE|YN_OE|YP_OE|ZN_OE|ZP_OE pfet_06v0 L=1U W=10U AS=4.4P AD=2.5P
+ PS=20.88U PD=10.5U
M$82 \$98 \$125 \$2406 VDD|XN_OE|XP_OE|YN_OE|YP_OE|ZN_OE|ZP_OE pfet_06v0 L=1U
+ W=10U AS=2.5P AD=4.4P PS=10.5U PD=20.88U
M$83 \$2404 \$102 VDD|XN_OE|XP_OE|YN_OE|YP_OE|ZN_OE|ZP_OE
+ VDD|XN_OE|XP_OE|YN_OE|YP_OE|ZN_OE|ZP_OE pfet_06v0 L=1U W=10U AS=4.4P AD=2.5P
+ PS=20.88U PD=10.5U
M$84 \$97 \$125 \$2404 VDD|XN_OE|XP_OE|YN_OE|YP_OE|ZN_OE|ZP_OE pfet_06v0 L=1U
+ W=10U AS=2.5P AD=4.4P PS=10.5U PD=20.88U
M$85 \$2402 \$102 VDD|XN_OE|XP_OE|YN_OE|YP_OE|ZN_OE|ZP_OE
+ VDD|XN_OE|XP_OE|YN_OE|YP_OE|ZN_OE|ZP_OE pfet_06v0 L=1U W=10U AS=4.4P AD=2.5P
+ PS=20.88U PD=10.5U
M$86 \$102 \$125 \$2402 VDD|XN_OE|XP_OE|YN_OE|YP_OE|ZN_OE|ZP_OE pfet_06v0 L=1U
+ W=10U AS=2.5P AD=4.4P PS=10.5U PD=20.88U
M$87 VDD|XN_OE|XP_OE|YN_OE|YP_OE|ZN_OE|ZP_OE
+ VSS|XN_CS|XN_IE|XN_PD|XN_PDRV0|XN_PDRV1|XN_PU|XN_SL|XP_CS|XP_IE|XP_PD|XP_PDRV0|XP_PDRV1|XP_PU|XP_SL|YN_CS|YN_IE|YN_PD|YN_PDRV0|YN_PDRV1|YN_PU|YN_SL|YP_CS|YP_IE|YP_PD|YP_PDRV0|YP_PDRV1|YP_PU|YP_SL|ZN_CS|ZN_IE|ZN_PD|ZN_PDRV0|ZN_PDRV1|ZN_PU|ZN_SL|ZP_CS|ZP_IE|ZP_PD|ZP_PDRV0|ZP_PDRV1|ZP_PU|ZP_SL
+ VDD|XN_OE|XP_OE|YN_OE|YP_OE|ZN_OE|ZP_OE
+ VDD|XN_OE|XP_OE|YN_OE|YP_OE|ZN_OE|ZP_OE pfet_06v0 L=2U W=18U AS=7.92P
+ AD=7.92P PS=36.88U PD=36.88U
M$88 \$4816 \$2510 VDD|XN_OE|XP_OE|YN_OE|YP_OE|ZN_OE|ZP_OE
+ VDD|XN_OE|XP_OE|YN_OE|YP_OE|ZN_OE|ZP_OE pfet_06v0 L=1U W=10U AS=4.4P AD=2.5P
+ PS=20.88U PD=10.5U
M$89 \$2546 \$2530 \$4816 VDD|XN_OE|XP_OE|YN_OE|YP_OE|ZN_OE|ZP_OE pfet_06v0
+ L=1U W=10U AS=2.5P AD=4.4P PS=10.5U PD=20.88U
M$90 \$4817 \$2510 VDD|XN_OE|XP_OE|YN_OE|YP_OE|ZN_OE|ZP_OE
+ VDD|XN_OE|XP_OE|YN_OE|YP_OE|ZN_OE|ZP_OE pfet_06v0 L=1U W=10U AS=4.4P AD=2.5P
+ PS=20.88U PD=10.5U
M$91 \$2546 \$2530 \$4817 VDD|XN_OE|XP_OE|YN_OE|YP_OE|ZN_OE|ZP_OE pfet_06v0
+ L=1U W=10U AS=2.5P AD=4.4P PS=10.5U PD=20.88U
M$92 \$103 \$14440 \$135 VDD|XN_OE|XP_OE|YN_OE|YP_OE|ZN_OE|ZP_OE pfet_06v0 L=1U
+ W=0.55U AS=0.242P AD=0.242P PS=1.98U PD=1.98U
M$93 \$26 \$14439 \$135 VDD|XN_OE|XP_OE|YN_OE|YP_OE|ZN_OE|ZP_OE pfet_06v0 L=1U
+ W=0.5U AS=0.22P AD=0.22P PS=1.88U PD=1.88U
M$94 \$2547 \$2530 \$2436 VDD|XN_OE|XP_OE|YN_OE|YP_OE|ZN_OE|ZP_OE pfet_06v0
+ L=1U W=10U AS=4.4P AD=4.4P PS=20.88U PD=20.88U
M$95 \$2531 \$2530 \$2435 VDD|XN_OE|XP_OE|YN_OE|YP_OE|ZN_OE|ZP_OE pfet_06v0
+ L=1U W=10U AS=4.4P AD=4.4P PS=20.88U PD=20.88U
M$96 \$25 \$136 VDD|XN_OE|XP_OE|YN_OE|YP_OE|ZN_OE|ZP_OE
+ VDD|XN_OE|XP_OE|YN_OE|YP_OE|ZN_OE|ZP_OE pfet_06v0 L=1U W=5U AS=2.2P AD=2.2P
+ PS=10.88U PD=10.88U
M$97 \$24 \$136 VDD|XN_OE|XP_OE|YN_OE|YP_OE|ZN_OE|ZP_OE
+ VDD|XN_OE|XP_OE|YN_OE|YP_OE|ZN_OE|ZP_OE pfet_06v0 L=1U W=5U AS=2.2P AD=2.2P
+ PS=10.88U PD=10.88U
M$98 \$63 \$28 \$136 VDD|XN_OE|XP_OE|YN_OE|YP_OE|ZN_OE|ZP_OE pfet_06v0 L=1U
+ W=4U AS=1.76P AD=1.76P PS=8.88U PD=8.88U
M$99 \$27 \$28 \$120 VDD|XN_OE|XP_OE|YN_OE|YP_OE|ZN_OE|ZP_OE pfet_06v0 L=1U
+ W=4U AS=1.76P AD=1.76P PS=8.88U PD=8.88U
M$100 \$4819 \$2517 VDD|XN_OE|XP_OE|YN_OE|YP_OE|ZN_OE|ZP_OE
+ VDD|XN_OE|XP_OE|YN_OE|YP_OE|ZN_OE|ZP_OE pfet_06v0 L=1U W=10U AS=4.4P AD=2.5P
+ PS=20.88U PD=10.5U
M$101 \$2517 \$2530 \$4819 VDD|XN_OE|XP_OE|YN_OE|YP_OE|ZN_OE|ZP_OE pfet_06v0
+ L=1U W=10U AS=2.5P AD=3.3P PS=10.5U PD=10.66U
M$102 \$2439 \$2439 \$2517 VDD|XN_OE|XP_OE|YN_OE|YP_OE|ZN_OE|ZP_OE pfet_06v0
+ L=1U W=10U AS=3.3P AD=4.4P PS=10.66U PD=20.88U
M$103 \$4821 \$2510 VDD|XN_OE|XP_OE|YN_OE|YP_OE|ZN_OE|ZP_OE
+ VDD|XN_OE|XP_OE|YN_OE|YP_OE|ZN_OE|ZP_OE pfet_06v0 L=1U W=10U AS=4.4P AD=2.5P
+ PS=20.88U PD=10.5U
M$104 \$2474 \$2530 \$4821 VDD|XN_OE|XP_OE|YN_OE|YP_OE|ZN_OE|ZP_OE pfet_06v0
+ L=1U W=10U AS=2.5P AD=4.4P PS=10.5U PD=20.88U
M$105 \$30 \$120 VDD|XN_OE|XP_OE|YN_OE|YP_OE|ZN_OE|ZP_OE
+ VDD|XN_OE|XP_OE|YN_OE|YP_OE|ZN_OE|ZP_OE pfet_06v0 L=1U W=1U AS=0.44P AD=0.44P
+ PS=2.88U PD=2.88U
M$106 \$30 \$120 VDD|XN_OE|XP_OE|YN_OE|YP_OE|ZN_OE|ZP_OE
+ VDD|XN_OE|XP_OE|YN_OE|YP_OE|ZN_OE|ZP_OE pfet_06v0 L=1U W=1U AS=0.44P AD=0.44P
+ PS=2.88U PD=2.88U
M$107 \$30 \$120 VDD|XN_OE|XP_OE|YN_OE|YP_OE|ZN_OE|ZP_OE
+ VDD|XN_OE|XP_OE|YN_OE|YP_OE|ZN_OE|ZP_OE pfet_06v0 L=1U W=1U AS=0.44P AD=0.44P
+ PS=2.88U PD=2.88U
M$108 \$30 \$120 VDD|XN_OE|XP_OE|YN_OE|YP_OE|ZN_OE|ZP_OE
+ VDD|XN_OE|XP_OE|YN_OE|YP_OE|ZN_OE|ZP_OE pfet_06v0 L=1U W=1U AS=0.44P AD=0.44P
+ PS=2.88U PD=2.88U
M$109 \$4823 \$2510 VDD|XN_OE|XP_OE|YN_OE|YP_OE|ZN_OE|ZP_OE
+ VDD|XN_OE|XP_OE|YN_OE|YP_OE|ZN_OE|ZP_OE pfet_06v0 L=1U W=10U AS=4.4P AD=2.5P
+ PS=20.88U PD=10.5U
M$110 \$2503 \$2530 \$4823 VDD|XN_OE|XP_OE|YN_OE|YP_OE|ZN_OE|ZP_OE pfet_06v0
+ L=1U W=10U AS=2.5P AD=4.4P PS=10.5U PD=20.88U
M$111 \$4824 \$2510 VDD|XN_OE|XP_OE|YN_OE|YP_OE|ZN_OE|ZP_OE
+ VDD|XN_OE|XP_OE|YN_OE|YP_OE|ZN_OE|ZP_OE pfet_06v0 L=1U W=10U AS=4.4P AD=2.5P
+ PS=20.88U PD=10.5U
M$112 \$2502 \$2530 \$4824 VDD|XN_OE|XP_OE|YN_OE|YP_OE|ZN_OE|ZP_OE pfet_06v0
+ L=1U W=10U AS=2.5P AD=4.4P PS=10.5U PD=20.88U
M$113 \$119 \$119 VDD|XN_OE|XP_OE|YN_OE|YP_OE|ZN_OE|ZP_OE
+ VDD|XN_OE|XP_OE|YN_OE|YP_OE|ZN_OE|ZP_OE pfet_06v0 L=1U W=2U AS=0.88P AD=0.88P
+ PS=4.88U PD=4.88U
M$114 \$4825 \$2510 VDD|XN_OE|XP_OE|YN_OE|YP_OE|ZN_OE|ZP_OE
+ VDD|XN_OE|XP_OE|YN_OE|YP_OE|ZN_OE|ZP_OE pfet_06v0 L=1U W=10U AS=4.4P AD=2.5P
+ PS=20.88U PD=10.5U
M$115 \$2510 \$2530 \$4825 VDD|XN_OE|XP_OE|YN_OE|YP_OE|ZN_OE|ZP_OE pfet_06v0
+ L=1U W=10U AS=2.5P AD=4.4P PS=10.5U PD=20.88U
M$116 VDD|XN_OE|XP_OE|YN_OE|YP_OE|ZN_OE|ZP_OE
+ VSS|XN_CS|XN_IE|XN_PD|XN_PDRV0|XN_PDRV1|XN_PU|XN_SL|XP_CS|XP_IE|XP_PD|XP_PDRV0|XP_PDRV1|XP_PU|XP_SL|YN_CS|YN_IE|YN_PD|YN_PDRV0|YN_PDRV1|YN_PU|YN_SL|YP_CS|YP_IE|YP_PD|YP_PDRV0|YP_PDRV1|YP_PU|YP_SL|ZN_CS|ZN_IE|ZN_PD|ZN_PDRV0|ZN_PDRV1|ZN_PU|ZN_SL|ZP_CS|ZP_IE|ZP_PD|ZP_PDRV0|ZP_PDRV1|ZP_PU|ZP_SL
+ VDD|XN_OE|XP_OE|YN_OE|YP_OE|ZN_OE|ZP_OE
+ VDD|XN_OE|XP_OE|YN_OE|YP_OE|ZN_OE|ZP_OE pfet_06v0 L=2U W=18U AS=7.92P
+ AD=7.92P PS=36.88U PD=36.88U
M$117 VDD|XN_OE|XP_OE|YN_OE|YP_OE|ZN_OE|ZP_OE
+ VSS|XN_CS|XN_IE|XN_PD|XN_PDRV0|XN_PDRV1|XN_PU|XN_SL|XP_CS|XP_IE|XP_PD|XP_PDRV0|XP_PDRV1|XP_PU|XP_SL|YN_CS|YN_IE|YN_PD|YN_PDRV0|YN_PDRV1|YN_PU|YN_SL|YP_CS|YP_IE|YP_PD|YP_PDRV0|YP_PDRV1|YP_PU|YP_SL|ZN_CS|ZN_IE|ZN_PD|ZN_PDRV0|ZN_PDRV1|ZN_PU|ZN_SL|ZP_CS|ZP_IE|ZP_PD|ZP_PDRV0|ZP_PDRV1|ZP_PU|ZP_SL
+ VDD|XN_OE|XP_OE|YN_OE|YP_OE|ZN_OE|ZP_OE
+ VDD|XN_OE|XP_OE|YN_OE|YP_OE|ZN_OE|ZP_OE pfet_06v0 L=2U W=18U AS=7.92P
+ AD=7.92P PS=36.88U PD=36.88U
M$118 \$4826 \$2511 VDD|XN_OE|XP_OE|YN_OE|YP_OE|ZN_OE|ZP_OE
+ VDD|XN_OE|XP_OE|YN_OE|YP_OE|ZN_OE|ZP_OE pfet_06v0 L=1U W=10U AS=4.4P AD=2.5P
+ PS=20.88U PD=10.5U
M$119 \$2548 \$2532 \$4826 VDD|XN_OE|XP_OE|YN_OE|YP_OE|ZN_OE|ZP_OE pfet_06v0
+ L=1U W=10U AS=2.5P AD=4.4P PS=10.5U PD=20.88U
M$120 \$4827 \$2511 VDD|XN_OE|XP_OE|YN_OE|YP_OE|ZN_OE|ZP_OE
+ VDD|XN_OE|XP_OE|YN_OE|YP_OE|ZN_OE|ZP_OE pfet_06v0 L=1U W=10U AS=4.4P AD=2.5P
+ PS=20.88U PD=10.5U
M$121 \$2548 \$2532 \$4827 VDD|XN_OE|XP_OE|YN_OE|YP_OE|ZN_OE|ZP_OE pfet_06v0
+ L=1U W=10U AS=2.5P AD=4.4P PS=10.5U PD=20.88U
M$122 \$107 \$14437 \$137 VDD|XN_OE|XP_OE|YN_OE|YP_OE|ZN_OE|ZP_OE pfet_06v0
+ L=1U W=0.55U AS=0.242P AD=0.242P PS=1.98U PD=1.98U
M$123 \$34 \$14438 \$137 VDD|XN_OE|XP_OE|YN_OE|YP_OE|ZN_OE|ZP_OE pfet_06v0 L=1U
+ W=0.5U AS=0.22P AD=0.22P PS=1.88U PD=1.88U
M$124 \$2550 \$2532 \$2444 VDD|XN_OE|XP_OE|YN_OE|YP_OE|ZN_OE|ZP_OE pfet_06v0
+ L=1U W=10U AS=4.4P AD=4.4P PS=20.88U PD=20.88U
M$125 \$2533 \$2532 \$2443 VDD|XN_OE|XP_OE|YN_OE|YP_OE|ZN_OE|ZP_OE pfet_06v0
+ L=1U W=10U AS=4.4P AD=4.4P PS=20.88U PD=20.88U
M$126 \$33 \$138 VDD|XN_OE|XP_OE|YN_OE|YP_OE|ZN_OE|ZP_OE
+ VDD|XN_OE|XP_OE|YN_OE|YP_OE|ZN_OE|ZP_OE pfet_06v0 L=1U W=5U AS=2.2P AD=2.2P
+ PS=10.88U PD=10.88U
M$127 \$32 \$138 VDD|XN_OE|XP_OE|YN_OE|YP_OE|ZN_OE|ZP_OE
+ VDD|XN_OE|XP_OE|YN_OE|YP_OE|ZN_OE|ZP_OE pfet_06v0 L=1U W=5U AS=2.2P AD=2.2P
+ PS=10.88U PD=10.88U
M$128 \$65 \$36 \$138 VDD|XN_OE|XP_OE|YN_OE|YP_OE|ZN_OE|ZP_OE pfet_06v0 L=1U
+ W=4U AS=1.76P AD=1.76P PS=8.88U PD=8.88U
M$129 \$35 \$36 \$122 VDD|XN_OE|XP_OE|YN_OE|YP_OE|ZN_OE|ZP_OE pfet_06v0 L=1U
+ W=4U AS=1.76P AD=1.76P PS=8.88U PD=8.88U
M$130 \$4829 \$2521 VDD|XN_OE|XP_OE|YN_OE|YP_OE|ZN_OE|ZP_OE
+ VDD|XN_OE|XP_OE|YN_OE|YP_OE|ZN_OE|ZP_OE pfet_06v0 L=1U W=10U AS=4.4P AD=2.5P
+ PS=20.88U PD=10.5U
M$131 \$2521 \$2532 \$4829 VDD|XN_OE|XP_OE|YN_OE|YP_OE|ZN_OE|ZP_OE pfet_06v0
+ L=1U W=10U AS=2.5P AD=3.3P PS=10.5U PD=10.66U
M$132 \$2447 \$2447 \$2521 VDD|XN_OE|XP_OE|YN_OE|YP_OE|ZN_OE|ZP_OE pfet_06v0
+ L=1U W=10U AS=3.3P AD=4.4P PS=10.66U PD=20.88U
M$133 \$4831 \$2511 VDD|XN_OE|XP_OE|YN_OE|YP_OE|ZN_OE|ZP_OE
+ VDD|XN_OE|XP_OE|YN_OE|YP_OE|ZN_OE|ZP_OE pfet_06v0 L=1U W=10U AS=4.4P AD=2.5P
+ PS=20.88U PD=10.5U
M$134 \$2475 \$2532 \$4831 VDD|XN_OE|XP_OE|YN_OE|YP_OE|ZN_OE|ZP_OE pfet_06v0
+ L=1U W=10U AS=2.5P AD=4.4P PS=10.5U PD=20.88U
M$135 \$38 \$122 VDD|XN_OE|XP_OE|YN_OE|YP_OE|ZN_OE|ZP_OE
+ VDD|XN_OE|XP_OE|YN_OE|YP_OE|ZN_OE|ZP_OE pfet_06v0 L=1U W=1U AS=0.44P AD=0.44P
+ PS=2.88U PD=2.88U
M$136 \$38 \$122 VDD|XN_OE|XP_OE|YN_OE|YP_OE|ZN_OE|ZP_OE
+ VDD|XN_OE|XP_OE|YN_OE|YP_OE|ZN_OE|ZP_OE pfet_06v0 L=1U W=1U AS=0.44P AD=0.44P
+ PS=2.88U PD=2.88U
M$137 \$38 \$122 VDD|XN_OE|XP_OE|YN_OE|YP_OE|ZN_OE|ZP_OE
+ VDD|XN_OE|XP_OE|YN_OE|YP_OE|ZN_OE|ZP_OE pfet_06v0 L=1U W=1U AS=0.44P AD=0.44P
+ PS=2.88U PD=2.88U
M$138 \$38 \$122 VDD|XN_OE|XP_OE|YN_OE|YP_OE|ZN_OE|ZP_OE
+ VDD|XN_OE|XP_OE|YN_OE|YP_OE|ZN_OE|ZP_OE pfet_06v0 L=1U W=1U AS=0.44P AD=0.44P
+ PS=2.88U PD=2.88U
M$139 \$4832 \$2511 VDD|XN_OE|XP_OE|YN_OE|YP_OE|ZN_OE|ZP_OE
+ VDD|XN_OE|XP_OE|YN_OE|YP_OE|ZN_OE|ZP_OE pfet_06v0 L=1U W=10U AS=4.4P AD=2.5P
+ PS=20.88U PD=10.5U
M$140 \$2505 \$2532 \$4832 VDD|XN_OE|XP_OE|YN_OE|YP_OE|ZN_OE|ZP_OE pfet_06v0
+ L=1U W=10U AS=2.5P AD=4.4P PS=10.5U PD=20.88U
M$141 \$4833 \$2511 VDD|XN_OE|XP_OE|YN_OE|YP_OE|ZN_OE|ZP_OE
+ VDD|XN_OE|XP_OE|YN_OE|YP_OE|ZN_OE|ZP_OE pfet_06v0 L=1U W=10U AS=4.4P AD=2.5P
+ PS=20.88U PD=10.5U
M$142 \$2504 \$2532 \$4833 VDD|XN_OE|XP_OE|YN_OE|YP_OE|ZN_OE|ZP_OE pfet_06v0
+ L=1U W=10U AS=2.5P AD=4.4P PS=10.5U PD=20.88U
M$143 \$121 \$121 VDD|XN_OE|XP_OE|YN_OE|YP_OE|ZN_OE|ZP_OE
+ VDD|XN_OE|XP_OE|YN_OE|YP_OE|ZN_OE|ZP_OE pfet_06v0 L=1U W=2U AS=0.88P AD=0.88P
+ PS=4.88U PD=4.88U
M$144 \$4834 \$2511 VDD|XN_OE|XP_OE|YN_OE|YP_OE|ZN_OE|ZP_OE
+ VDD|XN_OE|XP_OE|YN_OE|YP_OE|ZN_OE|ZP_OE pfet_06v0 L=1U W=10U AS=4.4P AD=2.5P
+ PS=20.88U PD=10.5U
M$145 \$2511 \$2532 \$4834 VDD|XN_OE|XP_OE|YN_OE|YP_OE|ZN_OE|ZP_OE pfet_06v0
+ L=1U W=10U AS=2.5P AD=4.4P PS=10.5U PD=20.88U
M$146 VDD|XN_OE|XP_OE|YN_OE|YP_OE|ZN_OE|ZP_OE
+ VSS|XN_CS|XN_IE|XN_PD|XN_PDRV0|XN_PDRV1|XN_PU|XN_SL|XP_CS|XP_IE|XP_PD|XP_PDRV0|XP_PDRV1|XP_PU|XP_SL|YN_CS|YN_IE|YN_PD|YN_PDRV0|YN_PDRV1|YN_PU|YN_SL|YP_CS|YP_IE|YP_PD|YP_PDRV0|YP_PDRV1|YP_PU|YP_SL|ZN_CS|ZN_IE|ZN_PD|ZN_PDRV0|ZN_PDRV1|ZN_PU|ZN_SL|ZP_CS|ZP_IE|ZP_PD|ZP_PDRV0|ZP_PDRV1|ZP_PU|ZP_SL
+ VDD|XN_OE|XP_OE|YN_OE|YP_OE|ZN_OE|ZP_OE
+ VDD|XN_OE|XP_OE|YN_OE|YP_OE|ZN_OE|ZP_OE pfet_06v0 L=2U W=18U AS=7.92P
+ AD=7.92P PS=36.88U PD=36.88U
M$147 VDD|XN_OE|XP_OE|YN_OE|YP_OE|ZN_OE|ZP_OE
+ VSS|XN_CS|XN_IE|XN_PD|XN_PDRV0|XN_PDRV1|XN_PU|XN_SL|XP_CS|XP_IE|XP_PD|XP_PDRV0|XP_PDRV1|XP_PU|XP_SL|YN_CS|YN_IE|YN_PD|YN_PDRV0|YN_PDRV1|YN_PU|YN_SL|YP_CS|YP_IE|YP_PD|YP_PDRV0|YP_PDRV1|YP_PU|YP_SL|ZN_CS|ZN_IE|ZN_PD|ZN_PDRV0|ZN_PDRV1|ZN_PU|ZN_SL|ZP_CS|ZP_IE|ZP_PD|ZP_PDRV0|ZP_PDRV1|ZP_PU|ZP_SL
+ VDD|XN_OE|XP_OE|YN_OE|YP_OE|ZN_OE|ZP_OE
+ VDD|XN_OE|XP_OE|YN_OE|YP_OE|ZN_OE|ZP_OE pfet_06v0 L=2U W=18U AS=7.92P
+ AD=7.92P PS=36.88U PD=36.88U
M$148 \$4835 \$2512 VDD|XN_OE|XP_OE|YN_OE|YP_OE|ZN_OE|ZP_OE
+ VDD|XN_OE|XP_OE|YN_OE|YP_OE|ZN_OE|ZP_OE pfet_06v0 L=1U W=10U AS=4.4P AD=2.5P
+ PS=20.88U PD=10.5U
M$149 \$2551 \$2534 \$4835 VDD|XN_OE|XP_OE|YN_OE|YP_OE|ZN_OE|ZP_OE pfet_06v0
+ L=1U W=10U AS=2.5P AD=4.4P PS=10.5U PD=20.88U
M$150 \$4836 \$2512 VDD|XN_OE|XP_OE|YN_OE|YP_OE|ZN_OE|ZP_OE
+ VDD|XN_OE|XP_OE|YN_OE|YP_OE|ZN_OE|ZP_OE pfet_06v0 L=1U W=10U AS=4.4P AD=2.5P
+ PS=20.88U PD=10.5U
M$151 \$2551 \$2534 \$4836 VDD|XN_OE|XP_OE|YN_OE|YP_OE|ZN_OE|ZP_OE pfet_06v0
+ L=1U W=10U AS=2.5P AD=4.4P PS=10.5U PD=20.88U
M$152 \$111 \$14436 \$139 VDD|XN_OE|XP_OE|YN_OE|YP_OE|ZN_OE|ZP_OE pfet_06v0
+ L=1U W=0.55U AS=0.242P AD=0.242P PS=1.98U PD=1.98U
M$153 \$42 \$14435 \$139 VDD|XN_OE|XP_OE|YN_OE|YP_OE|ZN_OE|ZP_OE pfet_06v0 L=1U
+ W=0.5U AS=0.22P AD=0.22P PS=1.88U PD=1.88U
M$154 \$2552 \$2534 \$2452 VDD|XN_OE|XP_OE|YN_OE|YP_OE|ZN_OE|ZP_OE pfet_06v0
+ L=1U W=10U AS=4.4P AD=4.4P PS=20.88U PD=20.88U
M$155 \$2535 \$2534 \$2451 VDD|XN_OE|XP_OE|YN_OE|YP_OE|ZN_OE|ZP_OE pfet_06v0
+ L=1U W=10U AS=4.4P AD=4.4P PS=20.88U PD=20.88U
M$156 \$41 \$140 VDD|XN_OE|XP_OE|YN_OE|YP_OE|ZN_OE|ZP_OE
+ VDD|XN_OE|XP_OE|YN_OE|YP_OE|ZN_OE|ZP_OE pfet_06v0 L=1U W=5U AS=2.2P AD=2.2P
+ PS=10.88U PD=10.88U
M$157 \$40 \$140 VDD|XN_OE|XP_OE|YN_OE|YP_OE|ZN_OE|ZP_OE
+ VDD|XN_OE|XP_OE|YN_OE|YP_OE|ZN_OE|ZP_OE pfet_06v0 L=1U W=5U AS=2.2P AD=2.2P
+ PS=10.88U PD=10.88U
M$158 \$67 \$44 \$140 VDD|XN_OE|XP_OE|YN_OE|YP_OE|ZN_OE|ZP_OE pfet_06v0 L=1U
+ W=4U AS=1.76P AD=1.76P PS=8.88U PD=8.88U
M$159 \$43 \$44 \$124 VDD|XN_OE|XP_OE|YN_OE|YP_OE|ZN_OE|ZP_OE pfet_06v0 L=1U
+ W=4U AS=1.76P AD=1.76P PS=8.88U PD=8.88U
M$160 \$4837 \$2525 VDD|XN_OE|XP_OE|YN_OE|YP_OE|ZN_OE|ZP_OE
+ VDD|XN_OE|XP_OE|YN_OE|YP_OE|ZN_OE|ZP_OE pfet_06v0 L=1U W=10U AS=4.4P AD=2.5P
+ PS=20.88U PD=10.5U
M$161 \$2525 \$2534 \$4837 VDD|XN_OE|XP_OE|YN_OE|YP_OE|ZN_OE|ZP_OE pfet_06v0
+ L=1U W=10U AS=2.5P AD=3.3P PS=10.5U PD=10.66U
M$162 \$2455 \$2455 \$2525 VDD|XN_OE|XP_OE|YN_OE|YP_OE|ZN_OE|ZP_OE pfet_06v0
+ L=1U W=10U AS=3.3P AD=4.4P PS=10.66U PD=20.88U
M$163 \$4839 \$2512 VDD|XN_OE|XP_OE|YN_OE|YP_OE|ZN_OE|ZP_OE
+ VDD|XN_OE|XP_OE|YN_OE|YP_OE|ZN_OE|ZP_OE pfet_06v0 L=1U W=10U AS=4.4P AD=2.5P
+ PS=20.88U PD=10.5U
M$164 \$2476 \$2534 \$4839 VDD|XN_OE|XP_OE|YN_OE|YP_OE|ZN_OE|ZP_OE pfet_06v0
+ L=1U W=10U AS=2.5P AD=4.4P PS=10.5U PD=20.88U
M$165 \$46 \$124 VDD|XN_OE|XP_OE|YN_OE|YP_OE|ZN_OE|ZP_OE
+ VDD|XN_OE|XP_OE|YN_OE|YP_OE|ZN_OE|ZP_OE pfet_06v0 L=1U W=1U AS=0.44P AD=0.44P
+ PS=2.88U PD=2.88U
M$166 \$46 \$124 VDD|XN_OE|XP_OE|YN_OE|YP_OE|ZN_OE|ZP_OE
+ VDD|XN_OE|XP_OE|YN_OE|YP_OE|ZN_OE|ZP_OE pfet_06v0 L=1U W=1U AS=0.44P AD=0.44P
+ PS=2.88U PD=2.88U
M$167 \$46 \$124 VDD|XN_OE|XP_OE|YN_OE|YP_OE|ZN_OE|ZP_OE
+ VDD|XN_OE|XP_OE|YN_OE|YP_OE|ZN_OE|ZP_OE pfet_06v0 L=1U W=1U AS=0.44P AD=0.44P
+ PS=2.88U PD=2.88U
M$168 \$46 \$124 VDD|XN_OE|XP_OE|YN_OE|YP_OE|ZN_OE|ZP_OE
+ VDD|XN_OE|XP_OE|YN_OE|YP_OE|ZN_OE|ZP_OE pfet_06v0 L=1U W=1U AS=0.44P AD=0.44P
+ PS=2.88U PD=2.88U
M$169 \$4841 \$2512 VDD|XN_OE|XP_OE|YN_OE|YP_OE|ZN_OE|ZP_OE
+ VDD|XN_OE|XP_OE|YN_OE|YP_OE|ZN_OE|ZP_OE pfet_06v0 L=1U W=10U AS=4.4P AD=2.5P
+ PS=20.88U PD=10.5U
M$170 \$2507 \$2534 \$4841 VDD|XN_OE|XP_OE|YN_OE|YP_OE|ZN_OE|ZP_OE pfet_06v0
+ L=1U W=10U AS=2.5P AD=4.4P PS=10.5U PD=20.88U
M$171 \$4842 \$2512 VDD|XN_OE|XP_OE|YN_OE|YP_OE|ZN_OE|ZP_OE
+ VDD|XN_OE|XP_OE|YN_OE|YP_OE|ZN_OE|ZP_OE pfet_06v0 L=1U W=10U AS=4.4P AD=2.5P
+ PS=20.88U PD=10.5U
M$172 \$2506 \$2534 \$4842 VDD|XN_OE|XP_OE|YN_OE|YP_OE|ZN_OE|ZP_OE pfet_06v0
+ L=1U W=10U AS=2.5P AD=4.4P PS=10.5U PD=20.88U
M$173 \$123 \$123 VDD|XN_OE|XP_OE|YN_OE|YP_OE|ZN_OE|ZP_OE
+ VDD|XN_OE|XP_OE|YN_OE|YP_OE|ZN_OE|ZP_OE pfet_06v0 L=1U W=2U AS=0.88P AD=0.88P
+ PS=4.88U PD=4.88U
M$174 \$4843 \$2512 VDD|XN_OE|XP_OE|YN_OE|YP_OE|ZN_OE|ZP_OE
+ VDD|XN_OE|XP_OE|YN_OE|YP_OE|ZN_OE|ZP_OE pfet_06v0 L=1U W=10U AS=4.4P AD=2.5P
+ PS=20.88U PD=10.5U
M$175 \$2512 \$2534 \$4843 VDD|XN_OE|XP_OE|YN_OE|YP_OE|ZN_OE|ZP_OE pfet_06v0
+ L=1U W=10U AS=2.5P AD=4.4P PS=10.5U PD=20.88U
M$176 VDD|XN_OE|XP_OE|YN_OE|YP_OE|ZN_OE|ZP_OE
+ VSS|XN_CS|XN_IE|XN_PD|XN_PDRV0|XN_PDRV1|XN_PU|XN_SL|XP_CS|XP_IE|XP_PD|XP_PDRV0|XP_PDRV1|XP_PU|XP_SL|YN_CS|YN_IE|YN_PD|YN_PDRV0|YN_PDRV1|YN_PU|YN_SL|YP_CS|YP_IE|YP_PD|YP_PDRV0|YP_PDRV1|YP_PU|YP_SL|ZN_CS|ZN_IE|ZN_PD|ZN_PDRV0|ZN_PDRV1|ZN_PU|ZN_SL|ZP_CS|ZP_IE|ZP_PD|ZP_PDRV0|ZP_PDRV1|ZP_PU|ZP_SL
+ VDD|XN_OE|XP_OE|YN_OE|YP_OE|ZN_OE|ZP_OE
+ VDD|XN_OE|XP_OE|YN_OE|YP_OE|ZN_OE|ZP_OE pfet_06v0 L=2U W=18U AS=7.92P
+ AD=7.92P PS=36.88U PD=36.88U
M$177 VDD|XN_OE|XP_OE|YN_OE|YP_OE|ZN_OE|ZP_OE
+ VSS|XN_CS|XN_IE|XN_PD|XN_PDRV0|XN_PDRV1|XN_PU|XN_SL|XP_CS|XP_IE|XP_PD|XP_PDRV0|XP_PDRV1|XP_PU|XP_SL|YN_CS|YN_IE|YN_PD|YN_PDRV0|YN_PDRV1|YN_PU|YN_SL|YP_CS|YP_IE|YP_PD|YP_PDRV0|YP_PDRV1|YP_PU|YP_SL|ZN_CS|ZN_IE|ZN_PD|ZN_PDRV0|ZN_PDRV1|ZN_PU|ZN_SL|ZP_CS|ZP_IE|ZP_PD|ZP_PDRV0|ZP_PDRV1|ZP_PU|ZP_SL
+ VDD|XN_OE|XP_OE|YN_OE|YP_OE|ZN_OE|ZP_OE
+ VDD|XN_OE|XP_OE|YN_OE|YP_OE|ZN_OE|ZP_OE pfet_06v0 L=2U W=18U AS=7.92P
+ AD=7.92P PS=36.88U PD=36.88U
M$178 \$4840 \$2513 VDD|XN_OE|XP_OE|YN_OE|YP_OE|ZN_OE|ZP_OE
+ VDD|XN_OE|XP_OE|YN_OE|YP_OE|ZN_OE|ZP_OE pfet_06v0 L=1U W=10U AS=4.4P AD=2.5P
+ PS=20.88U PD=10.5U
M$179 \$2553 \$2536 \$4840 VDD|XN_OE|XP_OE|YN_OE|YP_OE|ZN_OE|ZP_OE pfet_06v0
+ L=1U W=10U AS=2.5P AD=4.4P PS=10.5U PD=20.88U
M$180 \$4838 \$2513 VDD|XN_OE|XP_OE|YN_OE|YP_OE|ZN_OE|ZP_OE
+ VDD|XN_OE|XP_OE|YN_OE|YP_OE|ZN_OE|ZP_OE pfet_06v0 L=1U W=10U AS=4.4P AD=2.5P
+ PS=20.88U PD=10.5U
M$181 \$2553 \$2536 \$4838 VDD|XN_OE|XP_OE|YN_OE|YP_OE|ZN_OE|ZP_OE pfet_06v0
+ L=1U W=10U AS=2.5P AD=4.4P PS=10.5U PD=20.88U
M$182 \$115 \$14436 \$141 VDD|XN_OE|XP_OE|YN_OE|YP_OE|ZN_OE|ZP_OE pfet_06v0
+ L=1U W=0.55U AS=0.242P AD=0.242P PS=1.98U PD=1.98U
M$183 \$50 \$14435 \$141 VDD|XN_OE|XP_OE|YN_OE|YP_OE|ZN_OE|ZP_OE pfet_06v0 L=1U
+ W=0.5U AS=0.22P AD=0.22P PS=1.88U PD=1.88U
M$184 \$2554 \$2536 \$2460 VDD|XN_OE|XP_OE|YN_OE|YP_OE|ZN_OE|ZP_OE pfet_06v0
+ L=1U W=10U AS=4.4P AD=4.4P PS=20.88U PD=20.88U
M$185 \$2537 \$2536 \$2459 VDD|XN_OE|XP_OE|YN_OE|YP_OE|ZN_OE|ZP_OE pfet_06v0
+ L=1U W=10U AS=4.4P AD=4.4P PS=20.88U PD=20.88U
M$186 \$49 \$142 VDD|XN_OE|XP_OE|YN_OE|YP_OE|ZN_OE|ZP_OE
+ VDD|XN_OE|XP_OE|YN_OE|YP_OE|ZN_OE|ZP_OE pfet_06v0 L=1U W=5U AS=2.2P AD=2.2P
+ PS=10.88U PD=10.88U
M$187 \$48 \$142 VDD|XN_OE|XP_OE|YN_OE|YP_OE|ZN_OE|ZP_OE
+ VDD|XN_OE|XP_OE|YN_OE|YP_OE|ZN_OE|ZP_OE pfet_06v0 L=1U W=5U AS=2.2P AD=2.2P
+ PS=10.88U PD=10.88U
M$188 \$69 \$52 \$142 VDD|XN_OE|XP_OE|YN_OE|YP_OE|ZN_OE|ZP_OE pfet_06v0 L=1U
+ W=4U AS=1.76P AD=1.76P PS=8.88U PD=8.88U
M$189 \$51 \$52 \$126 VDD|XN_OE|XP_OE|YN_OE|YP_OE|ZN_OE|ZP_OE pfet_06v0 L=1U
+ W=4U AS=1.76P AD=1.76P PS=8.88U PD=8.88U
M$190 \$4830 \$2529 VDD|XN_OE|XP_OE|YN_OE|YP_OE|ZN_OE|ZP_OE
+ VDD|XN_OE|XP_OE|YN_OE|YP_OE|ZN_OE|ZP_OE pfet_06v0 L=1U W=10U AS=4.4P AD=2.5P
+ PS=20.88U PD=10.5U
M$191 \$2529 \$2536 \$4830 VDD|XN_OE|XP_OE|YN_OE|YP_OE|ZN_OE|ZP_OE pfet_06v0
+ L=1U W=10U AS=2.5P AD=3.3P PS=10.5U PD=10.66U
M$192 \$2463 \$2463 \$2529 VDD|XN_OE|XP_OE|YN_OE|YP_OE|ZN_OE|ZP_OE pfet_06v0
+ L=1U W=10U AS=3.3P AD=4.4P PS=10.66U PD=20.88U
M$193 \$4828 \$2513 VDD|XN_OE|XP_OE|YN_OE|YP_OE|ZN_OE|ZP_OE
+ VDD|XN_OE|XP_OE|YN_OE|YP_OE|ZN_OE|ZP_OE pfet_06v0 L=1U W=10U AS=4.4P AD=2.5P
+ PS=20.88U PD=10.5U
M$194 \$2477 \$2536 \$4828 VDD|XN_OE|XP_OE|YN_OE|YP_OE|ZN_OE|ZP_OE pfet_06v0
+ L=1U W=10U AS=2.5P AD=4.4P PS=10.5U PD=20.88U
M$195 \$54 \$126 VDD|XN_OE|XP_OE|YN_OE|YP_OE|ZN_OE|ZP_OE
+ VDD|XN_OE|XP_OE|YN_OE|YP_OE|ZN_OE|ZP_OE pfet_06v0 L=1U W=1U AS=0.44P AD=0.44P
+ PS=2.88U PD=2.88U
M$196 \$54 \$126 VDD|XN_OE|XP_OE|YN_OE|YP_OE|ZN_OE|ZP_OE
+ VDD|XN_OE|XP_OE|YN_OE|YP_OE|ZN_OE|ZP_OE pfet_06v0 L=1U W=1U AS=0.44P AD=0.44P
+ PS=2.88U PD=2.88U
M$197 \$54 \$126 VDD|XN_OE|XP_OE|YN_OE|YP_OE|ZN_OE|ZP_OE
+ VDD|XN_OE|XP_OE|YN_OE|YP_OE|ZN_OE|ZP_OE pfet_06v0 L=1U W=1U AS=0.44P AD=0.44P
+ PS=2.88U PD=2.88U
M$198 \$54 \$126 VDD|XN_OE|XP_OE|YN_OE|YP_OE|ZN_OE|ZP_OE
+ VDD|XN_OE|XP_OE|YN_OE|YP_OE|ZN_OE|ZP_OE pfet_06v0 L=1U W=1U AS=0.44P AD=0.44P
+ PS=2.88U PD=2.88U
M$199 \$4822 \$2513 VDD|XN_OE|XP_OE|YN_OE|YP_OE|ZN_OE|ZP_OE
+ VDD|XN_OE|XP_OE|YN_OE|YP_OE|ZN_OE|ZP_OE pfet_06v0 L=1U W=10U AS=4.4P AD=2.5P
+ PS=20.88U PD=10.5U
M$200 \$2509 \$2536 \$4822 VDD|XN_OE|XP_OE|YN_OE|YP_OE|ZN_OE|ZP_OE pfet_06v0
+ L=1U W=10U AS=2.5P AD=4.4P PS=10.5U PD=20.88U
M$201 \$4820 \$2513 VDD|XN_OE|XP_OE|YN_OE|YP_OE|ZN_OE|ZP_OE
+ VDD|XN_OE|XP_OE|YN_OE|YP_OE|ZN_OE|ZP_OE pfet_06v0 L=1U W=10U AS=4.4P AD=2.5P
+ PS=20.88U PD=10.5U
M$202 \$2508 \$2536 \$4820 VDD|XN_OE|XP_OE|YN_OE|YP_OE|ZN_OE|ZP_OE pfet_06v0
+ L=1U W=10U AS=2.5P AD=4.4P PS=10.5U PD=20.88U
M$203 \$125 \$125 VDD|XN_OE|XP_OE|YN_OE|YP_OE|ZN_OE|ZP_OE
+ VDD|XN_OE|XP_OE|YN_OE|YP_OE|ZN_OE|ZP_OE pfet_06v0 L=1U W=2U AS=0.88P AD=0.88P
+ PS=4.88U PD=4.88U
M$204 \$4818 \$2513 VDD|XN_OE|XP_OE|YN_OE|YP_OE|ZN_OE|ZP_OE
+ VDD|XN_OE|XP_OE|YN_OE|YP_OE|ZN_OE|ZP_OE pfet_06v0 L=1U W=10U AS=4.4P AD=2.5P
+ PS=20.88U PD=10.5U
M$205 \$2513 \$2536 \$4818 VDD|XN_OE|XP_OE|YN_OE|YP_OE|ZN_OE|ZP_OE pfet_06v0
+ L=1U W=10U AS=2.5P AD=4.4P PS=10.5U PD=20.88U
M$206 VDD|XN_OE|XP_OE|YN_OE|YP_OE|ZN_OE|ZP_OE
+ VSS|XN_CS|XN_IE|XN_PD|XN_PDRV0|XN_PDRV1|XN_PU|XN_SL|XP_CS|XP_IE|XP_PD|XP_PDRV0|XP_PDRV1|XP_PU|XP_SL|YN_CS|YN_IE|YN_PD|YN_PDRV0|YN_PDRV1|YN_PU|YN_SL|YP_CS|YP_IE|YP_PD|YP_PDRV0|YP_PDRV1|YP_PU|YP_SL|ZN_CS|ZN_IE|ZN_PD|ZN_PDRV0|ZN_PDRV1|ZN_PU|ZN_SL|ZP_CS|ZP_IE|ZP_PD|ZP_PDRV0|ZP_PDRV1|ZP_PU|ZP_SL
+ VDD|XN_OE|XP_OE|YN_OE|YP_OE|ZN_OE|ZP_OE
+ VDD|XN_OE|XP_OE|YN_OE|YP_OE|ZN_OE|ZP_OE pfet_06v0 L=2U W=18U AS=7.92P
+ AD=7.92P PS=36.88U PD=36.88U
M$207 VDD|XN_OE|XP_OE|YN_OE|YP_OE|ZN_OE|ZP_OE
+ VSS|XN_CS|XN_IE|XN_PD|XN_PDRV0|XN_PDRV1|XN_PU|XN_SL|XP_CS|XP_IE|XP_PD|XP_PDRV0|XP_PDRV1|XP_PU|XP_SL|YN_CS|YN_IE|YN_PD|YN_PDRV0|YN_PDRV1|YN_PU|YN_SL|YP_CS|YP_IE|YP_PD|YP_PDRV0|YP_PDRV1|YP_PU|YP_SL|ZN_CS|ZN_IE|ZN_PD|ZN_PDRV0|ZN_PDRV1|ZN_PU|ZN_SL|ZP_CS|ZP_IE|ZP_PD|ZP_PDRV0|ZP_PDRV1|ZP_PU|ZP_SL
+ VDD|XN_OE|XP_OE|YN_OE|YP_OE|ZN_OE|ZP_OE
+ VDD|XN_OE|XP_OE|YN_OE|YP_OE|ZN_OE|ZP_OE pfet_06v0 L=2U W=18U AS=7.92P
+ AD=7.92P PS=36.88U PD=36.88U
M$208 VDD|XN_OE|XP_OE|YN_OE|YP_OE|ZN_OE|ZP_OE
+ VSS|XN_CS|XN_IE|XN_PD|XN_PDRV0|XN_PDRV1|XN_PU|XN_SL|XP_CS|XP_IE|XP_PD|XP_PDRV0|XP_PDRV1|XP_PU|XP_SL|YN_CS|YN_IE|YN_PD|YN_PDRV0|YN_PDRV1|YN_PU|YN_SL|YP_CS|YP_IE|YP_PD|YP_PDRV0|YP_PDRV1|YP_PU|YP_SL|ZN_CS|ZN_IE|ZN_PD|ZN_PDRV0|ZN_PDRV1|ZN_PU|ZN_SL|ZP_CS|ZP_IE|ZP_PD|ZP_PDRV0|ZP_PDRV1|ZP_PU|ZP_SL
+ VDD|XN_OE|XP_OE|YN_OE|YP_OE|ZN_OE|ZP_OE
+ VDD|XN_OE|XP_OE|YN_OE|YP_OE|ZN_OE|ZP_OE pfet_06v0 L=2U W=18U AS=7.92P
+ AD=7.92P PS=36.88U PD=36.88U
M$209 \$7227 \$4925 VDD|XN_OE|XP_OE|YN_OE|YP_OE|ZN_OE|ZP_OE
+ VDD|XN_OE|XP_OE|YN_OE|YP_OE|ZN_OE|ZP_OE pfet_06v0 L=1U W=10U AS=4.4P AD=2.5P
+ PS=20.88U PD=10.5U
M$210 \$4961 \$4945 \$7227 VDD|XN_OE|XP_OE|YN_OE|YP_OE|ZN_OE|ZP_OE pfet_06v0
+ L=1U W=10U AS=2.5P AD=4.4P PS=10.5U PD=20.88U
M$211 \$7228 \$4925 VDD|XN_OE|XP_OE|YN_OE|YP_OE|ZN_OE|ZP_OE
+ VDD|XN_OE|XP_OE|YN_OE|YP_OE|ZN_OE|ZP_OE pfet_06v0 L=1U W=10U AS=4.4P AD=2.5P
+ PS=20.88U PD=10.5U
M$212 \$4961 \$4945 \$7228 VDD|XN_OE|XP_OE|YN_OE|YP_OE|ZN_OE|ZP_OE pfet_06v0
+ L=1U W=10U AS=2.5P AD=4.4P PS=10.5U PD=20.88U
M$213 \$2514 \$14440 \$2546 VDD|XN_OE|XP_OE|YN_OE|YP_OE|ZN_OE|ZP_OE pfet_06v0
+ L=1U W=0.55U AS=0.242P AD=0.242P PS=1.98U PD=1.98U
M$214 \$2437 \$14439 \$2546 VDD|XN_OE|XP_OE|YN_OE|YP_OE|ZN_OE|ZP_OE pfet_06v0
+ L=1U W=0.5U AS=0.22P AD=0.22P PS=1.88U PD=1.88U
M$215 \$4962 \$4945 \$4851 VDD|XN_OE|XP_OE|YN_OE|YP_OE|ZN_OE|ZP_OE pfet_06v0
+ L=1U W=10U AS=4.4P AD=4.4P PS=20.88U PD=20.88U
M$216 \$4951 \$4945 \$4850 VDD|XN_OE|XP_OE|YN_OE|YP_OE|ZN_OE|ZP_OE pfet_06v0
+ L=1U W=10U AS=4.4P AD=4.4P PS=20.88U PD=20.88U
M$217 \$2436 \$2547 VDD|XN_OE|XP_OE|YN_OE|YP_OE|ZN_OE|ZP_OE
+ VDD|XN_OE|XP_OE|YN_OE|YP_OE|ZN_OE|ZP_OE pfet_06v0 L=1U W=5U AS=2.2P AD=2.2P
+ PS=10.88U PD=10.88U
M$218 \$2435 \$2547 VDD|XN_OE|XP_OE|YN_OE|YP_OE|ZN_OE|ZP_OE
+ VDD|XN_OE|XP_OE|YN_OE|YP_OE|ZN_OE|ZP_OE pfet_06v0 L=1U W=5U AS=2.2P AD=2.2P
+ PS=10.88U PD=10.88U
M$219 \$2478 \$2439 \$2547 VDD|XN_OE|XP_OE|YN_OE|YP_OE|ZN_OE|ZP_OE pfet_06v0
+ L=1U W=4U AS=1.76P AD=1.76P PS=8.88U PD=8.88U
M$220 \$2438 \$2439 \$2531 VDD|XN_OE|XP_OE|YN_OE|YP_OE|ZN_OE|ZP_OE pfet_06v0
+ L=1U W=4U AS=1.76P AD=1.76P PS=8.88U PD=8.88U
M$221 \$7231 \$4932 VDD|XN_OE|XP_OE|YN_OE|YP_OE|ZN_OE|ZP_OE
+ VDD|XN_OE|XP_OE|YN_OE|YP_OE|ZN_OE|ZP_OE pfet_06v0 L=1U W=10U AS=4.4P AD=2.5P
+ PS=20.88U PD=10.5U
M$222 \$4932 \$4945 \$7231 VDD|XN_OE|XP_OE|YN_OE|YP_OE|ZN_OE|ZP_OE pfet_06v0
+ L=1U W=10U AS=2.5P AD=3.3P PS=10.5U PD=10.66U
M$223 \$4854 \$4854 \$4932 VDD|XN_OE|XP_OE|YN_OE|YP_OE|ZN_OE|ZP_OE pfet_06v0
+ L=1U W=10U AS=3.3P AD=4.4P PS=10.66U PD=20.88U
M$224 \$7232 \$4925 VDD|XN_OE|XP_OE|YN_OE|YP_OE|ZN_OE|ZP_OE
+ VDD|XN_OE|XP_OE|YN_OE|YP_OE|ZN_OE|ZP_OE pfet_06v0 L=1U W=10U AS=4.4P AD=2.5P
+ PS=20.88U PD=10.5U
M$225 \$4890 \$4945 \$7232 VDD|XN_OE|XP_OE|YN_OE|YP_OE|ZN_OE|ZP_OE pfet_06v0
+ L=1U W=10U AS=2.5P AD=4.4P PS=10.5U PD=20.88U
M$226 \$2441 \$2531 VDD|XN_OE|XP_OE|YN_OE|YP_OE|ZN_OE|ZP_OE
+ VDD|XN_OE|XP_OE|YN_OE|YP_OE|ZN_OE|ZP_OE pfet_06v0 L=1U W=1U AS=0.44P AD=0.44P
+ PS=2.88U PD=2.88U
M$227 \$2441 \$2531 VDD|XN_OE|XP_OE|YN_OE|YP_OE|ZN_OE|ZP_OE
+ VDD|XN_OE|XP_OE|YN_OE|YP_OE|ZN_OE|ZP_OE pfet_06v0 L=1U W=1U AS=0.44P AD=0.44P
+ PS=2.88U PD=2.88U
M$228 \$2441 \$2531 VDD|XN_OE|XP_OE|YN_OE|YP_OE|ZN_OE|ZP_OE
+ VDD|XN_OE|XP_OE|YN_OE|YP_OE|ZN_OE|ZP_OE pfet_06v0 L=1U W=1U AS=0.44P AD=0.44P
+ PS=2.88U PD=2.88U
M$229 \$2441 \$2531 VDD|XN_OE|XP_OE|YN_OE|YP_OE|ZN_OE|ZP_OE
+ VDD|XN_OE|XP_OE|YN_OE|YP_OE|ZN_OE|ZP_OE pfet_06v0 L=1U W=1U AS=0.44P AD=0.44P
+ PS=2.88U PD=2.88U
M$230 \$7233 \$4925 VDD|XN_OE|XP_OE|YN_OE|YP_OE|ZN_OE|ZP_OE
+ VDD|XN_OE|XP_OE|YN_OE|YP_OE|ZN_OE|ZP_OE pfet_06v0 L=1U W=10U AS=4.4P AD=2.5P
+ PS=20.88U PD=10.5U
M$231 \$4918 \$4945 \$7233 VDD|XN_OE|XP_OE|YN_OE|YP_OE|ZN_OE|ZP_OE pfet_06v0
+ L=1U W=10U AS=2.5P AD=4.4P PS=10.5U PD=20.88U
M$232 \$7235 \$4925 VDD|XN_OE|XP_OE|YN_OE|YP_OE|ZN_OE|ZP_OE
+ VDD|XN_OE|XP_OE|YN_OE|YP_OE|ZN_OE|ZP_OE pfet_06v0 L=1U W=10U AS=4.4P AD=2.5P
+ PS=20.88U PD=10.5U
M$233 \$4917 \$4945 \$7235 VDD|XN_OE|XP_OE|YN_OE|YP_OE|ZN_OE|ZP_OE pfet_06v0
+ L=1U W=10U AS=2.5P AD=4.4P PS=10.5U PD=20.88U
M$234 \$2530 \$2530 VDD|XN_OE|XP_OE|YN_OE|YP_OE|ZN_OE|ZP_OE
+ VDD|XN_OE|XP_OE|YN_OE|YP_OE|ZN_OE|ZP_OE pfet_06v0 L=1U W=2U AS=0.88P AD=0.88P
+ PS=4.88U PD=4.88U
M$235 \$7236 \$4925 VDD|XN_OE|XP_OE|YN_OE|YP_OE|ZN_OE|ZP_OE
+ VDD|XN_OE|XP_OE|YN_OE|YP_OE|ZN_OE|ZP_OE pfet_06v0 L=1U W=10U AS=4.4P AD=2.5P
+ PS=20.88U PD=10.5U
M$236 \$4925 \$4945 \$7236 VDD|XN_OE|XP_OE|YN_OE|YP_OE|ZN_OE|ZP_OE pfet_06v0
+ L=1U W=10U AS=2.5P AD=4.4P PS=10.5U PD=20.88U
M$237 VDD|XN_OE|XP_OE|YN_OE|YP_OE|ZN_OE|ZP_OE
+ VSS|XN_CS|XN_IE|XN_PD|XN_PDRV0|XN_PDRV1|XN_PU|XN_SL|XP_CS|XP_IE|XP_PD|XP_PDRV0|XP_PDRV1|XP_PU|XP_SL|YN_CS|YN_IE|YN_PD|YN_PDRV0|YN_PDRV1|YN_PU|YN_SL|YP_CS|YP_IE|YP_PD|YP_PDRV0|YP_PDRV1|YP_PU|YP_SL|ZN_CS|ZN_IE|ZN_PD|ZN_PDRV0|ZN_PDRV1|ZN_PU|ZN_SL|ZP_CS|ZP_IE|ZP_PD|ZP_PDRV0|ZP_PDRV1|ZP_PU|ZP_SL
+ VDD|XN_OE|XP_OE|YN_OE|YP_OE|ZN_OE|ZP_OE
+ VDD|XN_OE|XP_OE|YN_OE|YP_OE|ZN_OE|ZP_OE pfet_06v0 L=2U W=18U AS=7.92P
+ AD=7.92P PS=36.88U PD=36.88U
M$238 VDD|XN_OE|XP_OE|YN_OE|YP_OE|ZN_OE|ZP_OE
+ VSS|XN_CS|XN_IE|XN_PD|XN_PDRV0|XN_PDRV1|XN_PU|XN_SL|XP_CS|XP_IE|XP_PD|XP_PDRV0|XP_PDRV1|XP_PU|XP_SL|YN_CS|YN_IE|YN_PD|YN_PDRV0|YN_PDRV1|YN_PU|YN_SL|YP_CS|YP_IE|YP_PD|YP_PDRV0|YP_PDRV1|YP_PU|YP_SL|ZN_CS|ZN_IE|ZN_PD|ZN_PDRV0|ZN_PDRV1|ZN_PU|ZN_SL|ZP_CS|ZP_IE|ZP_PD|ZP_PDRV0|ZP_PDRV1|ZP_PU|ZP_SL
+ VDD|XN_OE|XP_OE|YN_OE|YP_OE|ZN_OE|ZP_OE
+ VDD|XN_OE|XP_OE|YN_OE|YP_OE|ZN_OE|ZP_OE pfet_06v0 L=2U W=18U AS=7.92P
+ AD=7.92P PS=36.88U PD=36.88U
M$239 \$7238 \$4926 VDD|XN_OE|XP_OE|YN_OE|YP_OE|ZN_OE|ZP_OE
+ VDD|XN_OE|XP_OE|YN_OE|YP_OE|ZN_OE|ZP_OE pfet_06v0 L=1U W=10U AS=4.4P AD=2.5P
+ PS=20.88U PD=10.5U
M$240 \$4963 \$4946 \$7238 VDD|XN_OE|XP_OE|YN_OE|YP_OE|ZN_OE|ZP_OE pfet_06v0
+ L=1U W=10U AS=2.5P AD=4.4P PS=10.5U PD=20.88U
M$241 \$7239 \$4926 VDD|XN_OE|XP_OE|YN_OE|YP_OE|ZN_OE|ZP_OE
+ VDD|XN_OE|XP_OE|YN_OE|YP_OE|ZN_OE|ZP_OE pfet_06v0 L=1U W=10U AS=4.4P AD=2.5P
+ PS=20.88U PD=10.5U
M$242 \$4963 \$4946 \$7239 VDD|XN_OE|XP_OE|YN_OE|YP_OE|ZN_OE|ZP_OE pfet_06v0
+ L=1U W=10U AS=2.5P AD=4.4P PS=10.5U PD=20.88U
M$243 \$2518 \$2549 \$2548 VDD|XN_OE|XP_OE|YN_OE|YP_OE|ZN_OE|ZP_OE pfet_06v0
+ L=1U W=0.55U AS=0.242P AD=0.242P PS=1.98U PD=1.98U
M$244 \$2445 S4N \$2548 VDD|XN_OE|XP_OE|YN_OE|YP_OE|ZN_OE|ZP_OE pfet_06v0 L=1U
+ W=0.5U AS=0.22P AD=0.22P PS=1.88U PD=1.88U
M$245 \$4964 \$4946 \$4859 VDD|XN_OE|XP_OE|YN_OE|YP_OE|ZN_OE|ZP_OE pfet_06v0
+ L=1U W=10U AS=4.4P AD=4.4P PS=20.88U PD=20.88U
M$246 \$4954 \$4946 \$4858 VDD|XN_OE|XP_OE|YN_OE|YP_OE|ZN_OE|ZP_OE pfet_06v0
+ L=1U W=10U AS=4.4P AD=4.4P PS=20.88U PD=20.88U
M$247 \$2444 \$2550 VDD|XN_OE|XP_OE|YN_OE|YP_OE|ZN_OE|ZP_OE
+ VDD|XN_OE|XP_OE|YN_OE|YP_OE|ZN_OE|ZP_OE pfet_06v0 L=1U W=5U AS=2.2P AD=2.2P
+ PS=10.88U PD=10.88U
M$248 \$2443 \$2550 VDD|XN_OE|XP_OE|YN_OE|YP_OE|ZN_OE|ZP_OE
+ VDD|XN_OE|XP_OE|YN_OE|YP_OE|ZN_OE|ZP_OE pfet_06v0 L=1U W=5U AS=2.2P AD=2.2P
+ PS=10.88U PD=10.88U
M$249 \$2479 \$2447 \$2550 VDD|XN_OE|XP_OE|YN_OE|YP_OE|ZN_OE|ZP_OE pfet_06v0
+ L=1U W=4U AS=1.76P AD=1.76P PS=8.88U PD=8.88U
M$250 \$2446 \$2447 \$2533 VDD|XN_OE|XP_OE|YN_OE|YP_OE|ZN_OE|ZP_OE pfet_06v0
+ L=1U W=4U AS=1.76P AD=1.76P PS=8.88U PD=8.88U
M$251 \$7240 \$4936 VDD|XN_OE|XP_OE|YN_OE|YP_OE|ZN_OE|ZP_OE
+ VDD|XN_OE|XP_OE|YN_OE|YP_OE|ZN_OE|ZP_OE pfet_06v0 L=1U W=10U AS=4.4P AD=2.5P
+ PS=20.88U PD=10.5U
M$252 \$4936 \$4946 \$7240 VDD|XN_OE|XP_OE|YN_OE|YP_OE|ZN_OE|ZP_OE pfet_06v0
+ L=1U W=10U AS=2.5P AD=3.3P PS=10.5U PD=10.66U
M$253 \$4862 \$4862 \$4936 VDD|XN_OE|XP_OE|YN_OE|YP_OE|ZN_OE|ZP_OE pfet_06v0
+ L=1U W=10U AS=3.3P AD=4.4P PS=10.66U PD=20.88U
M$254 \$7241 \$4926 VDD|XN_OE|XP_OE|YN_OE|YP_OE|ZN_OE|ZP_OE
+ VDD|XN_OE|XP_OE|YN_OE|YP_OE|ZN_OE|ZP_OE pfet_06v0 L=1U W=10U AS=4.4P AD=2.5P
+ PS=20.88U PD=10.5U
M$255 \$4892 \$4946 \$7241 VDD|XN_OE|XP_OE|YN_OE|YP_OE|ZN_OE|ZP_OE pfet_06v0
+ L=1U W=10U AS=2.5P AD=4.4P PS=10.5U PD=20.88U
M$256 \$2449 \$2533 VDD|XN_OE|XP_OE|YN_OE|YP_OE|ZN_OE|ZP_OE
+ VDD|XN_OE|XP_OE|YN_OE|YP_OE|ZN_OE|ZP_OE pfet_06v0 L=1U W=1U AS=0.44P AD=0.44P
+ PS=2.88U PD=2.88U
M$257 \$2449 \$2533 VDD|XN_OE|XP_OE|YN_OE|YP_OE|ZN_OE|ZP_OE
+ VDD|XN_OE|XP_OE|YN_OE|YP_OE|ZN_OE|ZP_OE pfet_06v0 L=1U W=1U AS=0.44P AD=0.44P
+ PS=2.88U PD=2.88U
M$258 \$2449 \$2533 VDD|XN_OE|XP_OE|YN_OE|YP_OE|ZN_OE|ZP_OE
+ VDD|XN_OE|XP_OE|YN_OE|YP_OE|ZN_OE|ZP_OE pfet_06v0 L=1U W=1U AS=0.44P AD=0.44P
+ PS=2.88U PD=2.88U
M$259 \$2449 \$2533 VDD|XN_OE|XP_OE|YN_OE|YP_OE|ZN_OE|ZP_OE
+ VDD|XN_OE|XP_OE|YN_OE|YP_OE|ZN_OE|ZP_OE pfet_06v0 L=1U W=1U AS=0.44P AD=0.44P
+ PS=2.88U PD=2.88U
M$260 \$7243 \$4926 VDD|XN_OE|XP_OE|YN_OE|YP_OE|ZN_OE|ZP_OE
+ VDD|XN_OE|XP_OE|YN_OE|YP_OE|ZN_OE|ZP_OE pfet_06v0 L=1U W=10U AS=4.4P AD=2.5P
+ PS=20.88U PD=10.5U
M$261 \$4920 \$4946 \$7243 VDD|XN_OE|XP_OE|YN_OE|YP_OE|ZN_OE|ZP_OE pfet_06v0
+ L=1U W=10U AS=2.5P AD=4.4P PS=10.5U PD=20.88U
M$262 \$7245 \$4926 VDD|XN_OE|XP_OE|YN_OE|YP_OE|ZN_OE|ZP_OE
+ VDD|XN_OE|XP_OE|YN_OE|YP_OE|ZN_OE|ZP_OE pfet_06v0 L=1U W=10U AS=4.4P AD=2.5P
+ PS=20.88U PD=10.5U
M$263 \$4919 \$4946 \$7245 VDD|XN_OE|XP_OE|YN_OE|YP_OE|ZN_OE|ZP_OE pfet_06v0
+ L=1U W=10U AS=2.5P AD=4.4P PS=10.5U PD=20.88U
M$264 \$2532 \$2532 VDD|XN_OE|XP_OE|YN_OE|YP_OE|ZN_OE|ZP_OE
+ VDD|XN_OE|XP_OE|YN_OE|YP_OE|ZN_OE|ZP_OE pfet_06v0 L=1U W=2U AS=0.88P AD=0.88P
+ PS=4.88U PD=4.88U
M$265 \$7246 \$4926 VDD|XN_OE|XP_OE|YN_OE|YP_OE|ZN_OE|ZP_OE
+ VDD|XN_OE|XP_OE|YN_OE|YP_OE|ZN_OE|ZP_OE pfet_06v0 L=1U W=10U AS=4.4P AD=2.5P
+ PS=20.88U PD=10.5U
M$266 \$4926 \$4946 \$7246 VDD|XN_OE|XP_OE|YN_OE|YP_OE|ZN_OE|ZP_OE pfet_06v0
+ L=1U W=10U AS=2.5P AD=4.4P PS=10.5U PD=20.88U
M$267 VDD|XN_OE|XP_OE|YN_OE|YP_OE|ZN_OE|ZP_OE
+ VSS|XN_CS|XN_IE|XN_PD|XN_PDRV0|XN_PDRV1|XN_PU|XN_SL|XP_CS|XP_IE|XP_PD|XP_PDRV0|XP_PDRV1|XP_PU|XP_SL|YN_CS|YN_IE|YN_PD|YN_PDRV0|YN_PDRV1|YN_PU|YN_SL|YP_CS|YP_IE|YP_PD|YP_PDRV0|YP_PDRV1|YP_PU|YP_SL|ZN_CS|ZN_IE|ZN_PD|ZN_PDRV0|ZN_PDRV1|ZN_PU|ZN_SL|ZP_CS|ZP_IE|ZP_PD|ZP_PDRV0|ZP_PDRV1|ZP_PU|ZP_SL
+ VDD|XN_OE|XP_OE|YN_OE|YP_OE|ZN_OE|ZP_OE
+ VDD|XN_OE|XP_OE|YN_OE|YP_OE|ZN_OE|ZP_OE pfet_06v0 L=2U W=18U AS=7.92P
+ AD=7.92P PS=36.88U PD=36.88U
M$268 VDD|XN_OE|XP_OE|YN_OE|YP_OE|ZN_OE|ZP_OE
+ VSS|XN_CS|XN_IE|XN_PD|XN_PDRV0|XN_PDRV1|XN_PU|XN_SL|XP_CS|XP_IE|XP_PD|XP_PDRV0|XP_PDRV1|XP_PU|XP_SL|YN_CS|YN_IE|YN_PD|YN_PDRV0|YN_PDRV1|YN_PU|YN_SL|YP_CS|YP_IE|YP_PD|YP_PDRV0|YP_PDRV1|YP_PU|YP_SL|ZN_CS|ZN_IE|ZN_PD|ZN_PDRV0|ZN_PDRV1|ZN_PU|ZN_SL|ZP_CS|ZP_IE|ZP_PD|ZP_PDRV0|ZP_PDRV1|ZP_PU|ZP_SL
+ VDD|XN_OE|XP_OE|YN_OE|YP_OE|ZN_OE|ZP_OE
+ VDD|XN_OE|XP_OE|YN_OE|YP_OE|ZN_OE|ZP_OE pfet_06v0 L=2U W=18U AS=7.92P
+ AD=7.92P PS=36.88U PD=36.88U
M$269 \$7248 \$4927 VDD|XN_OE|XP_OE|YN_OE|YP_OE|ZN_OE|ZP_OE
+ VDD|XN_OE|XP_OE|YN_OE|YP_OE|ZN_OE|ZP_OE pfet_06v0 L=1U W=10U AS=4.4P AD=2.5P
+ PS=20.88U PD=10.5U
M$270 \$4965 \$4947 \$7248 VDD|XN_OE|XP_OE|YN_OE|YP_OE|ZN_OE|ZP_OE pfet_06v0
+ L=1U W=10U AS=2.5P AD=4.4P PS=10.5U PD=20.88U
M$271 \$7249 \$4927 VDD|XN_OE|XP_OE|YN_OE|YP_OE|ZN_OE|ZP_OE
+ VDD|XN_OE|XP_OE|YN_OE|YP_OE|ZN_OE|ZP_OE pfet_06v0 L=1U W=10U AS=4.4P AD=2.5P
+ PS=20.88U PD=10.5U
M$272 \$4965 \$4947 \$7249 VDD|XN_OE|XP_OE|YN_OE|YP_OE|ZN_OE|ZP_OE pfet_06v0
+ L=1U W=10U AS=2.5P AD=4.4P PS=10.5U PD=20.88U
M$273 \$2522 S4P \$2551 VDD|XN_OE|XP_OE|YN_OE|YP_OE|ZN_OE|ZP_OE pfet_06v0 L=1U
+ W=0.55U AS=0.242P AD=0.242P PS=1.98U PD=1.98U
M$274 \$2453 S4N \$2551 VDD|XN_OE|XP_OE|YN_OE|YP_OE|ZN_OE|ZP_OE pfet_06v0 L=1U
+ W=0.5U AS=0.22P AD=0.22P PS=1.88U PD=1.88U
M$275 \$4966 \$4947 \$4867 VDD|XN_OE|XP_OE|YN_OE|YP_OE|ZN_OE|ZP_OE pfet_06v0
+ L=1U W=10U AS=4.4P AD=4.4P PS=20.88U PD=20.88U
M$276 \$4957 \$4947 \$4866 VDD|XN_OE|XP_OE|YN_OE|YP_OE|ZN_OE|ZP_OE pfet_06v0
+ L=1U W=10U AS=4.4P AD=4.4P PS=20.88U PD=20.88U
M$277 \$2452 \$2552 VDD|XN_OE|XP_OE|YN_OE|YP_OE|ZN_OE|ZP_OE
+ VDD|XN_OE|XP_OE|YN_OE|YP_OE|ZN_OE|ZP_OE pfet_06v0 L=1U W=5U AS=2.2P AD=2.2P
+ PS=10.88U PD=10.88U
M$278 \$2451 \$2552 VDD|XN_OE|XP_OE|YN_OE|YP_OE|ZN_OE|ZP_OE
+ VDD|XN_OE|XP_OE|YN_OE|YP_OE|ZN_OE|ZP_OE pfet_06v0 L=1U W=5U AS=2.2P AD=2.2P
+ PS=10.88U PD=10.88U
M$279 \$2480 \$2455 \$2552 VDD|XN_OE|XP_OE|YN_OE|YP_OE|ZN_OE|ZP_OE pfet_06v0
+ L=1U W=4U AS=1.76P AD=1.76P PS=8.88U PD=8.88U
M$280 \$2454 \$2455 \$2535 VDD|XN_OE|XP_OE|YN_OE|YP_OE|ZN_OE|ZP_OE pfet_06v0
+ L=1U W=4U AS=1.76P AD=1.76P PS=8.88U PD=8.88U
M$281 \$7252 \$4940 VDD|XN_OE|XP_OE|YN_OE|YP_OE|ZN_OE|ZP_OE
+ VDD|XN_OE|XP_OE|YN_OE|YP_OE|ZN_OE|ZP_OE pfet_06v0 L=1U W=10U AS=4.4P AD=2.5P
+ PS=20.88U PD=10.5U
M$282 \$4940 \$4947 \$7252 VDD|XN_OE|XP_OE|YN_OE|YP_OE|ZN_OE|ZP_OE pfet_06v0
+ L=1U W=10U AS=2.5P AD=3.3P PS=10.5U PD=10.66U
M$283 \$4870 \$4870 \$4940 VDD|XN_OE|XP_OE|YN_OE|YP_OE|ZN_OE|ZP_OE pfet_06v0
+ L=1U W=10U AS=3.3P AD=4.4P PS=10.66U PD=20.88U
M$284 \$7253 \$4927 VDD|XN_OE|XP_OE|YN_OE|YP_OE|ZN_OE|ZP_OE
+ VDD|XN_OE|XP_OE|YN_OE|YP_OE|ZN_OE|ZP_OE pfet_06v0 L=1U W=10U AS=4.4P AD=2.5P
+ PS=20.88U PD=10.5U
M$285 \$4894 \$4947 \$7253 VDD|XN_OE|XP_OE|YN_OE|YP_OE|ZN_OE|ZP_OE pfet_06v0
+ L=1U W=10U AS=2.5P AD=4.4P PS=10.5U PD=20.88U
M$286 \$2457 \$2535 VDD|XN_OE|XP_OE|YN_OE|YP_OE|ZN_OE|ZP_OE
+ VDD|XN_OE|XP_OE|YN_OE|YP_OE|ZN_OE|ZP_OE pfet_06v0 L=1U W=1U AS=0.44P AD=0.44P
+ PS=2.88U PD=2.88U
M$287 \$2457 \$2535 VDD|XN_OE|XP_OE|YN_OE|YP_OE|ZN_OE|ZP_OE
+ VDD|XN_OE|XP_OE|YN_OE|YP_OE|ZN_OE|ZP_OE pfet_06v0 L=1U W=1U AS=0.44P AD=0.44P
+ PS=2.88U PD=2.88U
M$288 \$2457 \$2535 VDD|XN_OE|XP_OE|YN_OE|YP_OE|ZN_OE|ZP_OE
+ VDD|XN_OE|XP_OE|YN_OE|YP_OE|ZN_OE|ZP_OE pfet_06v0 L=1U W=1U AS=0.44P AD=0.44P
+ PS=2.88U PD=2.88U
M$289 \$2457 \$2535 VDD|XN_OE|XP_OE|YN_OE|YP_OE|ZN_OE|ZP_OE
+ VDD|XN_OE|XP_OE|YN_OE|YP_OE|ZN_OE|ZP_OE pfet_06v0 L=1U W=1U AS=0.44P AD=0.44P
+ PS=2.88U PD=2.88U
M$290 \$7251 \$4927 VDD|XN_OE|XP_OE|YN_OE|YP_OE|ZN_OE|ZP_OE
+ VDD|XN_OE|XP_OE|YN_OE|YP_OE|ZN_OE|ZP_OE pfet_06v0 L=1U W=10U AS=4.4P AD=2.5P
+ PS=20.88U PD=10.5U
M$291 \$4922 \$4947 \$7251 VDD|XN_OE|XP_OE|YN_OE|YP_OE|ZN_OE|ZP_OE pfet_06v0
+ L=1U W=10U AS=2.5P AD=4.4P PS=10.5U PD=20.88U
M$292 \$7250 \$4927 VDD|XN_OE|XP_OE|YN_OE|YP_OE|ZN_OE|ZP_OE
+ VDD|XN_OE|XP_OE|YN_OE|YP_OE|ZN_OE|ZP_OE pfet_06v0 L=1U W=10U AS=4.4P AD=2.5P
+ PS=20.88U PD=10.5U
M$293 \$4921 \$4947 \$7250 VDD|XN_OE|XP_OE|YN_OE|YP_OE|ZN_OE|ZP_OE pfet_06v0
+ L=1U W=10U AS=2.5P AD=4.4P PS=10.5U PD=20.88U
M$294 \$2534 \$2534 VDD|XN_OE|XP_OE|YN_OE|YP_OE|ZN_OE|ZP_OE
+ VDD|XN_OE|XP_OE|YN_OE|YP_OE|ZN_OE|ZP_OE pfet_06v0 L=1U W=2U AS=0.88P AD=0.88P
+ PS=4.88U PD=4.88U
M$295 \$7247 \$4927 VDD|XN_OE|XP_OE|YN_OE|YP_OE|ZN_OE|ZP_OE
+ VDD|XN_OE|XP_OE|YN_OE|YP_OE|ZN_OE|ZP_OE pfet_06v0 L=1U W=10U AS=4.4P AD=2.5P
+ PS=20.88U PD=10.5U
M$296 \$4927 \$4947 \$7247 VDD|XN_OE|XP_OE|YN_OE|YP_OE|ZN_OE|ZP_OE pfet_06v0
+ L=1U W=10U AS=2.5P AD=4.4P PS=10.5U PD=20.88U
M$297 VDD|XN_OE|XP_OE|YN_OE|YP_OE|ZN_OE|ZP_OE
+ VSS|XN_CS|XN_IE|XN_PD|XN_PDRV0|XN_PDRV1|XN_PU|XN_SL|XP_CS|XP_IE|XP_PD|XP_PDRV0|XP_PDRV1|XP_PU|XP_SL|YN_CS|YN_IE|YN_PD|YN_PDRV0|YN_PDRV1|YN_PU|YN_SL|YP_CS|YP_IE|YP_PD|YP_PDRV0|YP_PDRV1|YP_PU|YP_SL|ZN_CS|ZN_IE|ZN_PD|ZN_PDRV0|ZN_PDRV1|ZN_PU|ZN_SL|ZP_CS|ZP_IE|ZP_PD|ZP_PDRV0|ZP_PDRV1|ZP_PU|ZP_SL
+ VDD|XN_OE|XP_OE|YN_OE|YP_OE|ZN_OE|ZP_OE
+ VDD|XN_OE|XP_OE|YN_OE|YP_OE|ZN_OE|ZP_OE pfet_06v0 L=2U W=18U AS=7.92P
+ AD=7.92P PS=36.88U PD=36.88U
M$298 VDD|XN_OE|XP_OE|YN_OE|YP_OE|ZN_OE|ZP_OE
+ VSS|XN_CS|XN_IE|XN_PD|XN_PDRV0|XN_PDRV1|XN_PU|XN_SL|XP_CS|XP_IE|XP_PD|XP_PDRV0|XP_PDRV1|XP_PU|XP_SL|YN_CS|YN_IE|YN_PD|YN_PDRV0|YN_PDRV1|YN_PU|YN_SL|YP_CS|YP_IE|YP_PD|YP_PDRV0|YP_PDRV1|YP_PU|YP_SL|ZN_CS|ZN_IE|ZN_PD|ZN_PDRV0|ZN_PDRV1|ZN_PU|ZN_SL|ZP_CS|ZP_IE|ZP_PD|ZP_PDRV0|ZP_PDRV1|ZP_PU|ZP_SL
+ VDD|XN_OE|XP_OE|YN_OE|YP_OE|ZN_OE|ZP_OE
+ VDD|XN_OE|XP_OE|YN_OE|YP_OE|ZN_OE|ZP_OE pfet_06v0 L=2U W=18U AS=7.92P
+ AD=7.92P PS=36.88U PD=36.88U
M$299 \$7244 \$4928 VDD|XN_OE|XP_OE|YN_OE|YP_OE|ZN_OE|ZP_OE
+ VDD|XN_OE|XP_OE|YN_OE|YP_OE|ZN_OE|ZP_OE pfet_06v0 L=1U W=10U AS=4.4P AD=2.5P
+ PS=20.88U PD=10.5U
M$300 \$4967 \$4948 \$7244 VDD|XN_OE|XP_OE|YN_OE|YP_OE|ZN_OE|ZP_OE pfet_06v0
+ L=1U W=10U AS=2.5P AD=4.4P PS=10.5U PD=20.88U
M$301 \$7242 \$4928 VDD|XN_OE|XP_OE|YN_OE|YP_OE|ZN_OE|ZP_OE
+ VDD|XN_OE|XP_OE|YN_OE|YP_OE|ZN_OE|ZP_OE pfet_06v0 L=1U W=10U AS=4.4P AD=2.5P
+ PS=20.88U PD=10.5U
M$302 \$4967 \$4948 \$7242 VDD|XN_OE|XP_OE|YN_OE|YP_OE|ZN_OE|ZP_OE pfet_06v0
+ L=1U W=10U AS=2.5P AD=4.4P PS=10.5U PD=20.88U
M$303 \$2526 \$14436 \$2553 VDD|XN_OE|XP_OE|YN_OE|YP_OE|ZN_OE|ZP_OE pfet_06v0
+ L=1U W=0.55U AS=0.242P AD=0.242P PS=1.98U PD=1.98U
M$304 \$2461 \$14435 \$2553 VDD|XN_OE|XP_OE|YN_OE|YP_OE|ZN_OE|ZP_OE pfet_06v0
+ L=1U W=0.5U AS=0.22P AD=0.22P PS=1.88U PD=1.88U
M$305 \$4968 \$4948 \$4875 VDD|XN_OE|XP_OE|YN_OE|YP_OE|ZN_OE|ZP_OE pfet_06v0
+ L=1U W=10U AS=4.4P AD=4.4P PS=20.88U PD=20.88U
M$306 \$4960 \$4948 \$4874 VDD|XN_OE|XP_OE|YN_OE|YP_OE|ZN_OE|ZP_OE pfet_06v0
+ L=1U W=10U AS=4.4P AD=4.4P PS=20.88U PD=20.88U
M$307 \$2460 \$2554 VDD|XN_OE|XP_OE|YN_OE|YP_OE|ZN_OE|ZP_OE
+ VDD|XN_OE|XP_OE|YN_OE|YP_OE|ZN_OE|ZP_OE pfet_06v0 L=1U W=5U AS=2.2P AD=2.2P
+ PS=10.88U PD=10.88U
M$308 \$2459 \$2554 VDD|XN_OE|XP_OE|YN_OE|YP_OE|ZN_OE|ZP_OE
+ VDD|XN_OE|XP_OE|YN_OE|YP_OE|ZN_OE|ZP_OE pfet_06v0 L=1U W=5U AS=2.2P AD=2.2P
+ PS=10.88U PD=10.88U
M$309 \$2481 \$2463 \$2554 VDD|XN_OE|XP_OE|YN_OE|YP_OE|ZN_OE|ZP_OE pfet_06v0
+ L=1U W=4U AS=1.76P AD=1.76P PS=8.88U PD=8.88U
M$310 \$2462 \$2463 \$2537 VDD|XN_OE|XP_OE|YN_OE|YP_OE|ZN_OE|ZP_OE pfet_06v0
+ L=1U W=4U AS=1.76P AD=1.76P PS=8.88U PD=8.88U
M$311 \$7237 \$4944 VDD|XN_OE|XP_OE|YN_OE|YP_OE|ZN_OE|ZP_OE
+ VDD|XN_OE|XP_OE|YN_OE|YP_OE|ZN_OE|ZP_OE pfet_06v0 L=1U W=10U AS=4.4P AD=2.5P
+ PS=20.88U PD=10.5U
M$312 \$4944 \$4948 \$7237 VDD|XN_OE|XP_OE|YN_OE|YP_OE|ZN_OE|ZP_OE pfet_06v0
+ L=1U W=10U AS=2.5P AD=3.3P PS=10.5U PD=10.66U
M$313 \$4878 \$4878 \$4944 VDD|XN_OE|XP_OE|YN_OE|YP_OE|ZN_OE|ZP_OE pfet_06v0
+ L=1U W=10U AS=3.3P AD=4.4P PS=10.66U PD=20.88U
M$314 \$7234 \$4928 VDD|XN_OE|XP_OE|YN_OE|YP_OE|ZN_OE|ZP_OE
+ VDD|XN_OE|XP_OE|YN_OE|YP_OE|ZN_OE|ZP_OE pfet_06v0 L=1U W=10U AS=4.4P AD=2.5P
+ PS=20.88U PD=10.5U
M$315 \$4896 \$4948 \$7234 VDD|XN_OE|XP_OE|YN_OE|YP_OE|ZN_OE|ZP_OE pfet_06v0
+ L=1U W=10U AS=2.5P AD=4.4P PS=10.5U PD=20.88U
M$316 \$2465 \$2537 VDD|XN_OE|XP_OE|YN_OE|YP_OE|ZN_OE|ZP_OE
+ VDD|XN_OE|XP_OE|YN_OE|YP_OE|ZN_OE|ZP_OE pfet_06v0 L=1U W=1U AS=0.44P AD=0.44P
+ PS=2.88U PD=2.88U
M$317 \$2465 \$2537 VDD|XN_OE|XP_OE|YN_OE|YP_OE|ZN_OE|ZP_OE
+ VDD|XN_OE|XP_OE|YN_OE|YP_OE|ZN_OE|ZP_OE pfet_06v0 L=1U W=1U AS=0.44P AD=0.44P
+ PS=2.88U PD=2.88U
M$318 \$2465 \$2537 VDD|XN_OE|XP_OE|YN_OE|YP_OE|ZN_OE|ZP_OE
+ VDD|XN_OE|XP_OE|YN_OE|YP_OE|ZN_OE|ZP_OE pfet_06v0 L=1U W=1U AS=0.44P AD=0.44P
+ PS=2.88U PD=2.88U
M$319 \$2465 \$2537 VDD|XN_OE|XP_OE|YN_OE|YP_OE|ZN_OE|ZP_OE
+ VDD|XN_OE|XP_OE|YN_OE|YP_OE|ZN_OE|ZP_OE pfet_06v0 L=1U W=1U AS=0.44P AD=0.44P
+ PS=2.88U PD=2.88U
M$320 \$7230 \$4928 VDD|XN_OE|XP_OE|YN_OE|YP_OE|ZN_OE|ZP_OE
+ VDD|XN_OE|XP_OE|YN_OE|YP_OE|ZN_OE|ZP_OE pfet_06v0 L=1U W=10U AS=4.4P AD=2.5P
+ PS=20.88U PD=10.5U
M$321 \$4924 \$4948 \$7230 VDD|XN_OE|XP_OE|YN_OE|YP_OE|ZN_OE|ZP_OE pfet_06v0
+ L=1U W=10U AS=2.5P AD=4.4P PS=10.5U PD=20.88U
M$322 \$7229 \$4928 VDD|XN_OE|XP_OE|YN_OE|YP_OE|ZN_OE|ZP_OE
+ VDD|XN_OE|XP_OE|YN_OE|YP_OE|ZN_OE|ZP_OE pfet_06v0 L=1U W=10U AS=4.4P AD=2.5P
+ PS=20.88U PD=10.5U
M$323 \$4923 \$4948 \$7229 VDD|XN_OE|XP_OE|YN_OE|YP_OE|ZN_OE|ZP_OE pfet_06v0
+ L=1U W=10U AS=2.5P AD=4.4P PS=10.5U PD=20.88U
M$324 \$2536 \$2536 VDD|XN_OE|XP_OE|YN_OE|YP_OE|ZN_OE|ZP_OE
+ VDD|XN_OE|XP_OE|YN_OE|YP_OE|ZN_OE|ZP_OE pfet_06v0 L=1U W=2U AS=0.88P AD=0.88P
+ PS=4.88U PD=4.88U
M$325 \$7226 \$4928 VDD|XN_OE|XP_OE|YN_OE|YP_OE|ZN_OE|ZP_OE
+ VDD|XN_OE|XP_OE|YN_OE|YP_OE|ZN_OE|ZP_OE pfet_06v0 L=1U W=10U AS=4.4P AD=2.5P
+ PS=20.88U PD=10.5U
M$326 \$4928 \$4948 \$7226 VDD|XN_OE|XP_OE|YN_OE|YP_OE|ZN_OE|ZP_OE pfet_06v0
+ L=1U W=10U AS=2.5P AD=4.4P PS=10.5U PD=20.88U
M$327 VDD|XN_OE|XP_OE|YN_OE|YP_OE|ZN_OE|ZP_OE
+ VSS|XN_CS|XN_IE|XN_PD|XN_PDRV0|XN_PDRV1|XN_PU|XN_SL|XP_CS|XP_IE|XP_PD|XP_PDRV0|XP_PDRV1|XP_PU|XP_SL|YN_CS|YN_IE|YN_PD|YN_PDRV0|YN_PDRV1|YN_PU|YN_SL|YP_CS|YP_IE|YP_PD|YP_PDRV0|YP_PDRV1|YP_PU|YP_SL|ZN_CS|ZN_IE|ZN_PD|ZN_PDRV0|ZN_PDRV1|ZN_PU|ZN_SL|ZP_CS|ZP_IE|ZP_PD|ZP_PDRV0|ZP_PDRV1|ZP_PU|ZP_SL
+ VDD|XN_OE|XP_OE|YN_OE|YP_OE|ZN_OE|ZP_OE
+ VDD|XN_OE|XP_OE|YN_OE|YP_OE|ZN_OE|ZP_OE pfet_06v0 L=2U W=18U AS=7.92P
+ AD=7.92P PS=36.88U PD=36.88U
M$328 VDD|XN_OE|XP_OE|YN_OE|YP_OE|ZN_OE|ZP_OE
+ VSS|XN_CS|XN_IE|XN_PD|XN_PDRV0|XN_PDRV1|XN_PU|XN_SL|XP_CS|XP_IE|XP_PD|XP_PDRV0|XP_PDRV1|XP_PU|XP_SL|YN_CS|YN_IE|YN_PD|YN_PDRV0|YN_PDRV1|YN_PU|YN_SL|YP_CS|YP_IE|YP_PD|YP_PDRV0|YP_PDRV1|YP_PU|YP_SL|ZN_CS|ZN_IE|ZN_PD|ZN_PDRV0|ZN_PDRV1|ZN_PU|ZN_SL|ZP_CS|ZP_IE|ZP_PD|ZP_PDRV0|ZP_PDRV1|ZP_PU|ZP_SL
+ VDD|XN_OE|XP_OE|YN_OE|YP_OE|ZN_OE|ZP_OE
+ VDD|XN_OE|XP_OE|YN_OE|YP_OE|ZN_OE|ZP_OE pfet_06v0 L=2U W=18U AS=7.92P
+ AD=7.92P PS=36.88U PD=36.88U
M$329 VDD|XN_OE|XP_OE|YN_OE|YP_OE|ZN_OE|ZP_OE
+ VSS|XN_CS|XN_IE|XN_PD|XN_PDRV0|XN_PDRV1|XN_PU|XN_SL|XP_CS|XP_IE|XP_PD|XP_PDRV0|XP_PDRV1|XP_PU|XP_SL|YN_CS|YN_IE|YN_PD|YN_PDRV0|YN_PDRV1|YN_PU|YN_SL|YP_CS|YP_IE|YP_PD|YP_PDRV0|YP_PDRV1|YP_PU|YP_SL|ZN_CS|ZN_IE|ZN_PD|ZN_PDRV0|ZN_PDRV1|ZN_PU|ZN_SL|ZP_CS|ZP_IE|ZP_PD|ZP_PDRV0|ZP_PDRV1|ZP_PU|ZP_SL
+ VDD|XN_OE|XP_OE|YN_OE|YP_OE|ZN_OE|ZP_OE
+ VDD|XN_OE|XP_OE|YN_OE|YP_OE|ZN_OE|ZP_OE pfet_06v0 L=2U W=9.75U AS=4.29P
+ AD=4.29P PS=20.38U PD=20.38U
M$330 \$4929 \$14437 \$4961 VDD|XN_OE|XP_OE|YN_OE|YP_OE|ZN_OE|ZP_OE pfet_06v0
+ L=1U W=0.55U AS=0.242P AD=0.242P PS=1.98U PD=1.98U
M$331 \$4852 \$14438 \$4961 VDD|XN_OE|XP_OE|YN_OE|YP_OE|ZN_OE|ZP_OE pfet_06v0
+ L=1U W=0.5U AS=0.22P AD=0.22P PS=1.88U PD=1.88U
M$332 \$4851 \$4962 VDD|XN_OE|XP_OE|YN_OE|YP_OE|ZN_OE|ZP_OE
+ VDD|XN_OE|XP_OE|YN_OE|YP_OE|ZN_OE|ZP_OE pfet_06v0 L=1U W=5U AS=2.2P AD=2.2P
+ PS=10.88U PD=10.88U
M$333 \$7284 \$30 \$7363 VDD|XN_OE|XP_OE|YN_OE|YP_OE|ZN_OE|ZP_OE pfet_06v0 L=1U
+ W=10U AS=4.4P AD=2.6P PS=20.88U PD=10.52U
M$334 \$7363 \$30 \$7284 VDD|XN_OE|XP_OE|YN_OE|YP_OE|ZN_OE|ZP_OE pfet_06v0 L=1U
+ W=10U AS=2.6P AD=4.4P PS=10.52U PD=20.88U
M$335 \$4850 \$4962 VDD|XN_OE|XP_OE|YN_OE|YP_OE|ZN_OE|ZP_OE
+ VDD|XN_OE|XP_OE|YN_OE|YP_OE|ZN_OE|ZP_OE pfet_06v0 L=1U W=5U AS=2.2P AD=2.2P
+ PS=10.88U PD=10.88U
M$336 \$7282 \$46 \$7363 VDD|XN_OE|XP_OE|YN_OE|YP_OE|ZN_OE|ZP_OE pfet_06v0 L=1U
+ W=10U AS=4.4P AD=2.6P PS=20.88U PD=10.52U
M$337 \$7363 \$46 \$7282 VDD|XN_OE|XP_OE|YN_OE|YP_OE|ZN_OE|ZP_OE pfet_06v0 L=1U
+ W=10U AS=2.6P AD=4.4P PS=10.52U PD=20.88U
M$338 \$4889 \$4854 \$4962 VDD|XN_OE|XP_OE|YN_OE|YP_OE|ZN_OE|ZP_OE pfet_06v0
+ L=1U W=4U AS=1.76P AD=1.76P PS=8.88U PD=8.88U
M$339 \$4853 \$4854 \$4951 VDD|XN_OE|XP_OE|YN_OE|YP_OE|ZN_OE|ZP_OE pfet_06v0
+ L=1U W=4U AS=1.76P AD=1.76P PS=8.88U PD=8.88U
M$340 \$4856 \$4951 VDD|XN_OE|XP_OE|YN_OE|YP_OE|ZN_OE|ZP_OE
+ VDD|XN_OE|XP_OE|YN_OE|YP_OE|ZN_OE|ZP_OE pfet_06v0 L=1U W=1U AS=0.44P AD=0.44P
+ PS=2.88U PD=2.88U
M$341 \$4856 \$4951 VDD|XN_OE|XP_OE|YN_OE|YP_OE|ZN_OE|ZP_OE
+ VDD|XN_OE|XP_OE|YN_OE|YP_OE|ZN_OE|ZP_OE pfet_06v0 L=1U W=1U AS=0.44P AD=0.44P
+ PS=2.88U PD=2.88U
M$342 \$4856 \$4951 VDD|XN_OE|XP_OE|YN_OE|YP_OE|ZN_OE|ZP_OE
+ VDD|XN_OE|XP_OE|YN_OE|YP_OE|ZN_OE|ZP_OE pfet_06v0 L=1U W=1U AS=0.44P AD=0.44P
+ PS=2.88U PD=2.88U
M$343 \$4856 \$4951 VDD|XN_OE|XP_OE|YN_OE|YP_OE|ZN_OE|ZP_OE
+ VDD|XN_OE|XP_OE|YN_OE|YP_OE|ZN_OE|ZP_OE pfet_06v0 L=1U W=1U AS=0.44P AD=0.44P
+ PS=2.88U PD=2.88U
M$344 \$4945 \$4945 VDD|XN_OE|XP_OE|YN_OE|YP_OE|ZN_OE|ZP_OE
+ VDD|XN_OE|XP_OE|YN_OE|YP_OE|ZN_OE|ZP_OE pfet_06v0 L=1U W=2U AS=0.88P AD=0.88P
+ PS=4.88U PD=4.88U
M$345 \$7286 \$7264 VDD|XN_OE|XP_OE|YN_OE|YP_OE|ZN_OE|ZP_OE
+ VDD|XN_OE|XP_OE|YN_OE|YP_OE|ZN_OE|ZP_OE pfet_06v0 L=1U W=10U AS=4.4P AD=2.6P
+ PS=20.88U PD=10.52U
M$346 VDD|XN_OE|XP_OE|YN_OE|YP_OE|ZN_OE|ZP_OE \$7264 \$7286
+ VDD|XN_OE|XP_OE|YN_OE|YP_OE|ZN_OE|ZP_OE pfet_06v0 L=1U W=10U AS=2.6P AD=2.6P
+ PS=10.52U PD=10.52U
M$347 \$7286 \$7264 VDD|XN_OE|XP_OE|YN_OE|YP_OE|ZN_OE|ZP_OE
+ VDD|XN_OE|XP_OE|YN_OE|YP_OE|ZN_OE|ZP_OE pfet_06v0 L=1U W=10U AS=2.6P AD=4.4P
+ PS=10.52U PD=20.88U
M$348 VDD|XN_OE|XP_OE|YN_OE|YP_OE|ZN_OE|ZP_OE
+ VSS|XN_CS|XN_IE|XN_PD|XN_PDRV0|XN_PDRV1|XN_PU|XN_SL|XP_CS|XP_IE|XP_PD|XP_PDRV0|XP_PDRV1|XP_PU|XP_SL|YN_CS|YN_IE|YN_PD|YN_PDRV0|YN_PDRV1|YN_PU|YN_SL|YP_CS|YP_IE|YP_PD|YP_PDRV0|YP_PDRV1|YP_PU|YP_SL|ZN_CS|ZN_IE|ZN_PD|ZN_PDRV0|ZN_PDRV1|ZN_PU|ZN_SL|ZP_CS|ZP_IE|ZP_PD|ZP_PDRV0|ZP_PDRV1|ZP_PU|ZP_SL
+ VDD|XN_OE|XP_OE|YN_OE|YP_OE|ZN_OE|ZP_OE
+ VDD|XN_OE|XP_OE|YN_OE|YP_OE|ZN_OE|ZP_OE pfet_06v0 L=2U W=9.75U AS=4.29P
+ AD=4.29P PS=20.38U PD=20.38U
M$349 VDD|XN_OE|XP_OE|YN_OE|YP_OE|ZN_OE|ZP_OE
+ VSS|XN_CS|XN_IE|XN_PD|XN_PDRV0|XN_PDRV1|XN_PU|XN_SL|XP_CS|XP_IE|XP_PD|XP_PDRV0|XP_PDRV1|XP_PU|XP_SL|YN_CS|YN_IE|YN_PD|YN_PDRV0|YN_PDRV1|YN_PU|YN_SL|YP_CS|YP_IE|YP_PD|YP_PDRV0|YP_PDRV1|YP_PU|YP_SL|ZN_CS|ZN_IE|ZN_PD|ZN_PDRV0|ZN_PDRV1|ZN_PU|ZN_SL|ZP_CS|ZP_IE|ZP_PD|ZP_PDRV0|ZP_PDRV1|ZP_PU|ZP_SL
+ VDD|XN_OE|XP_OE|YN_OE|YP_OE|ZN_OE|ZP_OE
+ VDD|XN_OE|XP_OE|YN_OE|YP_OE|ZN_OE|ZP_OE pfet_06v0 L=2U W=9.75U AS=4.29P
+ AD=4.29P PS=20.38U PD=20.38U
M$350 \$4933 \$14437 \$4963 VDD|XN_OE|XP_OE|YN_OE|YP_OE|ZN_OE|ZP_OE pfet_06v0
+ L=1U W=0.55U AS=0.242P AD=0.242P PS=1.98U PD=1.98U
M$351 \$4860 \$14438 \$4963 VDD|XN_OE|XP_OE|YN_OE|YP_OE|ZN_OE|ZP_OE pfet_06v0
+ L=1U W=0.5U AS=0.22P AD=0.22P PS=1.88U PD=1.88U
M$352 \$4859 \$4964 VDD|XN_OE|XP_OE|YN_OE|YP_OE|ZN_OE|ZP_OE
+ VDD|XN_OE|XP_OE|YN_OE|YP_OE|ZN_OE|ZP_OE pfet_06v0 L=1U W=5U AS=2.2P AD=2.2P
+ PS=10.88U PD=10.88U
M$353 \$4858 \$4964 VDD|XN_OE|XP_OE|YN_OE|YP_OE|ZN_OE|ZP_OE
+ VDD|XN_OE|XP_OE|YN_OE|YP_OE|ZN_OE|ZP_OE pfet_06v0 L=1U W=5U AS=2.2P AD=2.2P
+ PS=10.88U PD=10.88U
M$354 \$7293 \$38 \$7365 VDD|XN_OE|XP_OE|YN_OE|YP_OE|ZN_OE|ZP_OE pfet_06v0 L=1U
+ W=10U AS=4.4P AD=2.6P PS=20.88U PD=10.52U
M$355 \$7365 \$38 \$7293 VDD|XN_OE|XP_OE|YN_OE|YP_OE|ZN_OE|ZP_OE pfet_06v0 L=1U
+ W=10U AS=2.6P AD=4.4P PS=10.52U PD=20.88U
M$356 \$4891 \$4862 \$4964 VDD|XN_OE|XP_OE|YN_OE|YP_OE|ZN_OE|ZP_OE pfet_06v0
+ L=1U W=4U AS=1.76P AD=1.76P PS=8.88U PD=8.88U
M$357 \$7291 \$46 \$7365 VDD|XN_OE|XP_OE|YN_OE|YP_OE|ZN_OE|ZP_OE pfet_06v0 L=1U
+ W=10U AS=4.4P AD=2.6P PS=20.88U PD=10.52U
M$358 \$7365 \$46 \$7291 VDD|XN_OE|XP_OE|YN_OE|YP_OE|ZN_OE|ZP_OE pfet_06v0 L=1U
+ W=10U AS=2.6P AD=4.4P PS=10.52U PD=20.88U
M$359 \$4861 \$4862 \$4954 VDD|XN_OE|XP_OE|YN_OE|YP_OE|ZN_OE|ZP_OE pfet_06v0
+ L=1U W=4U AS=1.76P AD=1.76P PS=8.88U PD=8.88U
M$360 \$4864 \$4954 VDD|XN_OE|XP_OE|YN_OE|YP_OE|ZN_OE|ZP_OE
+ VDD|XN_OE|XP_OE|YN_OE|YP_OE|ZN_OE|ZP_OE pfet_06v0 L=1U W=1U AS=0.44P AD=0.44P
+ PS=2.88U PD=2.88U
M$361 \$4864 \$4954 VDD|XN_OE|XP_OE|YN_OE|YP_OE|ZN_OE|ZP_OE
+ VDD|XN_OE|XP_OE|YN_OE|YP_OE|ZN_OE|ZP_OE pfet_06v0 L=1U W=1U AS=0.44P AD=0.44P
+ PS=2.88U PD=2.88U
M$362 \$4864 \$4954 VDD|XN_OE|XP_OE|YN_OE|YP_OE|ZN_OE|ZP_OE
+ VDD|XN_OE|XP_OE|YN_OE|YP_OE|ZN_OE|ZP_OE pfet_06v0 L=1U W=1U AS=0.44P AD=0.44P
+ PS=2.88U PD=2.88U
M$363 \$4864 \$4954 VDD|XN_OE|XP_OE|YN_OE|YP_OE|ZN_OE|ZP_OE
+ VDD|XN_OE|XP_OE|YN_OE|YP_OE|ZN_OE|ZP_OE pfet_06v0 L=1U W=1U AS=0.44P AD=0.44P
+ PS=2.88U PD=2.88U
M$364 \$4946 \$4946 VDD|XN_OE|XP_OE|YN_OE|YP_OE|ZN_OE|ZP_OE
+ VDD|XN_OE|XP_OE|YN_OE|YP_OE|ZN_OE|ZP_OE pfet_06v0 L=1U W=2U AS=0.88P AD=0.88P
+ PS=4.88U PD=4.88U
M$365 \$7295 \$7268 VDD|XN_OE|XP_OE|YN_OE|YP_OE|ZN_OE|ZP_OE
+ VDD|XN_OE|XP_OE|YN_OE|YP_OE|ZN_OE|ZP_OE pfet_06v0 L=1U W=10U AS=4.4P AD=2.6P
+ PS=20.88U PD=10.52U
M$366 VDD|XN_OE|XP_OE|YN_OE|YP_OE|ZN_OE|ZP_OE \$7268 \$7295
+ VDD|XN_OE|XP_OE|YN_OE|YP_OE|ZN_OE|ZP_OE pfet_06v0 L=1U W=10U AS=2.6P AD=2.6P
+ PS=10.52U PD=10.52U
M$367 \$7295 \$7268 VDD|XN_OE|XP_OE|YN_OE|YP_OE|ZN_OE|ZP_OE
+ VDD|XN_OE|XP_OE|YN_OE|YP_OE|ZN_OE|ZP_OE pfet_06v0 L=1U W=10U AS=2.6P AD=4.4P
+ PS=10.52U PD=20.88U
M$368 VDD|XN_OE|XP_OE|YN_OE|YP_OE|ZN_OE|ZP_OE
+ VSS|XN_CS|XN_IE|XN_PD|XN_PDRV0|XN_PDRV1|XN_PU|XN_SL|XP_CS|XP_IE|XP_PD|XP_PDRV0|XP_PDRV1|XP_PU|XP_SL|YN_CS|YN_IE|YN_PD|YN_PDRV0|YN_PDRV1|YN_PU|YN_SL|YP_CS|YP_IE|YP_PD|YP_PDRV0|YP_PDRV1|YP_PU|YP_SL|ZN_CS|ZN_IE|ZN_PD|ZN_PDRV0|ZN_PDRV1|ZN_PU|ZN_SL|ZP_CS|ZP_IE|ZP_PD|ZP_PDRV0|ZP_PDRV1|ZP_PU|ZP_SL
+ VDD|XN_OE|XP_OE|YN_OE|YP_OE|ZN_OE|ZP_OE
+ VDD|XN_OE|XP_OE|YN_OE|YP_OE|ZN_OE|ZP_OE pfet_06v0 L=2U W=9.75U AS=4.29P
+ AD=4.29P PS=20.38U PD=20.38U
M$369 VDD|XN_OE|XP_OE|YN_OE|YP_OE|ZN_OE|ZP_OE
+ VSS|XN_CS|XN_IE|XN_PD|XN_PDRV0|XN_PDRV1|XN_PU|XN_SL|XP_CS|XP_IE|XP_PD|XP_PDRV0|XP_PDRV1|XP_PU|XP_SL|YN_CS|YN_IE|YN_PD|YN_PDRV0|YN_PDRV1|YN_PU|YN_SL|YP_CS|YP_IE|YP_PD|YP_PDRV0|YP_PDRV1|YP_PU|YP_SL|ZN_CS|ZN_IE|ZN_PD|ZN_PDRV0|ZN_PDRV1|ZN_PU|ZN_SL|ZP_CS|ZP_IE|ZP_PD|ZP_PDRV0|ZP_PDRV1|ZP_PU|ZP_SL
+ VDD|XN_OE|XP_OE|YN_OE|YP_OE|ZN_OE|ZP_OE
+ VDD|XN_OE|XP_OE|YN_OE|YP_OE|ZN_OE|ZP_OE pfet_06v0 L=2U W=9.75U AS=4.29P
+ AD=4.29P PS=20.38U PD=20.38U
M$370 \$4937 S4P \$4965 VDD|XN_OE|XP_OE|YN_OE|YP_OE|ZN_OE|ZP_OE pfet_06v0 L=1U
+ W=0.55U AS=0.242P AD=0.242P PS=1.98U PD=1.98U
M$371 \$4868 S4N \$4965 VDD|XN_OE|XP_OE|YN_OE|YP_OE|ZN_OE|ZP_OE pfet_06v0 L=1U
+ W=0.5U AS=0.22P AD=0.22P PS=1.88U PD=1.88U
M$372 \$4867 \$4966 VDD|XN_OE|XP_OE|YN_OE|YP_OE|ZN_OE|ZP_OE
+ VDD|XN_OE|XP_OE|YN_OE|YP_OE|ZN_OE|ZP_OE pfet_06v0 L=1U W=5U AS=2.2P AD=2.2P
+ PS=10.88U PD=10.88U
M$373 \$4866 \$4966 VDD|XN_OE|XP_OE|YN_OE|YP_OE|ZN_OE|ZP_OE
+ VDD|XN_OE|XP_OE|YN_OE|YP_OE|ZN_OE|ZP_OE pfet_06v0 L=1U W=5U AS=2.2P AD=2.2P
+ PS=10.88U PD=10.88U
M$374 \$4893 \$4870 \$4966 VDD|XN_OE|XP_OE|YN_OE|YP_OE|ZN_OE|ZP_OE pfet_06v0
+ L=1U W=4U AS=1.76P AD=1.76P PS=8.88U PD=8.88U
M$375 \$7302 \$38 \$7367 VDD|XN_OE|XP_OE|YN_OE|YP_OE|ZN_OE|ZP_OE pfet_06v0 L=1U
+ W=10U AS=4.4P AD=2.6P PS=20.88U PD=10.52U
M$376 \$7367 \$38 \$7302 VDD|XN_OE|XP_OE|YN_OE|YP_OE|ZN_OE|ZP_OE pfet_06v0 L=1U
+ W=10U AS=2.6P AD=4.4P PS=10.52U PD=20.88U
M$377 \$4869 \$4870 \$4957 VDD|XN_OE|XP_OE|YN_OE|YP_OE|ZN_OE|ZP_OE pfet_06v0
+ L=1U W=4U AS=1.76P AD=1.76P PS=8.88U PD=8.88U
M$378 \$7300 \$30 \$7367 VDD|XN_OE|XP_OE|YN_OE|YP_OE|ZN_OE|ZP_OE pfet_06v0 L=1U
+ W=10U AS=4.4P AD=2.6P PS=20.88U PD=10.52U
M$379 \$7367 \$30 \$7300 VDD|XN_OE|XP_OE|YN_OE|YP_OE|ZN_OE|ZP_OE pfet_06v0 L=1U
+ W=10U AS=2.6P AD=4.4P PS=10.52U PD=20.88U
M$380 \$4872 \$4957 VDD|XN_OE|XP_OE|YN_OE|YP_OE|ZN_OE|ZP_OE
+ VDD|XN_OE|XP_OE|YN_OE|YP_OE|ZN_OE|ZP_OE pfet_06v0 L=1U W=1U AS=0.44P AD=0.44P
+ PS=2.88U PD=2.88U
M$381 \$4872 \$4957 VDD|XN_OE|XP_OE|YN_OE|YP_OE|ZN_OE|ZP_OE
+ VDD|XN_OE|XP_OE|YN_OE|YP_OE|ZN_OE|ZP_OE pfet_06v0 L=1U W=1U AS=0.44P AD=0.44P
+ PS=2.88U PD=2.88U
M$382 \$4872 \$4957 VDD|XN_OE|XP_OE|YN_OE|YP_OE|ZN_OE|ZP_OE
+ VDD|XN_OE|XP_OE|YN_OE|YP_OE|ZN_OE|ZP_OE pfet_06v0 L=1U W=1U AS=0.44P AD=0.44P
+ PS=2.88U PD=2.88U
M$383 \$4872 \$4957 VDD|XN_OE|XP_OE|YN_OE|YP_OE|ZN_OE|ZP_OE
+ VDD|XN_OE|XP_OE|YN_OE|YP_OE|ZN_OE|ZP_OE pfet_06v0 L=1U W=1U AS=0.44P AD=0.44P
+ PS=2.88U PD=2.88U
M$384 \$4947 \$4947 VDD|XN_OE|XP_OE|YN_OE|YP_OE|ZN_OE|ZP_OE
+ VDD|XN_OE|XP_OE|YN_OE|YP_OE|ZN_OE|ZP_OE pfet_06v0 L=1U W=2U AS=0.88P AD=0.88P
+ PS=4.88U PD=4.88U
M$385 \$7304 \$7272 VDD|XN_OE|XP_OE|YN_OE|YP_OE|ZN_OE|ZP_OE
+ VDD|XN_OE|XP_OE|YN_OE|YP_OE|ZN_OE|ZP_OE pfet_06v0 L=1U W=10U AS=4.4P AD=2.6P
+ PS=20.88U PD=10.52U
M$386 VDD|XN_OE|XP_OE|YN_OE|YP_OE|ZN_OE|ZP_OE \$7272 \$7304
+ VDD|XN_OE|XP_OE|YN_OE|YP_OE|ZN_OE|ZP_OE pfet_06v0 L=1U W=10U AS=2.6P AD=2.6P
+ PS=10.52U PD=10.52U
M$387 \$7304 \$7272 VDD|XN_OE|XP_OE|YN_OE|YP_OE|ZN_OE|ZP_OE
+ VDD|XN_OE|XP_OE|YN_OE|YP_OE|ZN_OE|ZP_OE pfet_06v0 L=1U W=10U AS=2.6P AD=4.4P
+ PS=10.52U PD=20.88U
M$388 VDD|XN_OE|XP_OE|YN_OE|YP_OE|ZN_OE|ZP_OE
+ VSS|XN_CS|XN_IE|XN_PD|XN_PDRV0|XN_PDRV1|XN_PU|XN_SL|XP_CS|XP_IE|XP_PD|XP_PDRV0|XP_PDRV1|XP_PU|XP_SL|YN_CS|YN_IE|YN_PD|YN_PDRV0|YN_PDRV1|YN_PU|YN_SL|YP_CS|YP_IE|YP_PD|YP_PDRV0|YP_PDRV1|YP_PU|YP_SL|ZN_CS|ZN_IE|ZN_PD|ZN_PDRV0|ZN_PDRV1|ZN_PU|ZN_SL|ZP_CS|ZP_IE|ZP_PD|ZP_PDRV0|ZP_PDRV1|ZP_PU|ZP_SL
+ VDD|XN_OE|XP_OE|YN_OE|YP_OE|ZN_OE|ZP_OE
+ VDD|XN_OE|XP_OE|YN_OE|YP_OE|ZN_OE|ZP_OE pfet_06v0 L=2U W=9.75U AS=4.29P
+ AD=4.29P PS=20.38U PD=20.38U
M$389 VDD|XN_OE|XP_OE|YN_OE|YP_OE|ZN_OE|ZP_OE
+ VSS|XN_CS|XN_IE|XN_PD|XN_PDRV0|XN_PDRV1|XN_PU|XN_SL|XP_CS|XP_IE|XP_PD|XP_PDRV0|XP_PDRV1|XP_PU|XP_SL|YN_CS|YN_IE|YN_PD|YN_PDRV0|YN_PDRV1|YN_PU|YN_SL|YP_CS|YP_IE|YP_PD|YP_PDRV0|YP_PDRV1|YP_PU|YP_SL|ZN_CS|ZN_IE|ZN_PD|ZN_PDRV0|ZN_PDRV1|ZN_PU|ZN_SL|ZP_CS|ZP_IE|ZP_PD|ZP_PDRV0|ZP_PDRV1|ZP_PU|ZP_SL
+ VDD|XN_OE|XP_OE|YN_OE|YP_OE|ZN_OE|ZP_OE
+ VDD|XN_OE|XP_OE|YN_OE|YP_OE|ZN_OE|ZP_OE pfet_06v0 L=2U W=9.75U AS=4.29P
+ AD=4.29P PS=20.38U PD=20.38U
M$390 \$4941 \$14440 \$4967 VDD|XN_OE|XP_OE|YN_OE|YP_OE|ZN_OE|ZP_OE pfet_06v0
+ L=1U W=0.55U AS=0.242P AD=0.242P PS=1.98U PD=1.98U
M$391 \$4876 \$14439 \$4967 VDD|XN_OE|XP_OE|YN_OE|YP_OE|ZN_OE|ZP_OE pfet_06v0
+ L=1U W=0.5U AS=0.22P AD=0.22P PS=1.88U PD=1.88U
M$392 \$4875 \$4968 VDD|XN_OE|XP_OE|YN_OE|YP_OE|ZN_OE|ZP_OE
+ VDD|XN_OE|XP_OE|YN_OE|YP_OE|ZN_OE|ZP_OE pfet_06v0 L=1U W=5U AS=2.2P AD=2.2P
+ PS=10.88U PD=10.88U
M$393 \$4874 \$4968 VDD|XN_OE|XP_OE|YN_OE|YP_OE|ZN_OE|ZP_OE
+ VDD|XN_OE|XP_OE|YN_OE|YP_OE|ZN_OE|ZP_OE pfet_06v0 L=1U W=5U AS=2.2P AD=2.2P
+ PS=10.88U PD=10.88U
M$394 \$4895 \$4878 \$4968 VDD|XN_OE|XP_OE|YN_OE|YP_OE|ZN_OE|ZP_OE pfet_06v0
+ L=1U W=4U AS=1.76P AD=1.76P PS=8.88U PD=8.88U
M$395 \$4877 \$4878 \$4960 VDD|XN_OE|XP_OE|YN_OE|YP_OE|ZN_OE|ZP_OE pfet_06v0
+ L=1U W=4U AS=1.76P AD=1.76P PS=8.88U PD=8.88U
M$396 \$4880 \$4960 VDD|XN_OE|XP_OE|YN_OE|YP_OE|ZN_OE|ZP_OE
+ VDD|XN_OE|XP_OE|YN_OE|YP_OE|ZN_OE|ZP_OE pfet_06v0 L=1U W=1U AS=0.44P AD=0.44P
+ PS=2.88U PD=2.88U
M$397 VDD|XN_OE|XP_OE|YN_OE|YP_OE|ZN_OE|ZP_OE
+ VSS|XN_CS|XN_IE|XN_PD|XN_PDRV0|XN_PDRV1|XN_PU|XN_SL|XP_CS|XP_IE|XP_PD|XP_PDRV0|XP_PDRV1|XP_PU|XP_SL|YN_CS|YN_IE|YN_PD|YN_PDRV0|YN_PDRV1|YN_PU|YN_SL|YP_CS|YP_IE|YP_PD|YP_PDRV0|YP_PDRV1|YP_PU|YP_SL|ZN_CS|ZN_IE|ZN_PD|ZN_PDRV0|ZN_PDRV1|ZN_PU|ZN_SL|ZP_CS|ZP_IE|ZP_PD|ZP_PDRV0|ZP_PDRV1|ZP_PU|ZP_SL
+ VDD|XN_OE|XP_OE|YN_OE|YP_OE|ZN_OE|ZP_OE
+ VDD|XN_OE|XP_OE|YN_OE|YP_OE|ZN_OE|ZP_OE pfet_06v0 L=2U W=1U AS=0.44P AD=0.44P
+ PS=2.88U PD=2.88U
M$398 \$4880 \$4960 VDD|XN_OE|XP_OE|YN_OE|YP_OE|ZN_OE|ZP_OE
+ VDD|XN_OE|XP_OE|YN_OE|YP_OE|ZN_OE|ZP_OE pfet_06v0 L=1U W=1U AS=0.44P AD=0.44P
+ PS=2.88U PD=2.88U
M$399 VDD|XN_OE|XP_OE|YN_OE|YP_OE|ZN_OE|ZP_OE
+ VSS|XN_CS|XN_IE|XN_PD|XN_PDRV0|XN_PDRV1|XN_PU|XN_SL|XP_CS|XP_IE|XP_PD|XP_PDRV0|XP_PDRV1|XP_PU|XP_SL|YN_CS|YN_IE|YN_PD|YN_PDRV0|YN_PDRV1|YN_PU|YN_SL|YP_CS|YP_IE|YP_PD|YP_PDRV0|YP_PDRV1|YP_PU|YP_SL|ZN_CS|ZN_IE|ZN_PD|ZN_PDRV0|ZN_PDRV1|ZN_PU|ZN_SL|ZP_CS|ZP_IE|ZP_PD|ZP_PDRV0|ZP_PDRV1|ZP_PU|ZP_SL
+ VDD|XN_OE|XP_OE|YN_OE|YP_OE|ZN_OE|ZP_OE
+ VDD|XN_OE|XP_OE|YN_OE|YP_OE|ZN_OE|ZP_OE pfet_06v0 L=2U W=1U AS=0.44P AD=0.44P
+ PS=2.88U PD=2.88U
M$400 \$4880 \$4960 VDD|XN_OE|XP_OE|YN_OE|YP_OE|ZN_OE|ZP_OE
+ VDD|XN_OE|XP_OE|YN_OE|YP_OE|ZN_OE|ZP_OE pfet_06v0 L=1U W=1U AS=0.44P AD=0.44P
+ PS=2.88U PD=2.88U
M$401 \$4880 \$4960 VDD|XN_OE|XP_OE|YN_OE|YP_OE|ZN_OE|ZP_OE
+ VDD|XN_OE|XP_OE|YN_OE|YP_OE|ZN_OE|ZP_OE pfet_06v0 L=1U W=1U AS=0.44P AD=0.44P
+ PS=2.88U PD=2.88U
M$402 \$7276 \$7286 VDD|XN_OE|XP_OE|YN_OE|YP_OE|ZN_OE|ZP_OE
+ VDD|XN_OE|XP_OE|YN_OE|YP_OE|ZN_OE|ZP_OE pfet_06v0 L=1U W=3U AS=1.32P AD=1.32P
+ PS=6.88U PD=6.88U
M$403 \$7322 \$7306 VDD|XN_OE|XP_OE|YN_OE|YP_OE|ZN_OE|ZP_OE
+ VDD|XN_OE|XP_OE|YN_OE|YP_OE|ZN_OE|ZP_OE pfet_06v0 L=1U W=3U AS=1.32P AD=1.32P
+ PS=6.88U PD=6.88U
M$404 \$7306 \$7304 VDD|XN_OE|XP_OE|YN_OE|YP_OE|ZN_OE|ZP_OE
+ VDD|XN_OE|XP_OE|YN_OE|YP_OE|ZN_OE|ZP_OE pfet_06v0 L=1U W=3U AS=1.32P AD=0.99P
+ PS=6.88U PD=3.66U
M$405 VDD|XN_OE|XP_OE|YN_OE|YP_OE|ZN_OE|ZP_OE \$7276 \$7306
+ VDD|XN_OE|XP_OE|YN_OE|YP_OE|ZN_OE|ZP_OE pfet_06v0 L=1U W=3U AS=0.99P AD=1.32P
+ PS=3.66U PD=6.88U
M$406 \$4948 \$4948 VDD|XN_OE|XP_OE|YN_OE|YP_OE|ZN_OE|ZP_OE
+ VDD|XN_OE|XP_OE|YN_OE|YP_OE|ZN_OE|ZP_OE pfet_06v0 L=1U W=2U AS=0.88P AD=0.88P
+ PS=4.88U PD=4.88U
M$407 \$7393 \$7304 \$7305 VDD|XN_OE|XP_OE|YN_OE|YP_OE|ZN_OE|ZP_OE pfet_06v0
+ L=1U W=3U AS=1.32P AD=0.75P PS=6.88U PD=3.5U
M$408 VDD|XN_OE|XP_OE|YN_OE|YP_OE|ZN_OE|ZP_OE \$7295 \$7393
+ VDD|XN_OE|XP_OE|YN_OE|YP_OE|ZN_OE|ZP_OE pfet_06v0 L=1U W=3U AS=0.75P AD=1.32P
+ PS=3.5U PD=6.88U
M$409 \$7277 \$7307 VDD|XN_OE|XP_OE|YN_OE|YP_OE|ZN_OE|ZP_OE
+ VDD|XN_OE|XP_OE|YN_OE|YP_OE|ZN_OE|ZP_OE pfet_06v0 L=1U W=3U AS=1.32P AD=1.32P
+ PS=6.88U PD=6.88U
M$410 \$7307 \$7286 VDD|XN_OE|XP_OE|YN_OE|YP_OE|ZN_OE|ZP_OE
+ VDD|XN_OE|XP_OE|YN_OE|YP_OE|ZN_OE|ZP_OE pfet_06v0 L=1U W=3U AS=1.32P AD=0.99P
+ PS=6.88U PD=3.66U
M$411 VDD|XN_OE|XP_OE|YN_OE|YP_OE|ZN_OE|ZP_OE \$7295 \$7307
+ VDD|XN_OE|XP_OE|YN_OE|YP_OE|ZN_OE|ZP_OE pfet_06v0 L=1U W=3U AS=0.99P AD=1.32P
+ PS=3.66U PD=6.88U
M$412 VDD|XN_OE|XP_OE|YN_OE|YP_OE|ZN_OE|ZP_OE
+ VSS|XN_CS|XN_IE|XN_PD|XN_PDRV0|XN_PDRV1|XN_PU|XN_SL|XP_CS|XP_IE|XP_PD|XP_PDRV0|XP_PDRV1|XP_PU|XP_SL|YN_CS|YN_IE|YN_PD|YN_PDRV0|YN_PDRV1|YN_PU|YN_SL|YP_CS|YP_IE|YP_PD|YP_PDRV0|YP_PDRV1|YP_PU|YP_SL|ZN_CS|ZN_IE|ZN_PD|ZN_PDRV0|ZN_PDRV1|ZN_PU|ZN_SL|ZP_CS|ZP_IE|ZP_PD|ZP_PDRV0|ZP_PDRV1|ZP_PU|ZP_SL
+ VDD|XN_OE|XP_OE|YN_OE|YP_OE|ZN_OE|ZP_OE
+ VDD|XN_OE|XP_OE|YN_OE|YP_OE|ZN_OE|ZP_OE pfet_06v0 L=2U W=1U AS=0.44P AD=0.44P
+ PS=2.88U PD=2.88U
M$413 \$9035 \$7897 VDD|XN_OE|XP_OE|YN_OE|YP_OE|ZN_OE|ZP_OE
+ VDD|XN_OE|XP_OE|YN_OE|YP_OE|ZN_OE|ZP_OE pfet_06v0 L=1U W=10U AS=4.4P AD=2.5P
+ PS=20.88U PD=10.5U
M$414 \$7278 \$7898 \$9035 VDD|XN_OE|XP_OE|YN_OE|YP_OE|ZN_OE|ZP_OE pfet_06v0
+ L=1U W=10U AS=2.5P AD=4.4P PS=10.5U PD=20.88U
M$415 \$9036 \$7897 VDD|XN_OE|XP_OE|YN_OE|YP_OE|ZN_OE|ZP_OE
+ VDD|XN_OE|XP_OE|YN_OE|YP_OE|ZN_OE|ZP_OE pfet_06v0 L=1U W=10U AS=4.4P AD=2.5P
+ PS=20.88U PD=10.5U
M$416 \$7263 \$7898 \$9036 VDD|XN_OE|XP_OE|YN_OE|YP_OE|ZN_OE|ZP_OE pfet_06v0
+ L=1U W=10U AS=2.5P AD=4.4P PS=10.5U PD=20.88U
M$417 \$9037 \$7897 VDD|XN_OE|XP_OE|YN_OE|YP_OE|ZN_OE|ZP_OE
+ VDD|XN_OE|XP_OE|YN_OE|YP_OE|ZN_OE|ZP_OE pfet_06v0 L=1U W=10U AS=4.4P AD=2.5P
+ PS=20.88U PD=10.5U
M$418 \$7897 \$7898 \$9037 VDD|XN_OE|XP_OE|YN_OE|YP_OE|ZN_OE|ZP_OE pfet_06v0
+ L=1U W=10U AS=2.5P AD=4.4P PS=10.5U PD=20.88U
M$419 \$9038 \$7897 VDD|XN_OE|XP_OE|YN_OE|YP_OE|ZN_OE|ZP_OE
+ VDD|XN_OE|XP_OE|YN_OE|YP_OE|ZN_OE|ZP_OE pfet_06v0 L=1U W=10U AS=4.4P AD=2.5P
+ PS=20.88U PD=10.5U
M$420 \$7363 \$7898 \$9038 VDD|XN_OE|XP_OE|YN_OE|YP_OE|ZN_OE|ZP_OE pfet_06v0
+ L=1U W=10U AS=2.5P AD=3.3P PS=10.5U PD=10.66U
M$421 \$9039 \$7898 \$7363 VDD|XN_OE|XP_OE|YN_OE|YP_OE|ZN_OE|ZP_OE pfet_06v0
+ L=1U W=10U AS=3.3P AD=2.5P PS=10.66U PD=10.5U
M$422 VDD|XN_OE|XP_OE|YN_OE|YP_OE|ZN_OE|ZP_OE \$7897 \$9039
+ VDD|XN_OE|XP_OE|YN_OE|YP_OE|ZN_OE|ZP_OE pfet_06v0 L=1U W=10U AS=2.5P AD=4.4P
+ PS=10.5U PD=20.88U
M$423 \$9040 \$7352 VDD|XN_OE|XP_OE|YN_OE|YP_OE|ZN_OE|ZP_OE
+ VDD|XN_OE|XP_OE|YN_OE|YP_OE|ZN_OE|ZP_OE pfet_06v0 L=1U W=10U AS=4.4P AD=2.5P
+ PS=20.88U PD=10.5U
M$424 \$7352 \$7898 \$9040 VDD|XN_OE|XP_OE|YN_OE|YP_OE|ZN_OE|ZP_OE pfet_06v0
+ L=1U W=10U AS=2.5P AD=3.3P PS=10.5U PD=10.66U
M$425 \$7265 \$7265 \$7352 VDD|XN_OE|XP_OE|YN_OE|YP_OE|ZN_OE|ZP_OE pfet_06v0
+ L=1U W=10U AS=3.3P AD=4.4P PS=10.66U PD=20.88U
M$426 \$9041 \$7897 VDD|XN_OE|XP_OE|YN_OE|YP_OE|ZN_OE|ZP_OE
+ VDD|XN_OE|XP_OE|YN_OE|YP_OE|ZN_OE|ZP_OE pfet_06v0 L=1U W=10U AS=4.4P AD=2.5P
+ PS=20.88U PD=10.5U
M$427 \$7316 \$7898 \$9041 VDD|XN_OE|XP_OE|YN_OE|YP_OE|ZN_OE|ZP_OE pfet_06v0
+ L=1U W=10U AS=2.5P AD=4.4P PS=10.5U PD=20.88U
M$428 \$9042 \$7900 VDD|XN_OE|XP_OE|YN_OE|YP_OE|ZN_OE|ZP_OE
+ VDD|XN_OE|XP_OE|YN_OE|YP_OE|ZN_OE|ZP_OE pfet_06v0 L=1U W=10U AS=4.4P AD=2.5P
+ PS=20.88U PD=10.5U
M$429 \$7287 \$7901 \$9042 VDD|XN_OE|XP_OE|YN_OE|YP_OE|ZN_OE|ZP_OE pfet_06v0
+ L=1U W=10U AS=2.5P AD=4.4P PS=10.5U PD=20.88U
M$430 \$9043 \$7900 VDD|XN_OE|XP_OE|YN_OE|YP_OE|ZN_OE|ZP_OE
+ VDD|XN_OE|XP_OE|YN_OE|YP_OE|ZN_OE|ZP_OE pfet_06v0 L=1U W=10U AS=4.4P AD=2.5P
+ PS=20.88U PD=10.5U
M$431 \$7267 \$7901 \$9043 VDD|XN_OE|XP_OE|YN_OE|YP_OE|ZN_OE|ZP_OE pfet_06v0
+ L=1U W=10U AS=2.5P AD=4.4P PS=10.5U PD=20.88U
M$432 \$9044 \$7900 VDD|XN_OE|XP_OE|YN_OE|YP_OE|ZN_OE|ZP_OE
+ VDD|XN_OE|XP_OE|YN_OE|YP_OE|ZN_OE|ZP_OE pfet_06v0 L=1U W=10U AS=4.4P AD=2.5P
+ PS=20.88U PD=10.5U
M$433 \$7900 \$7901 \$9044 VDD|XN_OE|XP_OE|YN_OE|YP_OE|ZN_OE|ZP_OE pfet_06v0
+ L=1U W=10U AS=2.5P AD=4.4P PS=10.5U PD=20.88U
M$434 \$9046 \$7900 VDD|XN_OE|XP_OE|YN_OE|YP_OE|ZN_OE|ZP_OE
+ VDD|XN_OE|XP_OE|YN_OE|YP_OE|ZN_OE|ZP_OE pfet_06v0 L=1U W=10U AS=4.4P AD=2.5P
+ PS=20.88U PD=10.5U
M$435 \$7365 \$7901 \$9046 VDD|XN_OE|XP_OE|YN_OE|YP_OE|ZN_OE|ZP_OE pfet_06v0
+ L=1U W=10U AS=2.5P AD=3.3P PS=10.5U PD=10.66U
M$436 \$9045 \$7901 \$7365 VDD|XN_OE|XP_OE|YN_OE|YP_OE|ZN_OE|ZP_OE pfet_06v0
+ L=1U W=10U AS=3.3P AD=2.5P PS=10.66U PD=10.5U
M$437 VDD|XN_OE|XP_OE|YN_OE|YP_OE|ZN_OE|ZP_OE \$7900 \$9045
+ VDD|XN_OE|XP_OE|YN_OE|YP_OE|ZN_OE|ZP_OE pfet_06v0 L=1U W=10U AS=2.5P AD=4.4P
+ PS=10.5U PD=20.88U
M$438 \$9047 \$7355 VDD|XN_OE|XP_OE|YN_OE|YP_OE|ZN_OE|ZP_OE
+ VDD|XN_OE|XP_OE|YN_OE|YP_OE|ZN_OE|ZP_OE pfet_06v0 L=1U W=10U AS=4.4P AD=2.5P
+ PS=20.88U PD=10.5U
M$439 \$7355 \$7901 \$9047 VDD|XN_OE|XP_OE|YN_OE|YP_OE|ZN_OE|ZP_OE pfet_06v0
+ L=1U W=10U AS=2.5P AD=3.3P PS=10.5U PD=10.66U
M$440 \$7269 \$7269 \$7355 VDD|XN_OE|XP_OE|YN_OE|YP_OE|ZN_OE|ZP_OE pfet_06v0
+ L=1U W=10U AS=3.3P AD=4.4P PS=10.66U PD=20.88U
M$441 \$9048 \$7900 VDD|XN_OE|XP_OE|YN_OE|YP_OE|ZN_OE|ZP_OE
+ VDD|XN_OE|XP_OE|YN_OE|YP_OE|ZN_OE|ZP_OE pfet_06v0 L=1U W=10U AS=4.4P AD=2.5P
+ PS=20.88U PD=10.5U
M$442 \$7317 \$7901 \$9048 VDD|XN_OE|XP_OE|YN_OE|YP_OE|ZN_OE|ZP_OE pfet_06v0
+ L=1U W=10U AS=2.5P AD=4.4P PS=10.5U PD=20.88U
M$443 \$9049 \$7903 VDD|XN_OE|XP_OE|YN_OE|YP_OE|ZN_OE|ZP_OE
+ VDD|XN_OE|XP_OE|YN_OE|YP_OE|ZN_OE|ZP_OE pfet_06v0 L=1U W=10U AS=4.4P AD=2.5P
+ PS=20.88U PD=10.5U
M$444 \$7296 \$7904 \$9049 VDD|XN_OE|XP_OE|YN_OE|YP_OE|ZN_OE|ZP_OE pfet_06v0
+ L=1U W=10U AS=2.5P AD=4.4P PS=10.5U PD=20.88U
M$445 \$9051 \$7903 VDD|XN_OE|XP_OE|YN_OE|YP_OE|ZN_OE|ZP_OE
+ VDD|XN_OE|XP_OE|YN_OE|YP_OE|ZN_OE|ZP_OE pfet_06v0 L=1U W=10U AS=4.4P AD=2.5P
+ PS=20.88U PD=10.5U
M$446 \$7271 \$7904 \$9051 VDD|XN_OE|XP_OE|YN_OE|YP_OE|ZN_OE|ZP_OE pfet_06v0
+ L=1U W=10U AS=2.5P AD=4.4P PS=10.5U PD=20.88U
M$447 \$9052 \$7903 VDD|XN_OE|XP_OE|YN_OE|YP_OE|ZN_OE|ZP_OE
+ VDD|XN_OE|XP_OE|YN_OE|YP_OE|ZN_OE|ZP_OE pfet_06v0 L=1U W=10U AS=4.4P AD=2.5P
+ PS=20.88U PD=10.5U
M$448 \$7903 \$7904 \$9052 VDD|XN_OE|XP_OE|YN_OE|YP_OE|ZN_OE|ZP_OE pfet_06v0
+ L=1U W=10U AS=2.5P AD=4.4P PS=10.5U PD=20.88U
M$449 \$9053 \$7903 VDD|XN_OE|XP_OE|YN_OE|YP_OE|ZN_OE|ZP_OE
+ VDD|XN_OE|XP_OE|YN_OE|YP_OE|ZN_OE|ZP_OE pfet_06v0 L=1U W=10U AS=4.4P AD=2.5P
+ PS=20.88U PD=10.5U
M$450 \$7367 \$7904 \$9053 VDD|XN_OE|XP_OE|YN_OE|YP_OE|ZN_OE|ZP_OE pfet_06v0
+ L=1U W=10U AS=2.5P AD=3.3P PS=10.5U PD=10.66U
M$451 \$9054 \$7904 \$7367 VDD|XN_OE|XP_OE|YN_OE|YP_OE|ZN_OE|ZP_OE pfet_06v0
+ L=1U W=10U AS=3.3P AD=2.5P PS=10.66U PD=10.5U
M$452 VDD|XN_OE|XP_OE|YN_OE|YP_OE|ZN_OE|ZP_OE \$7903 \$9054
+ VDD|XN_OE|XP_OE|YN_OE|YP_OE|ZN_OE|ZP_OE pfet_06v0 L=1U W=10U AS=2.5P AD=4.4P
+ PS=10.5U PD=20.88U
M$453 \$9055 \$7358 VDD|XN_OE|XP_OE|YN_OE|YP_OE|ZN_OE|ZP_OE
+ VDD|XN_OE|XP_OE|YN_OE|YP_OE|ZN_OE|ZP_OE pfet_06v0 L=1U W=10U AS=4.4P AD=2.5P
+ PS=20.88U PD=10.5U
M$454 \$7358 \$7904 \$9055 VDD|XN_OE|XP_OE|YN_OE|YP_OE|ZN_OE|ZP_OE pfet_06v0
+ L=1U W=10U AS=2.5P AD=3.3P PS=10.5U PD=10.66U
M$455 \$7273 \$7273 \$7358 VDD|XN_OE|XP_OE|YN_OE|YP_OE|ZN_OE|ZP_OE pfet_06v0
+ L=1U W=10U AS=3.3P AD=4.4P PS=10.66U PD=20.88U
M$456 \$9050 \$7903 VDD|XN_OE|XP_OE|YN_OE|YP_OE|ZN_OE|ZP_OE
+ VDD|XN_OE|XP_OE|YN_OE|YP_OE|ZN_OE|ZP_OE pfet_06v0 L=1U W=10U AS=4.4P AD=2.5P
+ PS=20.88U PD=10.5U
M$457 \$7318 \$7904 \$9050 VDD|XN_OE|XP_OE|YN_OE|YP_OE|ZN_OE|ZP_OE pfet_06v0
+ L=1U W=10U AS=2.5P AD=4.4P PS=10.5U PD=20.88U
M$458 VDD|XN_OE|XP_OE|YN_OE|YP_OE|ZN_OE|ZP_OE
+ VSS|XN_CS|XN_IE|XN_PD|XN_PDRV0|XN_PDRV1|XN_PU|XN_SL|XP_CS|XP_IE|XP_PD|XP_PDRV0|XP_PDRV1|XP_PU|XP_SL|YN_CS|YN_IE|YN_PD|YN_PDRV0|YN_PDRV1|YN_PU|YN_SL|YP_CS|YP_IE|YP_PD|YP_PDRV0|YP_PDRV1|YP_PU|YP_SL|ZN_CS|ZN_IE|ZN_PD|ZN_PDRV0|ZN_PDRV1|ZN_PU|ZN_SL|ZP_CS|ZP_IE|ZP_PD|ZP_PDRV0|ZP_PDRV1|ZP_PU|ZP_SL
+ VDD|XN_OE|XP_OE|YN_OE|YP_OE|ZN_OE|ZP_OE
+ VDD|XN_OE|XP_OE|YN_OE|YP_OE|ZN_OE|ZP_OE pfet_06v0 L=2U W=9.75U AS=4.29P
+ AD=4.29P PS=20.38U PD=20.38U
M$459 \$7898 \$7898 VDD|XN_OE|XP_OE|YN_OE|YP_OE|ZN_OE|ZP_OE
+ VDD|XN_OE|XP_OE|YN_OE|YP_OE|ZN_OE|ZP_OE pfet_06v0 L=1U W=2U AS=0.88P AD=0.88P
+ PS=4.88U PD=4.88U
M$460 \$7364 \$7898 \$7281 VDD|XN_OE|XP_OE|YN_OE|YP_OE|ZN_OE|ZP_OE pfet_06v0
+ L=1U W=5U AS=2.2P AD=1.3P PS=10.88U PD=5.52U
M$461 \$7281 \$7898 \$7364 VDD|XN_OE|XP_OE|YN_OE|YP_OE|ZN_OE|ZP_OE pfet_06v0
+ L=1U W=5U AS=1.3P AD=2.2P PS=5.52U PD=10.88U
M$462 \$7264 \$7898 \$7280 VDD|XN_OE|XP_OE|YN_OE|YP_OE|ZN_OE|ZP_OE pfet_06v0
+ L=1U W=5U AS=2.2P AD=1.3P PS=10.88U PD=5.52U
M$463 \$7280 \$7898 \$7264 VDD|XN_OE|XP_OE|YN_OE|YP_OE|ZN_OE|ZP_OE pfet_06v0
+ L=1U W=5U AS=1.3P AD=2.2P PS=5.52U PD=10.88U
M$464 \$7281 \$7364 VDD|XN_OE|XP_OE|YN_OE|YP_OE|ZN_OE|ZP_OE
+ VDD|XN_OE|XP_OE|YN_OE|YP_OE|ZN_OE|ZP_OE pfet_06v0 L=1U W=5U AS=2.2P AD=1.3P
+ PS=10.88U PD=5.52U
M$465 VDD|XN_OE|XP_OE|YN_OE|YP_OE|ZN_OE|ZP_OE \$7364 \$7281
+ VDD|XN_OE|XP_OE|YN_OE|YP_OE|ZN_OE|ZP_OE pfet_06v0 L=1U W=5U AS=1.3P AD=1.3P
+ PS=5.52U PD=5.52U
M$466 \$7281 \$7364 VDD|XN_OE|XP_OE|YN_OE|YP_OE|ZN_OE|ZP_OE
+ VDD|XN_OE|XP_OE|YN_OE|YP_OE|ZN_OE|ZP_OE pfet_06v0 L=1U W=5U AS=1.3P AD=1.3P
+ PS=5.52U PD=5.52U
M$467 VDD|XN_OE|XP_OE|YN_OE|YP_OE|ZN_OE|ZP_OE \$7364 \$7281
+ VDD|XN_OE|XP_OE|YN_OE|YP_OE|ZN_OE|ZP_OE pfet_06v0 L=1U W=5U AS=1.3P AD=2.2P
+ PS=5.52U PD=10.88U
M$468 \$7280 \$7364 VDD|XN_OE|XP_OE|YN_OE|YP_OE|ZN_OE|ZP_OE
+ VDD|XN_OE|XP_OE|YN_OE|YP_OE|ZN_OE|ZP_OE pfet_06v0 L=1U W=5U AS=2.2P AD=1.3P
+ PS=10.88U PD=5.52U
M$469 VDD|XN_OE|XP_OE|YN_OE|YP_OE|ZN_OE|ZP_OE \$7364 \$7280
+ VDD|XN_OE|XP_OE|YN_OE|YP_OE|ZN_OE|ZP_OE pfet_06v0 L=1U W=5U AS=1.3P AD=1.3P
+ PS=5.52U PD=5.52U
M$470 \$7280 \$7364 VDD|XN_OE|XP_OE|YN_OE|YP_OE|ZN_OE|ZP_OE
+ VDD|XN_OE|XP_OE|YN_OE|YP_OE|ZN_OE|ZP_OE pfet_06v0 L=1U W=5U AS=1.3P AD=1.3P
+ PS=5.52U PD=5.52U
M$471 VDD|XN_OE|XP_OE|YN_OE|YP_OE|ZN_OE|ZP_OE \$7364 \$7280
+ VDD|XN_OE|XP_OE|YN_OE|YP_OE|ZN_OE|ZP_OE pfet_06v0 L=1U W=5U AS=1.3P AD=2.2P
+ PS=5.52U PD=10.88U
M$472 \$7283 \$7265 \$7364 VDD|XN_OE|XP_OE|YN_OE|YP_OE|ZN_OE|ZP_OE pfet_06v0
+ L=1U W=5U AS=2.2P AD=2.2P PS=10.88U PD=10.88U
M$473 \$7285 \$7265 \$7264 VDD|XN_OE|XP_OE|YN_OE|YP_OE|ZN_OE|ZP_OE pfet_06v0
+ L=1U W=5U AS=2.2P AD=2.2P PS=10.88U PD=10.88U
M$474 VDD|XN_OE|XP_OE|YN_OE|YP_OE|ZN_OE|ZP_OE
+ VSS|XN_CS|XN_IE|XN_PD|XN_PDRV0|XN_PDRV1|XN_PU|XN_SL|XP_CS|XP_IE|XP_PD|XP_PDRV0|XP_PDRV1|XP_PU|XP_SL|YN_CS|YN_IE|YN_PD|YN_PDRV0|YN_PDRV1|YN_PU|YN_SL|YP_CS|YP_IE|YP_PD|YP_PDRV0|YP_PDRV1|YP_PU|YP_SL|ZN_CS|ZN_IE|ZN_PD|ZN_PDRV0|ZN_PDRV1|ZN_PU|ZN_SL|ZP_CS|ZP_IE|ZP_PD|ZP_PDRV0|ZP_PDRV1|ZP_PU|ZP_SL
+ VDD|XN_OE|XP_OE|YN_OE|YP_OE|ZN_OE|ZP_OE
+ VDD|XN_OE|XP_OE|YN_OE|YP_OE|ZN_OE|ZP_OE pfet_06v0 L=2U W=9.75U AS=4.29P
+ AD=4.29P PS=20.38U PD=20.38U
M$475 VDD|XN_OE|XP_OE|YN_OE|YP_OE|ZN_OE|ZP_OE
+ VSS|XN_CS|XN_IE|XN_PD|XN_PDRV0|XN_PDRV1|XN_PU|XN_SL|XP_CS|XP_IE|XP_PD|XP_PDRV0|XP_PDRV1|XP_PU|XP_SL|YN_CS|YN_IE|YN_PD|YN_PDRV0|YN_PDRV1|YN_PU|YN_SL|YP_CS|YP_IE|YP_PD|YP_PDRV0|YP_PDRV1|YP_PU|YP_SL|ZN_CS|ZN_IE|ZN_PD|ZN_PDRV0|ZN_PDRV1|ZN_PU|ZN_SL|ZP_CS|ZP_IE|ZP_PD|ZP_PDRV0|ZP_PDRV1|ZP_PU|ZP_SL
+ VDD|XN_OE|XP_OE|YN_OE|YP_OE|ZN_OE|ZP_OE
+ VDD|XN_OE|XP_OE|YN_OE|YP_OE|ZN_OE|ZP_OE pfet_06v0 L=2U W=9.75U AS=4.29P
+ AD=4.29P PS=20.38U PD=20.38U
M$476 \$7901 \$7901 VDD|XN_OE|XP_OE|YN_OE|YP_OE|ZN_OE|ZP_OE
+ VDD|XN_OE|XP_OE|YN_OE|YP_OE|ZN_OE|ZP_OE pfet_06v0 L=1U W=2U AS=0.88P AD=0.88P
+ PS=4.88U PD=4.88U
M$477 \$7366 \$7901 \$7290 VDD|XN_OE|XP_OE|YN_OE|YP_OE|ZN_OE|ZP_OE pfet_06v0
+ L=1U W=5U AS=2.2P AD=1.3P PS=10.88U PD=5.52U
M$478 \$7290 \$7901 \$7366 VDD|XN_OE|XP_OE|YN_OE|YP_OE|ZN_OE|ZP_OE pfet_06v0
+ L=1U W=5U AS=1.3P AD=2.2P PS=5.52U PD=10.88U
M$479 \$7268 \$7901 \$7289 VDD|XN_OE|XP_OE|YN_OE|YP_OE|ZN_OE|ZP_OE pfet_06v0
+ L=1U W=5U AS=2.2P AD=1.3P PS=10.88U PD=5.52U
M$480 \$7289 \$7901 \$7268 VDD|XN_OE|XP_OE|YN_OE|YP_OE|ZN_OE|ZP_OE pfet_06v0
+ L=1U W=5U AS=1.3P AD=2.2P PS=5.52U PD=10.88U
M$481 \$7290 \$7366 VDD|XN_OE|XP_OE|YN_OE|YP_OE|ZN_OE|ZP_OE
+ VDD|XN_OE|XP_OE|YN_OE|YP_OE|ZN_OE|ZP_OE pfet_06v0 L=1U W=5U AS=2.2P AD=1.3P
+ PS=10.88U PD=5.52U
M$482 VDD|XN_OE|XP_OE|YN_OE|YP_OE|ZN_OE|ZP_OE \$7366 \$7290
+ VDD|XN_OE|XP_OE|YN_OE|YP_OE|ZN_OE|ZP_OE pfet_06v0 L=1U W=5U AS=1.3P AD=1.3P
+ PS=5.52U PD=5.52U
M$483 \$7290 \$7366 VDD|XN_OE|XP_OE|YN_OE|YP_OE|ZN_OE|ZP_OE
+ VDD|XN_OE|XP_OE|YN_OE|YP_OE|ZN_OE|ZP_OE pfet_06v0 L=1U W=5U AS=1.3P AD=1.3P
+ PS=5.52U PD=5.52U
M$484 VDD|XN_OE|XP_OE|YN_OE|YP_OE|ZN_OE|ZP_OE \$7366 \$7290
+ VDD|XN_OE|XP_OE|YN_OE|YP_OE|ZN_OE|ZP_OE pfet_06v0 L=1U W=5U AS=1.3P AD=2.2P
+ PS=5.52U PD=10.88U
M$485 \$7289 \$7366 VDD|XN_OE|XP_OE|YN_OE|YP_OE|ZN_OE|ZP_OE
+ VDD|XN_OE|XP_OE|YN_OE|YP_OE|ZN_OE|ZP_OE pfet_06v0 L=1U W=5U AS=2.2P AD=1.3P
+ PS=10.88U PD=5.52U
M$486 VDD|XN_OE|XP_OE|YN_OE|YP_OE|ZN_OE|ZP_OE \$7366 \$7289
+ VDD|XN_OE|XP_OE|YN_OE|YP_OE|ZN_OE|ZP_OE pfet_06v0 L=1U W=5U AS=1.3P AD=1.3P
+ PS=5.52U PD=5.52U
M$487 \$7289 \$7366 VDD|XN_OE|XP_OE|YN_OE|YP_OE|ZN_OE|ZP_OE
+ VDD|XN_OE|XP_OE|YN_OE|YP_OE|ZN_OE|ZP_OE pfet_06v0 L=1U W=5U AS=1.3P AD=1.3P
+ PS=5.52U PD=5.52U
M$488 VDD|XN_OE|XP_OE|YN_OE|YP_OE|ZN_OE|ZP_OE \$7366 \$7289
+ VDD|XN_OE|XP_OE|YN_OE|YP_OE|ZN_OE|ZP_OE pfet_06v0 L=1U W=5U AS=1.3P AD=2.2P
+ PS=5.52U PD=10.88U
M$489 \$7292 \$7269 \$7366 VDD|XN_OE|XP_OE|YN_OE|YP_OE|ZN_OE|ZP_OE pfet_06v0
+ L=1U W=5U AS=2.2P AD=2.2P PS=10.88U PD=10.88U
M$490 \$7294 \$7269 \$7268 VDD|XN_OE|XP_OE|YN_OE|YP_OE|ZN_OE|ZP_OE pfet_06v0
+ L=1U W=5U AS=2.2P AD=2.2P PS=10.88U PD=10.88U
M$491 VDD|XN_OE|XP_OE|YN_OE|YP_OE|ZN_OE|ZP_OE
+ VSS|XN_CS|XN_IE|XN_PD|XN_PDRV0|XN_PDRV1|XN_PU|XN_SL|XP_CS|XP_IE|XP_PD|XP_PDRV0|XP_PDRV1|XP_PU|XP_SL|YN_CS|YN_IE|YN_PD|YN_PDRV0|YN_PDRV1|YN_PU|YN_SL|YP_CS|YP_IE|YP_PD|YP_PDRV0|YP_PDRV1|YP_PU|YP_SL|ZN_CS|ZN_IE|ZN_PD|ZN_PDRV0|ZN_PDRV1|ZN_PU|ZN_SL|ZP_CS|ZP_IE|ZP_PD|ZP_PDRV0|ZP_PDRV1|ZP_PU|ZP_SL
+ VDD|XN_OE|XP_OE|YN_OE|YP_OE|ZN_OE|ZP_OE
+ VDD|XN_OE|XP_OE|YN_OE|YP_OE|ZN_OE|ZP_OE pfet_06v0 L=2U W=9.75U AS=4.29P
+ AD=4.29P PS=20.38U PD=20.38U
M$492 VDD|XN_OE|XP_OE|YN_OE|YP_OE|ZN_OE|ZP_OE
+ VSS|XN_CS|XN_IE|XN_PD|XN_PDRV0|XN_PDRV1|XN_PU|XN_SL|XP_CS|XP_IE|XP_PD|XP_PDRV0|XP_PDRV1|XP_PU|XP_SL|YN_CS|YN_IE|YN_PD|YN_PDRV0|YN_PDRV1|YN_PU|YN_SL|YP_CS|YP_IE|YP_PD|YP_PDRV0|YP_PDRV1|YP_PU|YP_SL|ZN_CS|ZN_IE|ZN_PD|ZN_PDRV0|ZN_PDRV1|ZN_PU|ZN_SL|ZP_CS|ZP_IE|ZP_PD|ZP_PDRV0|ZP_PDRV1|ZP_PU|ZP_SL
+ VDD|XN_OE|XP_OE|YN_OE|YP_OE|ZN_OE|ZP_OE
+ VDD|XN_OE|XP_OE|YN_OE|YP_OE|ZN_OE|ZP_OE pfet_06v0 L=2U W=9.75U AS=4.29P
+ AD=4.29P PS=20.38U PD=20.38U
M$493 \$7904 \$7904 VDD|XN_OE|XP_OE|YN_OE|YP_OE|ZN_OE|ZP_OE
+ VDD|XN_OE|XP_OE|YN_OE|YP_OE|ZN_OE|ZP_OE pfet_06v0 L=1U W=2U AS=0.88P AD=0.88P
+ PS=4.88U PD=4.88U
M$494 \$7368 \$7904 \$7299 VDD|XN_OE|XP_OE|YN_OE|YP_OE|ZN_OE|ZP_OE pfet_06v0
+ L=1U W=5U AS=2.2P AD=1.3P PS=10.88U PD=5.52U
M$495 \$7299 \$7904 \$7368 VDD|XN_OE|XP_OE|YN_OE|YP_OE|ZN_OE|ZP_OE pfet_06v0
+ L=1U W=5U AS=1.3P AD=2.2P PS=5.52U PD=10.88U
M$496 \$7272 \$7904 \$7298 VDD|XN_OE|XP_OE|YN_OE|YP_OE|ZN_OE|ZP_OE pfet_06v0
+ L=1U W=5U AS=2.2P AD=1.3P PS=10.88U PD=5.52U
M$497 \$7298 \$7904 \$7272 VDD|XN_OE|XP_OE|YN_OE|YP_OE|ZN_OE|ZP_OE pfet_06v0
+ L=1U W=5U AS=1.3P AD=2.2P PS=5.52U PD=10.88U
M$498 \$7299 \$7368 VDD|XN_OE|XP_OE|YN_OE|YP_OE|ZN_OE|ZP_OE
+ VDD|XN_OE|XP_OE|YN_OE|YP_OE|ZN_OE|ZP_OE pfet_06v0 L=1U W=5U AS=2.2P AD=1.3P
+ PS=10.88U PD=5.52U
M$499 VDD|XN_OE|XP_OE|YN_OE|YP_OE|ZN_OE|ZP_OE \$7368 \$7299
+ VDD|XN_OE|XP_OE|YN_OE|YP_OE|ZN_OE|ZP_OE pfet_06v0 L=1U W=5U AS=1.3P AD=1.3P
+ PS=5.52U PD=5.52U
M$500 \$7299 \$7368 VDD|XN_OE|XP_OE|YN_OE|YP_OE|ZN_OE|ZP_OE
+ VDD|XN_OE|XP_OE|YN_OE|YP_OE|ZN_OE|ZP_OE pfet_06v0 L=1U W=5U AS=1.3P AD=1.3P
+ PS=5.52U PD=5.52U
M$501 VDD|XN_OE|XP_OE|YN_OE|YP_OE|ZN_OE|ZP_OE \$7368 \$7299
+ VDD|XN_OE|XP_OE|YN_OE|YP_OE|ZN_OE|ZP_OE pfet_06v0 L=1U W=5U AS=1.3P AD=2.2P
+ PS=5.52U PD=10.88U
M$502 \$7298 \$7368 VDD|XN_OE|XP_OE|YN_OE|YP_OE|ZN_OE|ZP_OE
+ VDD|XN_OE|XP_OE|YN_OE|YP_OE|ZN_OE|ZP_OE pfet_06v0 L=1U W=5U AS=2.2P AD=1.3P
+ PS=10.88U PD=5.52U
M$503 VDD|XN_OE|XP_OE|YN_OE|YP_OE|ZN_OE|ZP_OE \$7368 \$7298
+ VDD|XN_OE|XP_OE|YN_OE|YP_OE|ZN_OE|ZP_OE pfet_06v0 L=1U W=5U AS=1.3P AD=1.3P
+ PS=5.52U PD=5.52U
M$504 \$7298 \$7368 VDD|XN_OE|XP_OE|YN_OE|YP_OE|ZN_OE|ZP_OE
+ VDD|XN_OE|XP_OE|YN_OE|YP_OE|ZN_OE|ZP_OE pfet_06v0 L=1U W=5U AS=1.3P AD=1.3P
+ PS=5.52U PD=5.52U
M$505 VDD|XN_OE|XP_OE|YN_OE|YP_OE|ZN_OE|ZP_OE \$7368 \$7298
+ VDD|XN_OE|XP_OE|YN_OE|YP_OE|ZN_OE|ZP_OE pfet_06v0 L=1U W=5U AS=1.3P AD=2.2P
+ PS=5.52U PD=10.88U
M$506 \$7301 \$7273 \$7368 VDD|XN_OE|XP_OE|YN_OE|YP_OE|ZN_OE|ZP_OE pfet_06v0
+ L=1U W=5U AS=2.2P AD=2.2P PS=10.88U PD=10.88U
M$507 \$7303 \$7273 \$7272 VDD|XN_OE|XP_OE|YN_OE|YP_OE|ZN_OE|ZP_OE pfet_06v0
+ L=1U W=5U AS=2.2P AD=2.2P PS=10.88U PD=10.88U
M$508 VDD|XN_OE|XP_OE|YN_OE|YP_OE|ZN_OE|ZP_OE
+ VSS|XN_CS|XN_IE|XN_PD|XN_PDRV0|XN_PDRV1|XN_PU|XN_SL|XP_CS|XP_IE|XP_PD|XP_PDRV0|XP_PDRV1|XP_PU|XP_SL|YN_CS|YN_IE|YN_PD|YN_PDRV0|YN_PDRV1|YN_PU|YN_SL|YP_CS|YP_IE|YP_PD|YP_PDRV0|YP_PDRV1|YP_PU|YP_SL|ZN_CS|ZN_IE|ZN_PD|ZN_PDRV0|ZN_PDRV1|ZN_PU|ZN_SL|ZP_CS|ZP_IE|ZP_PD|ZP_PDRV0|ZP_PDRV1|ZP_PU|ZP_SL
+ VDD|XN_OE|XP_OE|YN_OE|YP_OE|ZN_OE|ZP_OE
+ VDD|XN_OE|XP_OE|YN_OE|YP_OE|ZN_OE|ZP_OE pfet_06v0 L=2U W=9.75U AS=4.29P
+ AD=4.29P PS=20.38U PD=20.38U
M$509 VDD|XN_OE|XP_OE|YN_OE|YP_OE|ZN_OE|ZP_OE
+ VSS|XN_CS|XN_IE|XN_PD|XN_PDRV0|XN_PDRV1|XN_PU|XN_SL|XP_CS|XP_IE|XP_PD|XP_PDRV0|XP_PDRV1|XP_PU|XP_SL|YN_CS|YN_IE|YN_PD|YN_PDRV0|YN_PDRV1|YN_PU|YN_SL|YP_CS|YP_IE|YP_PD|YP_PDRV0|YP_PDRV1|YP_PU|YP_SL|ZN_CS|ZN_IE|ZN_PD|ZN_PDRV0|ZN_PDRV1|ZN_PU|ZN_SL|ZP_CS|ZP_IE|ZP_PD|ZP_PDRV0|ZP_PDRV1|ZP_PU|ZP_SL
+ VDD|XN_OE|XP_OE|YN_OE|YP_OE|ZN_OE|ZP_OE
+ VDD|XN_OE|XP_OE|YN_OE|YP_OE|ZN_OE|ZP_OE pfet_06v0 L=2U W=9.75U AS=4.29P
+ AD=4.29P PS=20.38U PD=20.38U
M$510 X X VDD|XN_OE|XP_OE|YN_OE|YP_OE|ZN_OE|ZP_OE
+ VDD|XN_OE|XP_OE|YN_OE|YP_OE|ZN_OE|ZP_OE pfet_06v0 L=1U W=2U AS=0.88P AD=0.52P
+ PS=4.88U PD=2.52U
M$511 VDD|XN_OE|XP_OE|YN_OE|YP_OE|ZN_OE|ZP_OE X X
+ VDD|XN_OE|XP_OE|YN_OE|YP_OE|ZN_OE|ZP_OE pfet_06v0 L=1U W=2U AS=0.52P AD=0.52P
+ PS=2.52U PD=2.52U
M$512 X X VDD|XN_OE|XP_OE|YN_OE|YP_OE|ZN_OE|ZP_OE
+ VDD|XN_OE|XP_OE|YN_OE|YP_OE|ZN_OE|ZP_OE pfet_06v0 L=1U W=2U AS=0.52P AD=0.52P
+ PS=2.52U PD=2.52U
M$513 VDD|XN_OE|XP_OE|YN_OE|YP_OE|ZN_OE|ZP_OE X X
+ VDD|XN_OE|XP_OE|YN_OE|YP_OE|ZN_OE|ZP_OE pfet_06v0 L=1U W=2U AS=0.52P AD=0.52P
+ PS=2.52U PD=2.52U
M$514 X X VDD|XN_OE|XP_OE|YN_OE|YP_OE|ZN_OE|ZP_OE
+ VDD|XN_OE|XP_OE|YN_OE|YP_OE|ZN_OE|ZP_OE pfet_06v0 L=1U W=2U AS=0.52P AD=0.52P
+ PS=2.52U PD=2.52U
M$515 VDD|XN_OE|XP_OE|YN_OE|YP_OE|ZN_OE|ZP_OE X X
+ VDD|XN_OE|XP_OE|YN_OE|YP_OE|ZN_OE|ZP_OE pfet_06v0 L=1U W=2U AS=0.52P AD=0.88P
+ PS=2.52U PD=4.88U
M$516 \$7261 \$7261 VDD|XN_OE|XP_OE|YN_OE|YP_OE|ZN_OE|ZP_OE
+ VDD|XN_OE|XP_OE|YN_OE|YP_OE|ZN_OE|ZP_OE pfet_06v0 L=1U W=2U AS=0.88P AD=0.88P
+ PS=4.88U PD=4.88U
M$517 VDD|XN_OE|XP_OE|YN_OE|YP_OE|ZN_OE|ZP_OE
+ VSS|XN_CS|XN_IE|XN_PD|XN_PDRV0|XN_PDRV1|XN_PU|XN_SL|XP_CS|XP_IE|XP_PD|XP_PDRV0|XP_PDRV1|XP_PU|XP_SL|YN_CS|YN_IE|YN_PD|YN_PDRV0|YN_PDRV1|YN_PU|YN_SL|YP_CS|YP_IE|YP_PD|YP_PDRV0|YP_PDRV1|YP_PU|YP_SL|ZN_CS|ZN_IE|ZN_PD|ZN_PDRV0|ZN_PDRV1|ZN_PU|ZN_SL|ZP_CS|ZP_IE|ZP_PD|ZP_PDRV0|ZP_PDRV1|ZP_PU|ZP_SL
+ VDD|XN_OE|XP_OE|YN_OE|YP_OE|ZN_OE|ZP_OE
+ VDD|XN_OE|XP_OE|YN_OE|YP_OE|ZN_OE|ZP_OE pfet_06v0 L=2U W=1U AS=0.44P AD=0.44P
+ PS=2.88U PD=2.88U
M$518 VDD|XN_OE|XP_OE|YN_OE|YP_OE|ZN_OE|ZP_OE
+ VSS|XN_CS|XN_IE|XN_PD|XN_PDRV0|XN_PDRV1|XN_PU|XN_SL|XP_CS|XP_IE|XP_PD|XP_PDRV0|XP_PDRV1|XP_PU|XP_SL|YN_CS|YN_IE|YN_PD|YN_PDRV0|YN_PDRV1|YN_PU|YN_SL|YP_CS|YP_IE|YP_PD|YP_PDRV0|YP_PDRV1|YP_PU|YP_SL|ZN_CS|ZN_IE|ZN_PD|ZN_PDRV0|ZN_PDRV1|ZN_PU|ZN_SL|ZP_CS|ZP_IE|ZP_PD|ZP_PDRV0|ZP_PDRV1|ZP_PU|ZP_SL
+ VDD|XN_OE|XP_OE|YN_OE|YP_OE|ZN_OE|ZP_OE
+ VDD|XN_OE|XP_OE|YN_OE|YP_OE|ZN_OE|ZP_OE pfet_06v0 L=2U W=1U AS=0.44P AD=0.44P
+ PS=2.88U PD=2.88U
M$519 \$9080 \$9089 VDD|XN_OE|XP_OE|YN_OE|YP_OE|ZN_OE|ZP_OE
+ VDD|XN_OE|XP_OE|YN_OE|YP_OE|ZN_OE|ZP_OE pfet_06v0 L=1U W=3U AS=1.32P AD=1.32P
+ PS=6.88U PD=6.88U
M$520 \$9122 \$9108 VDD|XN_OE|XP_OE|YN_OE|YP_OE|ZN_OE|ZP_OE
+ VDD|XN_OE|XP_OE|YN_OE|YP_OE|ZN_OE|ZP_OE pfet_06v0 L=1U W=3U AS=1.32P AD=1.32P
+ PS=6.88U PD=6.88U
M$521 \$9108 \$9106 VDD|XN_OE|XP_OE|YN_OE|YP_OE|ZN_OE|ZP_OE
+ VDD|XN_OE|XP_OE|YN_OE|YP_OE|ZN_OE|ZP_OE pfet_06v0 L=1U W=3U AS=1.32P AD=0.99P
+ PS=6.88U PD=3.66U
M$522 VDD|XN_OE|XP_OE|YN_OE|YP_OE|ZN_OE|ZP_OE \$9080 \$9108
+ VDD|XN_OE|XP_OE|YN_OE|YP_OE|ZN_OE|ZP_OE pfet_06v0 L=1U W=3U AS=0.99P AD=1.32P
+ PS=3.66U PD=6.88U
M$523 \$9170 \$9106 \$9107 VDD|XN_OE|XP_OE|YN_OE|YP_OE|ZN_OE|ZP_OE pfet_06v0
+ L=1U W=3U AS=1.32P AD=0.75P PS=6.88U PD=3.5U
M$524 VDD|XN_OE|XP_OE|YN_OE|YP_OE|ZN_OE|ZP_OE \$9109 \$9170
+ VDD|XN_OE|XP_OE|YN_OE|YP_OE|ZN_OE|ZP_OE pfet_06v0 L=1U W=3U AS=0.75P AD=1.32P
+ PS=3.5U PD=6.88U
M$525 \$7745 \$9110 VDD|XN_OE|XP_OE|YN_OE|YP_OE|ZN_OE|ZP_OE
+ VDD|XN_OE|XP_OE|YN_OE|YP_OE|ZN_OE|ZP_OE pfet_06v0 L=1U W=3U AS=1.32P AD=1.32P
+ PS=6.88U PD=6.88U
M$526 \$9110 \$9089 VDD|XN_OE|XP_OE|YN_OE|YP_OE|ZN_OE|ZP_OE
+ VDD|XN_OE|XP_OE|YN_OE|YP_OE|ZN_OE|ZP_OE pfet_06v0 L=1U W=3U AS=1.32P AD=0.99P
+ PS=6.88U PD=3.66U
M$527 VDD|XN_OE|XP_OE|YN_OE|YP_OE|ZN_OE|ZP_OE \$9109 \$9110
+ VDD|XN_OE|XP_OE|YN_OE|YP_OE|ZN_OE|ZP_OE pfet_06v0 L=1U W=3U AS=0.99P AD=1.32P
+ PS=3.66U PD=6.88U
M$528 VDD|XN_OE|XP_OE|YN_OE|YP_OE|ZN_OE|ZP_OE
+ VSS|XN_CS|XN_IE|XN_PD|XN_PDRV0|XN_PDRV1|XN_PU|XN_SL|XP_CS|XP_IE|XP_PD|XP_PDRV0|XP_PDRV1|XP_PU|XP_SL|YN_CS|YN_IE|YN_PD|YN_PDRV0|YN_PDRV1|YN_PU|YN_SL|YP_CS|YP_IE|YP_PD|YP_PDRV0|YP_PDRV1|YP_PU|YP_SL|ZN_CS|ZN_IE|ZN_PD|ZN_PDRV0|ZN_PDRV1|ZN_PU|ZN_SL|ZP_CS|ZP_IE|ZP_PD|ZP_PDRV0|ZP_PDRV1|ZP_PU|ZP_SL
+ VDD|XN_OE|XP_OE|YN_OE|YP_OE|ZN_OE|ZP_OE
+ VDD|XN_OE|XP_OE|YN_OE|YP_OE|ZN_OE|ZP_OE pfet_06v0 L=2U W=1U AS=0.44P AD=0.44P
+ PS=2.88U PD=2.88U
M$529 \$9087 \$54 \$9164 VDD|XN_OE|XP_OE|YN_OE|YP_OE|ZN_OE|ZP_OE pfet_06v0 L=1U
+ W=10U AS=4.4P AD=2.6P PS=20.88U PD=10.52U
M$530 \$9164 \$54 \$9087 VDD|XN_OE|XP_OE|YN_OE|YP_OE|ZN_OE|ZP_OE pfet_06v0 L=1U
+ W=10U AS=2.6P AD=4.4P PS=10.52U PD=20.88U
M$531 \$9085 \$2449 \$9164 VDD|XN_OE|XP_OE|YN_OE|YP_OE|ZN_OE|ZP_OE pfet_06v0
+ L=1U W=10U AS=4.4P AD=2.6P PS=20.88U PD=10.52U
M$532 \$9164 \$2449 \$9085 VDD|XN_OE|XP_OE|YN_OE|YP_OE|ZN_OE|ZP_OE pfet_06v0
+ L=1U W=10U AS=2.6P AD=4.4P PS=10.52U PD=20.88U
M$533 \$9089 \$9065 VDD|XN_OE|XP_OE|YN_OE|YP_OE|ZN_OE|ZP_OE
+ VDD|XN_OE|XP_OE|YN_OE|YP_OE|ZN_OE|ZP_OE pfet_06v0 L=1U W=10U AS=4.4P AD=2.6P
+ PS=20.88U PD=10.52U
M$534 VDD|XN_OE|XP_OE|YN_OE|YP_OE|ZN_OE|ZP_OE \$9065 \$9089
+ VDD|XN_OE|XP_OE|YN_OE|YP_OE|ZN_OE|ZP_OE pfet_06v0 L=1U W=10U AS=2.6P AD=2.6P
+ PS=10.52U PD=10.52U
M$535 \$9089 \$9065 VDD|XN_OE|XP_OE|YN_OE|YP_OE|ZN_OE|ZP_OE
+ VDD|XN_OE|XP_OE|YN_OE|YP_OE|ZN_OE|ZP_OE pfet_06v0 L=1U W=10U AS=2.6P AD=4.4P
+ PS=10.52U PD=20.88U
M$536 \$9096 \$2441 \$9166 VDD|XN_OE|XP_OE|YN_OE|YP_OE|ZN_OE|ZP_OE pfet_06v0
+ L=1U W=10U AS=4.4P AD=2.6P PS=20.88U PD=10.52U
M$537 \$9166 \$2441 \$9096 VDD|XN_OE|XP_OE|YN_OE|YP_OE|ZN_OE|ZP_OE pfet_06v0
+ L=1U W=10U AS=2.6P AD=4.4P PS=10.52U PD=20.88U
M$538 \$9094 \$2449 \$9166 VDD|XN_OE|XP_OE|YN_OE|YP_OE|ZN_OE|ZP_OE pfet_06v0
+ L=1U W=10U AS=4.4P AD=2.6P PS=20.88U PD=10.52U
M$539 \$9166 \$2449 \$9094 VDD|XN_OE|XP_OE|YN_OE|YP_OE|ZN_OE|ZP_OE pfet_06v0
+ L=1U W=10U AS=2.6P AD=4.4P PS=10.52U PD=20.88U
M$540 \$9109 \$9069 VDD|XN_OE|XP_OE|YN_OE|YP_OE|ZN_OE|ZP_OE
+ VDD|XN_OE|XP_OE|YN_OE|YP_OE|ZN_OE|ZP_OE pfet_06v0 L=1U W=10U AS=4.4P AD=2.6P
+ PS=20.88U PD=10.52U
M$541 VDD|XN_OE|XP_OE|YN_OE|YP_OE|ZN_OE|ZP_OE \$9069 \$9109
+ VDD|XN_OE|XP_OE|YN_OE|YP_OE|ZN_OE|ZP_OE pfet_06v0 L=1U W=10U AS=2.6P AD=2.6P
+ PS=10.52U PD=10.52U
M$542 \$9109 \$9069 VDD|XN_OE|XP_OE|YN_OE|YP_OE|ZN_OE|ZP_OE
+ VDD|XN_OE|XP_OE|YN_OE|YP_OE|ZN_OE|ZP_OE pfet_06v0 L=1U W=10U AS=2.6P AD=4.4P
+ PS=10.52U PD=20.88U
M$543 \$9104 \$2441 \$9168 VDD|XN_OE|XP_OE|YN_OE|YP_OE|ZN_OE|ZP_OE pfet_06v0
+ L=1U W=10U AS=4.4P AD=2.6P PS=20.88U PD=10.52U
M$544 \$9168 \$2441 \$9104 VDD|XN_OE|XP_OE|YN_OE|YP_OE|ZN_OE|ZP_OE pfet_06v0
+ L=1U W=10U AS=2.6P AD=4.4P PS=10.52U PD=20.88U
M$545 \$9102 \$54 \$9168 VDD|XN_OE|XP_OE|YN_OE|YP_OE|ZN_OE|ZP_OE pfet_06v0 L=1U
+ W=10U AS=4.4P AD=2.6P PS=20.88U PD=10.52U
M$546 \$9168 \$54 \$9102 VDD|XN_OE|XP_OE|YN_OE|YP_OE|ZN_OE|ZP_OE pfet_06v0 L=1U
+ W=10U AS=2.6P AD=4.4P PS=10.52U PD=20.88U
M$547 \$9106 \$9073 VDD|XN_OE|XP_OE|YN_OE|YP_OE|ZN_OE|ZP_OE
+ VDD|XN_OE|XP_OE|YN_OE|YP_OE|ZN_OE|ZP_OE pfet_06v0 L=1U W=10U AS=4.4P AD=2.6P
+ PS=20.88U PD=10.52U
M$548 VDD|XN_OE|XP_OE|YN_OE|YP_OE|ZN_OE|ZP_OE \$9073 \$9106
+ VDD|XN_OE|XP_OE|YN_OE|YP_OE|ZN_OE|ZP_OE pfet_06v0 L=1U W=10U AS=2.6P AD=2.6P
+ PS=10.52U PD=10.52U
M$549 \$9106 \$9073 VDD|XN_OE|XP_OE|YN_OE|YP_OE|ZN_OE|ZP_OE
+ VDD|XN_OE|XP_OE|YN_OE|YP_OE|ZN_OE|ZP_OE pfet_06v0 L=1U W=10U AS=2.6P AD=4.4P
+ PS=10.52U PD=20.88U
M$550 \$10838 \$9622 VDD|XN_OE|XP_OE|YN_OE|YP_OE|ZN_OE|ZP_OE
+ VDD|XN_OE|XP_OE|YN_OE|YP_OE|ZN_OE|ZP_OE pfet_06v0 L=1U W=10U AS=4.4P AD=2.5P
+ PS=20.88U PD=10.5U
M$551 \$9081 \$9701 \$10838 VDD|XN_OE|XP_OE|YN_OE|YP_OE|ZN_OE|ZP_OE pfet_06v0
+ L=1U W=10U AS=2.5P AD=4.4P PS=10.5U PD=20.88U
M$552 \$10839 \$9622 VDD|XN_OE|XP_OE|YN_OE|YP_OE|ZN_OE|ZP_OE
+ VDD|XN_OE|XP_OE|YN_OE|YP_OE|ZN_OE|ZP_OE pfet_06v0 L=1U W=10U AS=4.4P AD=2.5P
+ PS=20.88U PD=10.5U
M$553 \$9064 \$9701 \$10839 VDD|XN_OE|XP_OE|YN_OE|YP_OE|ZN_OE|ZP_OE pfet_06v0
+ L=1U W=10U AS=2.5P AD=4.4P PS=10.5U PD=20.88U
M$554 \$10840 \$9622 VDD|XN_OE|XP_OE|YN_OE|YP_OE|ZN_OE|ZP_OE
+ VDD|XN_OE|XP_OE|YN_OE|YP_OE|ZN_OE|ZP_OE pfet_06v0 L=1U W=10U AS=4.4P AD=2.5P
+ PS=20.88U PD=10.5U
M$555 \$9622 \$9701 \$10840 VDD|XN_OE|XP_OE|YN_OE|YP_OE|ZN_OE|ZP_OE pfet_06v0
+ L=1U W=10U AS=2.5P AD=4.4P PS=10.5U PD=20.88U
M$556 \$10841 \$9622 VDD|XN_OE|XP_OE|YN_OE|YP_OE|ZN_OE|ZP_OE
+ VDD|XN_OE|XP_OE|YN_OE|YP_OE|ZN_OE|ZP_OE pfet_06v0 L=1U W=10U AS=4.4P AD=2.5P
+ PS=20.88U PD=10.5U
M$557 \$9164 \$9701 \$10841 VDD|XN_OE|XP_OE|YN_OE|YP_OE|ZN_OE|ZP_OE pfet_06v0
+ L=1U W=10U AS=2.5P AD=3.3P PS=10.5U PD=10.66U
M$558 \$10842 \$9701 \$9164 VDD|XN_OE|XP_OE|YN_OE|YP_OE|ZN_OE|ZP_OE pfet_06v0
+ L=1U W=10U AS=3.3P AD=2.5P PS=10.66U PD=10.5U
M$559 VDD|XN_OE|XP_OE|YN_OE|YP_OE|ZN_OE|ZP_OE \$9622 \$10842
+ VDD|XN_OE|XP_OE|YN_OE|YP_OE|ZN_OE|ZP_OE pfet_06v0 L=1U W=10U AS=2.5P AD=4.4P
+ PS=10.5U PD=20.88U
M$560 \$10845 \$9154 VDD|XN_OE|XP_OE|YN_OE|YP_OE|ZN_OE|ZP_OE
+ VDD|XN_OE|XP_OE|YN_OE|YP_OE|ZN_OE|ZP_OE pfet_06v0 L=1U W=10U AS=4.4P AD=2.5P
+ PS=20.88U PD=10.5U
M$561 \$9154 \$9701 \$10845 VDD|XN_OE|XP_OE|YN_OE|YP_OE|ZN_OE|ZP_OE pfet_06v0
+ L=1U W=10U AS=2.5P AD=3.3P PS=10.5U PD=10.66U
M$562 \$9066 \$9066 \$9154 VDD|XN_OE|XP_OE|YN_OE|YP_OE|ZN_OE|ZP_OE pfet_06v0
+ L=1U W=10U AS=3.3P AD=4.4P PS=10.66U PD=20.88U
M$563 \$10846 \$9622 VDD|XN_OE|XP_OE|YN_OE|YP_OE|ZN_OE|ZP_OE
+ VDD|XN_OE|XP_OE|YN_OE|YP_OE|ZN_OE|ZP_OE pfet_06v0 L=1U W=10U AS=4.4P AD=2.5P
+ PS=20.88U PD=10.5U
M$564 \$9119 \$9701 \$10846 VDD|XN_OE|XP_OE|YN_OE|YP_OE|ZN_OE|ZP_OE pfet_06v0
+ L=1U W=10U AS=2.5P AD=4.4P PS=10.5U PD=20.88U
M$565 \$10847 \$9623 VDD|XN_OE|XP_OE|YN_OE|YP_OE|ZN_OE|ZP_OE
+ VDD|XN_OE|XP_OE|YN_OE|YP_OE|ZN_OE|ZP_OE pfet_06v0 L=1U W=10U AS=4.4P AD=2.5P
+ PS=20.88U PD=10.5U
M$566 \$9090 \$9703 \$10847 VDD|XN_OE|XP_OE|YN_OE|YP_OE|ZN_OE|ZP_OE pfet_06v0
+ L=1U W=10U AS=2.5P AD=4.4P PS=10.5U PD=20.88U
M$567 \$10848 \$9623 VDD|XN_OE|XP_OE|YN_OE|YP_OE|ZN_OE|ZP_OE
+ VDD|XN_OE|XP_OE|YN_OE|YP_OE|ZN_OE|ZP_OE pfet_06v0 L=1U W=10U AS=4.4P AD=2.5P
+ PS=20.88U PD=10.5U
M$568 \$9068 \$9703 \$10848 VDD|XN_OE|XP_OE|YN_OE|YP_OE|ZN_OE|ZP_OE pfet_06v0
+ L=1U W=10U AS=2.5P AD=4.4P PS=10.5U PD=20.88U
M$569 \$10849 \$9623 VDD|XN_OE|XP_OE|YN_OE|YP_OE|ZN_OE|ZP_OE
+ VDD|XN_OE|XP_OE|YN_OE|YP_OE|ZN_OE|ZP_OE pfet_06v0 L=1U W=10U AS=4.4P AD=2.5P
+ PS=20.88U PD=10.5U
M$570 \$9623 \$9703 \$10849 VDD|XN_OE|XP_OE|YN_OE|YP_OE|ZN_OE|ZP_OE pfet_06v0
+ L=1U W=10U AS=2.5P AD=4.4P PS=10.5U PD=20.88U
M$571 \$10850 \$9623 VDD|XN_OE|XP_OE|YN_OE|YP_OE|ZN_OE|ZP_OE
+ VDD|XN_OE|XP_OE|YN_OE|YP_OE|ZN_OE|ZP_OE pfet_06v0 L=1U W=10U AS=4.4P AD=2.5P
+ PS=20.88U PD=10.5U
M$572 \$9166 \$9703 \$10850 VDD|XN_OE|XP_OE|YN_OE|YP_OE|ZN_OE|ZP_OE pfet_06v0
+ L=1U W=10U AS=2.5P AD=3.3P PS=10.5U PD=10.66U
M$573 \$10851 \$9703 \$9166 VDD|XN_OE|XP_OE|YN_OE|YP_OE|ZN_OE|ZP_OE pfet_06v0
+ L=1U W=10U AS=3.3P AD=2.5P PS=10.66U PD=10.5U
M$574 VDD|XN_OE|XP_OE|YN_OE|YP_OE|ZN_OE|ZP_OE \$9623 \$10851
+ VDD|XN_OE|XP_OE|YN_OE|YP_OE|ZN_OE|ZP_OE pfet_06v0 L=1U W=10U AS=2.5P AD=4.4P
+ PS=10.5U PD=20.88U
M$575 \$10852 \$9157 VDD|XN_OE|XP_OE|YN_OE|YP_OE|ZN_OE|ZP_OE
+ VDD|XN_OE|XP_OE|YN_OE|YP_OE|ZN_OE|ZP_OE pfet_06v0 L=1U W=10U AS=4.4P AD=2.5P
+ PS=20.88U PD=10.5U
M$576 \$9157 \$9703 \$10852 VDD|XN_OE|XP_OE|YN_OE|YP_OE|ZN_OE|ZP_OE pfet_06v0
+ L=1U W=10U AS=2.5P AD=3.3P PS=10.5U PD=10.66U
M$577 \$9070 \$9070 \$9157 VDD|XN_OE|XP_OE|YN_OE|YP_OE|ZN_OE|ZP_OE pfet_06v0
+ L=1U W=10U AS=3.3P AD=4.4P PS=10.66U PD=20.88U
M$578 \$10853 \$9623 VDD|XN_OE|XP_OE|YN_OE|YP_OE|ZN_OE|ZP_OE
+ VDD|XN_OE|XP_OE|YN_OE|YP_OE|ZN_OE|ZP_OE pfet_06v0 L=1U W=10U AS=4.4P AD=2.5P
+ PS=20.88U PD=10.5U
M$579 \$9120 \$9703 \$10853 VDD|XN_OE|XP_OE|YN_OE|YP_OE|ZN_OE|ZP_OE pfet_06v0
+ L=1U W=10U AS=2.5P AD=4.4P PS=10.5U PD=20.88U
M$580 \$10855 \$9624 VDD|XN_OE|XP_OE|YN_OE|YP_OE|ZN_OE|ZP_OE
+ VDD|XN_OE|XP_OE|YN_OE|YP_OE|ZN_OE|ZP_OE pfet_06v0 L=1U W=10U AS=4.4P AD=2.5P
+ PS=20.88U PD=10.5U
M$581 \$9098 \$9705 \$10855 VDD|XN_OE|XP_OE|YN_OE|YP_OE|ZN_OE|ZP_OE pfet_06v0
+ L=1U W=10U AS=2.5P AD=4.4P PS=10.5U PD=20.88U
M$582 \$10856 \$9624 VDD|XN_OE|XP_OE|YN_OE|YP_OE|ZN_OE|ZP_OE
+ VDD|XN_OE|XP_OE|YN_OE|YP_OE|ZN_OE|ZP_OE pfet_06v0 L=1U W=10U AS=4.4P AD=2.5P
+ PS=20.88U PD=10.5U
M$583 \$9072 \$9705 \$10856 VDD|XN_OE|XP_OE|YN_OE|YP_OE|ZN_OE|ZP_OE pfet_06v0
+ L=1U W=10U AS=2.5P AD=4.4P PS=10.5U PD=20.88U
M$584 \$10857 \$9624 VDD|XN_OE|XP_OE|YN_OE|YP_OE|ZN_OE|ZP_OE
+ VDD|XN_OE|XP_OE|YN_OE|YP_OE|ZN_OE|ZP_OE pfet_06v0 L=1U W=10U AS=4.4P AD=2.5P
+ PS=20.88U PD=10.5U
M$585 \$9624 \$9705 \$10857 VDD|XN_OE|XP_OE|YN_OE|YP_OE|ZN_OE|ZP_OE pfet_06v0
+ L=1U W=10U AS=2.5P AD=4.4P PS=10.5U PD=20.88U
M$586 \$10858 \$9624 VDD|XN_OE|XP_OE|YN_OE|YP_OE|ZN_OE|ZP_OE
+ VDD|XN_OE|XP_OE|YN_OE|YP_OE|ZN_OE|ZP_OE pfet_06v0 L=1U W=10U AS=4.4P AD=2.5P
+ PS=20.88U PD=10.5U
M$587 \$9168 \$9705 \$10858 VDD|XN_OE|XP_OE|YN_OE|YP_OE|ZN_OE|ZP_OE pfet_06v0
+ L=1U W=10U AS=2.5P AD=3.3P PS=10.5U PD=10.66U
M$588 \$10854 \$9705 \$9168 VDD|XN_OE|XP_OE|YN_OE|YP_OE|ZN_OE|ZP_OE pfet_06v0
+ L=1U W=10U AS=3.3P AD=2.5P PS=10.66U PD=10.5U
M$589 VDD|XN_OE|XP_OE|YN_OE|YP_OE|ZN_OE|ZP_OE \$9624 \$10854
+ VDD|XN_OE|XP_OE|YN_OE|YP_OE|ZN_OE|ZP_OE pfet_06v0 L=1U W=10U AS=2.5P AD=4.4P
+ PS=10.5U PD=20.88U
M$590 \$10844 \$9160 VDD|XN_OE|XP_OE|YN_OE|YP_OE|ZN_OE|ZP_OE
+ VDD|XN_OE|XP_OE|YN_OE|YP_OE|ZN_OE|ZP_OE pfet_06v0 L=1U W=10U AS=4.4P AD=2.5P
+ PS=20.88U PD=10.5U
M$591 \$9160 \$9705 \$10844 VDD|XN_OE|XP_OE|YN_OE|YP_OE|ZN_OE|ZP_OE pfet_06v0
+ L=1U W=10U AS=2.5P AD=3.3P PS=10.5U PD=10.66U
M$592 \$9074 \$9074 \$9160 VDD|XN_OE|XP_OE|YN_OE|YP_OE|ZN_OE|ZP_OE pfet_06v0
+ L=1U W=10U AS=3.3P AD=4.4P PS=10.66U PD=20.88U
M$593 \$10843 \$9624 VDD|XN_OE|XP_OE|YN_OE|YP_OE|ZN_OE|ZP_OE
+ VDD|XN_OE|XP_OE|YN_OE|YP_OE|ZN_OE|ZP_OE pfet_06v0 L=1U W=10U AS=4.4P AD=2.5P
+ PS=20.88U PD=10.5U
M$594 \$9121 \$9705 \$10843 VDD|XN_OE|XP_OE|YN_OE|YP_OE|ZN_OE|ZP_OE pfet_06v0
+ L=1U W=10U AS=2.5P AD=4.4P PS=10.5U PD=20.88U
M$595 VDD|XN_OE|XP_OE|YN_OE|YP_OE|ZN_OE|ZP_OE
+ VSS|XN_CS|XN_IE|XN_PD|XN_PDRV0|XN_PDRV1|XN_PU|XN_SL|XP_CS|XP_IE|XP_PD|XP_PDRV0|XP_PDRV1|XP_PU|XP_SL|YN_CS|YN_IE|YN_PD|YN_PDRV0|YN_PDRV1|YN_PU|YN_SL|YP_CS|YP_IE|YP_PD|YP_PDRV0|YP_PDRV1|YP_PU|YP_SL|ZN_CS|ZN_IE|ZN_PD|ZN_PDRV0|ZN_PDRV1|ZN_PU|ZN_SL|ZP_CS|ZP_IE|ZP_PD|ZP_PDRV0|ZP_PDRV1|ZP_PU|ZP_SL
+ VDD|XN_OE|XP_OE|YN_OE|YP_OE|ZN_OE|ZP_OE
+ VDD|XN_OE|XP_OE|YN_OE|YP_OE|ZN_OE|ZP_OE pfet_06v0 L=2U W=9.75U AS=4.29P
+ AD=4.29P PS=20.38U PD=20.38U
M$596 \$9701 \$9701 VDD|XN_OE|XP_OE|YN_OE|YP_OE|ZN_OE|ZP_OE
+ VDD|XN_OE|XP_OE|YN_OE|YP_OE|ZN_OE|ZP_OE pfet_06v0 L=1U W=2U AS=0.88P AD=0.88P
+ PS=4.88U PD=4.88U
M$597 \$9165 \$9701 \$9084 VDD|XN_OE|XP_OE|YN_OE|YP_OE|ZN_OE|ZP_OE pfet_06v0
+ L=1U W=5U AS=2.2P AD=1.3P PS=10.88U PD=5.52U
M$598 \$9084 \$9701 \$9165 VDD|XN_OE|XP_OE|YN_OE|YP_OE|ZN_OE|ZP_OE pfet_06v0
+ L=1U W=5U AS=1.3P AD=2.2P PS=5.52U PD=10.88U
M$599 \$9065 \$9701 \$9083 VDD|XN_OE|XP_OE|YN_OE|YP_OE|ZN_OE|ZP_OE pfet_06v0
+ L=1U W=5U AS=2.2P AD=1.3P PS=10.88U PD=5.52U
M$600 \$9083 \$9701 \$9065 VDD|XN_OE|XP_OE|YN_OE|YP_OE|ZN_OE|ZP_OE pfet_06v0
+ L=1U W=5U AS=1.3P AD=2.2P PS=5.52U PD=10.88U
M$601 \$9084 \$9165 VDD|XN_OE|XP_OE|YN_OE|YP_OE|ZN_OE|ZP_OE
+ VDD|XN_OE|XP_OE|YN_OE|YP_OE|ZN_OE|ZP_OE pfet_06v0 L=1U W=5U AS=2.2P AD=1.3P
+ PS=10.88U PD=5.52U
M$602 VDD|XN_OE|XP_OE|YN_OE|YP_OE|ZN_OE|ZP_OE \$9165 \$9084
+ VDD|XN_OE|XP_OE|YN_OE|YP_OE|ZN_OE|ZP_OE pfet_06v0 L=1U W=5U AS=1.3P AD=1.3P
+ PS=5.52U PD=5.52U
M$603 \$9084 \$9165 VDD|XN_OE|XP_OE|YN_OE|YP_OE|ZN_OE|ZP_OE
+ VDD|XN_OE|XP_OE|YN_OE|YP_OE|ZN_OE|ZP_OE pfet_06v0 L=1U W=5U AS=1.3P AD=1.3P
+ PS=5.52U PD=5.52U
M$604 VDD|XN_OE|XP_OE|YN_OE|YP_OE|ZN_OE|ZP_OE \$9165 \$9084
+ VDD|XN_OE|XP_OE|YN_OE|YP_OE|ZN_OE|ZP_OE pfet_06v0 L=1U W=5U AS=1.3P AD=2.2P
+ PS=5.52U PD=10.88U
M$605 \$9083 \$9165 VDD|XN_OE|XP_OE|YN_OE|YP_OE|ZN_OE|ZP_OE
+ VDD|XN_OE|XP_OE|YN_OE|YP_OE|ZN_OE|ZP_OE pfet_06v0 L=1U W=5U AS=2.2P AD=1.3P
+ PS=10.88U PD=5.52U
M$606 VDD|XN_OE|XP_OE|YN_OE|YP_OE|ZN_OE|ZP_OE \$9165 \$9083
+ VDD|XN_OE|XP_OE|YN_OE|YP_OE|ZN_OE|ZP_OE pfet_06v0 L=1U W=5U AS=1.3P AD=1.3P
+ PS=5.52U PD=5.52U
M$607 \$9083 \$9165 VDD|XN_OE|XP_OE|YN_OE|YP_OE|ZN_OE|ZP_OE
+ VDD|XN_OE|XP_OE|YN_OE|YP_OE|ZN_OE|ZP_OE pfet_06v0 L=1U W=5U AS=1.3P AD=1.3P
+ PS=5.52U PD=5.52U
M$608 VDD|XN_OE|XP_OE|YN_OE|YP_OE|ZN_OE|ZP_OE \$9165 \$9083
+ VDD|XN_OE|XP_OE|YN_OE|YP_OE|ZN_OE|ZP_OE pfet_06v0 L=1U W=5U AS=1.3P AD=2.2P
+ PS=5.52U PD=10.88U
M$609 \$9086 \$9066 \$9165 VDD|XN_OE|XP_OE|YN_OE|YP_OE|ZN_OE|ZP_OE pfet_06v0
+ L=1U W=5U AS=2.2P AD=2.2P PS=10.88U PD=10.88U
M$610 \$9088 \$9066 \$9065 VDD|XN_OE|XP_OE|YN_OE|YP_OE|ZN_OE|ZP_OE pfet_06v0
+ L=1U W=5U AS=2.2P AD=2.2P PS=10.88U PD=10.88U
M$611 VDD|XN_OE|XP_OE|YN_OE|YP_OE|ZN_OE|ZP_OE
+ VSS|XN_CS|XN_IE|XN_PD|XN_PDRV0|XN_PDRV1|XN_PU|XN_SL|XP_CS|XP_IE|XP_PD|XP_PDRV0|XP_PDRV1|XP_PU|XP_SL|YN_CS|YN_IE|YN_PD|YN_PDRV0|YN_PDRV1|YN_PU|YN_SL|YP_CS|YP_IE|YP_PD|YP_PDRV0|YP_PDRV1|YP_PU|YP_SL|ZN_CS|ZN_IE|ZN_PD|ZN_PDRV0|ZN_PDRV1|ZN_PU|ZN_SL|ZP_CS|ZP_IE|ZP_PD|ZP_PDRV0|ZP_PDRV1|ZP_PU|ZP_SL
+ VDD|XN_OE|XP_OE|YN_OE|YP_OE|ZN_OE|ZP_OE
+ VDD|XN_OE|XP_OE|YN_OE|YP_OE|ZN_OE|ZP_OE pfet_06v0 L=2U W=9.75U AS=4.29P
+ AD=4.29P PS=20.38U PD=20.38U
M$612 VDD|XN_OE|XP_OE|YN_OE|YP_OE|ZN_OE|ZP_OE
+ VSS|XN_CS|XN_IE|XN_PD|XN_PDRV0|XN_PDRV1|XN_PU|XN_SL|XP_CS|XP_IE|XP_PD|XP_PDRV0|XP_PDRV1|XP_PU|XP_SL|YN_CS|YN_IE|YN_PD|YN_PDRV0|YN_PDRV1|YN_PU|YN_SL|YP_CS|YP_IE|YP_PD|YP_PDRV0|YP_PDRV1|YP_PU|YP_SL|ZN_CS|ZN_IE|ZN_PD|ZN_PDRV0|ZN_PDRV1|ZN_PU|ZN_SL|ZP_CS|ZP_IE|ZP_PD|ZP_PDRV0|ZP_PDRV1|ZP_PU|ZP_SL
+ VDD|XN_OE|XP_OE|YN_OE|YP_OE|ZN_OE|ZP_OE
+ VDD|XN_OE|XP_OE|YN_OE|YP_OE|ZN_OE|ZP_OE pfet_06v0 L=2U W=9.75U AS=4.29P
+ AD=4.29P PS=20.38U PD=20.38U
M$613 \$9703 \$9703 VDD|XN_OE|XP_OE|YN_OE|YP_OE|ZN_OE|ZP_OE
+ VDD|XN_OE|XP_OE|YN_OE|YP_OE|ZN_OE|ZP_OE pfet_06v0 L=1U W=2U AS=0.88P AD=0.88P
+ PS=4.88U PD=4.88U
M$614 \$9167 \$9703 \$9093 VDD|XN_OE|XP_OE|YN_OE|YP_OE|ZN_OE|ZP_OE pfet_06v0
+ L=1U W=5U AS=2.2P AD=1.3P PS=10.88U PD=5.52U
M$615 \$9093 \$9703 \$9167 VDD|XN_OE|XP_OE|YN_OE|YP_OE|ZN_OE|ZP_OE pfet_06v0
+ L=1U W=5U AS=1.3P AD=2.2P PS=5.52U PD=10.88U
M$616 \$9069 \$9703 \$9092 VDD|XN_OE|XP_OE|YN_OE|YP_OE|ZN_OE|ZP_OE pfet_06v0
+ L=1U W=5U AS=2.2P AD=1.3P PS=10.88U PD=5.52U
M$617 \$9092 \$9703 \$9069 VDD|XN_OE|XP_OE|YN_OE|YP_OE|ZN_OE|ZP_OE pfet_06v0
+ L=1U W=5U AS=1.3P AD=2.2P PS=5.52U PD=10.88U
M$618 \$9093 \$9167 VDD|XN_OE|XP_OE|YN_OE|YP_OE|ZN_OE|ZP_OE
+ VDD|XN_OE|XP_OE|YN_OE|YP_OE|ZN_OE|ZP_OE pfet_06v0 L=1U W=5U AS=2.2P AD=1.3P
+ PS=10.88U PD=5.52U
M$619 VDD|XN_OE|XP_OE|YN_OE|YP_OE|ZN_OE|ZP_OE \$9167 \$9093
+ VDD|XN_OE|XP_OE|YN_OE|YP_OE|ZN_OE|ZP_OE pfet_06v0 L=1U W=5U AS=1.3P AD=1.3P
+ PS=5.52U PD=5.52U
M$620 \$9093 \$9167 VDD|XN_OE|XP_OE|YN_OE|YP_OE|ZN_OE|ZP_OE
+ VDD|XN_OE|XP_OE|YN_OE|YP_OE|ZN_OE|ZP_OE pfet_06v0 L=1U W=5U AS=1.3P AD=1.3P
+ PS=5.52U PD=5.52U
M$621 VDD|XN_OE|XP_OE|YN_OE|YP_OE|ZN_OE|ZP_OE \$9167 \$9093
+ VDD|XN_OE|XP_OE|YN_OE|YP_OE|ZN_OE|ZP_OE pfet_06v0 L=1U W=5U AS=1.3P AD=2.2P
+ PS=5.52U PD=10.88U
M$622 \$9092 \$9167 VDD|XN_OE|XP_OE|YN_OE|YP_OE|ZN_OE|ZP_OE
+ VDD|XN_OE|XP_OE|YN_OE|YP_OE|ZN_OE|ZP_OE pfet_06v0 L=1U W=5U AS=2.2P AD=1.3P
+ PS=10.88U PD=5.52U
M$623 VDD|XN_OE|XP_OE|YN_OE|YP_OE|ZN_OE|ZP_OE \$9167 \$9092
+ VDD|XN_OE|XP_OE|YN_OE|YP_OE|ZN_OE|ZP_OE pfet_06v0 L=1U W=5U AS=1.3P AD=1.3P
+ PS=5.52U PD=5.52U
M$624 \$9092 \$9167 VDD|XN_OE|XP_OE|YN_OE|YP_OE|ZN_OE|ZP_OE
+ VDD|XN_OE|XP_OE|YN_OE|YP_OE|ZN_OE|ZP_OE pfet_06v0 L=1U W=5U AS=1.3P AD=1.3P
+ PS=5.52U PD=5.52U
M$625 VDD|XN_OE|XP_OE|YN_OE|YP_OE|ZN_OE|ZP_OE \$9167 \$9092
+ VDD|XN_OE|XP_OE|YN_OE|YP_OE|ZN_OE|ZP_OE pfet_06v0 L=1U W=5U AS=1.3P AD=2.2P
+ PS=5.52U PD=10.88U
M$626 \$9095 \$9070 \$9167 VDD|XN_OE|XP_OE|YN_OE|YP_OE|ZN_OE|ZP_OE pfet_06v0
+ L=1U W=5U AS=2.2P AD=2.2P PS=10.88U PD=10.88U
M$627 \$9097 \$9070 \$9069 VDD|XN_OE|XP_OE|YN_OE|YP_OE|ZN_OE|ZP_OE pfet_06v0
+ L=1U W=5U AS=2.2P AD=2.2P PS=10.88U PD=10.88U
M$628 VDD|XN_OE|XP_OE|YN_OE|YP_OE|ZN_OE|ZP_OE
+ VSS|XN_CS|XN_IE|XN_PD|XN_PDRV0|XN_PDRV1|XN_PU|XN_SL|XP_CS|XP_IE|XP_PD|XP_PDRV0|XP_PDRV1|XP_PU|XP_SL|YN_CS|YN_IE|YN_PD|YN_PDRV0|YN_PDRV1|YN_PU|YN_SL|YP_CS|YP_IE|YP_PD|YP_PDRV0|YP_PDRV1|YP_PU|YP_SL|ZN_CS|ZN_IE|ZN_PD|ZN_PDRV0|ZN_PDRV1|ZN_PU|ZN_SL|ZP_CS|ZP_IE|ZP_PD|ZP_PDRV0|ZP_PDRV1|ZP_PU|ZP_SL
+ VDD|XN_OE|XP_OE|YN_OE|YP_OE|ZN_OE|ZP_OE
+ VDD|XN_OE|XP_OE|YN_OE|YP_OE|ZN_OE|ZP_OE pfet_06v0 L=2U W=9.75U AS=4.29P
+ AD=4.29P PS=20.38U PD=20.38U
M$629 VDD|XN_OE|XP_OE|YN_OE|YP_OE|ZN_OE|ZP_OE
+ VSS|XN_CS|XN_IE|XN_PD|XN_PDRV0|XN_PDRV1|XN_PU|XN_SL|XP_CS|XP_IE|XP_PD|XP_PDRV0|XP_PDRV1|XP_PU|XP_SL|YN_CS|YN_IE|YN_PD|YN_PDRV0|YN_PDRV1|YN_PU|YN_SL|YP_CS|YP_IE|YP_PD|YP_PDRV0|YP_PDRV1|YP_PU|YP_SL|ZN_CS|ZN_IE|ZN_PD|ZN_PDRV0|ZN_PDRV1|ZN_PU|ZN_SL|ZP_CS|ZP_IE|ZP_PD|ZP_PDRV0|ZP_PDRV1|ZP_PU|ZP_SL
+ VDD|XN_OE|XP_OE|YN_OE|YP_OE|ZN_OE|ZP_OE
+ VDD|XN_OE|XP_OE|YN_OE|YP_OE|ZN_OE|ZP_OE pfet_06v0 L=2U W=9.75U AS=4.29P
+ AD=4.29P PS=20.38U PD=20.38U
M$630 \$9705 \$9705 VDD|XN_OE|XP_OE|YN_OE|YP_OE|ZN_OE|ZP_OE
+ VDD|XN_OE|XP_OE|YN_OE|YP_OE|ZN_OE|ZP_OE pfet_06v0 L=1U W=2U AS=0.88P AD=0.88P
+ PS=4.88U PD=4.88U
M$631 \$9169 \$9705 \$9101 VDD|XN_OE|XP_OE|YN_OE|YP_OE|ZN_OE|ZP_OE pfet_06v0
+ L=1U W=5U AS=2.2P AD=1.3P PS=10.88U PD=5.52U
M$632 \$9101 \$9705 \$9169 VDD|XN_OE|XP_OE|YN_OE|YP_OE|ZN_OE|ZP_OE pfet_06v0
+ L=1U W=5U AS=1.3P AD=2.2P PS=5.52U PD=10.88U
M$633 \$9073 \$9705 \$9100 VDD|XN_OE|XP_OE|YN_OE|YP_OE|ZN_OE|ZP_OE pfet_06v0
+ L=1U W=5U AS=2.2P AD=1.3P PS=10.88U PD=5.52U
M$634 \$9100 \$9705 \$9073 VDD|XN_OE|XP_OE|YN_OE|YP_OE|ZN_OE|ZP_OE pfet_06v0
+ L=1U W=5U AS=1.3P AD=2.2P PS=5.52U PD=10.88U
M$635 \$9101 \$9169 VDD|XN_OE|XP_OE|YN_OE|YP_OE|ZN_OE|ZP_OE
+ VDD|XN_OE|XP_OE|YN_OE|YP_OE|ZN_OE|ZP_OE pfet_06v0 L=1U W=5U AS=2.2P AD=1.3P
+ PS=10.88U PD=5.52U
M$636 VDD|XN_OE|XP_OE|YN_OE|YP_OE|ZN_OE|ZP_OE \$9169 \$9101
+ VDD|XN_OE|XP_OE|YN_OE|YP_OE|ZN_OE|ZP_OE pfet_06v0 L=1U W=5U AS=1.3P AD=1.3P
+ PS=5.52U PD=5.52U
M$637 \$9101 \$9169 VDD|XN_OE|XP_OE|YN_OE|YP_OE|ZN_OE|ZP_OE
+ VDD|XN_OE|XP_OE|YN_OE|YP_OE|ZN_OE|ZP_OE pfet_06v0 L=1U W=5U AS=1.3P AD=1.3P
+ PS=5.52U PD=5.52U
M$638 VDD|XN_OE|XP_OE|YN_OE|YP_OE|ZN_OE|ZP_OE \$9169 \$9101
+ VDD|XN_OE|XP_OE|YN_OE|YP_OE|ZN_OE|ZP_OE pfet_06v0 L=1U W=5U AS=1.3P AD=2.2P
+ PS=5.52U PD=10.88U
M$639 \$9100 \$9169 VDD|XN_OE|XP_OE|YN_OE|YP_OE|ZN_OE|ZP_OE
+ VDD|XN_OE|XP_OE|YN_OE|YP_OE|ZN_OE|ZP_OE pfet_06v0 L=1U W=5U AS=2.2P AD=1.3P
+ PS=10.88U PD=5.52U
M$640 VDD|XN_OE|XP_OE|YN_OE|YP_OE|ZN_OE|ZP_OE \$9169 \$9100
+ VDD|XN_OE|XP_OE|YN_OE|YP_OE|ZN_OE|ZP_OE pfet_06v0 L=1U W=5U AS=1.3P AD=1.3P
+ PS=5.52U PD=5.52U
M$641 \$9100 \$9169 VDD|XN_OE|XP_OE|YN_OE|YP_OE|ZN_OE|ZP_OE
+ VDD|XN_OE|XP_OE|YN_OE|YP_OE|ZN_OE|ZP_OE pfet_06v0 L=1U W=5U AS=1.3P AD=1.3P
+ PS=5.52U PD=5.52U
M$642 VDD|XN_OE|XP_OE|YN_OE|YP_OE|ZN_OE|ZP_OE \$9169 \$9100
+ VDD|XN_OE|XP_OE|YN_OE|YP_OE|ZN_OE|ZP_OE pfet_06v0 L=1U W=5U AS=1.3P AD=2.2P
+ PS=5.52U PD=10.88U
M$643 \$9103 \$9074 \$9169 VDD|XN_OE|XP_OE|YN_OE|YP_OE|ZN_OE|ZP_OE pfet_06v0
+ L=1U W=5U AS=2.2P AD=2.2P PS=10.88U PD=10.88U
M$644 \$9105 \$9074 \$9073 VDD|XN_OE|XP_OE|YN_OE|YP_OE|ZN_OE|ZP_OE pfet_06v0
+ L=1U W=5U AS=2.2P AD=2.2P PS=10.88U PD=10.88U
M$645 VDD|XN_OE|XP_OE|YN_OE|YP_OE|ZN_OE|ZP_OE
+ VSS|XN_CS|XN_IE|XN_PD|XN_PDRV0|XN_PDRV1|XN_PU|XN_SL|XP_CS|XP_IE|XP_PD|XP_PDRV0|XP_PDRV1|XP_PU|XP_SL|YN_CS|YN_IE|YN_PD|YN_PDRV0|YN_PDRV1|YN_PU|YN_SL|YP_CS|YP_IE|YP_PD|YP_PDRV0|YP_PDRV1|YP_PU|YP_SL|ZN_CS|ZN_IE|ZN_PD|ZN_PDRV0|ZN_PDRV1|ZN_PU|ZN_SL|ZP_CS|ZP_IE|ZP_PD|ZP_PDRV0|ZP_PDRV1|ZP_PU|ZP_SL
+ VDD|XN_OE|XP_OE|YN_OE|YP_OE|ZN_OE|ZP_OE
+ VDD|XN_OE|XP_OE|YN_OE|YP_OE|ZN_OE|ZP_OE pfet_06v0 L=2U W=9.75U AS=4.29P
+ AD=4.29P PS=20.38U PD=20.38U
M$646 VDD|XN_OE|XP_OE|YN_OE|YP_OE|ZN_OE|ZP_OE
+ VSS|XN_CS|XN_IE|XN_PD|XN_PDRV0|XN_PDRV1|XN_PU|XN_SL|XP_CS|XP_IE|XP_PD|XP_PDRV0|XP_PDRV1|XP_PU|XP_SL|YN_CS|YN_IE|YN_PD|YN_PDRV0|YN_PDRV1|YN_PU|YN_SL|YP_CS|YP_IE|YP_PD|YP_PDRV0|YP_PDRV1|YP_PU|YP_SL|ZN_CS|ZN_IE|ZN_PD|ZN_PDRV0|ZN_PDRV1|ZN_PU|ZN_SL|ZP_CS|ZP_IE|ZP_PD|ZP_PDRV0|ZP_PDRV1|ZP_PU|ZP_SL
+ VDD|XN_OE|XP_OE|YN_OE|YP_OE|ZN_OE|ZP_OE
+ VDD|XN_OE|XP_OE|YN_OE|YP_OE|ZN_OE|ZP_OE pfet_06v0 L=2U W=9.75U AS=4.29P
+ AD=4.29P PS=20.38U PD=20.38U
M$647 Y Y VDD|XN_OE|XP_OE|YN_OE|YP_OE|ZN_OE|ZP_OE
+ VDD|XN_OE|XP_OE|YN_OE|YP_OE|ZN_OE|ZP_OE pfet_06v0 L=1U W=2U AS=0.88P AD=0.52P
+ PS=4.88U PD=2.52U
M$648 VDD|XN_OE|XP_OE|YN_OE|YP_OE|ZN_OE|ZP_OE Y Y
+ VDD|XN_OE|XP_OE|YN_OE|YP_OE|ZN_OE|ZP_OE pfet_06v0 L=1U W=2U AS=0.52P AD=0.52P
+ PS=2.52U PD=2.52U
M$649 Y Y VDD|XN_OE|XP_OE|YN_OE|YP_OE|ZN_OE|ZP_OE
+ VDD|XN_OE|XP_OE|YN_OE|YP_OE|ZN_OE|ZP_OE pfet_06v0 L=1U W=2U AS=0.52P AD=0.52P
+ PS=2.52U PD=2.52U
M$650 VDD|XN_OE|XP_OE|YN_OE|YP_OE|ZN_OE|ZP_OE Y Y
+ VDD|XN_OE|XP_OE|YN_OE|YP_OE|ZN_OE|ZP_OE pfet_06v0 L=1U W=2U AS=0.52P AD=0.52P
+ PS=2.52U PD=2.52U
M$651 Y Y VDD|XN_OE|XP_OE|YN_OE|YP_OE|ZN_OE|ZP_OE
+ VDD|XN_OE|XP_OE|YN_OE|YP_OE|ZN_OE|ZP_OE pfet_06v0 L=1U W=2U AS=0.52P AD=0.52P
+ PS=2.52U PD=2.52U
M$652 VDD|XN_OE|XP_OE|YN_OE|YP_OE|ZN_OE|ZP_OE Y Y
+ VDD|XN_OE|XP_OE|YN_OE|YP_OE|ZN_OE|ZP_OE pfet_06v0 L=1U W=2U AS=0.52P AD=0.88P
+ PS=2.52U PD=4.88U
M$653 \$9076 \$9076 VDD|XN_OE|XP_OE|YN_OE|YP_OE|ZN_OE|ZP_OE
+ VDD|XN_OE|XP_OE|YN_OE|YP_OE|ZN_OE|ZP_OE pfet_06v0 L=1U W=2U AS=0.88P AD=0.88P
+ PS=4.88U PD=4.88U
M$654 VDD|XN_OE|XP_OE|YN_OE|YP_OE|ZN_OE|ZP_OE
+ VSS|XN_CS|XN_IE|XN_PD|XN_PDRV0|XN_PDRV1|XN_PU|XN_SL|XP_CS|XP_IE|XP_PD|XP_PDRV0|XP_PDRV1|XP_PU|XP_SL|YN_CS|YN_IE|YN_PD|YN_PDRV0|YN_PDRV1|YN_PU|YN_SL|YP_CS|YP_IE|YP_PD|YP_PDRV0|YP_PDRV1|YP_PU|YP_SL|ZN_CS|ZN_IE|ZN_PD|ZN_PDRV0|ZN_PDRV1|ZN_PU|ZN_SL|ZP_CS|ZP_IE|ZP_PD|ZP_PDRV0|ZP_PDRV1|ZP_PU|ZP_SL
+ VDD|XN_OE|XP_OE|YN_OE|YP_OE|ZN_OE|ZP_OE
+ VDD|XN_OE|XP_OE|YN_OE|YP_OE|ZN_OE|ZP_OE pfet_06v0 L=2U W=1U AS=0.44P AD=0.44P
+ PS=2.88U PD=2.88U
M$655 VDD|XN_OE|XP_OE|YN_OE|YP_OE|ZN_OE|ZP_OE
+ VSS|XN_CS|XN_IE|XN_PD|XN_PDRV0|XN_PDRV1|XN_PU|XN_SL|XP_CS|XP_IE|XP_PD|XP_PDRV0|XP_PDRV1|XP_PU|XP_SL|YN_CS|YN_IE|YN_PD|YN_PDRV0|YN_PDRV1|YN_PU|YN_SL|YP_CS|YP_IE|YP_PD|YP_PDRV0|YP_PDRV1|YP_PU|YP_SL|ZN_CS|ZN_IE|ZN_PD|ZN_PDRV0|ZN_PDRV1|ZN_PU|ZN_SL|ZP_CS|ZP_IE|ZP_PD|ZP_PDRV0|ZP_PDRV1|ZP_PU|ZP_SL
+ VDD|XN_OE|XP_OE|YN_OE|YP_OE|ZN_OE|ZP_OE
+ VDD|XN_OE|XP_OE|YN_OE|YP_OE|ZN_OE|ZP_OE pfet_06v0 L=2U W=1U AS=0.44P AD=0.44P
+ PS=2.88U PD=2.88U
M$656 \$10879 \$10888 VDD|XN_OE|XP_OE|YN_OE|YP_OE|ZN_OE|ZP_OE
+ VDD|XN_OE|XP_OE|YN_OE|YP_OE|ZN_OE|ZP_OE pfet_06v0 L=1U W=3U AS=1.32P AD=1.32P
+ PS=6.88U PD=6.88U
M$657 \$9148 \$10906 VDD|XN_OE|XP_OE|YN_OE|YP_OE|ZN_OE|ZP_OE
+ VDD|XN_OE|XP_OE|YN_OE|YP_OE|ZN_OE|ZP_OE pfet_06v0 L=1U W=3U AS=1.32P AD=1.32P
+ PS=6.88U PD=6.88U
M$658 \$10906 \$10905 VDD|XN_OE|XP_OE|YN_OE|YP_OE|ZN_OE|ZP_OE
+ VDD|XN_OE|XP_OE|YN_OE|YP_OE|ZN_OE|ZP_OE pfet_06v0 L=1U W=3U AS=1.32P AD=0.99P
+ PS=6.88U PD=3.66U
M$659 VDD|XN_OE|XP_OE|YN_OE|YP_OE|ZN_OE|ZP_OE \$10879 \$10906
+ VDD|XN_OE|XP_OE|YN_OE|YP_OE|ZN_OE|ZP_OE pfet_06v0 L=1U W=3U AS=0.99P AD=1.32P
+ PS=3.66U PD=6.88U
M$660 \$10965 \$10905 \$10920 VDD|XN_OE|XP_OE|YN_OE|YP_OE|ZN_OE|ZP_OE pfet_06v0
+ L=1U W=3U AS=1.32P AD=0.75P PS=6.88U PD=3.5U
M$661 VDD|XN_OE|XP_OE|YN_OE|YP_OE|ZN_OE|ZP_OE \$10907 \$10965
+ VDD|XN_OE|XP_OE|YN_OE|YP_OE|ZN_OE|ZP_OE pfet_06v0 L=1U W=3U AS=0.75P AD=1.32P
+ PS=3.5U PD=6.88U
M$662 \$7345 \$10908 VDD|XN_OE|XP_OE|YN_OE|YP_OE|ZN_OE|ZP_OE
+ VDD|XN_OE|XP_OE|YN_OE|YP_OE|ZN_OE|ZP_OE pfet_06v0 L=1U W=3U AS=1.32P AD=1.32P
+ PS=6.88U PD=6.88U
M$663 \$10908 \$10888 VDD|XN_OE|XP_OE|YN_OE|YP_OE|ZN_OE|ZP_OE
+ VDD|XN_OE|XP_OE|YN_OE|YP_OE|ZN_OE|ZP_OE pfet_06v0 L=1U W=3U AS=1.32P AD=0.99P
+ PS=6.88U PD=3.66U
M$664 VDD|XN_OE|XP_OE|YN_OE|YP_OE|ZN_OE|ZP_OE \$10907 \$10908
+ VDD|XN_OE|XP_OE|YN_OE|YP_OE|ZN_OE|ZP_OE pfet_06v0 L=1U W=3U AS=0.99P AD=1.32P
+ PS=3.66U PD=6.88U
M$665 VDD|XN_OE|XP_OE|YN_OE|YP_OE|ZN_OE|ZP_OE
+ VSS|XN_CS|XN_IE|XN_PD|XN_PDRV0|XN_PDRV1|XN_PU|XN_SL|XP_CS|XP_IE|XP_PD|XP_PDRV0|XP_PDRV1|XP_PU|XP_SL|YN_CS|YN_IE|YN_PD|YN_PDRV0|YN_PDRV1|YN_PU|YN_SL|YP_CS|YP_IE|YP_PD|YP_PDRV0|YP_PDRV1|YP_PU|YP_SL|ZN_CS|ZN_IE|ZN_PD|ZN_PDRV0|ZN_PDRV1|ZN_PU|ZN_SL|ZP_CS|ZP_IE|ZP_PD|ZP_PDRV0|ZP_PDRV1|ZP_PU|ZP_SL
+ VDD|XN_OE|XP_OE|YN_OE|YP_OE|ZN_OE|ZP_OE
+ VDD|XN_OE|XP_OE|YN_OE|YP_OE|ZN_OE|ZP_OE pfet_06v0 L=2U W=1U AS=0.44P AD=0.44P
+ PS=2.88U PD=2.88U
M$666 \$10886 \$2457 \$10962 VDD|XN_OE|XP_OE|YN_OE|YP_OE|ZN_OE|ZP_OE pfet_06v0
+ L=1U W=10U AS=4.4P AD=2.6P PS=20.88U PD=10.52U
M$667 \$10962 \$2457 \$10886 VDD|XN_OE|XP_OE|YN_OE|YP_OE|ZN_OE|ZP_OE pfet_06v0
+ L=1U W=10U AS=2.6P AD=4.4P PS=10.52U PD=20.88U
M$668 \$10884 \$4856 \$10962 VDD|XN_OE|XP_OE|YN_OE|YP_OE|ZN_OE|ZP_OE pfet_06v0
+ L=1U W=10U AS=4.4P AD=2.6P PS=20.88U PD=10.52U
M$669 \$10962 \$4856 \$10884 VDD|XN_OE|XP_OE|YN_OE|YP_OE|ZN_OE|ZP_OE pfet_06v0
+ L=1U W=10U AS=2.6P AD=4.4P PS=10.52U PD=20.88U
M$670 \$10888 \$10867 VDD|XN_OE|XP_OE|YN_OE|YP_OE|ZN_OE|ZP_OE
+ VDD|XN_OE|XP_OE|YN_OE|YP_OE|ZN_OE|ZP_OE pfet_06v0 L=1U W=10U AS=4.4P AD=2.6P
+ PS=20.88U PD=10.52U
M$671 VDD|XN_OE|XP_OE|YN_OE|YP_OE|ZN_OE|ZP_OE \$10867 \$10888
+ VDD|XN_OE|XP_OE|YN_OE|YP_OE|ZN_OE|ZP_OE pfet_06v0 L=1U W=10U AS=2.6P AD=2.6P
+ PS=10.52U PD=10.52U
M$672 \$10888 \$10867 VDD|XN_OE|XP_OE|YN_OE|YP_OE|ZN_OE|ZP_OE
+ VDD|XN_OE|XP_OE|YN_OE|YP_OE|ZN_OE|ZP_OE pfet_06v0 L=1U W=10U AS=2.6P AD=4.4P
+ PS=10.52U PD=20.88U
M$673 \$10895 \$2465 \$10963 VDD|XN_OE|XP_OE|YN_OE|YP_OE|ZN_OE|ZP_OE pfet_06v0
+ L=1U W=10U AS=4.4P AD=2.6P PS=20.88U PD=10.52U
M$674 \$10963 \$2465 \$10895 VDD|XN_OE|XP_OE|YN_OE|YP_OE|ZN_OE|ZP_OE pfet_06v0
+ L=1U W=10U AS=2.6P AD=4.4P PS=10.52U PD=20.88U
M$675 \$10893 \$4856 \$10963 VDD|XN_OE|XP_OE|YN_OE|YP_OE|ZN_OE|ZP_OE pfet_06v0
+ L=1U W=10U AS=4.4P AD=2.6P PS=20.88U PD=10.52U
M$676 \$10963 \$4856 \$10893 VDD|XN_OE|XP_OE|YN_OE|YP_OE|ZN_OE|ZP_OE pfet_06v0
+ L=1U W=10U AS=2.6P AD=4.4P PS=10.52U PD=20.88U
M$677 \$10907 \$10871 VDD|XN_OE|XP_OE|YN_OE|YP_OE|ZN_OE|ZP_OE
+ VDD|XN_OE|XP_OE|YN_OE|YP_OE|ZN_OE|ZP_OE pfet_06v0 L=1U W=10U AS=4.4P AD=2.6P
+ PS=20.88U PD=10.52U
M$678 VDD|XN_OE|XP_OE|YN_OE|YP_OE|ZN_OE|ZP_OE \$10871 \$10907
+ VDD|XN_OE|XP_OE|YN_OE|YP_OE|ZN_OE|ZP_OE pfet_06v0 L=1U W=10U AS=2.6P AD=2.6P
+ PS=10.52U PD=10.52U
M$679 \$10907 \$10871 VDD|XN_OE|XP_OE|YN_OE|YP_OE|ZN_OE|ZP_OE
+ VDD|XN_OE|XP_OE|YN_OE|YP_OE|ZN_OE|ZP_OE pfet_06v0 L=1U W=10U AS=2.6P AD=4.4P
+ PS=10.52U PD=20.88U
M$680 \$10903 \$2465 \$10964 VDD|XN_OE|XP_OE|YN_OE|YP_OE|ZN_OE|ZP_OE pfet_06v0
+ L=1U W=10U AS=4.4P AD=2.6P PS=20.88U PD=10.52U
M$681 \$10964 \$2465 \$10903 VDD|XN_OE|XP_OE|YN_OE|YP_OE|ZN_OE|ZP_OE pfet_06v0
+ L=1U W=10U AS=2.6P AD=4.4P PS=10.52U PD=20.88U
M$682 \$10901 \$2457 \$10964 VDD|XN_OE|XP_OE|YN_OE|YP_OE|ZN_OE|ZP_OE pfet_06v0
+ L=1U W=10U AS=4.4P AD=2.6P PS=20.88U PD=10.52U
M$683 \$10964 \$2457 \$10901 VDD|XN_OE|XP_OE|YN_OE|YP_OE|ZN_OE|ZP_OE pfet_06v0
+ L=1U W=10U AS=2.6P AD=4.4P PS=10.52U PD=20.88U
M$684 \$10905 \$10875 VDD|XN_OE|XP_OE|YN_OE|YP_OE|ZN_OE|ZP_OE
+ VDD|XN_OE|XP_OE|YN_OE|YP_OE|ZN_OE|ZP_OE pfet_06v0 L=1U W=10U AS=4.4P AD=2.6P
+ PS=20.88U PD=10.52U
M$685 VDD|XN_OE|XP_OE|YN_OE|YP_OE|ZN_OE|ZP_OE \$10875 \$10905
+ VDD|XN_OE|XP_OE|YN_OE|YP_OE|ZN_OE|ZP_OE pfet_06v0 L=1U W=10U AS=2.6P AD=2.6P
+ PS=10.52U PD=10.52U
M$686 \$10905 \$10875 VDD|XN_OE|XP_OE|YN_OE|YP_OE|ZN_OE|ZP_OE
+ VDD|XN_OE|XP_OE|YN_OE|YP_OE|ZN_OE|ZP_OE pfet_06v0 L=1U W=10U AS=2.6P AD=4.4P
+ PS=10.52U PD=20.88U
M$687 \$12633 \$11420 VDD|XN_OE|XP_OE|YN_OE|YP_OE|ZN_OE|ZP_OE
+ VDD|XN_OE|XP_OE|YN_OE|YP_OE|ZN_OE|ZP_OE pfet_06v0 L=1U W=10U AS=4.4P AD=2.5P
+ PS=20.88U PD=10.5U
M$688 \$10880 \$11421 \$12633 VDD|XN_OE|XP_OE|YN_OE|YP_OE|ZN_OE|ZP_OE pfet_06v0
+ L=1U W=10U AS=2.5P AD=4.4P PS=10.5U PD=20.88U
M$689 \$12634 \$11420 VDD|XN_OE|XP_OE|YN_OE|YP_OE|ZN_OE|ZP_OE
+ VDD|XN_OE|XP_OE|YN_OE|YP_OE|ZN_OE|ZP_OE pfet_06v0 L=1U W=10U AS=4.4P AD=2.5P
+ PS=20.88U PD=10.5U
M$690 \$10866 \$11421 \$12634 VDD|XN_OE|XP_OE|YN_OE|YP_OE|ZN_OE|ZP_OE pfet_06v0
+ L=1U W=10U AS=2.5P AD=4.4P PS=10.5U PD=20.88U
M$691 \$12635 \$11420 VDD|XN_OE|XP_OE|YN_OE|YP_OE|ZN_OE|ZP_OE
+ VDD|XN_OE|XP_OE|YN_OE|YP_OE|ZN_OE|ZP_OE pfet_06v0 L=1U W=10U AS=4.4P AD=2.5P
+ PS=20.88U PD=10.5U
M$692 \$11420 \$11421 \$12635 VDD|XN_OE|XP_OE|YN_OE|YP_OE|ZN_OE|ZP_OE pfet_06v0
+ L=1U W=10U AS=2.5P AD=4.4P PS=10.5U PD=20.88U
M$693 \$12636 \$11420 VDD|XN_OE|XP_OE|YN_OE|YP_OE|ZN_OE|ZP_OE
+ VDD|XN_OE|XP_OE|YN_OE|YP_OE|ZN_OE|ZP_OE pfet_06v0 L=1U W=10U AS=4.4P AD=2.5P
+ PS=20.88U PD=10.5U
M$694 \$10962 \$11421 \$12636 VDD|XN_OE|XP_OE|YN_OE|YP_OE|ZN_OE|ZP_OE pfet_06v0
+ L=1U W=10U AS=2.5P AD=3.3P PS=10.5U PD=10.66U
M$695 \$12637 \$11421 \$10962 VDD|XN_OE|XP_OE|YN_OE|YP_OE|ZN_OE|ZP_OE pfet_06v0
+ L=1U W=10U AS=3.3P AD=2.5P PS=10.66U PD=10.5U
M$696 VDD|XN_OE|XP_OE|YN_OE|YP_OE|ZN_OE|ZP_OE \$11420 \$12637
+ VDD|XN_OE|XP_OE|YN_OE|YP_OE|ZN_OE|ZP_OE pfet_06v0 L=1U W=10U AS=2.5P AD=4.4P
+ PS=10.5U PD=20.88U
M$697 \$12638 \$10951 VDD|XN_OE|XP_OE|YN_OE|YP_OE|ZN_OE|ZP_OE
+ VDD|XN_OE|XP_OE|YN_OE|YP_OE|ZN_OE|ZP_OE pfet_06v0 L=1U W=10U AS=4.4P AD=2.5P
+ PS=20.88U PD=10.5U
M$698 \$10951 \$11421 \$12638 VDD|XN_OE|XP_OE|YN_OE|YP_OE|ZN_OE|ZP_OE pfet_06v0
+ L=1U W=10U AS=2.5P AD=3.3P PS=10.5U PD=10.66U
M$699 \$10868 \$10868 \$10951 VDD|XN_OE|XP_OE|YN_OE|YP_OE|ZN_OE|ZP_OE pfet_06v0
+ L=1U W=10U AS=3.3P AD=4.4P PS=10.66U PD=20.88U
M$700 \$12639 \$11420 VDD|XN_OE|XP_OE|YN_OE|YP_OE|ZN_OE|ZP_OE
+ VDD|XN_OE|XP_OE|YN_OE|YP_OE|ZN_OE|ZP_OE pfet_06v0 L=1U W=10U AS=4.4P AD=2.5P
+ PS=20.88U PD=10.5U
M$701 \$10917 \$11421 \$12639 VDD|XN_OE|XP_OE|YN_OE|YP_OE|ZN_OE|ZP_OE pfet_06v0
+ L=1U W=10U AS=2.5P AD=4.4P PS=10.5U PD=20.88U
M$702 \$12640 \$11423 VDD|XN_OE|XP_OE|YN_OE|YP_OE|ZN_OE|ZP_OE
+ VDD|XN_OE|XP_OE|YN_OE|YP_OE|ZN_OE|ZP_OE pfet_06v0 L=1U W=10U AS=4.4P AD=2.5P
+ PS=20.88U PD=10.5U
M$703 \$10889 \$11424 \$12640 VDD|XN_OE|XP_OE|YN_OE|YP_OE|ZN_OE|ZP_OE pfet_06v0
+ L=1U W=10U AS=2.5P AD=4.4P PS=10.5U PD=20.88U
M$704 \$12641 \$11423 VDD|XN_OE|XP_OE|YN_OE|YP_OE|ZN_OE|ZP_OE
+ VDD|XN_OE|XP_OE|YN_OE|YP_OE|ZN_OE|ZP_OE pfet_06v0 L=1U W=10U AS=4.4P AD=2.5P
+ PS=20.88U PD=10.5U
M$705 \$10870 \$11424 \$12641 VDD|XN_OE|XP_OE|YN_OE|YP_OE|ZN_OE|ZP_OE pfet_06v0
+ L=1U W=10U AS=2.5P AD=4.4P PS=10.5U PD=20.88U
M$706 \$12642 \$11423 VDD|XN_OE|XP_OE|YN_OE|YP_OE|ZN_OE|ZP_OE
+ VDD|XN_OE|XP_OE|YN_OE|YP_OE|ZN_OE|ZP_OE pfet_06v0 L=1U W=10U AS=4.4P AD=2.5P
+ PS=20.88U PD=10.5U
M$707 \$11423 \$11424 \$12642 VDD|XN_OE|XP_OE|YN_OE|YP_OE|ZN_OE|ZP_OE pfet_06v0
+ L=1U W=10U AS=2.5P AD=4.4P PS=10.5U PD=20.88U
M$708 \$12643 \$11423 VDD|XN_OE|XP_OE|YN_OE|YP_OE|ZN_OE|ZP_OE
+ VDD|XN_OE|XP_OE|YN_OE|YP_OE|ZN_OE|ZP_OE pfet_06v0 L=1U W=10U AS=4.4P AD=2.5P
+ PS=20.88U PD=10.5U
M$709 \$10963 \$11424 \$12643 VDD|XN_OE|XP_OE|YN_OE|YP_OE|ZN_OE|ZP_OE pfet_06v0
+ L=1U W=10U AS=2.5P AD=3.3P PS=10.5U PD=10.66U
M$710 \$12644 \$11424 \$10963 VDD|XN_OE|XP_OE|YN_OE|YP_OE|ZN_OE|ZP_OE pfet_06v0
+ L=1U W=10U AS=3.3P AD=2.5P PS=10.66U PD=10.5U
M$711 VDD|XN_OE|XP_OE|YN_OE|YP_OE|ZN_OE|ZP_OE \$11423 \$12644
+ VDD|XN_OE|XP_OE|YN_OE|YP_OE|ZN_OE|ZP_OE pfet_06v0 L=1U W=10U AS=2.5P AD=4.4P
+ PS=10.5U PD=20.88U
M$712 \$12645 \$10954 VDD|XN_OE|XP_OE|YN_OE|YP_OE|ZN_OE|ZP_OE
+ VDD|XN_OE|XP_OE|YN_OE|YP_OE|ZN_OE|ZP_OE pfet_06v0 L=1U W=10U AS=4.4P AD=2.5P
+ PS=20.88U PD=10.5U
M$713 \$10954 \$11424 \$12645 VDD|XN_OE|XP_OE|YN_OE|YP_OE|ZN_OE|ZP_OE pfet_06v0
+ L=1U W=10U AS=2.5P AD=3.3P PS=10.5U PD=10.66U
M$714 \$10872 \$10872 \$10954 VDD|XN_OE|XP_OE|YN_OE|YP_OE|ZN_OE|ZP_OE pfet_06v0
+ L=1U W=10U AS=3.3P AD=4.4P PS=10.66U PD=20.88U
M$715 \$12646 \$11423 VDD|XN_OE|XP_OE|YN_OE|YP_OE|ZN_OE|ZP_OE
+ VDD|XN_OE|XP_OE|YN_OE|YP_OE|ZN_OE|ZP_OE pfet_06v0 L=1U W=10U AS=4.4P AD=2.5P
+ PS=20.88U PD=10.5U
M$716 \$10918 \$11424 \$12646 VDD|XN_OE|XP_OE|YN_OE|YP_OE|ZN_OE|ZP_OE pfet_06v0
+ L=1U W=10U AS=2.5P AD=4.4P PS=10.5U PD=20.88U
M$717 \$12648 \$11426 VDD|XN_OE|XP_OE|YN_OE|YP_OE|ZN_OE|ZP_OE
+ VDD|XN_OE|XP_OE|YN_OE|YP_OE|ZN_OE|ZP_OE pfet_06v0 L=1U W=10U AS=4.4P AD=2.5P
+ PS=20.88U PD=10.5U
M$718 \$10897 \$11427 \$12648 VDD|XN_OE|XP_OE|YN_OE|YP_OE|ZN_OE|ZP_OE pfet_06v0
+ L=1U W=10U AS=2.5P AD=4.4P PS=10.5U PD=20.88U
M$719 \$12649 \$11426 VDD|XN_OE|XP_OE|YN_OE|YP_OE|ZN_OE|ZP_OE
+ VDD|XN_OE|XP_OE|YN_OE|YP_OE|ZN_OE|ZP_OE pfet_06v0 L=1U W=10U AS=4.4P AD=2.5P
+ PS=20.88U PD=10.5U
M$720 \$10874 \$11427 \$12649 VDD|XN_OE|XP_OE|YN_OE|YP_OE|ZN_OE|ZP_OE pfet_06v0
+ L=1U W=10U AS=2.5P AD=4.4P PS=10.5U PD=20.88U
M$721 \$12650 \$11426 VDD|XN_OE|XP_OE|YN_OE|YP_OE|ZN_OE|ZP_OE
+ VDD|XN_OE|XP_OE|YN_OE|YP_OE|ZN_OE|ZP_OE pfet_06v0 L=1U W=10U AS=4.4P AD=2.5P
+ PS=20.88U PD=10.5U
M$722 \$11426 \$11427 \$12650 VDD|XN_OE|XP_OE|YN_OE|YP_OE|ZN_OE|ZP_OE pfet_06v0
+ L=1U W=10U AS=2.5P AD=4.4P PS=10.5U PD=20.88U
M$723 \$12651 \$11426 VDD|XN_OE|XP_OE|YN_OE|YP_OE|ZN_OE|ZP_OE
+ VDD|XN_OE|XP_OE|YN_OE|YP_OE|ZN_OE|ZP_OE pfet_06v0 L=1U W=10U AS=4.4P AD=2.5P
+ PS=20.88U PD=10.5U
M$724 \$10964 \$11427 \$12651 VDD|XN_OE|XP_OE|YN_OE|YP_OE|ZN_OE|ZP_OE pfet_06v0
+ L=1U W=10U AS=2.5P AD=3.3P PS=10.5U PD=10.66U
M$725 \$12652 \$11427 \$10964 VDD|XN_OE|XP_OE|YN_OE|YP_OE|ZN_OE|ZP_OE pfet_06v0
+ L=1U W=10U AS=3.3P AD=2.5P PS=10.66U PD=10.5U
M$726 VDD|XN_OE|XP_OE|YN_OE|YP_OE|ZN_OE|ZP_OE \$11426 \$12652
+ VDD|XN_OE|XP_OE|YN_OE|YP_OE|ZN_OE|ZP_OE pfet_06v0 L=1U W=10U AS=2.5P AD=4.4P
+ PS=10.5U PD=20.88U
M$727 \$12653 \$10957 VDD|XN_OE|XP_OE|YN_OE|YP_OE|ZN_OE|ZP_OE
+ VDD|XN_OE|XP_OE|YN_OE|YP_OE|ZN_OE|ZP_OE pfet_06v0 L=1U W=10U AS=4.4P AD=2.5P
+ PS=20.88U PD=10.5U
M$728 \$10957 \$11427 \$12653 VDD|XN_OE|XP_OE|YN_OE|YP_OE|ZN_OE|ZP_OE pfet_06v0
+ L=1U W=10U AS=2.5P AD=3.3P PS=10.5U PD=10.66U
M$729 \$10876 \$10876 \$10957 VDD|XN_OE|XP_OE|YN_OE|YP_OE|ZN_OE|ZP_OE pfet_06v0
+ L=1U W=10U AS=3.3P AD=4.4P PS=10.66U PD=20.88U
M$730 \$12647 \$11426 VDD|XN_OE|XP_OE|YN_OE|YP_OE|ZN_OE|ZP_OE
+ VDD|XN_OE|XP_OE|YN_OE|YP_OE|ZN_OE|ZP_OE pfet_06v0 L=1U W=10U AS=4.4P AD=2.5P
+ PS=20.88U PD=10.5U
M$731 \$10919 \$11427 \$12647 VDD|XN_OE|XP_OE|YN_OE|YP_OE|ZN_OE|ZP_OE pfet_06v0
+ L=1U W=10U AS=2.5P AD=4.4P PS=10.5U PD=20.88U
M$732 \$11421 \$11421 VDD|XN_OE|XP_OE|YN_OE|YP_OE|ZN_OE|ZP_OE
+ VDD|XN_OE|XP_OE|YN_OE|YP_OE|ZN_OE|ZP_OE pfet_06v0 L=1U W=2U AS=0.88P AD=0.88P
+ PS=4.88U PD=4.88U
M$733 \$11116 \$11421 \$10883 VDD|XN_OE|XP_OE|YN_OE|YP_OE|ZN_OE|ZP_OE pfet_06v0
+ L=1U W=5U AS=2.2P AD=1.3P PS=10.88U PD=5.52U
M$734 \$10883 \$11421 \$11116 VDD|XN_OE|XP_OE|YN_OE|YP_OE|ZN_OE|ZP_OE pfet_06v0
+ L=1U W=5U AS=1.3P AD=2.2P PS=5.52U PD=10.88U
M$735 \$10867 \$11421 \$10882 VDD|XN_OE|XP_OE|YN_OE|YP_OE|ZN_OE|ZP_OE pfet_06v0
+ L=1U W=5U AS=2.2P AD=1.3P PS=10.88U PD=5.52U
M$736 \$10882 \$11421 \$10867 VDD|XN_OE|XP_OE|YN_OE|YP_OE|ZN_OE|ZP_OE pfet_06v0
+ L=1U W=5U AS=1.3P AD=2.2P PS=5.52U PD=10.88U
M$737 \$10883 \$11116 VDD|XN_OE|XP_OE|YN_OE|YP_OE|ZN_OE|ZP_OE
+ VDD|XN_OE|XP_OE|YN_OE|YP_OE|ZN_OE|ZP_OE pfet_06v0 L=1U W=5U AS=2.2P AD=1.3P
+ PS=10.88U PD=5.52U
M$738 VDD|XN_OE|XP_OE|YN_OE|YP_OE|ZN_OE|ZP_OE \$11116 \$10883
+ VDD|XN_OE|XP_OE|YN_OE|YP_OE|ZN_OE|ZP_OE pfet_06v0 L=1U W=5U AS=1.3P AD=1.3P
+ PS=5.52U PD=5.52U
M$739 \$10883 \$11116 VDD|XN_OE|XP_OE|YN_OE|YP_OE|ZN_OE|ZP_OE
+ VDD|XN_OE|XP_OE|YN_OE|YP_OE|ZN_OE|ZP_OE pfet_06v0 L=1U W=5U AS=1.3P AD=1.3P
+ PS=5.52U PD=5.52U
M$740 VDD|XN_OE|XP_OE|YN_OE|YP_OE|ZN_OE|ZP_OE \$11116 \$10883
+ VDD|XN_OE|XP_OE|YN_OE|YP_OE|ZN_OE|ZP_OE pfet_06v0 L=1U W=5U AS=1.3P AD=2.2P
+ PS=5.52U PD=10.88U
M$741 \$10882 \$11116 VDD|XN_OE|XP_OE|YN_OE|YP_OE|ZN_OE|ZP_OE
+ VDD|XN_OE|XP_OE|YN_OE|YP_OE|ZN_OE|ZP_OE pfet_06v0 L=1U W=5U AS=2.2P AD=1.3P
+ PS=10.88U PD=5.52U
M$742 VDD|XN_OE|XP_OE|YN_OE|YP_OE|ZN_OE|ZP_OE \$11116 \$10882
+ VDD|XN_OE|XP_OE|YN_OE|YP_OE|ZN_OE|ZP_OE pfet_06v0 L=1U W=5U AS=1.3P AD=1.3P
+ PS=5.52U PD=5.52U
M$743 \$10882 \$11116 VDD|XN_OE|XP_OE|YN_OE|YP_OE|ZN_OE|ZP_OE
+ VDD|XN_OE|XP_OE|YN_OE|YP_OE|ZN_OE|ZP_OE pfet_06v0 L=1U W=5U AS=1.3P AD=1.3P
+ PS=5.52U PD=5.52U
M$744 VDD|XN_OE|XP_OE|YN_OE|YP_OE|ZN_OE|ZP_OE \$11116 \$10882
+ VDD|XN_OE|XP_OE|YN_OE|YP_OE|ZN_OE|ZP_OE pfet_06v0 L=1U W=5U AS=1.3P AD=2.2P
+ PS=5.52U PD=10.88U
M$745 \$10885 \$10868 \$11116 VDD|XN_OE|XP_OE|YN_OE|YP_OE|ZN_OE|ZP_OE pfet_06v0
+ L=1U W=5U AS=2.2P AD=2.2P PS=10.88U PD=10.88U
M$746 \$10887 \$10868 \$10867 VDD|XN_OE|XP_OE|YN_OE|YP_OE|ZN_OE|ZP_OE pfet_06v0
+ L=1U W=5U AS=2.2P AD=2.2P PS=10.88U PD=10.88U
M$747 \$11424 \$11424 VDD|XN_OE|XP_OE|YN_OE|YP_OE|ZN_OE|ZP_OE
+ VDD|XN_OE|XP_OE|YN_OE|YP_OE|ZN_OE|ZP_OE pfet_06v0 L=1U W=2U AS=0.88P AD=0.88P
+ PS=4.88U PD=4.88U
M$748 \$11117 \$11424 \$10892 VDD|XN_OE|XP_OE|YN_OE|YP_OE|ZN_OE|ZP_OE pfet_06v0
+ L=1U W=5U AS=2.2P AD=1.3P PS=10.88U PD=5.52U
M$749 \$10892 \$11424 \$11117 VDD|XN_OE|XP_OE|YN_OE|YP_OE|ZN_OE|ZP_OE pfet_06v0
+ L=1U W=5U AS=1.3P AD=2.2P PS=5.52U PD=10.88U
M$750 \$10871 \$11424 \$10891 VDD|XN_OE|XP_OE|YN_OE|YP_OE|ZN_OE|ZP_OE pfet_06v0
+ L=1U W=5U AS=2.2P AD=1.3P PS=10.88U PD=5.52U
M$751 \$10891 \$11424 \$10871 VDD|XN_OE|XP_OE|YN_OE|YP_OE|ZN_OE|ZP_OE pfet_06v0
+ L=1U W=5U AS=1.3P AD=2.2P PS=5.52U PD=10.88U
M$752 \$10892 \$11117 VDD|XN_OE|XP_OE|YN_OE|YP_OE|ZN_OE|ZP_OE
+ VDD|XN_OE|XP_OE|YN_OE|YP_OE|ZN_OE|ZP_OE pfet_06v0 L=1U W=5U AS=2.2P AD=1.3P
+ PS=10.88U PD=5.52U
M$753 VDD|XN_OE|XP_OE|YN_OE|YP_OE|ZN_OE|ZP_OE \$11117 \$10892
+ VDD|XN_OE|XP_OE|YN_OE|YP_OE|ZN_OE|ZP_OE pfet_06v0 L=1U W=5U AS=1.3P AD=1.3P
+ PS=5.52U PD=5.52U
M$754 \$10892 \$11117 VDD|XN_OE|XP_OE|YN_OE|YP_OE|ZN_OE|ZP_OE
+ VDD|XN_OE|XP_OE|YN_OE|YP_OE|ZN_OE|ZP_OE pfet_06v0 L=1U W=5U AS=1.3P AD=1.3P
+ PS=5.52U PD=5.52U
M$755 VDD|XN_OE|XP_OE|YN_OE|YP_OE|ZN_OE|ZP_OE \$11117 \$10892
+ VDD|XN_OE|XP_OE|YN_OE|YP_OE|ZN_OE|ZP_OE pfet_06v0 L=1U W=5U AS=1.3P AD=2.2P
+ PS=5.52U PD=10.88U
M$756 \$10891 \$11117 VDD|XN_OE|XP_OE|YN_OE|YP_OE|ZN_OE|ZP_OE
+ VDD|XN_OE|XP_OE|YN_OE|YP_OE|ZN_OE|ZP_OE pfet_06v0 L=1U W=5U AS=2.2P AD=1.3P
+ PS=10.88U PD=5.52U
M$757 VDD|XN_OE|XP_OE|YN_OE|YP_OE|ZN_OE|ZP_OE \$11117 \$10891
+ VDD|XN_OE|XP_OE|YN_OE|YP_OE|ZN_OE|ZP_OE pfet_06v0 L=1U W=5U AS=1.3P AD=1.3P
+ PS=5.52U PD=5.52U
M$758 \$10891 \$11117 VDD|XN_OE|XP_OE|YN_OE|YP_OE|ZN_OE|ZP_OE
+ VDD|XN_OE|XP_OE|YN_OE|YP_OE|ZN_OE|ZP_OE pfet_06v0 L=1U W=5U AS=1.3P AD=1.3P
+ PS=5.52U PD=5.52U
M$759 VDD|XN_OE|XP_OE|YN_OE|YP_OE|ZN_OE|ZP_OE \$11117 \$10891
+ VDD|XN_OE|XP_OE|YN_OE|YP_OE|ZN_OE|ZP_OE pfet_06v0 L=1U W=5U AS=1.3P AD=2.2P
+ PS=5.52U PD=10.88U
M$760 \$10894 \$10872 \$11117 VDD|XN_OE|XP_OE|YN_OE|YP_OE|ZN_OE|ZP_OE pfet_06v0
+ L=1U W=5U AS=2.2P AD=2.2P PS=10.88U PD=10.88U
M$761 \$10896 \$10872 \$10871 VDD|XN_OE|XP_OE|YN_OE|YP_OE|ZN_OE|ZP_OE pfet_06v0
+ L=1U W=5U AS=2.2P AD=2.2P PS=10.88U PD=10.88U
M$762 \$11427 \$11427 VDD|XN_OE|XP_OE|YN_OE|YP_OE|ZN_OE|ZP_OE
+ VDD|XN_OE|XP_OE|YN_OE|YP_OE|ZN_OE|ZP_OE pfet_06v0 L=1U W=2U AS=0.88P AD=0.88P
+ PS=4.88U PD=4.88U
M$763 \$11118 \$11427 \$10900 VDD|XN_OE|XP_OE|YN_OE|YP_OE|ZN_OE|ZP_OE pfet_06v0
+ L=1U W=5U AS=2.2P AD=1.3P PS=10.88U PD=5.52U
M$764 \$10900 \$11427 \$11118 VDD|XN_OE|XP_OE|YN_OE|YP_OE|ZN_OE|ZP_OE pfet_06v0
+ L=1U W=5U AS=1.3P AD=2.2P PS=5.52U PD=10.88U
M$765 \$10875 \$11427 \$10899 VDD|XN_OE|XP_OE|YN_OE|YP_OE|ZN_OE|ZP_OE pfet_06v0
+ L=1U W=5U AS=2.2P AD=1.3P PS=10.88U PD=5.52U
M$766 \$10899 \$11427 \$10875 VDD|XN_OE|XP_OE|YN_OE|YP_OE|ZN_OE|ZP_OE pfet_06v0
+ L=1U W=5U AS=1.3P AD=2.2P PS=5.52U PD=10.88U
M$767 \$10900 \$11118 VDD|XN_OE|XP_OE|YN_OE|YP_OE|ZN_OE|ZP_OE
+ VDD|XN_OE|XP_OE|YN_OE|YP_OE|ZN_OE|ZP_OE pfet_06v0 L=1U W=5U AS=2.2P AD=1.3P
+ PS=10.88U PD=5.52U
M$768 VDD|XN_OE|XP_OE|YN_OE|YP_OE|ZN_OE|ZP_OE \$11118 \$10900
+ VDD|XN_OE|XP_OE|YN_OE|YP_OE|ZN_OE|ZP_OE pfet_06v0 L=1U W=5U AS=1.3P AD=1.3P
+ PS=5.52U PD=5.52U
M$769 \$10900 \$11118 VDD|XN_OE|XP_OE|YN_OE|YP_OE|ZN_OE|ZP_OE
+ VDD|XN_OE|XP_OE|YN_OE|YP_OE|ZN_OE|ZP_OE pfet_06v0 L=1U W=5U AS=1.3P AD=1.3P
+ PS=5.52U PD=5.52U
M$770 VDD|XN_OE|XP_OE|YN_OE|YP_OE|ZN_OE|ZP_OE \$11118 \$10900
+ VDD|XN_OE|XP_OE|YN_OE|YP_OE|ZN_OE|ZP_OE pfet_06v0 L=1U W=5U AS=1.3P AD=2.2P
+ PS=5.52U PD=10.88U
M$771 \$10899 \$11118 VDD|XN_OE|XP_OE|YN_OE|YP_OE|ZN_OE|ZP_OE
+ VDD|XN_OE|XP_OE|YN_OE|YP_OE|ZN_OE|ZP_OE pfet_06v0 L=1U W=5U AS=2.2P AD=1.3P
+ PS=10.88U PD=5.52U
M$772 VDD|XN_OE|XP_OE|YN_OE|YP_OE|ZN_OE|ZP_OE \$11118 \$10899
+ VDD|XN_OE|XP_OE|YN_OE|YP_OE|ZN_OE|ZP_OE pfet_06v0 L=1U W=5U AS=1.3P AD=1.3P
+ PS=5.52U PD=5.52U
M$773 \$10899 \$11118 VDD|XN_OE|XP_OE|YN_OE|YP_OE|ZN_OE|ZP_OE
+ VDD|XN_OE|XP_OE|YN_OE|YP_OE|ZN_OE|ZP_OE pfet_06v0 L=1U W=5U AS=1.3P AD=1.3P
+ PS=5.52U PD=5.52U
M$774 VDD|XN_OE|XP_OE|YN_OE|YP_OE|ZN_OE|ZP_OE \$11118 \$10899
+ VDD|XN_OE|XP_OE|YN_OE|YP_OE|ZN_OE|ZP_OE pfet_06v0 L=1U W=5U AS=1.3P AD=2.2P
+ PS=5.52U PD=10.88U
M$775 \$10902 \$10876 \$11118 VDD|XN_OE|XP_OE|YN_OE|YP_OE|ZN_OE|ZP_OE pfet_06v0
+ L=1U W=5U AS=2.2P AD=2.2P PS=10.88U PD=10.88U
M$776 \$10904 \$10876 \$10875 VDD|XN_OE|XP_OE|YN_OE|YP_OE|ZN_OE|ZP_OE pfet_06v0
+ L=1U W=5U AS=2.2P AD=2.2P PS=10.88U PD=10.88U
M$777 \$12670 \$12679 VDD|XN_OE|XP_OE|YN_OE|YP_OE|ZN_OE|ZP_OE
+ VDD|XN_OE|XP_OE|YN_OE|YP_OE|ZN_OE|ZP_OE pfet_06v0 L=1U W=3U AS=1.32P AD=1.32P
+ PS=6.88U PD=6.88U
M$778 Z Z VDD|XN_OE|XP_OE|YN_OE|YP_OE|ZN_OE|ZP_OE
+ VDD|XN_OE|XP_OE|YN_OE|YP_OE|ZN_OE|ZP_OE pfet_06v0 L=1U W=2U AS=0.88P AD=0.52P
+ PS=4.88U PD=2.52U
M$779 VDD|XN_OE|XP_OE|YN_OE|YP_OE|ZN_OE|ZP_OE Z Z
+ VDD|XN_OE|XP_OE|YN_OE|YP_OE|ZN_OE|ZP_OE pfet_06v0 L=1U W=2U AS=0.52P AD=0.52P
+ PS=2.52U PD=2.52U
M$780 Z Z VDD|XN_OE|XP_OE|YN_OE|YP_OE|ZN_OE|ZP_OE
+ VDD|XN_OE|XP_OE|YN_OE|YP_OE|ZN_OE|ZP_OE pfet_06v0 L=1U W=2U AS=0.52P AD=0.52P
+ PS=2.52U PD=2.52U
M$781 VDD|XN_OE|XP_OE|YN_OE|YP_OE|ZN_OE|ZP_OE Z Z
+ VDD|XN_OE|XP_OE|YN_OE|YP_OE|ZN_OE|ZP_OE pfet_06v0 L=1U W=2U AS=0.52P AD=0.52P
+ PS=2.52U PD=2.52U
M$782 Z Z VDD|XN_OE|XP_OE|YN_OE|YP_OE|ZN_OE|ZP_OE
+ VDD|XN_OE|XP_OE|YN_OE|YP_OE|ZN_OE|ZP_OE pfet_06v0 L=1U W=2U AS=0.52P AD=0.52P
+ PS=2.52U PD=2.52U
M$783 VDD|XN_OE|XP_OE|YN_OE|YP_OE|ZN_OE|ZP_OE Z Z
+ VDD|XN_OE|XP_OE|YN_OE|YP_OE|ZN_OE|ZP_OE pfet_06v0 L=1U W=2U AS=0.52P AD=0.88P
+ PS=2.52U PD=4.88U
M$784 \$9147 \$12698 VDD|XN_OE|XP_OE|YN_OE|YP_OE|ZN_OE|ZP_OE
+ VDD|XN_OE|XP_OE|YN_OE|YP_OE|ZN_OE|ZP_OE pfet_06v0 L=1U W=3U AS=1.32P AD=1.32P
+ PS=6.88U PD=6.88U
M$785 \$12698 \$12697 VDD|XN_OE|XP_OE|YN_OE|YP_OE|ZN_OE|ZP_OE
+ VDD|XN_OE|XP_OE|YN_OE|YP_OE|ZN_OE|ZP_OE pfet_06v0 L=1U W=3U AS=1.32P AD=0.99P
+ PS=6.88U PD=3.66U
M$786 VDD|XN_OE|XP_OE|YN_OE|YP_OE|ZN_OE|ZP_OE \$12670 \$12698
+ VDD|XN_OE|XP_OE|YN_OE|YP_OE|ZN_OE|ZP_OE pfet_06v0 L=1U W=3U AS=0.99P AD=1.32P
+ PS=3.66U PD=6.88U
M$787 \$12824 \$12697 \$10945 VDD|XN_OE|XP_OE|YN_OE|YP_OE|ZN_OE|ZP_OE pfet_06v0
+ L=1U W=3U AS=1.32P AD=0.75P PS=6.88U PD=3.5U
M$788 VDD|XN_OE|XP_OE|YN_OE|YP_OE|ZN_OE|ZP_OE \$12688 \$12824
+ VDD|XN_OE|XP_OE|YN_OE|YP_OE|ZN_OE|ZP_OE pfet_06v0 L=1U W=3U AS=0.75P AD=1.32P
+ PS=3.5U PD=6.88U
M$789 \$10862 \$10862 VDD|XN_OE|XP_OE|YN_OE|YP_OE|ZN_OE|ZP_OE
+ VDD|XN_OE|XP_OE|YN_OE|YP_OE|ZN_OE|ZP_OE pfet_06v0 L=1U W=2U AS=0.88P AD=0.88P
+ PS=4.88U PD=4.88U
M$790 \$7344 \$12699 VDD|XN_OE|XP_OE|YN_OE|YP_OE|ZN_OE|ZP_OE
+ VDD|XN_OE|XP_OE|YN_OE|YP_OE|ZN_OE|ZP_OE pfet_06v0 L=1U W=3U AS=1.32P AD=1.32P
+ PS=6.88U PD=6.88U
M$791 \$12699 \$12679 VDD|XN_OE|XP_OE|YN_OE|YP_OE|ZN_OE|ZP_OE
+ VDD|XN_OE|XP_OE|YN_OE|YP_OE|ZN_OE|ZP_OE pfet_06v0 L=1U W=3U AS=1.32P AD=0.99P
+ PS=6.88U PD=3.66U
M$792 VDD|XN_OE|XP_OE|YN_OE|YP_OE|ZN_OE|ZP_OE \$12688 \$12699
+ VDD|XN_OE|XP_OE|YN_OE|YP_OE|ZN_OE|ZP_OE pfet_06v0 L=1U W=3U AS=0.99P AD=1.32P
+ PS=3.66U PD=6.88U
M$793 VDD|XN_OE|XP_OE|YN_OE|YP_OE|ZN_OE|ZP_OE
+ VSS|XN_CS|XN_IE|XN_PD|XN_PDRV0|XN_PDRV1|XN_PU|XN_SL|XP_CS|XP_IE|XP_PD|XP_PDRV0|XP_PDRV1|XP_PU|XP_SL|YN_CS|YN_IE|YN_PD|YN_PDRV0|YN_PDRV1|YN_PU|YN_SL|YP_CS|YP_IE|YP_PD|YP_PDRV0|YP_PDRV1|YP_PU|YP_SL|ZN_CS|ZN_IE|ZN_PD|ZN_PDRV0|ZN_PDRV1|ZN_PU|ZN_SL|ZP_CS|ZP_IE|ZP_PD|ZP_PDRV0|ZP_PDRV1|ZP_PU|ZP_SL
+ VDD|XN_OE|XP_OE|YN_OE|YP_OE|ZN_OE|ZP_OE
+ VDD|XN_OE|XP_OE|YN_OE|YP_OE|ZN_OE|ZP_OE pfet_06v0 L=2U W=1U AS=0.44P AD=0.44P
+ PS=2.88U PD=2.88U
M$794 VDD|XN_OE|XP_OE|YN_OE|YP_OE|ZN_OE|ZP_OE
+ VSS|XN_CS|XN_IE|XN_PD|XN_PDRV0|XN_PDRV1|XN_PU|XN_SL|XP_CS|XP_IE|XP_PD|XP_PDRV0|XP_PDRV1|XP_PU|XP_SL|YN_CS|YN_IE|YN_PD|YN_PDRV0|YN_PDRV1|YN_PU|YN_SL|YP_CS|YP_IE|YP_PD|YP_PDRV0|YP_PDRV1|YP_PU|YP_SL|ZN_CS|ZN_IE|ZN_PD|ZN_PDRV0|ZN_PDRV1|ZN_PU|ZN_SL|ZP_CS|ZP_IE|ZP_PD|ZP_PDRV0|ZP_PDRV1|ZP_PU|ZP_SL
+ VDD|XN_OE|XP_OE|YN_OE|YP_OE|ZN_OE|ZP_OE
+ VDD|XN_OE|XP_OE|YN_OE|YP_OE|ZN_OE|ZP_OE pfet_06v0 L=2U W=1U AS=0.44P AD=0.44P
+ PS=2.88U PD=2.88U
M$795 VDD|XN_OE|XP_OE|YN_OE|YP_OE|ZN_OE|ZP_OE
+ VSS|XN_CS|XN_IE|XN_PD|XN_PDRV0|XN_PDRV1|XN_PU|XN_SL|XP_CS|XP_IE|XP_PD|XP_PDRV0|XP_PDRV1|XP_PU|XP_SL|YN_CS|YN_IE|YN_PD|YN_PDRV0|YN_PDRV1|YN_PU|YN_SL|YP_CS|YP_IE|YP_PD|YP_PDRV0|YP_PDRV1|YP_PU|YP_SL|ZN_CS|ZN_IE|ZN_PD|ZN_PDRV0|ZN_PDRV1|ZN_PU|ZN_SL|ZP_CS|ZP_IE|ZP_PD|ZP_PDRV0|ZP_PDRV1|ZP_PU|ZP_SL
+ VDD|XN_OE|XP_OE|YN_OE|YP_OE|ZN_OE|ZP_OE
+ VDD|XN_OE|XP_OE|YN_OE|YP_OE|ZN_OE|ZP_OE pfet_06v0 L=2U W=1U AS=0.44P AD=0.44P
+ PS=2.88U PD=2.88U
M$796 VDD|XN_OE|XP_OE|YN_OE|YP_OE|ZN_OE|ZP_OE
+ VSS|XN_CS|XN_IE|XN_PD|XN_PDRV0|XN_PDRV1|XN_PU|XN_SL|XP_CS|XP_IE|XP_PD|XP_PDRV0|XP_PDRV1|XP_PU|XP_SL|YN_CS|YN_IE|YN_PD|YN_PDRV0|YN_PDRV1|YN_PU|YN_SL|YP_CS|YP_IE|YP_PD|YP_PDRV0|YP_PDRV1|YP_PU|YP_SL|ZN_CS|ZN_IE|ZN_PD|ZN_PDRV0|ZN_PDRV1|ZN_PU|ZN_SL|ZP_CS|ZP_IE|ZP_PD|ZP_PDRV0|ZP_PDRV1|ZP_PU|ZP_SL
+ VDD|XN_OE|XP_OE|YN_OE|YP_OE|ZN_OE|ZP_OE
+ VDD|XN_OE|XP_OE|YN_OE|YP_OE|ZN_OE|ZP_OE pfet_06v0 L=2U W=1U AS=0.44P AD=0.44P
+ PS=2.88U PD=2.88U
M$797 VDD|XN_OE|XP_OE|YN_OE|YP_OE|ZN_OE|ZP_OE
+ VSS|XN_CS|XN_IE|XN_PD|XN_PDRV0|XN_PDRV1|XN_PU|XN_SL|XP_CS|XP_IE|XP_PD|XP_PDRV0|XP_PDRV1|XP_PU|XP_SL|YN_CS|YN_IE|YN_PD|YN_PDRV0|YN_PDRV1|YN_PU|YN_SL|YP_CS|YP_IE|YP_PD|YP_PDRV0|YP_PDRV1|YP_PU|YP_SL|ZN_CS|ZN_IE|ZN_PD|ZN_PDRV0|ZN_PDRV1|ZN_PU|ZN_SL|ZP_CS|ZP_IE|ZP_PD|ZP_PDRV0|ZP_PDRV1|ZP_PU|ZP_SL
+ VDD|XN_OE|XP_OE|YN_OE|YP_OE|ZN_OE|ZP_OE
+ VDD|XN_OE|XP_OE|YN_OE|YP_OE|ZN_OE|ZP_OE pfet_06v0 L=2U W=1U AS=0.44P AD=0.44P
+ PS=2.88U PD=2.88U
M$798 VDD|XN_OE|XP_OE|YN_OE|YP_OE|ZN_OE|ZP_OE
+ VSS|XN_CS|XN_IE|XN_PD|XN_PDRV0|XN_PDRV1|XN_PU|XN_SL|XP_CS|XP_IE|XP_PD|XP_PDRV0|XP_PDRV1|XP_PU|XP_SL|YN_CS|YN_IE|YN_PD|YN_PDRV0|YN_PDRV1|YN_PU|YN_SL|YP_CS|YP_IE|YP_PD|YP_PDRV0|YP_PDRV1|YP_PU|YP_SL|ZN_CS|ZN_IE|ZN_PD|ZN_PDRV0|ZN_PDRV1|ZN_PU|ZN_SL|ZP_CS|ZP_IE|ZP_PD|ZP_PDRV0|ZP_PDRV1|ZP_PU|ZP_SL
+ VDD|XN_OE|XP_OE|YN_OE|YP_OE|ZN_OE|ZP_OE
+ VDD|XN_OE|XP_OE|YN_OE|YP_OE|ZN_OE|ZP_OE pfet_06v0 L=2U W=1U AS=0.44P AD=0.44P
+ PS=2.88U PD=2.88U
M$799 VDD|XN_OE|XP_OE|YN_OE|YP_OE|ZN_OE|ZP_OE
+ VSS|XN_CS|XN_IE|XN_PD|XN_PDRV0|XN_PDRV1|XN_PU|XN_SL|XP_CS|XP_IE|XP_PD|XP_PDRV0|XP_PDRV1|XP_PU|XP_SL|YN_CS|YN_IE|YN_PD|YN_PDRV0|YN_PDRV1|YN_PU|YN_SL|YP_CS|YP_IE|YP_PD|YP_PDRV0|YP_PDRV1|YP_PU|YP_SL|ZN_CS|ZN_IE|ZN_PD|ZN_PDRV0|ZN_PDRV1|ZN_PU|ZN_SL|ZP_CS|ZP_IE|ZP_PD|ZP_PDRV0|ZP_PDRV1|ZP_PU|ZP_SL
+ VDD|XN_OE|XP_OE|YN_OE|YP_OE|ZN_OE|ZP_OE
+ VDD|XN_OE|XP_OE|YN_OE|YP_OE|ZN_OE|ZP_OE pfet_06v0 L=2U W=1U AS=0.44P AD=0.44P
+ PS=2.88U PD=2.88U
M$800 VDD|XN_OE|XP_OE|YN_OE|YP_OE|ZN_OE|ZP_OE
+ VSS|XN_CS|XN_IE|XN_PD|XN_PDRV0|XN_PDRV1|XN_PU|XN_SL|XP_CS|XP_IE|XP_PD|XP_PDRV0|XP_PDRV1|XP_PU|XP_SL|YN_CS|YN_IE|YN_PD|YN_PDRV0|YN_PDRV1|YN_PU|YN_SL|YP_CS|YP_IE|YP_PD|YP_PDRV0|YP_PDRV1|YP_PU|YP_SL|ZN_CS|ZN_IE|ZN_PD|ZN_PDRV0|ZN_PDRV1|ZN_PU|ZN_SL|ZP_CS|ZP_IE|ZP_PD|ZP_PDRV0|ZP_PDRV1|ZP_PU|ZP_SL
+ VDD|XN_OE|XP_OE|YN_OE|YP_OE|ZN_OE|ZP_OE
+ VDD|XN_OE|XP_OE|YN_OE|YP_OE|ZN_OE|ZP_OE pfet_06v0 L=2U W=1U AS=0.44P AD=0.44P
+ PS=2.88U PD=2.88U
M$801 VDD|XN_OE|XP_OE|YN_OE|YP_OE|ZN_OE|ZP_OE
+ VSS|XN_CS|XN_IE|XN_PD|XN_PDRV0|XN_PDRV1|XN_PU|XN_SL|XP_CS|XP_IE|XP_PD|XP_PDRV0|XP_PDRV1|XP_PU|XP_SL|YN_CS|YN_IE|YN_PD|YN_PDRV0|YN_PDRV1|YN_PU|YN_SL|YP_CS|YP_IE|YP_PD|YP_PDRV0|YP_PDRV1|YP_PU|YP_SL|ZN_CS|ZN_IE|ZN_PD|ZN_PDRV0|ZN_PDRV1|ZN_PU|ZN_SL|ZP_CS|ZP_IE|ZP_PD|ZP_PDRV0|ZP_PDRV1|ZP_PU|ZP_SL
+ VDD|XN_OE|XP_OE|YN_OE|YP_OE|ZN_OE|ZP_OE
+ VDD|XN_OE|XP_OE|YN_OE|YP_OE|ZN_OE|ZP_OE pfet_06v0 L=2U W=1U AS=0.44P AD=0.44P
+ PS=2.88U PD=2.88U
M$802 VDD|XN_OE|XP_OE|YN_OE|YP_OE|ZN_OE|ZP_OE
+ VSS|XN_CS|XN_IE|XN_PD|XN_PDRV0|XN_PDRV1|XN_PU|XN_SL|XP_CS|XP_IE|XP_PD|XP_PDRV0|XP_PDRV1|XP_PU|XP_SL|YN_CS|YN_IE|YN_PD|YN_PDRV0|YN_PDRV1|YN_PU|YN_SL|YP_CS|YP_IE|YP_PD|YP_PDRV0|YP_PDRV1|YP_PU|YP_SL|ZN_CS|ZN_IE|ZN_PD|ZN_PDRV0|ZN_PDRV1|ZN_PU|ZN_SL|ZP_CS|ZP_IE|ZP_PD|ZP_PDRV0|ZP_PDRV1|ZP_PU|ZP_SL
+ VDD|XN_OE|XP_OE|YN_OE|YP_OE|ZN_OE|ZP_OE
+ VDD|XN_OE|XP_OE|YN_OE|YP_OE|ZN_OE|ZP_OE pfet_06v0 L=2U W=1U AS=0.44P AD=0.44P
+ PS=2.88U PD=2.88U
M$803 VDD|XN_OE|XP_OE|YN_OE|YP_OE|ZN_OE|ZP_OE
+ VSS|XN_CS|XN_IE|XN_PD|XN_PDRV0|XN_PDRV1|XN_PU|XN_SL|XP_CS|XP_IE|XP_PD|XP_PDRV0|XP_PDRV1|XP_PU|XP_SL|YN_CS|YN_IE|YN_PD|YN_PDRV0|YN_PDRV1|YN_PU|YN_SL|YP_CS|YP_IE|YP_PD|YP_PDRV0|YP_PDRV1|YP_PU|YP_SL|ZN_CS|ZN_IE|ZN_PD|ZN_PDRV0|ZN_PDRV1|ZN_PU|ZN_SL|ZP_CS|ZP_IE|ZP_PD|ZP_PDRV0|ZP_PDRV1|ZP_PU|ZP_SL
+ VDD|XN_OE|XP_OE|YN_OE|YP_OE|ZN_OE|ZP_OE
+ VDD|XN_OE|XP_OE|YN_OE|YP_OE|ZN_OE|ZP_OE pfet_06v0 L=2U W=1U AS=0.44P AD=0.44P
+ PS=2.88U PD=2.88U
M$804 VDD|XN_OE|XP_OE|YN_OE|YP_OE|ZN_OE|ZP_OE
+ VSS|XN_CS|XN_IE|XN_PD|XN_PDRV0|XN_PDRV1|XN_PU|XN_SL|XP_CS|XP_IE|XP_PD|XP_PDRV0|XP_PDRV1|XP_PU|XP_SL|YN_CS|YN_IE|YN_PD|YN_PDRV0|YN_PDRV1|YN_PU|YN_SL|YP_CS|YP_IE|YP_PD|YP_PDRV0|YP_PDRV1|YP_PU|YP_SL|ZN_CS|ZN_IE|ZN_PD|ZN_PDRV0|ZN_PDRV1|ZN_PU|ZN_SL|ZP_CS|ZP_IE|ZP_PD|ZP_PDRV0|ZP_PDRV1|ZP_PU|ZP_SL
+ VDD|XN_OE|XP_OE|YN_OE|YP_OE|ZN_OE|ZP_OE
+ VDD|XN_OE|XP_OE|YN_OE|YP_OE|ZN_OE|ZP_OE pfet_06v0 L=2U W=1U AS=0.44P AD=0.44P
+ PS=2.88U PD=2.88U
M$805 VDD|XN_OE|XP_OE|YN_OE|YP_OE|ZN_OE|ZP_OE
+ VSS|XN_CS|XN_IE|XN_PD|XN_PDRV0|XN_PDRV1|XN_PU|XN_SL|XP_CS|XP_IE|XP_PD|XP_PDRV0|XP_PDRV1|XP_PU|XP_SL|YN_CS|YN_IE|YN_PD|YN_PDRV0|YN_PDRV1|YN_PU|YN_SL|YP_CS|YP_IE|YP_PD|YP_PDRV0|YP_PDRV1|YP_PU|YP_SL|ZN_CS|ZN_IE|ZN_PD|ZN_PDRV0|ZN_PDRV1|ZN_PU|ZN_SL|ZP_CS|ZP_IE|ZP_PD|ZP_PDRV0|ZP_PDRV1|ZP_PU|ZP_SL
+ VDD|XN_OE|XP_OE|YN_OE|YP_OE|ZN_OE|ZP_OE
+ VDD|XN_OE|XP_OE|YN_OE|YP_OE|ZN_OE|ZP_OE pfet_06v0 L=2U W=9.75U AS=4.29P
+ AD=4.29P PS=20.38U PD=20.38U
M$806 \$12677 \$4864 \$12743 VDD|XN_OE|XP_OE|YN_OE|YP_OE|ZN_OE|ZP_OE pfet_06v0
+ L=1U W=10U AS=4.4P AD=2.6P PS=20.88U PD=10.52U
M$807 \$12743 \$4864 \$12677 VDD|XN_OE|XP_OE|YN_OE|YP_OE|ZN_OE|ZP_OE pfet_06v0
+ L=1U W=10U AS=2.6P AD=4.4P PS=10.52U PD=20.88U
M$808 \$12675 \$4880 \$12743 VDD|XN_OE|XP_OE|YN_OE|YP_OE|ZN_OE|ZP_OE pfet_06v0
+ L=1U W=10U AS=4.4P AD=2.6P PS=20.88U PD=10.52U
M$809 \$12743 \$4880 \$12675 VDD|XN_OE|XP_OE|YN_OE|YP_OE|ZN_OE|ZP_OE pfet_06v0
+ L=1U W=10U AS=2.6P AD=4.4P PS=10.52U PD=20.88U
M$810 \$12679 \$12659 VDD|XN_OE|XP_OE|YN_OE|YP_OE|ZN_OE|ZP_OE
+ VDD|XN_OE|XP_OE|YN_OE|YP_OE|ZN_OE|ZP_OE pfet_06v0 L=1U W=10U AS=4.4P AD=2.6P
+ PS=20.88U PD=10.52U
M$811 VDD|XN_OE|XP_OE|YN_OE|YP_OE|ZN_OE|ZP_OE \$12659 \$12679
+ VDD|XN_OE|XP_OE|YN_OE|YP_OE|ZN_OE|ZP_OE pfet_06v0 L=1U W=10U AS=2.6P AD=2.6P
+ PS=10.52U PD=10.52U
M$812 \$12679 \$12659 VDD|XN_OE|XP_OE|YN_OE|YP_OE|ZN_OE|ZP_OE
+ VDD|XN_OE|XP_OE|YN_OE|YP_OE|ZN_OE|ZP_OE pfet_06v0 L=1U W=10U AS=2.6P AD=4.4P
+ PS=10.52U PD=20.88U
M$813 VDD|XN_OE|XP_OE|YN_OE|YP_OE|ZN_OE|ZP_OE
+ VSS|XN_CS|XN_IE|XN_PD|XN_PDRV0|XN_PDRV1|XN_PU|XN_SL|XP_CS|XP_IE|XP_PD|XP_PDRV0|XP_PDRV1|XP_PU|XP_SL|YN_CS|YN_IE|YN_PD|YN_PDRV0|YN_PDRV1|YN_PU|YN_SL|YP_CS|YP_IE|YP_PD|YP_PDRV0|YP_PDRV1|YP_PU|YP_SL|ZN_CS|ZN_IE|ZN_PD|ZN_PDRV0|ZN_PDRV1|ZN_PU|ZN_SL|ZP_CS|ZP_IE|ZP_PD|ZP_PDRV0|ZP_PDRV1|ZP_PU|ZP_SL
+ VDD|XN_OE|XP_OE|YN_OE|YP_OE|ZN_OE|ZP_OE
+ VDD|XN_OE|XP_OE|YN_OE|YP_OE|ZN_OE|ZP_OE pfet_06v0 L=2U W=9.75U AS=4.29P
+ AD=4.29P PS=20.38U PD=20.38U
M$814 VDD|XN_OE|XP_OE|YN_OE|YP_OE|ZN_OE|ZP_OE
+ VSS|XN_CS|XN_IE|XN_PD|XN_PDRV0|XN_PDRV1|XN_PU|XN_SL|XP_CS|XP_IE|XP_PD|XP_PDRV0|XP_PDRV1|XP_PU|XP_SL|YN_CS|YN_IE|YN_PD|YN_PDRV0|YN_PDRV1|YN_PU|YN_SL|YP_CS|YP_IE|YP_PD|YP_PDRV0|YP_PDRV1|YP_PU|YP_SL|ZN_CS|ZN_IE|ZN_PD|ZN_PDRV0|ZN_PDRV1|ZN_PU|ZN_SL|ZP_CS|ZP_IE|ZP_PD|ZP_PDRV0|ZP_PDRV1|ZP_PU|ZP_SL
+ VDD|XN_OE|XP_OE|YN_OE|YP_OE|ZN_OE|ZP_OE
+ VDD|XN_OE|XP_OE|YN_OE|YP_OE|ZN_OE|ZP_OE pfet_06v0 L=2U W=9.75U AS=4.29P
+ AD=4.29P PS=20.38U PD=20.38U
M$815 \$12686 \$4872 \$12745 VDD|XN_OE|XP_OE|YN_OE|YP_OE|ZN_OE|ZP_OE pfet_06v0
+ L=1U W=10U AS=4.4P AD=2.6P PS=20.88U PD=10.52U
M$816 \$12745 \$4872 \$12686 VDD|XN_OE|XP_OE|YN_OE|YP_OE|ZN_OE|ZP_OE pfet_06v0
+ L=1U W=10U AS=2.6P AD=4.4P PS=10.52U PD=20.88U
M$817 \$12684 \$4880 \$12745 VDD|XN_OE|XP_OE|YN_OE|YP_OE|ZN_OE|ZP_OE pfet_06v0
+ L=1U W=10U AS=4.4P AD=2.6P PS=20.88U PD=10.52U
M$818 \$12745 \$4880 \$12684 VDD|XN_OE|XP_OE|YN_OE|YP_OE|ZN_OE|ZP_OE pfet_06v0
+ L=1U W=10U AS=2.6P AD=4.4P PS=10.52U PD=20.88U
M$819 \$12688 \$12663 VDD|XN_OE|XP_OE|YN_OE|YP_OE|ZN_OE|ZP_OE
+ VDD|XN_OE|XP_OE|YN_OE|YP_OE|ZN_OE|ZP_OE pfet_06v0 L=1U W=10U AS=4.4P AD=2.6P
+ PS=20.88U PD=10.52U
M$820 VDD|XN_OE|XP_OE|YN_OE|YP_OE|ZN_OE|ZP_OE \$12663 \$12688
+ VDD|XN_OE|XP_OE|YN_OE|YP_OE|ZN_OE|ZP_OE pfet_06v0 L=1U W=10U AS=2.6P AD=2.6P
+ PS=10.52U PD=10.52U
M$821 \$12688 \$12663 VDD|XN_OE|XP_OE|YN_OE|YP_OE|ZN_OE|ZP_OE
+ VDD|XN_OE|XP_OE|YN_OE|YP_OE|ZN_OE|ZP_OE pfet_06v0 L=1U W=10U AS=2.6P AD=4.4P
+ PS=10.52U PD=20.88U
M$822 VDD|XN_OE|XP_OE|YN_OE|YP_OE|ZN_OE|ZP_OE
+ VSS|XN_CS|XN_IE|XN_PD|XN_PDRV0|XN_PDRV1|XN_PU|XN_SL|XP_CS|XP_IE|XP_PD|XP_PDRV0|XP_PDRV1|XP_PU|XP_SL|YN_CS|YN_IE|YN_PD|YN_PDRV0|YN_PDRV1|YN_PU|YN_SL|YP_CS|YP_IE|YP_PD|YP_PDRV0|YP_PDRV1|YP_PU|YP_SL|ZN_CS|ZN_IE|ZN_PD|ZN_PDRV0|ZN_PDRV1|ZN_PU|ZN_SL|ZP_CS|ZP_IE|ZP_PD|ZP_PDRV0|ZP_PDRV1|ZP_PU|ZP_SL
+ VDD|XN_OE|XP_OE|YN_OE|YP_OE|ZN_OE|ZP_OE
+ VDD|XN_OE|XP_OE|YN_OE|YP_OE|ZN_OE|ZP_OE pfet_06v0 L=2U W=9.75U AS=4.29P
+ AD=4.29P PS=20.38U PD=20.38U
M$823 VDD|XN_OE|XP_OE|YN_OE|YP_OE|ZN_OE|ZP_OE
+ VSS|XN_CS|XN_IE|XN_PD|XN_PDRV0|XN_PDRV1|XN_PU|XN_SL|XP_CS|XP_IE|XP_PD|XP_PDRV0|XP_PDRV1|XP_PU|XP_SL|YN_CS|YN_IE|YN_PD|YN_PDRV0|YN_PDRV1|YN_PU|YN_SL|YP_CS|YP_IE|YP_PD|YP_PDRV0|YP_PDRV1|YP_PU|YP_SL|ZN_CS|ZN_IE|ZN_PD|ZN_PDRV0|ZN_PDRV1|ZN_PU|ZN_SL|ZP_CS|ZP_IE|ZP_PD|ZP_PDRV0|ZP_PDRV1|ZP_PU|ZP_SL
+ VDD|XN_OE|XP_OE|YN_OE|YP_OE|ZN_OE|ZP_OE
+ VDD|XN_OE|XP_OE|YN_OE|YP_OE|ZN_OE|ZP_OE pfet_06v0 L=2U W=9.75U AS=4.29P
+ AD=4.29P PS=20.38U PD=20.38U
M$824 \$12695 \$4872 \$12747 VDD|XN_OE|XP_OE|YN_OE|YP_OE|ZN_OE|ZP_OE pfet_06v0
+ L=1U W=10U AS=4.4P AD=2.6P PS=20.88U PD=10.52U
M$825 \$12747 \$4872 \$12695 VDD|XN_OE|XP_OE|YN_OE|YP_OE|ZN_OE|ZP_OE pfet_06v0
+ L=1U W=10U AS=2.6P AD=4.4P PS=10.52U PD=20.88U
M$826 \$12693 \$4864 \$12747 VDD|XN_OE|XP_OE|YN_OE|YP_OE|ZN_OE|ZP_OE pfet_06v0
+ L=1U W=10U AS=4.4P AD=2.6P PS=20.88U PD=10.52U
M$827 \$12747 \$4864 \$12693 VDD|XN_OE|XP_OE|YN_OE|YP_OE|ZN_OE|ZP_OE pfet_06v0
+ L=1U W=10U AS=2.6P AD=4.4P PS=10.52U PD=20.88U
M$828 \$12697 \$12667 VDD|XN_OE|XP_OE|YN_OE|YP_OE|ZN_OE|ZP_OE
+ VDD|XN_OE|XP_OE|YN_OE|YP_OE|ZN_OE|ZP_OE pfet_06v0 L=1U W=10U AS=4.4P AD=2.6P
+ PS=20.88U PD=10.52U
M$829 VDD|XN_OE|XP_OE|YN_OE|YP_OE|ZN_OE|ZP_OE \$12667 \$12697
+ VDD|XN_OE|XP_OE|YN_OE|YP_OE|ZN_OE|ZP_OE pfet_06v0 L=1U W=10U AS=2.6P AD=2.6P
+ PS=10.52U PD=10.52U
M$830 \$12697 \$12667 VDD|XN_OE|XP_OE|YN_OE|YP_OE|ZN_OE|ZP_OE
+ VDD|XN_OE|XP_OE|YN_OE|YP_OE|ZN_OE|ZP_OE pfet_06v0 L=1U W=10U AS=2.6P AD=4.4P
+ PS=10.52U PD=20.88U
M$831 VDD|XN_OE|XP_OE|YN_OE|YP_OE|ZN_OE|ZP_OE
+ VSS|XN_CS|XN_IE|XN_PD|XN_PDRV0|XN_PDRV1|XN_PU|XN_SL|XP_CS|XP_IE|XP_PD|XP_PDRV0|XP_PDRV1|XP_PU|XP_SL|YN_CS|YN_IE|YN_PD|YN_PDRV0|YN_PDRV1|YN_PU|YN_SL|YP_CS|YP_IE|YP_PD|YP_PDRV0|YP_PDRV1|YP_PU|YP_SL|ZN_CS|ZN_IE|ZN_PD|ZN_PDRV0|ZN_PDRV1|ZN_PU|ZN_SL|ZP_CS|ZP_IE|ZP_PD|ZP_PDRV0|ZP_PDRV1|ZP_PU|ZP_SL
+ VDD|XN_OE|XP_OE|YN_OE|YP_OE|ZN_OE|ZP_OE
+ VDD|XN_OE|XP_OE|YN_OE|YP_OE|ZN_OE|ZP_OE pfet_06v0 L=2U W=9.75U AS=4.29P
+ AD=4.29P PS=20.38U PD=20.38U
M$832 VDD|XN_OE|XP_OE|YN_OE|YP_OE|ZN_OE|ZP_OE
+ VSS|XN_CS|XN_IE|XN_PD|XN_PDRV0|XN_PDRV1|XN_PU|XN_SL|XP_CS|XP_IE|XP_PD|XP_PDRV0|XP_PDRV1|XP_PU|XP_SL|YN_CS|YN_IE|YN_PD|YN_PDRV0|YN_PDRV1|YN_PU|YN_SL|YP_CS|YP_IE|YP_PD|YP_PDRV0|YP_PDRV1|YP_PU|YP_SL|ZN_CS|ZN_IE|ZN_PD|ZN_PDRV0|ZN_PDRV1|ZN_PU|ZN_SL|ZP_CS|ZP_IE|ZP_PD|ZP_PDRV0|ZP_PDRV1|ZP_PU|ZP_SL
+ VDD|XN_OE|XP_OE|YN_OE|YP_OE|ZN_OE|ZP_OE
+ VDD|XN_OE|XP_OE|YN_OE|YP_OE|ZN_OE|ZP_OE pfet_06v0 L=2U W=9.75U AS=4.29P
+ AD=4.29P PS=20.38U PD=20.38U
M$833 \$14414 \$13200 VDD|XN_OE|XP_OE|YN_OE|YP_OE|ZN_OE|ZP_OE
+ VDD|XN_OE|XP_OE|YN_OE|YP_OE|ZN_OE|ZP_OE pfet_06v0 L=1U W=10U AS=4.4P AD=2.5P
+ PS=20.88U PD=10.5U
M$834 \$12671 \$13279 \$14414 VDD|XN_OE|XP_OE|YN_OE|YP_OE|ZN_OE|ZP_OE pfet_06v0
+ L=1U W=10U AS=2.5P AD=4.4P PS=10.5U PD=20.88U
M$835 \$14415 \$13200 VDD|XN_OE|XP_OE|YN_OE|YP_OE|ZN_OE|ZP_OE
+ VDD|XN_OE|XP_OE|YN_OE|YP_OE|ZN_OE|ZP_OE pfet_06v0 L=1U W=10U AS=4.4P AD=2.5P
+ PS=20.88U PD=10.5U
M$836 \$12658 \$13279 \$14415 VDD|XN_OE|XP_OE|YN_OE|YP_OE|ZN_OE|ZP_OE pfet_06v0
+ L=1U W=10U AS=2.5P AD=4.4P PS=10.5U PD=20.88U
M$837 \$14416 \$13200 VDD|XN_OE|XP_OE|YN_OE|YP_OE|ZN_OE|ZP_OE
+ VDD|XN_OE|XP_OE|YN_OE|YP_OE|ZN_OE|ZP_OE pfet_06v0 L=1U W=10U AS=4.4P AD=2.5P
+ PS=20.88U PD=10.5U
M$838 \$13200 \$13279 \$14416 VDD|XN_OE|XP_OE|YN_OE|YP_OE|ZN_OE|ZP_OE pfet_06v0
+ L=1U W=10U AS=2.5P AD=4.4P PS=10.5U PD=20.88U
M$839 \$14417 \$13200 VDD|XN_OE|XP_OE|YN_OE|YP_OE|ZN_OE|ZP_OE
+ VDD|XN_OE|XP_OE|YN_OE|YP_OE|ZN_OE|ZP_OE pfet_06v0 L=1U W=10U AS=4.4P AD=2.5P
+ PS=20.88U PD=10.5U
M$840 \$12743 \$13279 \$14417 VDD|XN_OE|XP_OE|YN_OE|YP_OE|ZN_OE|ZP_OE pfet_06v0
+ L=1U W=10U AS=2.5P AD=3.3P PS=10.5U PD=10.66U
M$841 \$14418 \$13279 \$12743 VDD|XN_OE|XP_OE|YN_OE|YP_OE|ZN_OE|ZP_OE pfet_06v0
+ L=1U W=10U AS=3.3P AD=2.5P PS=10.66U PD=10.5U
M$842 VDD|XN_OE|XP_OE|YN_OE|YP_OE|ZN_OE|ZP_OE \$13200 \$14418
+ VDD|XN_OE|XP_OE|YN_OE|YP_OE|ZN_OE|ZP_OE pfet_06v0 L=1U W=10U AS=2.5P AD=4.4P
+ PS=10.5U PD=20.88U
M$843 \$14420 \$12740 VDD|XN_OE|XP_OE|YN_OE|YP_OE|ZN_OE|ZP_OE
+ VDD|XN_OE|XP_OE|YN_OE|YP_OE|ZN_OE|ZP_OE pfet_06v0 L=1U W=10U AS=4.4P AD=2.5P
+ PS=20.88U PD=10.5U
M$844 \$12740 \$13279 \$14420 VDD|XN_OE|XP_OE|YN_OE|YP_OE|ZN_OE|ZP_OE pfet_06v0
+ L=1U W=10U AS=2.5P AD=3.3P PS=10.5U PD=10.66U
M$845 \$12660 \$12660 \$12740 VDD|XN_OE|XP_OE|YN_OE|YP_OE|ZN_OE|ZP_OE pfet_06v0
+ L=1U W=10U AS=3.3P AD=4.4P PS=10.66U PD=20.88U
M$846 \$14422 \$13200 VDD|XN_OE|XP_OE|YN_OE|YP_OE|ZN_OE|ZP_OE
+ VDD|XN_OE|XP_OE|YN_OE|YP_OE|ZN_OE|ZP_OE pfet_06v0 L=1U W=10U AS=4.4P AD=2.5P
+ PS=20.88U PD=10.5U
M$847 \$12708 \$13279 \$14422 VDD|XN_OE|XP_OE|YN_OE|YP_OE|ZN_OE|ZP_OE pfet_06v0
+ L=1U W=10U AS=2.5P AD=4.4P PS=10.5U PD=20.88U
M$848 \$14423 \$13201 VDD|XN_OE|XP_OE|YN_OE|YP_OE|ZN_OE|ZP_OE
+ VDD|XN_OE|XP_OE|YN_OE|YP_OE|ZN_OE|ZP_OE pfet_06v0 L=1U W=10U AS=4.4P AD=2.5P
+ PS=20.88U PD=10.5U
M$849 \$12680 \$13281 \$14423 VDD|XN_OE|XP_OE|YN_OE|YP_OE|ZN_OE|ZP_OE pfet_06v0
+ L=1U W=10U AS=2.5P AD=4.4P PS=10.5U PD=20.88U
M$850 \$14424 \$13201 VDD|XN_OE|XP_OE|YN_OE|YP_OE|ZN_OE|ZP_OE
+ VDD|XN_OE|XP_OE|YN_OE|YP_OE|ZN_OE|ZP_OE pfet_06v0 L=1U W=10U AS=4.4P AD=2.5P
+ PS=20.88U PD=10.5U
M$851 \$12662 \$13281 \$14424 VDD|XN_OE|XP_OE|YN_OE|YP_OE|ZN_OE|ZP_OE pfet_06v0
+ L=1U W=10U AS=2.5P AD=4.4P PS=10.5U PD=20.88U
M$852 \$14425 \$13201 VDD|XN_OE|XP_OE|YN_OE|YP_OE|ZN_OE|ZP_OE
+ VDD|XN_OE|XP_OE|YN_OE|YP_OE|ZN_OE|ZP_OE pfet_06v0 L=1U W=10U AS=4.4P AD=2.5P
+ PS=20.88U PD=10.5U
M$853 \$13201 \$13281 \$14425 VDD|XN_OE|XP_OE|YN_OE|YP_OE|ZN_OE|ZP_OE pfet_06v0
+ L=1U W=10U AS=2.5P AD=4.4P PS=10.5U PD=20.88U
M$854 \$14426 \$13201 VDD|XN_OE|XP_OE|YN_OE|YP_OE|ZN_OE|ZP_OE
+ VDD|XN_OE|XP_OE|YN_OE|YP_OE|ZN_OE|ZP_OE pfet_06v0 L=1U W=10U AS=4.4P AD=2.5P
+ PS=20.88U PD=10.5U
M$855 \$12745 \$13281 \$14426 VDD|XN_OE|XP_OE|YN_OE|YP_OE|ZN_OE|ZP_OE pfet_06v0
+ L=1U W=10U AS=2.5P AD=3.3P PS=10.5U PD=10.66U
M$856 \$14427 \$13281 \$12745 VDD|XN_OE|XP_OE|YN_OE|YP_OE|ZN_OE|ZP_OE pfet_06v0
+ L=1U W=10U AS=3.3P AD=2.5P PS=10.66U PD=10.5U
M$857 VDD|XN_OE|XP_OE|YN_OE|YP_OE|ZN_OE|ZP_OE \$13201 \$14427
+ VDD|XN_OE|XP_OE|YN_OE|YP_OE|ZN_OE|ZP_OE pfet_06v0 L=1U W=10U AS=2.5P AD=4.4P
+ PS=10.5U PD=20.88U
M$858 \$14428 \$12741 VDD|XN_OE|XP_OE|YN_OE|YP_OE|ZN_OE|ZP_OE
+ VDD|XN_OE|XP_OE|YN_OE|YP_OE|ZN_OE|ZP_OE pfet_06v0 L=1U W=10U AS=4.4P AD=2.5P
+ PS=20.88U PD=10.5U
M$859 \$12741 \$13281 \$14428 VDD|XN_OE|XP_OE|YN_OE|YP_OE|ZN_OE|ZP_OE pfet_06v0
+ L=1U W=10U AS=2.5P AD=3.3P PS=10.5U PD=10.66U
M$860 \$12664 \$12664 \$12741 VDD|XN_OE|XP_OE|YN_OE|YP_OE|ZN_OE|ZP_OE pfet_06v0
+ L=1U W=10U AS=3.3P AD=4.4P PS=10.66U PD=20.88U
M$861 \$14429 \$13201 VDD|XN_OE|XP_OE|YN_OE|YP_OE|ZN_OE|ZP_OE
+ VDD|XN_OE|XP_OE|YN_OE|YP_OE|ZN_OE|ZP_OE pfet_06v0 L=1U W=10U AS=4.4P AD=2.5P
+ PS=20.88U PD=10.5U
M$862 \$12709 \$13281 \$14429 VDD|XN_OE|XP_OE|YN_OE|YP_OE|ZN_OE|ZP_OE pfet_06v0
+ L=1U W=10U AS=2.5P AD=4.4P PS=10.5U PD=20.88U
M$863 \$14430 \$13202 VDD|XN_OE|XP_OE|YN_OE|YP_OE|ZN_OE|ZP_OE
+ VDD|XN_OE|XP_OE|YN_OE|YP_OE|ZN_OE|ZP_OE pfet_06v0 L=1U W=10U AS=4.4P AD=2.5P
+ PS=20.88U PD=10.5U
M$864 \$12689 \$13283 \$14430 VDD|XN_OE|XP_OE|YN_OE|YP_OE|ZN_OE|ZP_OE pfet_06v0
+ L=1U W=10U AS=2.5P AD=4.4P PS=10.5U PD=20.88U
M$865 \$14431 \$13202 VDD|XN_OE|XP_OE|YN_OE|YP_OE|ZN_OE|ZP_OE
+ VDD|XN_OE|XP_OE|YN_OE|YP_OE|ZN_OE|ZP_OE pfet_06v0 L=1U W=10U AS=4.4P AD=2.5P
+ PS=20.88U PD=10.5U
M$866 \$12666 \$13283 \$14431 VDD|XN_OE|XP_OE|YN_OE|YP_OE|ZN_OE|ZP_OE pfet_06v0
+ L=1U W=10U AS=2.5P AD=4.4P PS=10.5U PD=20.88U
M$867 \$14432 \$13202 VDD|XN_OE|XP_OE|YN_OE|YP_OE|ZN_OE|ZP_OE
+ VDD|XN_OE|XP_OE|YN_OE|YP_OE|ZN_OE|ZP_OE pfet_06v0 L=1U W=10U AS=4.4P AD=2.5P
+ PS=20.88U PD=10.5U
M$868 \$13202 \$13283 \$14432 VDD|XN_OE|XP_OE|YN_OE|YP_OE|ZN_OE|ZP_OE pfet_06v0
+ L=1U W=10U AS=2.5P AD=4.4P PS=10.5U PD=20.88U
M$869 \$14433 \$13202 VDD|XN_OE|XP_OE|YN_OE|YP_OE|ZN_OE|ZP_OE
+ VDD|XN_OE|XP_OE|YN_OE|YP_OE|ZN_OE|ZP_OE pfet_06v0 L=1U W=10U AS=4.4P AD=2.5P
+ PS=20.88U PD=10.5U
M$870 \$12747 \$13283 \$14433 VDD|XN_OE|XP_OE|YN_OE|YP_OE|ZN_OE|ZP_OE pfet_06v0
+ L=1U W=10U AS=2.5P AD=3.3P PS=10.5U PD=10.66U
M$871 \$14434 \$13283 \$12747 VDD|XN_OE|XP_OE|YN_OE|YP_OE|ZN_OE|ZP_OE pfet_06v0
+ L=1U W=10U AS=3.3P AD=2.5P PS=10.66U PD=10.5U
M$872 VDD|XN_OE|XP_OE|YN_OE|YP_OE|ZN_OE|ZP_OE \$13202 \$14434
+ VDD|XN_OE|XP_OE|YN_OE|YP_OE|ZN_OE|ZP_OE pfet_06v0 L=1U W=10U AS=2.5P AD=4.4P
+ PS=10.5U PD=20.88U
M$873 \$14421 \$12742 VDD|XN_OE|XP_OE|YN_OE|YP_OE|ZN_OE|ZP_OE
+ VDD|XN_OE|XP_OE|YN_OE|YP_OE|ZN_OE|ZP_OE pfet_06v0 L=1U W=10U AS=4.4P AD=2.5P
+ PS=20.88U PD=10.5U
M$874 \$12742 \$13283 \$14421 VDD|XN_OE|XP_OE|YN_OE|YP_OE|ZN_OE|ZP_OE pfet_06v0
+ L=1U W=10U AS=2.5P AD=3.3P PS=10.5U PD=10.66U
M$875 \$12668 \$12668 \$12742 VDD|XN_OE|XP_OE|YN_OE|YP_OE|ZN_OE|ZP_OE pfet_06v0
+ L=1U W=10U AS=3.3P AD=4.4P PS=10.66U PD=20.88U
M$876 \$14419 \$13202 VDD|XN_OE|XP_OE|YN_OE|YP_OE|ZN_OE|ZP_OE
+ VDD|XN_OE|XP_OE|YN_OE|YP_OE|ZN_OE|ZP_OE pfet_06v0 L=1U W=10U AS=4.4P AD=2.5P
+ PS=20.88U PD=10.5U
M$877 \$12710 \$13283 \$14419 VDD|XN_OE|XP_OE|YN_OE|YP_OE|ZN_OE|ZP_OE pfet_06v0
+ L=1U W=10U AS=2.5P AD=4.4P PS=10.5U PD=20.88U
M$878 \$13279 \$13279 VDD|XN_OE|XP_OE|YN_OE|YP_OE|ZN_OE|ZP_OE
+ VDD|XN_OE|XP_OE|YN_OE|YP_OE|ZN_OE|ZP_OE pfet_06v0 L=1U W=2U AS=0.88P AD=0.88P
+ PS=4.88U PD=4.88U
M$879 \$12744 \$13279 \$12674 VDD|XN_OE|XP_OE|YN_OE|YP_OE|ZN_OE|ZP_OE pfet_06v0
+ L=1U W=5U AS=2.2P AD=1.3P PS=10.88U PD=5.52U
M$880 \$12674 \$13279 \$12744 VDD|XN_OE|XP_OE|YN_OE|YP_OE|ZN_OE|ZP_OE pfet_06v0
+ L=1U W=5U AS=1.3P AD=2.2P PS=5.52U PD=10.88U
M$881 \$12659 \$13279 \$12673 VDD|XN_OE|XP_OE|YN_OE|YP_OE|ZN_OE|ZP_OE pfet_06v0
+ L=1U W=5U AS=2.2P AD=1.3P PS=10.88U PD=5.52U
M$882 \$12673 \$13279 \$12659 VDD|XN_OE|XP_OE|YN_OE|YP_OE|ZN_OE|ZP_OE pfet_06v0
+ L=1U W=5U AS=1.3P AD=2.2P PS=5.52U PD=10.88U
M$883 \$12674 \$12744 VDD|XN_OE|XP_OE|YN_OE|YP_OE|ZN_OE|ZP_OE
+ VDD|XN_OE|XP_OE|YN_OE|YP_OE|ZN_OE|ZP_OE pfet_06v0 L=1U W=5U AS=2.2P AD=1.3P
+ PS=10.88U PD=5.52U
M$884 VDD|XN_OE|XP_OE|YN_OE|YP_OE|ZN_OE|ZP_OE \$12744 \$12674
+ VDD|XN_OE|XP_OE|YN_OE|YP_OE|ZN_OE|ZP_OE pfet_06v0 L=1U W=5U AS=1.3P AD=1.3P
+ PS=5.52U PD=5.52U
M$885 \$12674 \$12744 VDD|XN_OE|XP_OE|YN_OE|YP_OE|ZN_OE|ZP_OE
+ VDD|XN_OE|XP_OE|YN_OE|YP_OE|ZN_OE|ZP_OE pfet_06v0 L=1U W=5U AS=1.3P AD=1.3P
+ PS=5.52U PD=5.52U
M$886 VDD|XN_OE|XP_OE|YN_OE|YP_OE|ZN_OE|ZP_OE \$12744 \$12674
+ VDD|XN_OE|XP_OE|YN_OE|YP_OE|ZN_OE|ZP_OE pfet_06v0 L=1U W=5U AS=1.3P AD=2.2P
+ PS=5.52U PD=10.88U
M$887 \$12673 \$12744 VDD|XN_OE|XP_OE|YN_OE|YP_OE|ZN_OE|ZP_OE
+ VDD|XN_OE|XP_OE|YN_OE|YP_OE|ZN_OE|ZP_OE pfet_06v0 L=1U W=5U AS=2.2P AD=1.3P
+ PS=10.88U PD=5.52U
M$888 VDD|XN_OE|XP_OE|YN_OE|YP_OE|ZN_OE|ZP_OE \$12744 \$12673
+ VDD|XN_OE|XP_OE|YN_OE|YP_OE|ZN_OE|ZP_OE pfet_06v0 L=1U W=5U AS=1.3P AD=1.3P
+ PS=5.52U PD=5.52U
M$889 \$12673 \$12744 VDD|XN_OE|XP_OE|YN_OE|YP_OE|ZN_OE|ZP_OE
+ VDD|XN_OE|XP_OE|YN_OE|YP_OE|ZN_OE|ZP_OE pfet_06v0 L=1U W=5U AS=1.3P AD=1.3P
+ PS=5.52U PD=5.52U
M$890 VDD|XN_OE|XP_OE|YN_OE|YP_OE|ZN_OE|ZP_OE \$12744 \$12673
+ VDD|XN_OE|XP_OE|YN_OE|YP_OE|ZN_OE|ZP_OE pfet_06v0 L=1U W=5U AS=1.3P AD=2.2P
+ PS=5.52U PD=10.88U
M$891 \$12676 \$12660 \$12744 VDD|XN_OE|XP_OE|YN_OE|YP_OE|ZN_OE|ZP_OE pfet_06v0
+ L=1U W=5U AS=2.2P AD=2.2P PS=10.88U PD=10.88U
M$892 \$12678 \$12660 \$12659 VDD|XN_OE|XP_OE|YN_OE|YP_OE|ZN_OE|ZP_OE pfet_06v0
+ L=1U W=5U AS=2.2P AD=2.2P PS=10.88U PD=10.88U
M$893 \$13281 \$13281 VDD|XN_OE|XP_OE|YN_OE|YP_OE|ZN_OE|ZP_OE
+ VDD|XN_OE|XP_OE|YN_OE|YP_OE|ZN_OE|ZP_OE pfet_06v0 L=1U W=2U AS=0.88P AD=0.88P
+ PS=4.88U PD=4.88U
M$894 \$12746 \$13281 \$12683 VDD|XN_OE|XP_OE|YN_OE|YP_OE|ZN_OE|ZP_OE pfet_06v0
+ L=1U W=5U AS=2.2P AD=1.3P PS=10.88U PD=5.52U
M$895 \$12683 \$13281 \$12746 VDD|XN_OE|XP_OE|YN_OE|YP_OE|ZN_OE|ZP_OE pfet_06v0
+ L=1U W=5U AS=1.3P AD=2.2P PS=5.52U PD=10.88U
M$896 \$12663 \$13281 \$12682 VDD|XN_OE|XP_OE|YN_OE|YP_OE|ZN_OE|ZP_OE pfet_06v0
+ L=1U W=5U AS=2.2P AD=1.3P PS=10.88U PD=5.52U
M$897 \$12682 \$13281 \$12663 VDD|XN_OE|XP_OE|YN_OE|YP_OE|ZN_OE|ZP_OE pfet_06v0
+ L=1U W=5U AS=1.3P AD=2.2P PS=5.52U PD=10.88U
M$898 \$12683 \$12746 VDD|XN_OE|XP_OE|YN_OE|YP_OE|ZN_OE|ZP_OE
+ VDD|XN_OE|XP_OE|YN_OE|YP_OE|ZN_OE|ZP_OE pfet_06v0 L=1U W=5U AS=2.2P AD=1.3P
+ PS=10.88U PD=5.52U
M$899 VDD|XN_OE|XP_OE|YN_OE|YP_OE|ZN_OE|ZP_OE \$12746 \$12683
+ VDD|XN_OE|XP_OE|YN_OE|YP_OE|ZN_OE|ZP_OE pfet_06v0 L=1U W=5U AS=1.3P AD=1.3P
+ PS=5.52U PD=5.52U
M$900 \$12683 \$12746 VDD|XN_OE|XP_OE|YN_OE|YP_OE|ZN_OE|ZP_OE
+ VDD|XN_OE|XP_OE|YN_OE|YP_OE|ZN_OE|ZP_OE pfet_06v0 L=1U W=5U AS=1.3P AD=1.3P
+ PS=5.52U PD=5.52U
M$901 VDD|XN_OE|XP_OE|YN_OE|YP_OE|ZN_OE|ZP_OE \$12746 \$12683
+ VDD|XN_OE|XP_OE|YN_OE|YP_OE|ZN_OE|ZP_OE pfet_06v0 L=1U W=5U AS=1.3P AD=2.2P
+ PS=5.52U PD=10.88U
M$902 \$12682 \$12746 VDD|XN_OE|XP_OE|YN_OE|YP_OE|ZN_OE|ZP_OE
+ VDD|XN_OE|XP_OE|YN_OE|YP_OE|ZN_OE|ZP_OE pfet_06v0 L=1U W=5U AS=2.2P AD=1.3P
+ PS=10.88U PD=5.52U
M$903 VDD|XN_OE|XP_OE|YN_OE|YP_OE|ZN_OE|ZP_OE \$12746 \$12682
+ VDD|XN_OE|XP_OE|YN_OE|YP_OE|ZN_OE|ZP_OE pfet_06v0 L=1U W=5U AS=1.3P AD=1.3P
+ PS=5.52U PD=5.52U
M$904 \$12682 \$12746 VDD|XN_OE|XP_OE|YN_OE|YP_OE|ZN_OE|ZP_OE
+ VDD|XN_OE|XP_OE|YN_OE|YP_OE|ZN_OE|ZP_OE pfet_06v0 L=1U W=5U AS=1.3P AD=1.3P
+ PS=5.52U PD=5.52U
M$905 VDD|XN_OE|XP_OE|YN_OE|YP_OE|ZN_OE|ZP_OE \$12746 \$12682
+ VDD|XN_OE|XP_OE|YN_OE|YP_OE|ZN_OE|ZP_OE pfet_06v0 L=1U W=5U AS=1.3P AD=2.2P
+ PS=5.52U PD=10.88U
M$906 \$12685 \$12664 \$12746 VDD|XN_OE|XP_OE|YN_OE|YP_OE|ZN_OE|ZP_OE pfet_06v0
+ L=1U W=5U AS=2.2P AD=2.2P PS=10.88U PD=10.88U
M$907 \$12687 \$12664 \$12663 VDD|XN_OE|XP_OE|YN_OE|YP_OE|ZN_OE|ZP_OE pfet_06v0
+ L=1U W=5U AS=2.2P AD=2.2P PS=10.88U PD=10.88U
M$908 \$13283 \$13283 VDD|XN_OE|XP_OE|YN_OE|YP_OE|ZN_OE|ZP_OE
+ VDD|XN_OE|XP_OE|YN_OE|YP_OE|ZN_OE|ZP_OE pfet_06v0 L=1U W=2U AS=0.88P AD=0.88P
+ PS=4.88U PD=4.88U
M$909 \$12748 \$13283 \$12692 VDD|XN_OE|XP_OE|YN_OE|YP_OE|ZN_OE|ZP_OE pfet_06v0
+ L=1U W=5U AS=2.2P AD=1.3P PS=10.88U PD=5.52U
M$910 \$12692 \$13283 \$12748 VDD|XN_OE|XP_OE|YN_OE|YP_OE|ZN_OE|ZP_OE pfet_06v0
+ L=1U W=5U AS=1.3P AD=2.2P PS=5.52U PD=10.88U
M$911 \$12667 \$13283 \$12691 VDD|XN_OE|XP_OE|YN_OE|YP_OE|ZN_OE|ZP_OE pfet_06v0
+ L=1U W=5U AS=2.2P AD=1.3P PS=10.88U PD=5.52U
M$912 \$12691 \$13283 \$12667 VDD|XN_OE|XP_OE|YN_OE|YP_OE|ZN_OE|ZP_OE pfet_06v0
+ L=1U W=5U AS=1.3P AD=2.2P PS=5.52U PD=10.88U
M$913 \$12692 \$12748 VDD|XN_OE|XP_OE|YN_OE|YP_OE|ZN_OE|ZP_OE
+ VDD|XN_OE|XP_OE|YN_OE|YP_OE|ZN_OE|ZP_OE pfet_06v0 L=1U W=5U AS=2.2P AD=1.3P
+ PS=10.88U PD=5.52U
M$914 VDD|XN_OE|XP_OE|YN_OE|YP_OE|ZN_OE|ZP_OE \$12748 \$12692
+ VDD|XN_OE|XP_OE|YN_OE|YP_OE|ZN_OE|ZP_OE pfet_06v0 L=1U W=5U AS=1.3P AD=1.3P
+ PS=5.52U PD=5.52U
M$915 \$12692 \$12748 VDD|XN_OE|XP_OE|YN_OE|YP_OE|ZN_OE|ZP_OE
+ VDD|XN_OE|XP_OE|YN_OE|YP_OE|ZN_OE|ZP_OE pfet_06v0 L=1U W=5U AS=1.3P AD=1.3P
+ PS=5.52U PD=5.52U
M$916 VDD|XN_OE|XP_OE|YN_OE|YP_OE|ZN_OE|ZP_OE \$12748 \$12692
+ VDD|XN_OE|XP_OE|YN_OE|YP_OE|ZN_OE|ZP_OE pfet_06v0 L=1U W=5U AS=1.3P AD=2.2P
+ PS=5.52U PD=10.88U
M$917 \$12691 \$12748 VDD|XN_OE|XP_OE|YN_OE|YP_OE|ZN_OE|ZP_OE
+ VDD|XN_OE|XP_OE|YN_OE|YP_OE|ZN_OE|ZP_OE pfet_06v0 L=1U W=5U AS=2.2P AD=1.3P
+ PS=10.88U PD=5.52U
M$918 VDD|XN_OE|XP_OE|YN_OE|YP_OE|ZN_OE|ZP_OE \$12748 \$12691
+ VDD|XN_OE|XP_OE|YN_OE|YP_OE|ZN_OE|ZP_OE pfet_06v0 L=1U W=5U AS=1.3P AD=1.3P
+ PS=5.52U PD=5.52U
M$919 \$12691 \$12748 VDD|XN_OE|XP_OE|YN_OE|YP_OE|ZN_OE|ZP_OE
+ VDD|XN_OE|XP_OE|YN_OE|YP_OE|ZN_OE|ZP_OE pfet_06v0 L=1U W=5U AS=1.3P AD=1.3P
+ PS=5.52U PD=5.52U
M$920 VDD|XN_OE|XP_OE|YN_OE|YP_OE|ZN_OE|ZP_OE \$12748 \$12691
+ VDD|XN_OE|XP_OE|YN_OE|YP_OE|ZN_OE|ZP_OE pfet_06v0 L=1U W=5U AS=1.3P AD=2.2P
+ PS=5.52U PD=10.88U
M$921 \$12694 \$12668 \$12748 VDD|XN_OE|XP_OE|YN_OE|YP_OE|ZN_OE|ZP_OE pfet_06v0
+ L=1U W=5U AS=2.2P AD=2.2P PS=10.88U PD=10.88U
M$922 \$12696 \$12668 \$12667 VDD|XN_OE|XP_OE|YN_OE|YP_OE|ZN_OE|ZP_OE pfet_06v0
+ L=1U W=5U AS=2.2P AD=2.2P PS=10.88U PD=10.88U
M$923 \$7260 X
+ VSS|XN_CS|XN_IE|XN_PD|XN_PDRV0|XN_PDRV1|XN_PU|XN_SL|XP_CS|XP_IE|XP_PD|XP_PDRV0|XP_PDRV1|XP_PU|XP_SL|YN_CS|YN_IE|YN_PD|YN_PDRV0|YN_PDRV1|YN_PU|YN_SL|YP_CS|YP_IE|YP_PD|YP_PDRV0|YP_PDRV1|YP_PU|YP_SL|ZN_CS|ZN_IE|ZN_PD|ZN_PDRV0|ZN_PDRV1|ZN_PU|ZN_SL|ZP_CS|ZP_IE|ZP_PD|ZP_PDRV0|ZP_PDRV1|ZP_PU|ZP_SL
+ VSS|XN_CS|XN_IE|XN_PD|XN_PDRV0|XN_PDRV1|XN_PU|XN_SL|XP_CS|XP_IE|XP_PD|XP_PDRV0|XP_PDRV1|XP_PU|XP_SL|YN_CS|YN_IE|YN_PD|YN_PDRV0|YN_PDRV1|YN_PU|YN_SL|YP_CS|YP_IE|YP_PD|YP_PDRV0|YP_PDRV1|YP_PU|YP_SL|ZN_CS|ZN_IE|ZN_PD|ZN_PDRV0|ZN_PDRV1|ZN_PU|ZN_SL|ZP_CS|ZP_IE|ZP_PD|ZP_PDRV0|ZP_PDRV1|ZP_PU|ZP_SL
+ nfet_05v0 L=0.6U W=1.32U AS=0.5808P AD=0.5808P PS=3.52U PD=3.52U
M$924 XN_OUT \$7260
+ VSS|XN_CS|XN_IE|XN_PD|XN_PDRV0|XN_PDRV1|XN_PU|XN_SL|XP_CS|XP_IE|XP_PD|XP_PDRV0|XP_PDRV1|XP_PU|XP_SL|YN_CS|YN_IE|YN_PD|YN_PDRV0|YN_PDRV1|YN_PU|YN_SL|YP_CS|YP_IE|YP_PD|YP_PDRV0|YP_PDRV1|YP_PU|YP_SL|ZN_CS|ZN_IE|ZN_PD|ZN_PDRV0|ZN_PDRV1|ZN_PU|ZN_SL|ZP_CS|ZP_IE|ZP_PD|ZP_PDRV0|ZP_PDRV1|ZP_PU|ZP_SL
+ VSS|XN_CS|XN_IE|XN_PD|XN_PDRV0|XN_PDRV1|XN_PU|XN_SL|XP_CS|XP_IE|XP_PD|XP_PDRV0|XP_PDRV1|XP_PU|XP_SL|YN_CS|YN_IE|YN_PD|YN_PDRV0|YN_PDRV1|YN_PU|YN_SL|YP_CS|YP_IE|YP_PD|YP_PDRV0|YP_PDRV1|YP_PU|YP_SL|ZN_CS|ZN_IE|ZN_PD|ZN_PDRV0|ZN_PDRV1|ZN_PU|ZN_SL|ZP_CS|ZP_IE|ZP_PD|ZP_PDRV0|ZP_PDRV1|ZP_PU|ZP_SL
+ nfet_05v0 L=0.6U W=1.32U AS=0.5808P AD=0.5808P PS=3.52U PD=3.52U
M$925 XP_OUT XN_OUT
+ VSS|XN_CS|XN_IE|XN_PD|XN_PDRV0|XN_PDRV1|XN_PU|XN_SL|XP_CS|XP_IE|XP_PD|XP_PDRV0|XP_PDRV1|XP_PU|XP_SL|YN_CS|YN_IE|YN_PD|YN_PDRV0|YN_PDRV1|YN_PU|YN_SL|YP_CS|YP_IE|YP_PD|YP_PDRV0|YP_PDRV1|YP_PU|YP_SL|ZN_CS|ZN_IE|ZN_PD|ZN_PDRV0|ZN_PDRV1|ZN_PU|ZN_SL|ZP_CS|ZP_IE|ZP_PD|ZP_PDRV0|ZP_PDRV1|ZP_PU|ZP_SL
+ VSS|XN_CS|XN_IE|XN_PD|XN_PDRV0|XN_PDRV1|XN_PU|XN_SL|XP_CS|XP_IE|XP_PD|XP_PDRV0|XP_PDRV1|XP_PU|XP_SL|YN_CS|YN_IE|YN_PD|YN_PDRV0|YN_PDRV1|YN_PU|YN_SL|YP_CS|YP_IE|YP_PD|YP_PDRV0|YP_PDRV1|YP_PU|YP_SL|ZN_CS|ZN_IE|ZN_PD|ZN_PDRV0|ZN_PDRV1|ZN_PU|ZN_SL|ZP_CS|ZP_IE|ZP_PD|ZP_PDRV0|ZP_PDRV1|ZP_PU|ZP_SL
+ nfet_05v0 L=0.6U W=1.32U AS=0.5808P AD=0.5808P PS=3.52U PD=3.52U
M$926 \$9063 Y
+ VSS|XN_CS|XN_IE|XN_PD|XN_PDRV0|XN_PDRV1|XN_PU|XN_SL|XP_CS|XP_IE|XP_PD|XP_PDRV0|XP_PDRV1|XP_PU|XP_SL|YN_CS|YN_IE|YN_PD|YN_PDRV0|YN_PDRV1|YN_PU|YN_SL|YP_CS|YP_IE|YP_PD|YP_PDRV0|YP_PDRV1|YP_PU|YP_SL|ZN_CS|ZN_IE|ZN_PD|ZN_PDRV0|ZN_PDRV1|ZN_PU|ZN_SL|ZP_CS|ZP_IE|ZP_PD|ZP_PDRV0|ZP_PDRV1|ZP_PU|ZP_SL
+ VSS|XN_CS|XN_IE|XN_PD|XN_PDRV0|XN_PDRV1|XN_PU|XN_SL|XP_CS|XP_IE|XP_PD|XP_PDRV0|XP_PDRV1|XP_PU|XP_SL|YN_CS|YN_IE|YN_PD|YN_PDRV0|YN_PDRV1|YN_PU|YN_SL|YP_CS|YP_IE|YP_PD|YP_PDRV0|YP_PDRV1|YP_PU|YP_SL|ZN_CS|ZN_IE|ZN_PD|ZN_PDRV0|ZN_PDRV1|ZN_PU|ZN_SL|ZP_CS|ZP_IE|ZP_PD|ZP_PDRV0|ZP_PDRV1|ZP_PU|ZP_SL
+ nfet_05v0 L=0.6U W=1.32U AS=0.5808P AD=0.5808P PS=3.52U PD=3.52U
M$927 YN_OUT \$9063
+ VSS|XN_CS|XN_IE|XN_PD|XN_PDRV0|XN_PDRV1|XN_PU|XN_SL|XP_CS|XP_IE|XP_PD|XP_PDRV0|XP_PDRV1|XP_PU|XP_SL|YN_CS|YN_IE|YN_PD|YN_PDRV0|YN_PDRV1|YN_PU|YN_SL|YP_CS|YP_IE|YP_PD|YP_PDRV0|YP_PDRV1|YP_PU|YP_SL|ZN_CS|ZN_IE|ZN_PD|ZN_PDRV0|ZN_PDRV1|ZN_PU|ZN_SL|ZP_CS|ZP_IE|ZP_PD|ZP_PDRV0|ZP_PDRV1|ZP_PU|ZP_SL
+ VSS|XN_CS|XN_IE|XN_PD|XN_PDRV0|XN_PDRV1|XN_PU|XN_SL|XP_CS|XP_IE|XP_PD|XP_PDRV0|XP_PDRV1|XP_PU|XP_SL|YN_CS|YN_IE|YN_PD|YN_PDRV0|YN_PDRV1|YN_PU|YN_SL|YP_CS|YP_IE|YP_PD|YP_PDRV0|YP_PDRV1|YP_PU|YP_SL|ZN_CS|ZN_IE|ZN_PD|ZN_PDRV0|ZN_PDRV1|ZN_PU|ZN_SL|ZP_CS|ZP_IE|ZP_PD|ZP_PDRV0|ZP_PDRV1|ZP_PU|ZP_SL
+ nfet_05v0 L=0.6U W=1.32U AS=0.5808P AD=0.5808P PS=3.52U PD=3.52U
M$928 YP_OUT YN_OUT
+ VSS|XN_CS|XN_IE|XN_PD|XN_PDRV0|XN_PDRV1|XN_PU|XN_SL|XP_CS|XP_IE|XP_PD|XP_PDRV0|XP_PDRV1|XP_PU|XP_SL|YN_CS|YN_IE|YN_PD|YN_PDRV0|YN_PDRV1|YN_PU|YN_SL|YP_CS|YP_IE|YP_PD|YP_PDRV0|YP_PDRV1|YP_PU|YP_SL|ZN_CS|ZN_IE|ZN_PD|ZN_PDRV0|ZN_PDRV1|ZN_PU|ZN_SL|ZP_CS|ZP_IE|ZP_PD|ZP_PDRV0|ZP_PDRV1|ZP_PU|ZP_SL
+ VSS|XN_CS|XN_IE|XN_PD|XN_PDRV0|XN_PDRV1|XN_PU|XN_SL|XP_CS|XP_IE|XP_PD|XP_PDRV0|XP_PDRV1|XP_PU|XP_SL|YN_CS|YN_IE|YN_PD|YN_PDRV0|YN_PDRV1|YN_PU|YN_SL|YP_CS|YP_IE|YP_PD|YP_PDRV0|YP_PDRV1|YP_PU|YP_SL|ZN_CS|ZN_IE|ZN_PD|ZN_PDRV0|ZN_PDRV1|ZN_PU|ZN_SL|ZP_CS|ZP_IE|ZP_PD|ZP_PDRV0|ZP_PDRV1|ZP_PU|ZP_SL
+ nfet_05v0 L=0.6U W=1.32U AS=0.5808P AD=0.5808P PS=3.52U PD=3.52U
M$929 \$10864 Z
+ VSS|XN_CS|XN_IE|XN_PD|XN_PDRV0|XN_PDRV1|XN_PU|XN_SL|XP_CS|XP_IE|XP_PD|XP_PDRV0|XP_PDRV1|XP_PU|XP_SL|YN_CS|YN_IE|YN_PD|YN_PDRV0|YN_PDRV1|YN_PU|YN_SL|YP_CS|YP_IE|YP_PD|YP_PDRV0|YP_PDRV1|YP_PU|YP_SL|ZN_CS|ZN_IE|ZN_PD|ZN_PDRV0|ZN_PDRV1|ZN_PU|ZN_SL|ZP_CS|ZP_IE|ZP_PD|ZP_PDRV0|ZP_PDRV1|ZP_PU|ZP_SL
+ VSS|XN_CS|XN_IE|XN_PD|XN_PDRV0|XN_PDRV1|XN_PU|XN_SL|XP_CS|XP_IE|XP_PD|XP_PDRV0|XP_PDRV1|XP_PU|XP_SL|YN_CS|YN_IE|YN_PD|YN_PDRV0|YN_PDRV1|YN_PU|YN_SL|YP_CS|YP_IE|YP_PD|YP_PDRV0|YP_PDRV1|YP_PU|YP_SL|ZN_CS|ZN_IE|ZN_PD|ZN_PDRV0|ZN_PDRV1|ZN_PU|ZN_SL|ZP_CS|ZP_IE|ZP_PD|ZP_PDRV0|ZP_PDRV1|ZP_PU|ZP_SL
+ nfet_05v0 L=0.6U W=1.32U AS=0.5808P AD=0.5808P PS=3.52U PD=3.52U
M$930 ZN_OUT \$10864
+ VSS|XN_CS|XN_IE|XN_PD|XN_PDRV0|XN_PDRV1|XN_PU|XN_SL|XP_CS|XP_IE|XP_PD|XP_PDRV0|XP_PDRV1|XP_PU|XP_SL|YN_CS|YN_IE|YN_PD|YN_PDRV0|YN_PDRV1|YN_PU|YN_SL|YP_CS|YP_IE|YP_PD|YP_PDRV0|YP_PDRV1|YP_PU|YP_SL|ZN_CS|ZN_IE|ZN_PD|ZN_PDRV0|ZN_PDRV1|ZN_PU|ZN_SL|ZP_CS|ZP_IE|ZP_PD|ZP_PDRV0|ZP_PDRV1|ZP_PU|ZP_SL
+ VSS|XN_CS|XN_IE|XN_PD|XN_PDRV0|XN_PDRV1|XN_PU|XN_SL|XP_CS|XP_IE|XP_PD|XP_PDRV0|XP_PDRV1|XP_PU|XP_SL|YN_CS|YN_IE|YN_PD|YN_PDRV0|YN_PDRV1|YN_PU|YN_SL|YP_CS|YP_IE|YP_PD|YP_PDRV0|YP_PDRV1|YP_PU|YP_SL|ZN_CS|ZN_IE|ZN_PD|ZN_PDRV0|ZN_PDRV1|ZN_PU|ZN_SL|ZP_CS|ZP_IE|ZP_PD|ZP_PDRV0|ZP_PDRV1|ZP_PU|ZP_SL
+ nfet_05v0 L=0.6U W=1.32U AS=0.5808P AD=0.5808P PS=3.52U PD=3.52U
M$931 ZP_OUT ZN_OUT
+ VSS|XN_CS|XN_IE|XN_PD|XN_PDRV0|XN_PDRV1|XN_PU|XN_SL|XP_CS|XP_IE|XP_PD|XP_PDRV0|XP_PDRV1|XP_PU|XP_SL|YN_CS|YN_IE|YN_PD|YN_PDRV0|YN_PDRV1|YN_PU|YN_SL|YP_CS|YP_IE|YP_PD|YP_PDRV0|YP_PDRV1|YP_PU|YP_SL|ZN_CS|ZN_IE|ZN_PD|ZN_PDRV0|ZN_PDRV1|ZN_PU|ZN_SL|ZP_CS|ZP_IE|ZP_PD|ZP_PDRV0|ZP_PDRV1|ZP_PU|ZP_SL
+ VSS|XN_CS|XN_IE|XN_PD|XN_PDRV0|XN_PDRV1|XN_PU|XN_SL|XP_CS|XP_IE|XP_PD|XP_PDRV0|XP_PDRV1|XP_PU|XP_SL|YN_CS|YN_IE|YN_PD|YN_PDRV0|YN_PDRV1|YN_PU|YN_SL|YP_CS|YP_IE|YP_PD|YP_PDRV0|YP_PDRV1|YP_PU|YP_SL|ZN_CS|ZN_IE|ZN_PD|ZN_PDRV0|ZN_PDRV1|ZN_PU|ZN_SL|ZP_CS|ZP_IE|ZP_PD|ZP_PDRV0|ZP_PDRV1|ZP_PU|ZP_SL
+ nfet_05v0 L=0.6U W=1.32U AS=0.5808P AD=0.5808P PS=3.52U PD=3.52U
M$932 \$71 \$91
+ VSS|XN_CS|XN_IE|XN_PD|XN_PDRV0|XN_PDRV1|XN_PU|XN_SL|XP_CS|XP_IE|XP_PD|XP_PDRV0|XP_PDRV1|XP_PU|XP_SL|YN_CS|YN_IE|YN_PD|YN_PDRV0|YN_PDRV1|YN_PU|YN_SL|YP_CS|YP_IE|YP_PD|YP_PDRV0|YP_PDRV1|YP_PU|YP_SL|ZN_CS|ZN_IE|ZN_PD|ZN_PDRV0|ZN_PDRV1|ZN_PU|ZN_SL|ZP_CS|ZP_IE|ZP_PD|ZP_PDRV0|ZP_PDRV1|ZP_PU|ZP_SL
+ VSS|XN_CS|XN_IE|XN_PD|XN_PDRV0|XN_PDRV1|XN_PU|XN_SL|XP_CS|XP_IE|XP_PD|XP_PDRV0|XP_PDRV1|XP_PU|XP_SL|YN_CS|YN_IE|YN_PD|YN_PDRV0|YN_PDRV1|YN_PU|YN_SL|YP_CS|YP_IE|YP_PD|YP_PDRV0|YP_PDRV1|YP_PU|YP_SL|ZN_CS|ZN_IE|ZN_PD|ZN_PDRV0|ZN_PDRV1|ZN_PU|ZN_SL|ZP_CS|ZP_IE|ZP_PD|ZP_PDRV0|ZP_PDRV1|ZP_PU|ZP_SL
+ nfet_06v0 L=1U W=5U AS=2.2P AD=1.25P PS=10.88U PD=5.5U
M$933 \$23 \$92 \$71
+ VSS|XN_CS|XN_IE|XN_PD|XN_PDRV0|XN_PDRV1|XN_PU|XN_SL|XP_CS|XP_IE|XP_PD|XP_PDRV0|XP_PDRV1|XP_PU|XP_SL|YN_CS|YN_IE|YN_PD|YN_PDRV0|YN_PDRV1|YN_PU|YN_SL|YP_CS|YP_IE|YP_PD|YP_PDRV0|YP_PDRV1|YP_PU|YP_SL|ZN_CS|ZN_IE|ZN_PD|ZN_PDRV0|ZN_PDRV1|ZN_PU|ZN_SL|ZP_CS|ZP_IE|ZP_PD|ZP_PDRV0|ZP_PDRV1|ZP_PU|ZP_SL
+ nfet_06v0 L=1U W=5U AS=1.25P AD=2.2P PS=5.5U PD=10.88U
M$934 \$72 \$91
+ VSS|XN_CS|XN_IE|XN_PD|XN_PDRV0|XN_PDRV1|XN_PU|XN_SL|XP_CS|XP_IE|XP_PD|XP_PDRV0|XP_PDRV1|XP_PU|XP_SL|YN_CS|YN_IE|YN_PD|YN_PDRV0|YN_PDRV1|YN_PU|YN_SL|YP_CS|YP_IE|YP_PD|YP_PDRV0|YP_PDRV1|YP_PU|YP_SL|ZN_CS|ZN_IE|ZN_PD|ZN_PDRV0|ZN_PDRV1|ZN_PU|ZN_SL|ZP_CS|ZP_IE|ZP_PD|ZP_PDRV0|ZP_PDRV1|ZP_PU|ZP_SL
+ VSS|XN_CS|XN_IE|XN_PD|XN_PDRV0|XN_PDRV1|XN_PU|XN_SL|XP_CS|XP_IE|XP_PD|XP_PDRV0|XP_PDRV1|XP_PU|XP_SL|YN_CS|YN_IE|YN_PD|YN_PDRV0|YN_PDRV1|YN_PU|YN_SL|YP_CS|YP_IE|YP_PD|YP_PDRV0|YP_PDRV1|YP_PU|YP_SL|ZN_CS|ZN_IE|ZN_PD|ZN_PDRV0|ZN_PDRV1|ZN_PU|ZN_SL|ZP_CS|ZP_IE|ZP_PD|ZP_PDRV0|ZP_PDRV1|ZP_PU|ZP_SL
+ nfet_06v0 L=1U W=5U AS=2.2P AD=1.25P PS=10.88U PD=5.5U
M$935 \$23 \$92 \$72
+ VSS|XN_CS|XN_IE|XN_PD|XN_PDRV0|XN_PDRV1|XN_PU|XN_SL|XP_CS|XP_IE|XP_PD|XP_PDRV0|XP_PDRV1|XP_PU|XP_SL|YN_CS|YN_IE|YN_PD|YN_PDRV0|YN_PDRV1|YN_PU|YN_SL|YP_CS|YP_IE|YP_PD|YP_PDRV0|YP_PDRV1|YP_PU|YP_SL|ZN_CS|ZN_IE|ZN_PD|ZN_PDRV0|ZN_PDRV1|ZN_PU|ZN_SL|ZP_CS|ZP_IE|ZP_PD|ZP_PDRV0|ZP_PDRV1|ZP_PU|ZP_SL
+ nfet_06v0 L=1U W=5U AS=1.25P AD=2.2P PS=5.5U PD=10.88U
M$936 \$24 \$14440 \$23
+ VSS|XN_CS|XN_IE|XN_PD|XN_PDRV0|XN_PDRV1|XN_PU|XN_SL|XP_CS|XP_IE|XP_PD|XP_PDRV0|XP_PDRV1|XP_PU|XP_SL|YN_CS|YN_IE|YN_PD|YN_PDRV0|YN_PDRV1|YN_PU|YN_SL|YP_CS|YP_IE|YP_PD|YP_PDRV0|YP_PDRV1|YP_PU|YP_SL|ZN_CS|ZN_IE|ZN_PD|ZN_PDRV0|ZN_PDRV1|ZN_PU|ZN_SL|ZP_CS|ZP_IE|ZP_PD|ZP_PDRV0|ZP_PDRV1|ZP_PU|ZP_SL
+ nfet_06v0 L=1U W=7.5U AS=3.3P AD=3.3P PS=15.88U PD=15.88U
M$937 \$25 \$14439 \$23
+ VSS|XN_CS|XN_IE|XN_PD|XN_PDRV0|XN_PDRV1|XN_PU|XN_SL|XP_CS|XP_IE|XP_PD|XP_PDRV0|XP_PDRV1|XP_PU|XP_SL|YN_CS|YN_IE|YN_PD|YN_PDRV0|YN_PDRV1|YN_PU|YN_SL|YP_CS|YP_IE|YP_PD|YP_PDRV0|YP_PDRV1|YP_PU|YP_SL|ZN_CS|ZN_IE|ZN_PD|ZN_PDRV0|ZN_PDRV1|ZN_PU|ZN_SL|ZP_CS|ZP_IE|ZP_PD|ZP_PDRV0|ZP_PDRV1|ZP_PU|ZP_SL
+ nfet_06v0 L=1U W=8.5U AS=3.74P AD=3.74P PS=17.88U PD=17.88U
M$938 \$26 \$63
+ VSS|XN_CS|XN_IE|XN_PD|XN_PDRV0|XN_PDRV1|XN_PU|XN_SL|XP_CS|XP_IE|XP_PD|XP_PDRV0|XP_PDRV1|XP_PU|XP_SL|YN_CS|YN_IE|YN_PD|YN_PDRV0|YN_PDRV1|YN_PU|YN_SL|YP_CS|YP_IE|YP_PD|YP_PDRV0|YP_PDRV1|YP_PU|YP_SL|ZN_CS|ZN_IE|ZN_PD|ZN_PDRV0|ZN_PDRV1|ZN_PU|ZN_SL|ZP_CS|ZP_IE|ZP_PD|ZP_PDRV0|ZP_PDRV1|ZP_PU|ZP_SL
+ VSS|XN_CS|XN_IE|XN_PD|XN_PDRV0|XN_PDRV1|XN_PU|XN_SL|XP_CS|XP_IE|XP_PD|XP_PDRV0|XP_PDRV1|XP_PU|XP_SL|YN_CS|YN_IE|YN_PD|YN_PDRV0|YN_PDRV1|YN_PU|YN_SL|YP_CS|YP_IE|YP_PD|YP_PDRV0|YP_PDRV1|YP_PU|YP_SL|ZN_CS|ZN_IE|ZN_PD|ZN_PDRV0|ZN_PDRV1|ZN_PU|ZN_SL|ZP_CS|ZP_IE|ZP_PD|ZP_PDRV0|ZP_PDRV1|ZP_PU|ZP_SL
+ nfet_06v0 L=1U W=2.5U AS=1.1P AD=0.825P PS=5.88U PD=3.16U
M$939 \$63 \$92 \$26
+ VSS|XN_CS|XN_IE|XN_PD|XN_PDRV0|XN_PDRV1|XN_PU|XN_SL|XP_CS|XP_IE|XP_PD|XP_PDRV0|XP_PDRV1|XP_PU|XP_SL|YN_CS|YN_IE|YN_PD|YN_PDRV0|YN_PDRV1|YN_PU|YN_SL|YP_CS|YP_IE|YP_PD|YP_PDRV0|YP_PDRV1|YP_PU|YP_SL|ZN_CS|ZN_IE|ZN_PD|ZN_PDRV0|ZN_PDRV1|ZN_PU|ZN_SL|ZP_CS|ZP_IE|ZP_PD|ZP_PDRV0|ZP_PDRV1|ZP_PU|ZP_SL
+ nfet_06v0 L=1U W=2.5U AS=0.825P AD=1.1P PS=3.16U PD=5.88U
M$940 \$103 \$63
+ VSS|XN_CS|XN_IE|XN_PD|XN_PDRV0|XN_PDRV1|XN_PU|XN_SL|XP_CS|XP_IE|XP_PD|XP_PDRV0|XP_PDRV1|XP_PU|XP_SL|YN_CS|YN_IE|YN_PD|YN_PDRV0|YN_PDRV1|YN_PU|YN_SL|YP_CS|YP_IE|YP_PD|YP_PDRV0|YP_PDRV1|YP_PU|YP_SL|ZN_CS|ZN_IE|ZN_PD|ZN_PDRV0|ZN_PDRV1|ZN_PU|ZN_SL|ZP_CS|ZP_IE|ZP_PD|ZP_PDRV0|ZP_PDRV1|ZP_PU|ZP_SL
+ VSS|XN_CS|XN_IE|XN_PD|XN_PDRV0|XN_PDRV1|XN_PU|XN_SL|XP_CS|XP_IE|XP_PD|XP_PDRV0|XP_PDRV1|XP_PU|XP_SL|YN_CS|YN_IE|YN_PD|YN_PDRV0|YN_PDRV1|YN_PU|YN_SL|YP_CS|YP_IE|YP_PD|YP_PDRV0|YP_PDRV1|YP_PU|YP_SL|ZN_CS|ZN_IE|ZN_PD|ZN_PDRV0|ZN_PDRV1|ZN_PU|ZN_SL|ZP_CS|ZP_IE|ZP_PD|ZP_PDRV0|ZP_PDRV1|ZP_PU|ZP_SL
+ nfet_06v0 L=1U W=2.5U AS=1.1P AD=0.825P PS=5.88U PD=3.16U
M$941 \$27 \$92 \$103
+ VSS|XN_CS|XN_IE|XN_PD|XN_PDRV0|XN_PDRV1|XN_PU|XN_SL|XP_CS|XP_IE|XP_PD|XP_PDRV0|XP_PDRV1|XP_PU|XP_SL|YN_CS|YN_IE|YN_PD|YN_PDRV0|YN_PDRV1|YN_PU|YN_SL|YP_CS|YP_IE|YP_PD|YP_PDRV0|YP_PDRV1|YP_PU|YP_SL|ZN_CS|ZN_IE|ZN_PD|ZN_PDRV0|ZN_PDRV1|ZN_PU|ZN_SL|ZP_CS|ZP_IE|ZP_PD|ZP_PDRV0|ZP_PDRV1|ZP_PU|ZP_SL
+ nfet_06v0 L=1U W=2.5U AS=0.825P AD=1.1P PS=3.16U PD=5.88U
M$942 \$136 \$64 \$63
+ VSS|XN_CS|XN_IE|XN_PD|XN_PDRV0|XN_PDRV1|XN_PU|XN_SL|XP_CS|XP_IE|XP_PD|XP_PDRV0|XP_PDRV1|XP_PU|XP_SL|YN_CS|YN_IE|YN_PD|YN_PDRV0|YN_PDRV1|YN_PU|YN_SL|YP_CS|YP_IE|YP_PD|YP_PDRV0|YP_PDRV1|YP_PU|YP_SL|ZN_CS|ZN_IE|ZN_PD|ZN_PDRV0|ZN_PDRV1|ZN_PU|ZN_SL|ZP_CS|ZP_IE|ZP_PD|ZP_PDRV0|ZP_PDRV1|ZP_PU|ZP_SL
+ nfet_06v0 L=1U W=2U AS=0.88P AD=0.88P PS=4.88U PD=4.88U
M$943 \$120 \$64 \$27
+ VSS|XN_CS|XN_IE|XN_PD|XN_PDRV0|XN_PDRV1|XN_PU|XN_SL|XP_CS|XP_IE|XP_PD|XP_PDRV0|XP_PDRV1|XP_PU|XP_SL|YN_CS|YN_IE|YN_PD|YN_PDRV0|YN_PDRV1|YN_PU|YN_SL|YP_CS|YP_IE|YP_PD|YP_PDRV0|YP_PDRV1|YP_PU|YP_SL|ZN_CS|ZN_IE|ZN_PD|ZN_PDRV0|ZN_PDRV1|ZN_PU|ZN_SL|ZP_CS|ZP_IE|ZP_PD|ZP_PDRV0|ZP_PDRV1|ZP_PU|ZP_SL
+ nfet_06v0 L=1U W=2U AS=0.88P AD=0.88P PS=4.88U PD=4.88U
M$944 \$74 \$91
+ VSS|XN_CS|XN_IE|XN_PD|XN_PDRV0|XN_PDRV1|XN_PU|XN_SL|XP_CS|XP_IE|XP_PD|XP_PDRV0|XP_PDRV1|XP_PU|XP_SL|YN_CS|YN_IE|YN_PD|YN_PDRV0|YN_PDRV1|YN_PU|YN_SL|YP_CS|YP_IE|YP_PD|YP_PDRV0|YP_PDRV1|YP_PU|YP_SL|ZN_CS|ZN_IE|ZN_PD|ZN_PDRV0|ZN_PDRV1|ZN_PU|ZN_SL|ZP_CS|ZP_IE|ZP_PD|ZP_PDRV0|ZP_PDRV1|ZP_PU|ZP_SL
+ VSS|XN_CS|XN_IE|XN_PD|XN_PDRV0|XN_PDRV1|XN_PU|XN_SL|XP_CS|XP_IE|XP_PD|XP_PDRV0|XP_PDRV1|XP_PU|XP_SL|YN_CS|YN_IE|YN_PD|YN_PDRV0|YN_PDRV1|YN_PU|YN_SL|YP_CS|YP_IE|YP_PD|YP_PDRV0|YP_PDRV1|YP_PU|YP_SL|ZN_CS|ZN_IE|ZN_PD|ZN_PDRV0|ZN_PDRV1|ZN_PU|ZN_SL|ZP_CS|ZP_IE|ZP_PD|ZP_PDRV0|ZP_PDRV1|ZP_PU|ZP_SL
+ nfet_06v0 L=1U W=5U AS=2.2P AD=1.25P PS=10.88U PD=5.5U
M$945 \$28 \$92 \$74
+ VSS|XN_CS|XN_IE|XN_PD|XN_PDRV0|XN_PDRV1|XN_PU|XN_SL|XP_CS|XP_IE|XP_PD|XP_PDRV0|XP_PDRV1|XP_PU|XP_SL|YN_CS|YN_IE|YN_PD|YN_PDRV0|YN_PDRV1|YN_PU|YN_SL|YP_CS|YP_IE|YP_PD|YP_PDRV0|YP_PDRV1|YP_PU|YP_SL|ZN_CS|ZN_IE|ZN_PD|ZN_PDRV0|ZN_PDRV1|ZN_PU|ZN_SL|ZP_CS|ZP_IE|ZP_PD|ZP_PDRV0|ZP_PDRV1|ZP_PU|ZP_SL
+ nfet_06v0 L=1U W=5U AS=1.25P AD=2.2P PS=5.5U PD=10.88U
M$946 \$75 \$29
+ VSS|XN_CS|XN_IE|XN_PD|XN_PDRV0|XN_PDRV1|XN_PU|XN_SL|XP_CS|XP_IE|XP_PD|XP_PDRV0|XP_PDRV1|XP_PU|XP_SL|YN_CS|YN_IE|YN_PD|YN_PDRV0|YN_PDRV1|YN_PU|YN_SL|YP_CS|YP_IE|YP_PD|YP_PDRV0|YP_PDRV1|YP_PU|YP_SL|ZN_CS|ZN_IE|ZN_PD|ZN_PDRV0|ZN_PDRV1|ZN_PU|ZN_SL|ZP_CS|ZP_IE|ZP_PD|ZP_PDRV0|ZP_PDRV1|ZP_PU|ZP_SL
+ VSS|XN_CS|XN_IE|XN_PD|XN_PDRV0|XN_PDRV1|XN_PU|XN_SL|XP_CS|XP_IE|XP_PD|XP_PDRV0|XP_PDRV1|XP_PU|XP_SL|YN_CS|YN_IE|YN_PD|YN_PDRV0|YN_PDRV1|YN_PU|YN_SL|YP_CS|YP_IE|YP_PD|YP_PDRV0|YP_PDRV1|YP_PU|YP_SL|ZN_CS|ZN_IE|ZN_PD|ZN_PDRV0|ZN_PDRV1|ZN_PU|ZN_SL|ZP_CS|ZP_IE|ZP_PD|ZP_PDRV0|ZP_PDRV1|ZP_PU|ZP_SL
+ nfet_06v0 L=1U W=5U AS=2.2P AD=1.25P PS=10.88U PD=5.5U
M$947 \$29 \$92 \$75
+ VSS|XN_CS|XN_IE|XN_PD|XN_PDRV0|XN_PDRV1|XN_PU|XN_SL|XP_CS|XP_IE|XP_PD|XP_PDRV0|XP_PDRV1|XP_PU|XP_SL|YN_CS|YN_IE|YN_PD|YN_PDRV0|YN_PDRV1|YN_PU|YN_SL|YP_CS|YP_IE|YP_PD|YP_PDRV0|YP_PDRV1|YP_PU|YP_SL|ZN_CS|ZN_IE|ZN_PD|ZN_PDRV0|ZN_PDRV1|ZN_PU|ZN_SL|ZP_CS|ZP_IE|ZP_PD|ZP_PDRV0|ZP_PDRV1|ZP_PU|ZP_SL
+ nfet_06v0 L=1U W=5U AS=1.25P AD=1.65P PS=5.5U PD=5.66U
M$948 \$64 \$64 \$29
+ VSS|XN_CS|XN_IE|XN_PD|XN_PDRV0|XN_PDRV1|XN_PU|XN_SL|XP_CS|XP_IE|XP_PD|XP_PDRV0|XP_PDRV1|XP_PU|XP_SL|YN_CS|YN_IE|YN_PD|YN_PDRV0|YN_PDRV1|YN_PU|YN_SL|YP_CS|YP_IE|YP_PD|YP_PDRV0|YP_PDRV1|YP_PU|YP_SL|ZN_CS|ZN_IE|ZN_PD|ZN_PDRV0|ZN_PDRV1|ZN_PU|ZN_SL|ZP_CS|ZP_IE|ZP_PD|ZP_PDRV0|ZP_PDRV1|ZP_PU|ZP_SL
+ nfet_06v0 L=1U W=5U AS=1.65P AD=2.2P PS=5.66U PD=10.88U
M$949 \$30 \$27
+ VSS|XN_CS|XN_IE|XN_PD|XN_PDRV0|XN_PDRV1|XN_PU|XN_SL|XP_CS|XP_IE|XP_PD|XP_PDRV0|XP_PDRV1|XP_PU|XP_SL|YN_CS|YN_IE|YN_PD|YN_PDRV0|YN_PDRV1|YN_PU|YN_SL|YP_CS|YP_IE|YP_PD|YP_PDRV0|YP_PDRV1|YP_PU|YP_SL|ZN_CS|ZN_IE|ZN_PD|ZN_PDRV0|ZN_PDRV1|ZN_PU|ZN_SL|ZP_CS|ZP_IE|ZP_PD|ZP_PDRV0|ZP_PDRV1|ZP_PU|ZP_SL
+ VSS|XN_CS|XN_IE|XN_PD|XN_PDRV0|XN_PDRV1|XN_PU|XN_SL|XP_CS|XP_IE|XP_PD|XP_PDRV0|XP_PDRV1|XP_PU|XP_SL|YN_CS|YN_IE|YN_PD|YN_PDRV0|YN_PDRV1|YN_PU|YN_SL|YP_CS|YP_IE|YP_PD|YP_PDRV0|YP_PDRV1|YP_PU|YP_SL|ZN_CS|ZN_IE|ZN_PD|ZN_PDRV0|ZN_PDRV1|ZN_PU|ZN_SL|ZP_CS|ZP_IE|ZP_PD|ZP_PDRV0|ZP_PDRV1|ZP_PU|ZP_SL
+ nfet_06v0 L=1U W=1U AS=0.44P AD=0.44P PS=2.88U PD=2.88U
M$950 \$92 \$92
+ VSS|XN_CS|XN_IE|XN_PD|XN_PDRV0|XN_PDRV1|XN_PU|XN_SL|XP_CS|XP_IE|XP_PD|XP_PDRV0|XP_PDRV1|XP_PU|XP_SL|YN_CS|YN_IE|YN_PD|YN_PDRV0|YN_PDRV1|YN_PU|YN_SL|YP_CS|YP_IE|YP_PD|YP_PDRV0|YP_PDRV1|YP_PU|YP_SL|ZN_CS|ZN_IE|ZN_PD|ZN_PDRV0|ZN_PDRV1|ZN_PU|ZN_SL|ZP_CS|ZP_IE|ZP_PD|ZP_PDRV0|ZP_PDRV1|ZP_PU|ZP_SL
+ VSS|XN_CS|XN_IE|XN_PD|XN_PDRV0|XN_PDRV1|XN_PU|XN_SL|XP_CS|XP_IE|XP_PD|XP_PDRV0|XP_PDRV1|XP_PU|XP_SL|YN_CS|YN_IE|YN_PD|YN_PDRV0|YN_PDRV1|YN_PU|YN_SL|YP_CS|YP_IE|YP_PD|YP_PDRV0|YP_PDRV1|YP_PU|YP_SL|ZN_CS|ZN_IE|ZN_PD|ZN_PDRV0|ZN_PDRV1|ZN_PU|ZN_SL|ZP_CS|ZP_IE|ZP_PD|ZP_PDRV0|ZP_PDRV1|ZP_PU|ZP_SL
+ nfet_06v0 L=1U W=1U AS=0.44P AD=0.44P PS=2.88U PD=2.88U
M$951 \$77 \$91
+ VSS|XN_CS|XN_IE|XN_PD|XN_PDRV0|XN_PDRV1|XN_PU|XN_SL|XP_CS|XP_IE|XP_PD|XP_PDRV0|XP_PDRV1|XP_PU|XP_SL|YN_CS|YN_IE|YN_PD|YN_PDRV0|YN_PDRV1|YN_PU|YN_SL|YP_CS|YP_IE|YP_PD|YP_PDRV0|YP_PDRV1|YP_PU|YP_SL|ZN_CS|ZN_IE|ZN_PD|ZN_PDRV0|ZN_PDRV1|ZN_PU|ZN_SL|ZP_CS|ZP_IE|ZP_PD|ZP_PDRV0|ZP_PDRV1|ZP_PU|ZP_SL
+ VSS|XN_CS|XN_IE|XN_PD|XN_PDRV0|XN_PDRV1|XN_PU|XN_SL|XP_CS|XP_IE|XP_PD|XP_PDRV0|XP_PDRV1|XP_PU|XP_SL|YN_CS|YN_IE|YN_PD|YN_PDRV0|YN_PDRV1|YN_PU|YN_SL|YP_CS|YP_IE|YP_PD|YP_PDRV0|YP_PDRV1|YP_PU|YP_SL|ZN_CS|ZN_IE|ZN_PD|ZN_PDRV0|ZN_PDRV1|ZN_PU|ZN_SL|ZP_CS|ZP_IE|ZP_PD|ZP_PDRV0|ZP_PDRV1|ZP_PU|ZP_SL
+ nfet_06v0 L=1U W=5U AS=2.2P AD=1.25P PS=10.88U PD=5.5U
M$952 \$91 \$92 \$77
+ VSS|XN_CS|XN_IE|XN_PD|XN_PDRV0|XN_PDRV1|XN_PU|XN_SL|XP_CS|XP_IE|XP_PD|XP_PDRV0|XP_PDRV1|XP_PU|XP_SL|YN_CS|YN_IE|YN_PD|YN_PDRV0|YN_PDRV1|YN_PU|YN_SL|YP_CS|YP_IE|YP_PD|YP_PDRV0|YP_PDRV1|YP_PU|YP_SL|ZN_CS|ZN_IE|ZN_PD|ZN_PDRV0|ZN_PDRV1|ZN_PU|ZN_SL|ZP_CS|ZP_IE|ZP_PD|ZP_PDRV0|ZP_PDRV1|ZP_PU|ZP_SL
+ nfet_06v0 L=1U W=5U AS=1.25P AD=2.2P PS=5.5U PD=10.88U
M$953 \$57 \$119
+ VSS|XN_CS|XN_IE|XN_PD|XN_PDRV0|XN_PDRV1|XN_PU|XN_SL|XP_CS|XP_IE|XP_PD|XP_PDRV0|XP_PDRV1|XP_PU|XP_SL|YN_CS|YN_IE|YN_PD|YN_PDRV0|YN_PDRV1|YN_PU|YN_SL|YP_CS|YP_IE|YP_PD|YP_PDRV0|YP_PDRV1|YP_PU|YP_SL|ZN_CS|ZN_IE|ZN_PD|ZN_PDRV0|ZN_PDRV1|ZN_PU|ZN_SL|ZP_CS|ZP_IE|ZP_PD|ZP_PDRV0|ZP_PDRV1|ZP_PU|ZP_SL
+ VSS|XN_CS|XN_IE|XN_PD|XN_PDRV0|XN_PDRV1|XN_PU|XN_SL|XP_CS|XP_IE|XP_PD|XP_PDRV0|XP_PDRV1|XP_PU|XP_SL|YN_CS|YN_IE|YN_PD|YN_PDRV0|YN_PDRV1|YN_PU|YN_SL|YP_CS|YP_IE|YP_PD|YP_PDRV0|YP_PDRV1|YP_PU|YP_SL|ZN_CS|ZN_IE|ZN_PD|ZN_PDRV0|ZN_PDRV1|ZN_PU|ZN_SL|ZP_CS|ZP_IE|ZP_PD|ZP_PDRV0|ZP_PDRV1|ZP_PU|ZP_SL
+ nfet_06v0 L=1U W=1U AS=0.44P AD=0.25P PS=2.88U PD=1.5U
M$954 \$99 \$119 \$57
+ VSS|XN_CS|XN_IE|XN_PD|XN_PDRV0|XN_PDRV1|XN_PU|XN_SL|XP_CS|XP_IE|XP_PD|XP_PDRV0|XP_PDRV1|XP_PU|XP_SL|YN_CS|YN_IE|YN_PD|YN_PDRV0|YN_PDRV1|YN_PU|YN_SL|YP_CS|YP_IE|YP_PD|YP_PDRV0|YP_PDRV1|YP_PU|YP_SL|ZN_CS|ZN_IE|ZN_PD|ZN_PDRV0|ZN_PDRV1|ZN_PU|ZN_SL|ZP_CS|ZP_IE|ZP_PD|ZP_PDRV0|ZP_PDRV1|ZP_PU|ZP_SL
+ nfet_06v0 L=1U W=1U AS=0.25P AD=0.44P PS=1.5U PD=2.88U
M$955 \$58 \$119
+ VSS|XN_CS|XN_IE|XN_PD|XN_PDRV0|XN_PDRV1|XN_PU|XN_SL|XP_CS|XP_IE|XP_PD|XP_PDRV0|XP_PDRV1|XP_PU|XP_SL|YN_CS|YN_IE|YN_PD|YN_PDRV0|YN_PDRV1|YN_PU|YN_SL|YP_CS|YP_IE|YP_PD|YP_PDRV0|YP_PDRV1|YP_PU|YP_SL|ZN_CS|ZN_IE|ZN_PD|ZN_PDRV0|ZN_PDRV1|ZN_PU|ZN_SL|ZP_CS|ZP_IE|ZP_PD|ZP_PDRV0|ZP_PDRV1|ZP_PU|ZP_SL
+ VSS|XN_CS|XN_IE|XN_PD|XN_PDRV0|XN_PDRV1|XN_PU|XN_SL|XP_CS|XP_IE|XP_PD|XP_PDRV0|XP_PDRV1|XP_PU|XP_SL|YN_CS|YN_IE|YN_PD|YN_PDRV0|YN_PDRV1|YN_PU|YN_SL|YP_CS|YP_IE|YP_PD|YP_PDRV0|YP_PDRV1|YP_PU|YP_SL|ZN_CS|ZN_IE|ZN_PD|ZN_PDRV0|ZN_PDRV1|ZN_PU|ZN_SL|ZP_CS|ZP_IE|ZP_PD|ZP_PDRV0|ZP_PDRV1|ZP_PU|ZP_SL
+ nfet_06v0 L=1U W=1U AS=0.44P AD=0.25P PS=2.88U PD=1.5U
M$956 \$119 \$119 \$58
+ VSS|XN_CS|XN_IE|XN_PD|XN_PDRV0|XN_PDRV1|XN_PU|XN_SL|XP_CS|XP_IE|XP_PD|XP_PDRV0|XP_PDRV1|XP_PU|XP_SL|YN_CS|YN_IE|YN_PD|YN_PDRV0|YN_PDRV1|YN_PU|YN_SL|YP_CS|YP_IE|YP_PD|YP_PDRV0|YP_PDRV1|YP_PU|YP_SL|ZN_CS|ZN_IE|ZN_PD|ZN_PDRV0|ZN_PDRV1|ZN_PU|ZN_SL|ZP_CS|ZP_IE|ZP_PD|ZP_PDRV0|ZP_PDRV1|ZP_PU|ZP_SL
+ nfet_06v0 L=1U W=1U AS=0.25P AD=0.44P PS=1.5U PD=2.88U
M$957 \$79 \$93
+ VSS|XN_CS|XN_IE|XN_PD|XN_PDRV0|XN_PDRV1|XN_PU|XN_SL|XP_CS|XP_IE|XP_PD|XP_PDRV0|XP_PDRV1|XP_PU|XP_SL|YN_CS|YN_IE|YN_PD|YN_PDRV0|YN_PDRV1|YN_PU|YN_SL|YP_CS|YP_IE|YP_PD|YP_PDRV0|YP_PDRV1|YP_PU|YP_SL|ZN_CS|ZN_IE|ZN_PD|ZN_PDRV0|ZN_PDRV1|ZN_PU|ZN_SL|ZP_CS|ZP_IE|ZP_PD|ZP_PDRV0|ZP_PDRV1|ZP_PU|ZP_SL
+ VSS|XN_CS|XN_IE|XN_PD|XN_PDRV0|XN_PDRV1|XN_PU|XN_SL|XP_CS|XP_IE|XP_PD|XP_PDRV0|XP_PDRV1|XP_PU|XP_SL|YN_CS|YN_IE|YN_PD|YN_PDRV0|YN_PDRV1|YN_PU|YN_SL|YP_CS|YP_IE|YP_PD|YP_PDRV0|YP_PDRV1|YP_PU|YP_SL|ZN_CS|ZN_IE|ZN_PD|ZN_PDRV0|ZN_PDRV1|ZN_PU|ZN_SL|ZP_CS|ZP_IE|ZP_PD|ZP_PDRV0|ZP_PDRV1|ZP_PU|ZP_SL
+ nfet_06v0 L=1U W=5U AS=2.2P AD=1.25P PS=10.88U PD=5.5U
M$958 \$31 \$94 \$79
+ VSS|XN_CS|XN_IE|XN_PD|XN_PDRV0|XN_PDRV1|XN_PU|XN_SL|XP_CS|XP_IE|XP_PD|XP_PDRV0|XP_PDRV1|XP_PU|XP_SL|YN_CS|YN_IE|YN_PD|YN_PDRV0|YN_PDRV1|YN_PU|YN_SL|YP_CS|YP_IE|YP_PD|YP_PDRV0|YP_PDRV1|YP_PU|YP_SL|ZN_CS|ZN_IE|ZN_PD|ZN_PDRV0|ZN_PDRV1|ZN_PU|ZN_SL|ZP_CS|ZP_IE|ZP_PD|ZP_PDRV0|ZP_PDRV1|ZP_PU|ZP_SL
+ nfet_06v0 L=1U W=5U AS=1.25P AD=2.2P PS=5.5U PD=10.88U
M$959 \$80 \$93
+ VSS|XN_CS|XN_IE|XN_PD|XN_PDRV0|XN_PDRV1|XN_PU|XN_SL|XP_CS|XP_IE|XP_PD|XP_PDRV0|XP_PDRV1|XP_PU|XP_SL|YN_CS|YN_IE|YN_PD|YN_PDRV0|YN_PDRV1|YN_PU|YN_SL|YP_CS|YP_IE|YP_PD|YP_PDRV0|YP_PDRV1|YP_PU|YP_SL|ZN_CS|ZN_IE|ZN_PD|ZN_PDRV0|ZN_PDRV1|ZN_PU|ZN_SL|ZP_CS|ZP_IE|ZP_PD|ZP_PDRV0|ZP_PDRV1|ZP_PU|ZP_SL
+ VSS|XN_CS|XN_IE|XN_PD|XN_PDRV0|XN_PDRV1|XN_PU|XN_SL|XP_CS|XP_IE|XP_PD|XP_PDRV0|XP_PDRV1|XP_PU|XP_SL|YN_CS|YN_IE|YN_PD|YN_PDRV0|YN_PDRV1|YN_PU|YN_SL|YP_CS|YP_IE|YP_PD|YP_PDRV0|YP_PDRV1|YP_PU|YP_SL|ZN_CS|ZN_IE|ZN_PD|ZN_PDRV0|ZN_PDRV1|ZN_PU|ZN_SL|ZP_CS|ZP_IE|ZP_PD|ZP_PDRV0|ZP_PDRV1|ZP_PU|ZP_SL
+ nfet_06v0 L=1U W=5U AS=2.2P AD=1.25P PS=10.88U PD=5.5U
M$960 \$31 \$94 \$80
+ VSS|XN_CS|XN_IE|XN_PD|XN_PDRV0|XN_PDRV1|XN_PU|XN_SL|XP_CS|XP_IE|XP_PD|XP_PDRV0|XP_PDRV1|XP_PU|XP_SL|YN_CS|YN_IE|YN_PD|YN_PDRV0|YN_PDRV1|YN_PU|YN_SL|YP_CS|YP_IE|YP_PD|YP_PDRV0|YP_PDRV1|YP_PU|YP_SL|ZN_CS|ZN_IE|ZN_PD|ZN_PDRV0|ZN_PDRV1|ZN_PU|ZN_SL|ZP_CS|ZP_IE|ZP_PD|ZP_PDRV0|ZP_PDRV1|ZP_PU|ZP_SL
+ nfet_06v0 L=1U W=5U AS=1.25P AD=2.2P PS=5.5U PD=10.88U
M$961 \$32 \$14437 \$31
+ VSS|XN_CS|XN_IE|XN_PD|XN_PDRV0|XN_PDRV1|XN_PU|XN_SL|XP_CS|XP_IE|XP_PD|XP_PDRV0|XP_PDRV1|XP_PU|XP_SL|YN_CS|YN_IE|YN_PD|YN_PDRV0|YN_PDRV1|YN_PU|YN_SL|YP_CS|YP_IE|YP_PD|YP_PDRV0|YP_PDRV1|YP_PU|YP_SL|ZN_CS|ZN_IE|ZN_PD|ZN_PDRV0|ZN_PDRV1|ZN_PU|ZN_SL|ZP_CS|ZP_IE|ZP_PD|ZP_PDRV0|ZP_PDRV1|ZP_PU|ZP_SL
+ nfet_06v0 L=1U W=7.5U AS=3.3P AD=3.3P PS=15.88U PD=15.88U
M$962 \$33 \$14438 \$31
+ VSS|XN_CS|XN_IE|XN_PD|XN_PDRV0|XN_PDRV1|XN_PU|XN_SL|XP_CS|XP_IE|XP_PD|XP_PDRV0|XP_PDRV1|XP_PU|XP_SL|YN_CS|YN_IE|YN_PD|YN_PDRV0|YN_PDRV1|YN_PU|YN_SL|YP_CS|YP_IE|YP_PD|YP_PDRV0|YP_PDRV1|YP_PU|YP_SL|ZN_CS|ZN_IE|ZN_PD|ZN_PDRV0|ZN_PDRV1|ZN_PU|ZN_SL|ZP_CS|ZP_IE|ZP_PD|ZP_PDRV0|ZP_PDRV1|ZP_PU|ZP_SL
+ nfet_06v0 L=1U W=8.5U AS=3.74P AD=3.74P PS=17.88U PD=17.88U
M$963 \$34 \$65
+ VSS|XN_CS|XN_IE|XN_PD|XN_PDRV0|XN_PDRV1|XN_PU|XN_SL|XP_CS|XP_IE|XP_PD|XP_PDRV0|XP_PDRV1|XP_PU|XP_SL|YN_CS|YN_IE|YN_PD|YN_PDRV0|YN_PDRV1|YN_PU|YN_SL|YP_CS|YP_IE|YP_PD|YP_PDRV0|YP_PDRV1|YP_PU|YP_SL|ZN_CS|ZN_IE|ZN_PD|ZN_PDRV0|ZN_PDRV1|ZN_PU|ZN_SL|ZP_CS|ZP_IE|ZP_PD|ZP_PDRV0|ZP_PDRV1|ZP_PU|ZP_SL
+ VSS|XN_CS|XN_IE|XN_PD|XN_PDRV0|XN_PDRV1|XN_PU|XN_SL|XP_CS|XP_IE|XP_PD|XP_PDRV0|XP_PDRV1|XP_PU|XP_SL|YN_CS|YN_IE|YN_PD|YN_PDRV0|YN_PDRV1|YN_PU|YN_SL|YP_CS|YP_IE|YP_PD|YP_PDRV0|YP_PDRV1|YP_PU|YP_SL|ZN_CS|ZN_IE|ZN_PD|ZN_PDRV0|ZN_PDRV1|ZN_PU|ZN_SL|ZP_CS|ZP_IE|ZP_PD|ZP_PDRV0|ZP_PDRV1|ZP_PU|ZP_SL
+ nfet_06v0 L=1U W=2.5U AS=1.1P AD=0.825P PS=5.88U PD=3.16U
M$964 \$65 \$94 \$34
+ VSS|XN_CS|XN_IE|XN_PD|XN_PDRV0|XN_PDRV1|XN_PU|XN_SL|XP_CS|XP_IE|XP_PD|XP_PDRV0|XP_PDRV1|XP_PU|XP_SL|YN_CS|YN_IE|YN_PD|YN_PDRV0|YN_PDRV1|YN_PU|YN_SL|YP_CS|YP_IE|YP_PD|YP_PDRV0|YP_PDRV1|YP_PU|YP_SL|ZN_CS|ZN_IE|ZN_PD|ZN_PDRV0|ZN_PDRV1|ZN_PU|ZN_SL|ZP_CS|ZP_IE|ZP_PD|ZP_PDRV0|ZP_PDRV1|ZP_PU|ZP_SL
+ nfet_06v0 L=1U W=2.5U AS=0.825P AD=1.1P PS=3.16U PD=5.88U
M$965 \$107 \$65
+ VSS|XN_CS|XN_IE|XN_PD|XN_PDRV0|XN_PDRV1|XN_PU|XN_SL|XP_CS|XP_IE|XP_PD|XP_PDRV0|XP_PDRV1|XP_PU|XP_SL|YN_CS|YN_IE|YN_PD|YN_PDRV0|YN_PDRV1|YN_PU|YN_SL|YP_CS|YP_IE|YP_PD|YP_PDRV0|YP_PDRV1|YP_PU|YP_SL|ZN_CS|ZN_IE|ZN_PD|ZN_PDRV0|ZN_PDRV1|ZN_PU|ZN_SL|ZP_CS|ZP_IE|ZP_PD|ZP_PDRV0|ZP_PDRV1|ZP_PU|ZP_SL
+ VSS|XN_CS|XN_IE|XN_PD|XN_PDRV0|XN_PDRV1|XN_PU|XN_SL|XP_CS|XP_IE|XP_PD|XP_PDRV0|XP_PDRV1|XP_PU|XP_SL|YN_CS|YN_IE|YN_PD|YN_PDRV0|YN_PDRV1|YN_PU|YN_SL|YP_CS|YP_IE|YP_PD|YP_PDRV0|YP_PDRV1|YP_PU|YP_SL|ZN_CS|ZN_IE|ZN_PD|ZN_PDRV0|ZN_PDRV1|ZN_PU|ZN_SL|ZP_CS|ZP_IE|ZP_PD|ZP_PDRV0|ZP_PDRV1|ZP_PU|ZP_SL
+ nfet_06v0 L=1U W=2.5U AS=1.1P AD=0.825P PS=5.88U PD=3.16U
M$966 \$35 \$94 \$107
+ VSS|XN_CS|XN_IE|XN_PD|XN_PDRV0|XN_PDRV1|XN_PU|XN_SL|XP_CS|XP_IE|XP_PD|XP_PDRV0|XP_PDRV1|XP_PU|XP_SL|YN_CS|YN_IE|YN_PD|YN_PDRV0|YN_PDRV1|YN_PU|YN_SL|YP_CS|YP_IE|YP_PD|YP_PDRV0|YP_PDRV1|YP_PU|YP_SL|ZN_CS|ZN_IE|ZN_PD|ZN_PDRV0|ZN_PDRV1|ZN_PU|ZN_SL|ZP_CS|ZP_IE|ZP_PD|ZP_PDRV0|ZP_PDRV1|ZP_PU|ZP_SL
+ nfet_06v0 L=1U W=2.5U AS=0.825P AD=1.1P PS=3.16U PD=5.88U
M$967 \$138 \$66 \$65
+ VSS|XN_CS|XN_IE|XN_PD|XN_PDRV0|XN_PDRV1|XN_PU|XN_SL|XP_CS|XP_IE|XP_PD|XP_PDRV0|XP_PDRV1|XP_PU|XP_SL|YN_CS|YN_IE|YN_PD|YN_PDRV0|YN_PDRV1|YN_PU|YN_SL|YP_CS|YP_IE|YP_PD|YP_PDRV0|YP_PDRV1|YP_PU|YP_SL|ZN_CS|ZN_IE|ZN_PD|ZN_PDRV0|ZN_PDRV1|ZN_PU|ZN_SL|ZP_CS|ZP_IE|ZP_PD|ZP_PDRV0|ZP_PDRV1|ZP_PU|ZP_SL
+ nfet_06v0 L=1U W=2U AS=0.88P AD=0.88P PS=4.88U PD=4.88U
M$968 \$122 \$66 \$35
+ VSS|XN_CS|XN_IE|XN_PD|XN_PDRV0|XN_PDRV1|XN_PU|XN_SL|XP_CS|XP_IE|XP_PD|XP_PDRV0|XP_PDRV1|XP_PU|XP_SL|YN_CS|YN_IE|YN_PD|YN_PDRV0|YN_PDRV1|YN_PU|YN_SL|YP_CS|YP_IE|YP_PD|YP_PDRV0|YP_PDRV1|YP_PU|YP_SL|ZN_CS|ZN_IE|ZN_PD|ZN_PDRV0|ZN_PDRV1|ZN_PU|ZN_SL|ZP_CS|ZP_IE|ZP_PD|ZP_PDRV0|ZP_PDRV1|ZP_PU|ZP_SL
+ nfet_06v0 L=1U W=2U AS=0.88P AD=0.88P PS=4.88U PD=4.88U
M$969 \$81 \$93
+ VSS|XN_CS|XN_IE|XN_PD|XN_PDRV0|XN_PDRV1|XN_PU|XN_SL|XP_CS|XP_IE|XP_PD|XP_PDRV0|XP_PDRV1|XP_PU|XP_SL|YN_CS|YN_IE|YN_PD|YN_PDRV0|YN_PDRV1|YN_PU|YN_SL|YP_CS|YP_IE|YP_PD|YP_PDRV0|YP_PDRV1|YP_PU|YP_SL|ZN_CS|ZN_IE|ZN_PD|ZN_PDRV0|ZN_PDRV1|ZN_PU|ZN_SL|ZP_CS|ZP_IE|ZP_PD|ZP_PDRV0|ZP_PDRV1|ZP_PU|ZP_SL
+ VSS|XN_CS|XN_IE|XN_PD|XN_PDRV0|XN_PDRV1|XN_PU|XN_SL|XP_CS|XP_IE|XP_PD|XP_PDRV0|XP_PDRV1|XP_PU|XP_SL|YN_CS|YN_IE|YN_PD|YN_PDRV0|YN_PDRV1|YN_PU|YN_SL|YP_CS|YP_IE|YP_PD|YP_PDRV0|YP_PDRV1|YP_PU|YP_SL|ZN_CS|ZN_IE|ZN_PD|ZN_PDRV0|ZN_PDRV1|ZN_PU|ZN_SL|ZP_CS|ZP_IE|ZP_PD|ZP_PDRV0|ZP_PDRV1|ZP_PU|ZP_SL
+ nfet_06v0 L=1U W=5U AS=2.2P AD=1.25P PS=10.88U PD=5.5U
M$970 \$36 \$94 \$81
+ VSS|XN_CS|XN_IE|XN_PD|XN_PDRV0|XN_PDRV1|XN_PU|XN_SL|XP_CS|XP_IE|XP_PD|XP_PDRV0|XP_PDRV1|XP_PU|XP_SL|YN_CS|YN_IE|YN_PD|YN_PDRV0|YN_PDRV1|YN_PU|YN_SL|YP_CS|YP_IE|YP_PD|YP_PDRV0|YP_PDRV1|YP_PU|YP_SL|ZN_CS|ZN_IE|ZN_PD|ZN_PDRV0|ZN_PDRV1|ZN_PU|ZN_SL|ZP_CS|ZP_IE|ZP_PD|ZP_PDRV0|ZP_PDRV1|ZP_PU|ZP_SL
+ nfet_06v0 L=1U W=5U AS=1.25P AD=2.2P PS=5.5U PD=10.88U
M$971 \$82 \$37
+ VSS|XN_CS|XN_IE|XN_PD|XN_PDRV0|XN_PDRV1|XN_PU|XN_SL|XP_CS|XP_IE|XP_PD|XP_PDRV0|XP_PDRV1|XP_PU|XP_SL|YN_CS|YN_IE|YN_PD|YN_PDRV0|YN_PDRV1|YN_PU|YN_SL|YP_CS|YP_IE|YP_PD|YP_PDRV0|YP_PDRV1|YP_PU|YP_SL|ZN_CS|ZN_IE|ZN_PD|ZN_PDRV0|ZN_PDRV1|ZN_PU|ZN_SL|ZP_CS|ZP_IE|ZP_PD|ZP_PDRV0|ZP_PDRV1|ZP_PU|ZP_SL
+ VSS|XN_CS|XN_IE|XN_PD|XN_PDRV0|XN_PDRV1|XN_PU|XN_SL|XP_CS|XP_IE|XP_PD|XP_PDRV0|XP_PDRV1|XP_PU|XP_SL|YN_CS|YN_IE|YN_PD|YN_PDRV0|YN_PDRV1|YN_PU|YN_SL|YP_CS|YP_IE|YP_PD|YP_PDRV0|YP_PDRV1|YP_PU|YP_SL|ZN_CS|ZN_IE|ZN_PD|ZN_PDRV0|ZN_PDRV1|ZN_PU|ZN_SL|ZP_CS|ZP_IE|ZP_PD|ZP_PDRV0|ZP_PDRV1|ZP_PU|ZP_SL
+ nfet_06v0 L=1U W=5U AS=2.2P AD=1.25P PS=10.88U PD=5.5U
M$972 \$37 \$94 \$82
+ VSS|XN_CS|XN_IE|XN_PD|XN_PDRV0|XN_PDRV1|XN_PU|XN_SL|XP_CS|XP_IE|XP_PD|XP_PDRV0|XP_PDRV1|XP_PU|XP_SL|YN_CS|YN_IE|YN_PD|YN_PDRV0|YN_PDRV1|YN_PU|YN_SL|YP_CS|YP_IE|YP_PD|YP_PDRV0|YP_PDRV1|YP_PU|YP_SL|ZN_CS|ZN_IE|ZN_PD|ZN_PDRV0|ZN_PDRV1|ZN_PU|ZN_SL|ZP_CS|ZP_IE|ZP_PD|ZP_PDRV0|ZP_PDRV1|ZP_PU|ZP_SL
+ nfet_06v0 L=1U W=5U AS=1.25P AD=1.65P PS=5.5U PD=5.66U
M$973 \$66 \$66 \$37
+ VSS|XN_CS|XN_IE|XN_PD|XN_PDRV0|XN_PDRV1|XN_PU|XN_SL|XP_CS|XP_IE|XP_PD|XP_PDRV0|XP_PDRV1|XP_PU|XP_SL|YN_CS|YN_IE|YN_PD|YN_PDRV0|YN_PDRV1|YN_PU|YN_SL|YP_CS|YP_IE|YP_PD|YP_PDRV0|YP_PDRV1|YP_PU|YP_SL|ZN_CS|ZN_IE|ZN_PD|ZN_PDRV0|ZN_PDRV1|ZN_PU|ZN_SL|ZP_CS|ZP_IE|ZP_PD|ZP_PDRV0|ZP_PDRV1|ZP_PU|ZP_SL
+ nfet_06v0 L=1U W=5U AS=1.65P AD=2.2P PS=5.66U PD=10.88U
M$974 \$38 \$35
+ VSS|XN_CS|XN_IE|XN_PD|XN_PDRV0|XN_PDRV1|XN_PU|XN_SL|XP_CS|XP_IE|XP_PD|XP_PDRV0|XP_PDRV1|XP_PU|XP_SL|YN_CS|YN_IE|YN_PD|YN_PDRV0|YN_PDRV1|YN_PU|YN_SL|YP_CS|YP_IE|YP_PD|YP_PDRV0|YP_PDRV1|YP_PU|YP_SL|ZN_CS|ZN_IE|ZN_PD|ZN_PDRV0|ZN_PDRV1|ZN_PU|ZN_SL|ZP_CS|ZP_IE|ZP_PD|ZP_PDRV0|ZP_PDRV1|ZP_PU|ZP_SL
+ VSS|XN_CS|XN_IE|XN_PD|XN_PDRV0|XN_PDRV1|XN_PU|XN_SL|XP_CS|XP_IE|XP_PD|XP_PDRV0|XP_PDRV1|XP_PU|XP_SL|YN_CS|YN_IE|YN_PD|YN_PDRV0|YN_PDRV1|YN_PU|YN_SL|YP_CS|YP_IE|YP_PD|YP_PDRV0|YP_PDRV1|YP_PU|YP_SL|ZN_CS|ZN_IE|ZN_PD|ZN_PDRV0|ZN_PDRV1|ZN_PU|ZN_SL|ZP_CS|ZP_IE|ZP_PD|ZP_PDRV0|ZP_PDRV1|ZP_PU|ZP_SL
+ nfet_06v0 L=1U W=1U AS=0.44P AD=0.44P PS=2.88U PD=2.88U
M$975 \$94 \$94
+ VSS|XN_CS|XN_IE|XN_PD|XN_PDRV0|XN_PDRV1|XN_PU|XN_SL|XP_CS|XP_IE|XP_PD|XP_PDRV0|XP_PDRV1|XP_PU|XP_SL|YN_CS|YN_IE|YN_PD|YN_PDRV0|YN_PDRV1|YN_PU|YN_SL|YP_CS|YP_IE|YP_PD|YP_PDRV0|YP_PDRV1|YP_PU|YP_SL|ZN_CS|ZN_IE|ZN_PD|ZN_PDRV0|ZN_PDRV1|ZN_PU|ZN_SL|ZP_CS|ZP_IE|ZP_PD|ZP_PDRV0|ZP_PDRV1|ZP_PU|ZP_SL
+ VSS|XN_CS|XN_IE|XN_PD|XN_PDRV0|XN_PDRV1|XN_PU|XN_SL|XP_CS|XP_IE|XP_PD|XP_PDRV0|XP_PDRV1|XP_PU|XP_SL|YN_CS|YN_IE|YN_PD|YN_PDRV0|YN_PDRV1|YN_PU|YN_SL|YP_CS|YP_IE|YP_PD|YP_PDRV0|YP_PDRV1|YP_PU|YP_SL|ZN_CS|ZN_IE|ZN_PD|ZN_PDRV0|ZN_PDRV1|ZN_PU|ZN_SL|ZP_CS|ZP_IE|ZP_PD|ZP_PDRV0|ZP_PDRV1|ZP_PU|ZP_SL
+ nfet_06v0 L=1U W=1U AS=0.44P AD=0.44P PS=2.88U PD=2.88U
M$976 \$83 \$93
+ VSS|XN_CS|XN_IE|XN_PD|XN_PDRV0|XN_PDRV1|XN_PU|XN_SL|XP_CS|XP_IE|XP_PD|XP_PDRV0|XP_PDRV1|XP_PU|XP_SL|YN_CS|YN_IE|YN_PD|YN_PDRV0|YN_PDRV1|YN_PU|YN_SL|YP_CS|YP_IE|YP_PD|YP_PDRV0|YP_PDRV1|YP_PU|YP_SL|ZN_CS|ZN_IE|ZN_PD|ZN_PDRV0|ZN_PDRV1|ZN_PU|ZN_SL|ZP_CS|ZP_IE|ZP_PD|ZP_PDRV0|ZP_PDRV1|ZP_PU|ZP_SL
+ VSS|XN_CS|XN_IE|XN_PD|XN_PDRV0|XN_PDRV1|XN_PU|XN_SL|XP_CS|XP_IE|XP_PD|XP_PDRV0|XP_PDRV1|XP_PU|XP_SL|YN_CS|YN_IE|YN_PD|YN_PDRV0|YN_PDRV1|YN_PU|YN_SL|YP_CS|YP_IE|YP_PD|YP_PDRV0|YP_PDRV1|YP_PU|YP_SL|ZN_CS|ZN_IE|ZN_PD|ZN_PDRV0|ZN_PDRV1|ZN_PU|ZN_SL|ZP_CS|ZP_IE|ZP_PD|ZP_PDRV0|ZP_PDRV1|ZP_PU|ZP_SL
+ nfet_06v0 L=1U W=5U AS=2.2P AD=1.25P PS=10.88U PD=5.5U
M$977 \$93 \$94 \$83
+ VSS|XN_CS|XN_IE|XN_PD|XN_PDRV0|XN_PDRV1|XN_PU|XN_SL|XP_CS|XP_IE|XP_PD|XP_PDRV0|XP_PDRV1|XP_PU|XP_SL|YN_CS|YN_IE|YN_PD|YN_PDRV0|YN_PDRV1|YN_PU|YN_SL|YP_CS|YP_IE|YP_PD|YP_PDRV0|YP_PDRV1|YP_PU|YP_SL|ZN_CS|ZN_IE|ZN_PD|ZN_PDRV0|ZN_PDRV1|ZN_PU|ZN_SL|ZP_CS|ZP_IE|ZP_PD|ZP_PDRV0|ZP_PDRV1|ZP_PU|ZP_SL
+ nfet_06v0 L=1U W=5U AS=1.25P AD=2.2P PS=5.5U PD=10.88U
M$978 \$59 \$121
+ VSS|XN_CS|XN_IE|XN_PD|XN_PDRV0|XN_PDRV1|XN_PU|XN_SL|XP_CS|XP_IE|XP_PD|XP_PDRV0|XP_PDRV1|XP_PU|XP_SL|YN_CS|YN_IE|YN_PD|YN_PDRV0|YN_PDRV1|YN_PU|YN_SL|YP_CS|YP_IE|YP_PD|YP_PDRV0|YP_PDRV1|YP_PU|YP_SL|ZN_CS|ZN_IE|ZN_PD|ZN_PDRV0|ZN_PDRV1|ZN_PU|ZN_SL|ZP_CS|ZP_IE|ZP_PD|ZP_PDRV0|ZP_PDRV1|ZP_PU|ZP_SL
+ VSS|XN_CS|XN_IE|XN_PD|XN_PDRV0|XN_PDRV1|XN_PU|XN_SL|XP_CS|XP_IE|XP_PD|XP_PDRV0|XP_PDRV1|XP_PU|XP_SL|YN_CS|YN_IE|YN_PD|YN_PDRV0|YN_PDRV1|YN_PU|YN_SL|YP_CS|YP_IE|YP_PD|YP_PDRV0|YP_PDRV1|YP_PU|YP_SL|ZN_CS|ZN_IE|ZN_PD|ZN_PDRV0|ZN_PDRV1|ZN_PU|ZN_SL|ZP_CS|ZP_IE|ZP_PD|ZP_PDRV0|ZP_PDRV1|ZP_PU|ZP_SL
+ nfet_06v0 L=1U W=1U AS=0.44P AD=0.25P PS=2.88U PD=1.5U
M$979 \$100 \$121 \$59
+ VSS|XN_CS|XN_IE|XN_PD|XN_PDRV0|XN_PDRV1|XN_PU|XN_SL|XP_CS|XP_IE|XP_PD|XP_PDRV0|XP_PDRV1|XP_PU|XP_SL|YN_CS|YN_IE|YN_PD|YN_PDRV0|YN_PDRV1|YN_PU|YN_SL|YP_CS|YP_IE|YP_PD|YP_PDRV0|YP_PDRV1|YP_PU|YP_SL|ZN_CS|ZN_IE|ZN_PD|ZN_PDRV0|ZN_PDRV1|ZN_PU|ZN_SL|ZP_CS|ZP_IE|ZP_PD|ZP_PDRV0|ZP_PDRV1|ZP_PU|ZP_SL
+ nfet_06v0 L=1U W=1U AS=0.25P AD=0.44P PS=1.5U PD=2.88U
M$980 \$60 \$121
+ VSS|XN_CS|XN_IE|XN_PD|XN_PDRV0|XN_PDRV1|XN_PU|XN_SL|XP_CS|XP_IE|XP_PD|XP_PDRV0|XP_PDRV1|XP_PU|XP_SL|YN_CS|YN_IE|YN_PD|YN_PDRV0|YN_PDRV1|YN_PU|YN_SL|YP_CS|YP_IE|YP_PD|YP_PDRV0|YP_PDRV1|YP_PU|YP_SL|ZN_CS|ZN_IE|ZN_PD|ZN_PDRV0|ZN_PDRV1|ZN_PU|ZN_SL|ZP_CS|ZP_IE|ZP_PD|ZP_PDRV0|ZP_PDRV1|ZP_PU|ZP_SL
+ VSS|XN_CS|XN_IE|XN_PD|XN_PDRV0|XN_PDRV1|XN_PU|XN_SL|XP_CS|XP_IE|XP_PD|XP_PDRV0|XP_PDRV1|XP_PU|XP_SL|YN_CS|YN_IE|YN_PD|YN_PDRV0|YN_PDRV1|YN_PU|YN_SL|YP_CS|YP_IE|YP_PD|YP_PDRV0|YP_PDRV1|YP_PU|YP_SL|ZN_CS|ZN_IE|ZN_PD|ZN_PDRV0|ZN_PDRV1|ZN_PU|ZN_SL|ZP_CS|ZP_IE|ZP_PD|ZP_PDRV0|ZP_PDRV1|ZP_PU|ZP_SL
+ nfet_06v0 L=1U W=1U AS=0.44P AD=0.25P PS=2.88U PD=1.5U
M$981 \$121 \$121 \$60
+ VSS|XN_CS|XN_IE|XN_PD|XN_PDRV0|XN_PDRV1|XN_PU|XN_SL|XP_CS|XP_IE|XP_PD|XP_PDRV0|XP_PDRV1|XP_PU|XP_SL|YN_CS|YN_IE|YN_PD|YN_PDRV0|YN_PDRV1|YN_PU|YN_SL|YP_CS|YP_IE|YP_PD|YP_PDRV0|YP_PDRV1|YP_PU|YP_SL|ZN_CS|ZN_IE|ZN_PD|ZN_PDRV0|ZN_PDRV1|ZN_PU|ZN_SL|ZP_CS|ZP_IE|ZP_PD|ZP_PDRV0|ZP_PDRV1|ZP_PU|ZP_SL
+ nfet_06v0 L=1U W=1U AS=0.25P AD=0.44P PS=1.5U PD=2.88U
M$982 \$86 \$95
+ VSS|XN_CS|XN_IE|XN_PD|XN_PDRV0|XN_PDRV1|XN_PU|XN_SL|XP_CS|XP_IE|XP_PD|XP_PDRV0|XP_PDRV1|XP_PU|XP_SL|YN_CS|YN_IE|YN_PD|YN_PDRV0|YN_PDRV1|YN_PU|YN_SL|YP_CS|YP_IE|YP_PD|YP_PDRV0|YP_PDRV1|YP_PU|YP_SL|ZN_CS|ZN_IE|ZN_PD|ZN_PDRV0|ZN_PDRV1|ZN_PU|ZN_SL|ZP_CS|ZP_IE|ZP_PD|ZP_PDRV0|ZP_PDRV1|ZP_PU|ZP_SL
+ VSS|XN_CS|XN_IE|XN_PD|XN_PDRV0|XN_PDRV1|XN_PU|XN_SL|XP_CS|XP_IE|XP_PD|XP_PDRV0|XP_PDRV1|XP_PU|XP_SL|YN_CS|YN_IE|YN_PD|YN_PDRV0|YN_PDRV1|YN_PU|YN_SL|YP_CS|YP_IE|YP_PD|YP_PDRV0|YP_PDRV1|YP_PU|YP_SL|ZN_CS|ZN_IE|ZN_PD|ZN_PDRV0|ZN_PDRV1|ZN_PU|ZN_SL|ZP_CS|ZP_IE|ZP_PD|ZP_PDRV0|ZP_PDRV1|ZP_PU|ZP_SL
+ nfet_06v0 L=1U W=5U AS=2.2P AD=1.25P PS=10.88U PD=5.5U
M$983 \$39 \$96 \$86
+ VSS|XN_CS|XN_IE|XN_PD|XN_PDRV0|XN_PDRV1|XN_PU|XN_SL|XP_CS|XP_IE|XP_PD|XP_PDRV0|XP_PDRV1|XP_PU|XP_SL|YN_CS|YN_IE|YN_PD|YN_PDRV0|YN_PDRV1|YN_PU|YN_SL|YP_CS|YP_IE|YP_PD|YP_PDRV0|YP_PDRV1|YP_PU|YP_SL|ZN_CS|ZN_IE|ZN_PD|ZN_PDRV0|ZN_PDRV1|ZN_PU|ZN_SL|ZP_CS|ZP_IE|ZP_PD|ZP_PDRV0|ZP_PDRV1|ZP_PU|ZP_SL
+ nfet_06v0 L=1U W=5U AS=1.25P AD=2.2P PS=5.5U PD=10.88U
M$984 \$87 \$95
+ VSS|XN_CS|XN_IE|XN_PD|XN_PDRV0|XN_PDRV1|XN_PU|XN_SL|XP_CS|XP_IE|XP_PD|XP_PDRV0|XP_PDRV1|XP_PU|XP_SL|YN_CS|YN_IE|YN_PD|YN_PDRV0|YN_PDRV1|YN_PU|YN_SL|YP_CS|YP_IE|YP_PD|YP_PDRV0|YP_PDRV1|YP_PU|YP_SL|ZN_CS|ZN_IE|ZN_PD|ZN_PDRV0|ZN_PDRV1|ZN_PU|ZN_SL|ZP_CS|ZP_IE|ZP_PD|ZP_PDRV0|ZP_PDRV1|ZP_PU|ZP_SL
+ VSS|XN_CS|XN_IE|XN_PD|XN_PDRV0|XN_PDRV1|XN_PU|XN_SL|XP_CS|XP_IE|XP_PD|XP_PDRV0|XP_PDRV1|XP_PU|XP_SL|YN_CS|YN_IE|YN_PD|YN_PDRV0|YN_PDRV1|YN_PU|YN_SL|YP_CS|YP_IE|YP_PD|YP_PDRV0|YP_PDRV1|YP_PU|YP_SL|ZN_CS|ZN_IE|ZN_PD|ZN_PDRV0|ZN_PDRV1|ZN_PU|ZN_SL|ZP_CS|ZP_IE|ZP_PD|ZP_PDRV0|ZP_PDRV1|ZP_PU|ZP_SL
+ nfet_06v0 L=1U W=5U AS=2.2P AD=1.25P PS=10.88U PD=5.5U
M$985 \$39 \$96 \$87
+ VSS|XN_CS|XN_IE|XN_PD|XN_PDRV0|XN_PDRV1|XN_PU|XN_SL|XP_CS|XP_IE|XP_PD|XP_PDRV0|XP_PDRV1|XP_PU|XP_SL|YN_CS|YN_IE|YN_PD|YN_PDRV0|YN_PDRV1|YN_PU|YN_SL|YP_CS|YP_IE|YP_PD|YP_PDRV0|YP_PDRV1|YP_PU|YP_SL|ZN_CS|ZN_IE|ZN_PD|ZN_PDRV0|ZN_PDRV1|ZN_PU|ZN_SL|ZP_CS|ZP_IE|ZP_PD|ZP_PDRV0|ZP_PDRV1|ZP_PU|ZP_SL
+ nfet_06v0 L=1U W=5U AS=1.25P AD=2.2P PS=5.5U PD=10.88U
M$986 \$40 \$14436 \$39
+ VSS|XN_CS|XN_IE|XN_PD|XN_PDRV0|XN_PDRV1|XN_PU|XN_SL|XP_CS|XP_IE|XP_PD|XP_PDRV0|XP_PDRV1|XP_PU|XP_SL|YN_CS|YN_IE|YN_PD|YN_PDRV0|YN_PDRV1|YN_PU|YN_SL|YP_CS|YP_IE|YP_PD|YP_PDRV0|YP_PDRV1|YP_PU|YP_SL|ZN_CS|ZN_IE|ZN_PD|ZN_PDRV0|ZN_PDRV1|ZN_PU|ZN_SL|ZP_CS|ZP_IE|ZP_PD|ZP_PDRV0|ZP_PDRV1|ZP_PU|ZP_SL
+ nfet_06v0 L=1U W=7.5U AS=3.3P AD=3.3P PS=15.88U PD=15.88U
M$987 \$41 \$14435 \$39
+ VSS|XN_CS|XN_IE|XN_PD|XN_PDRV0|XN_PDRV1|XN_PU|XN_SL|XP_CS|XP_IE|XP_PD|XP_PDRV0|XP_PDRV1|XP_PU|XP_SL|YN_CS|YN_IE|YN_PD|YN_PDRV0|YN_PDRV1|YN_PU|YN_SL|YP_CS|YP_IE|YP_PD|YP_PDRV0|YP_PDRV1|YP_PU|YP_SL|ZN_CS|ZN_IE|ZN_PD|ZN_PDRV0|ZN_PDRV1|ZN_PU|ZN_SL|ZP_CS|ZP_IE|ZP_PD|ZP_PDRV0|ZP_PDRV1|ZP_PU|ZP_SL
+ nfet_06v0 L=1U W=8.5U AS=3.74P AD=3.74P PS=17.88U PD=17.88U
M$988 \$42 \$67
+ VSS|XN_CS|XN_IE|XN_PD|XN_PDRV0|XN_PDRV1|XN_PU|XN_SL|XP_CS|XP_IE|XP_PD|XP_PDRV0|XP_PDRV1|XP_PU|XP_SL|YN_CS|YN_IE|YN_PD|YN_PDRV0|YN_PDRV1|YN_PU|YN_SL|YP_CS|YP_IE|YP_PD|YP_PDRV0|YP_PDRV1|YP_PU|YP_SL|ZN_CS|ZN_IE|ZN_PD|ZN_PDRV0|ZN_PDRV1|ZN_PU|ZN_SL|ZP_CS|ZP_IE|ZP_PD|ZP_PDRV0|ZP_PDRV1|ZP_PU|ZP_SL
+ VSS|XN_CS|XN_IE|XN_PD|XN_PDRV0|XN_PDRV1|XN_PU|XN_SL|XP_CS|XP_IE|XP_PD|XP_PDRV0|XP_PDRV1|XP_PU|XP_SL|YN_CS|YN_IE|YN_PD|YN_PDRV0|YN_PDRV1|YN_PU|YN_SL|YP_CS|YP_IE|YP_PD|YP_PDRV0|YP_PDRV1|YP_PU|YP_SL|ZN_CS|ZN_IE|ZN_PD|ZN_PDRV0|ZN_PDRV1|ZN_PU|ZN_SL|ZP_CS|ZP_IE|ZP_PD|ZP_PDRV0|ZP_PDRV1|ZP_PU|ZP_SL
+ nfet_06v0 L=1U W=2.5U AS=1.1P AD=0.825P PS=5.88U PD=3.16U
M$989 \$67 \$96 \$42
+ VSS|XN_CS|XN_IE|XN_PD|XN_PDRV0|XN_PDRV1|XN_PU|XN_SL|XP_CS|XP_IE|XP_PD|XP_PDRV0|XP_PDRV1|XP_PU|XP_SL|YN_CS|YN_IE|YN_PD|YN_PDRV0|YN_PDRV1|YN_PU|YN_SL|YP_CS|YP_IE|YP_PD|YP_PDRV0|YP_PDRV1|YP_PU|YP_SL|ZN_CS|ZN_IE|ZN_PD|ZN_PDRV0|ZN_PDRV1|ZN_PU|ZN_SL|ZP_CS|ZP_IE|ZP_PD|ZP_PDRV0|ZP_PDRV1|ZP_PU|ZP_SL
+ nfet_06v0 L=1U W=2.5U AS=0.825P AD=1.1P PS=3.16U PD=5.88U
M$990 \$111 \$67
+ VSS|XN_CS|XN_IE|XN_PD|XN_PDRV0|XN_PDRV1|XN_PU|XN_SL|XP_CS|XP_IE|XP_PD|XP_PDRV0|XP_PDRV1|XP_PU|XP_SL|YN_CS|YN_IE|YN_PD|YN_PDRV0|YN_PDRV1|YN_PU|YN_SL|YP_CS|YP_IE|YP_PD|YP_PDRV0|YP_PDRV1|YP_PU|YP_SL|ZN_CS|ZN_IE|ZN_PD|ZN_PDRV0|ZN_PDRV1|ZN_PU|ZN_SL|ZP_CS|ZP_IE|ZP_PD|ZP_PDRV0|ZP_PDRV1|ZP_PU|ZP_SL
+ VSS|XN_CS|XN_IE|XN_PD|XN_PDRV0|XN_PDRV1|XN_PU|XN_SL|XP_CS|XP_IE|XP_PD|XP_PDRV0|XP_PDRV1|XP_PU|XP_SL|YN_CS|YN_IE|YN_PD|YN_PDRV0|YN_PDRV1|YN_PU|YN_SL|YP_CS|YP_IE|YP_PD|YP_PDRV0|YP_PDRV1|YP_PU|YP_SL|ZN_CS|ZN_IE|ZN_PD|ZN_PDRV0|ZN_PDRV1|ZN_PU|ZN_SL|ZP_CS|ZP_IE|ZP_PD|ZP_PDRV0|ZP_PDRV1|ZP_PU|ZP_SL
+ nfet_06v0 L=1U W=2.5U AS=1.1P AD=0.825P PS=5.88U PD=3.16U
M$991 \$43 \$96 \$111
+ VSS|XN_CS|XN_IE|XN_PD|XN_PDRV0|XN_PDRV1|XN_PU|XN_SL|XP_CS|XP_IE|XP_PD|XP_PDRV0|XP_PDRV1|XP_PU|XP_SL|YN_CS|YN_IE|YN_PD|YN_PDRV0|YN_PDRV1|YN_PU|YN_SL|YP_CS|YP_IE|YP_PD|YP_PDRV0|YP_PDRV1|YP_PU|YP_SL|ZN_CS|ZN_IE|ZN_PD|ZN_PDRV0|ZN_PDRV1|ZN_PU|ZN_SL|ZP_CS|ZP_IE|ZP_PD|ZP_PDRV0|ZP_PDRV1|ZP_PU|ZP_SL
+ nfet_06v0 L=1U W=2.5U AS=0.825P AD=1.1P PS=3.16U PD=5.88U
M$992 \$140 \$68 \$67
+ VSS|XN_CS|XN_IE|XN_PD|XN_PDRV0|XN_PDRV1|XN_PU|XN_SL|XP_CS|XP_IE|XP_PD|XP_PDRV0|XP_PDRV1|XP_PU|XP_SL|YN_CS|YN_IE|YN_PD|YN_PDRV0|YN_PDRV1|YN_PU|YN_SL|YP_CS|YP_IE|YP_PD|YP_PDRV0|YP_PDRV1|YP_PU|YP_SL|ZN_CS|ZN_IE|ZN_PD|ZN_PDRV0|ZN_PDRV1|ZN_PU|ZN_SL|ZP_CS|ZP_IE|ZP_PD|ZP_PDRV0|ZP_PDRV1|ZP_PU|ZP_SL
+ nfet_06v0 L=1U W=2U AS=0.88P AD=0.88P PS=4.88U PD=4.88U
M$993 \$124 \$68 \$43
+ VSS|XN_CS|XN_IE|XN_PD|XN_PDRV0|XN_PDRV1|XN_PU|XN_SL|XP_CS|XP_IE|XP_PD|XP_PDRV0|XP_PDRV1|XP_PU|XP_SL|YN_CS|YN_IE|YN_PD|YN_PDRV0|YN_PDRV1|YN_PU|YN_SL|YP_CS|YP_IE|YP_PD|YP_PDRV0|YP_PDRV1|YP_PU|YP_SL|ZN_CS|ZN_IE|ZN_PD|ZN_PDRV0|ZN_PDRV1|ZN_PU|ZN_SL|ZP_CS|ZP_IE|ZP_PD|ZP_PDRV0|ZP_PDRV1|ZP_PU|ZP_SL
+ nfet_06v0 L=1U W=2U AS=0.88P AD=0.88P PS=4.88U PD=4.88U
M$994 \$89 \$95
+ VSS|XN_CS|XN_IE|XN_PD|XN_PDRV0|XN_PDRV1|XN_PU|XN_SL|XP_CS|XP_IE|XP_PD|XP_PDRV0|XP_PDRV1|XP_PU|XP_SL|YN_CS|YN_IE|YN_PD|YN_PDRV0|YN_PDRV1|YN_PU|YN_SL|YP_CS|YP_IE|YP_PD|YP_PDRV0|YP_PDRV1|YP_PU|YP_SL|ZN_CS|ZN_IE|ZN_PD|ZN_PDRV0|ZN_PDRV1|ZN_PU|ZN_SL|ZP_CS|ZP_IE|ZP_PD|ZP_PDRV0|ZP_PDRV1|ZP_PU|ZP_SL
+ VSS|XN_CS|XN_IE|XN_PD|XN_PDRV0|XN_PDRV1|XN_PU|XN_SL|XP_CS|XP_IE|XP_PD|XP_PDRV0|XP_PDRV1|XP_PU|XP_SL|YN_CS|YN_IE|YN_PD|YN_PDRV0|YN_PDRV1|YN_PU|YN_SL|YP_CS|YP_IE|YP_PD|YP_PDRV0|YP_PDRV1|YP_PU|YP_SL|ZN_CS|ZN_IE|ZN_PD|ZN_PDRV0|ZN_PDRV1|ZN_PU|ZN_SL|ZP_CS|ZP_IE|ZP_PD|ZP_PDRV0|ZP_PDRV1|ZP_PU|ZP_SL
+ nfet_06v0 L=1U W=5U AS=2.2P AD=1.25P PS=10.88U PD=5.5U
M$995 \$44 \$96 \$89
+ VSS|XN_CS|XN_IE|XN_PD|XN_PDRV0|XN_PDRV1|XN_PU|XN_SL|XP_CS|XP_IE|XP_PD|XP_PDRV0|XP_PDRV1|XP_PU|XP_SL|YN_CS|YN_IE|YN_PD|YN_PDRV0|YN_PDRV1|YN_PU|YN_SL|YP_CS|YP_IE|YP_PD|YP_PDRV0|YP_PDRV1|YP_PU|YP_SL|ZN_CS|ZN_IE|ZN_PD|ZN_PDRV0|ZN_PDRV1|ZN_PU|ZN_SL|ZP_CS|ZP_IE|ZP_PD|ZP_PDRV0|ZP_PDRV1|ZP_PU|ZP_SL
+ nfet_06v0 L=1U W=5U AS=1.25P AD=2.2P PS=5.5U PD=10.88U
M$996 \$90 \$45
+ VSS|XN_CS|XN_IE|XN_PD|XN_PDRV0|XN_PDRV1|XN_PU|XN_SL|XP_CS|XP_IE|XP_PD|XP_PDRV0|XP_PDRV1|XP_PU|XP_SL|YN_CS|YN_IE|YN_PD|YN_PDRV0|YN_PDRV1|YN_PU|YN_SL|YP_CS|YP_IE|YP_PD|YP_PDRV0|YP_PDRV1|YP_PU|YP_SL|ZN_CS|ZN_IE|ZN_PD|ZN_PDRV0|ZN_PDRV1|ZN_PU|ZN_SL|ZP_CS|ZP_IE|ZP_PD|ZP_PDRV0|ZP_PDRV1|ZP_PU|ZP_SL
+ VSS|XN_CS|XN_IE|XN_PD|XN_PDRV0|XN_PDRV1|XN_PU|XN_SL|XP_CS|XP_IE|XP_PD|XP_PDRV0|XP_PDRV1|XP_PU|XP_SL|YN_CS|YN_IE|YN_PD|YN_PDRV0|YN_PDRV1|YN_PU|YN_SL|YP_CS|YP_IE|YP_PD|YP_PDRV0|YP_PDRV1|YP_PU|YP_SL|ZN_CS|ZN_IE|ZN_PD|ZN_PDRV0|ZN_PDRV1|ZN_PU|ZN_SL|ZP_CS|ZP_IE|ZP_PD|ZP_PDRV0|ZP_PDRV1|ZP_PU|ZP_SL
+ nfet_06v0 L=1U W=5U AS=2.2P AD=1.25P PS=10.88U PD=5.5U
M$997 \$45 \$96 \$90
+ VSS|XN_CS|XN_IE|XN_PD|XN_PDRV0|XN_PDRV1|XN_PU|XN_SL|XP_CS|XP_IE|XP_PD|XP_PDRV0|XP_PDRV1|XP_PU|XP_SL|YN_CS|YN_IE|YN_PD|YN_PDRV0|YN_PDRV1|YN_PU|YN_SL|YP_CS|YP_IE|YP_PD|YP_PDRV0|YP_PDRV1|YP_PU|YP_SL|ZN_CS|ZN_IE|ZN_PD|ZN_PDRV0|ZN_PDRV1|ZN_PU|ZN_SL|ZP_CS|ZP_IE|ZP_PD|ZP_PDRV0|ZP_PDRV1|ZP_PU|ZP_SL
+ nfet_06v0 L=1U W=5U AS=1.25P AD=1.65P PS=5.5U PD=5.66U
M$998 \$68 \$68 \$45
+ VSS|XN_CS|XN_IE|XN_PD|XN_PDRV0|XN_PDRV1|XN_PU|XN_SL|XP_CS|XP_IE|XP_PD|XP_PDRV0|XP_PDRV1|XP_PU|XP_SL|YN_CS|YN_IE|YN_PD|YN_PDRV0|YN_PDRV1|YN_PU|YN_SL|YP_CS|YP_IE|YP_PD|YP_PDRV0|YP_PDRV1|YP_PU|YP_SL|ZN_CS|ZN_IE|ZN_PD|ZN_PDRV0|ZN_PDRV1|ZN_PU|ZN_SL|ZP_CS|ZP_IE|ZP_PD|ZP_PDRV0|ZP_PDRV1|ZP_PU|ZP_SL
+ nfet_06v0 L=1U W=5U AS=1.65P AD=2.2P PS=5.66U PD=10.88U
M$999 \$46 \$43
+ VSS|XN_CS|XN_IE|XN_PD|XN_PDRV0|XN_PDRV1|XN_PU|XN_SL|XP_CS|XP_IE|XP_PD|XP_PDRV0|XP_PDRV1|XP_PU|XP_SL|YN_CS|YN_IE|YN_PD|YN_PDRV0|YN_PDRV1|YN_PU|YN_SL|YP_CS|YP_IE|YP_PD|YP_PDRV0|YP_PDRV1|YP_PU|YP_SL|ZN_CS|ZN_IE|ZN_PD|ZN_PDRV0|ZN_PDRV1|ZN_PU|ZN_SL|ZP_CS|ZP_IE|ZP_PD|ZP_PDRV0|ZP_PDRV1|ZP_PU|ZP_SL
+ VSS|XN_CS|XN_IE|XN_PD|XN_PDRV0|XN_PDRV1|XN_PU|XN_SL|XP_CS|XP_IE|XP_PD|XP_PDRV0|XP_PDRV1|XP_PU|XP_SL|YN_CS|YN_IE|YN_PD|YN_PDRV0|YN_PDRV1|YN_PU|YN_SL|YP_CS|YP_IE|YP_PD|YP_PDRV0|YP_PDRV1|YP_PU|YP_SL|ZN_CS|ZN_IE|ZN_PD|ZN_PDRV0|ZN_PDRV1|ZN_PU|ZN_SL|ZP_CS|ZP_IE|ZP_PD|ZP_PDRV0|ZP_PDRV1|ZP_PU|ZP_SL
+ nfet_06v0 L=1U W=1U AS=0.44P AD=0.44P PS=2.88U PD=2.88U
M$1000 \$96 \$96
+ VSS|XN_CS|XN_IE|XN_PD|XN_PDRV0|XN_PDRV1|XN_PU|XN_SL|XP_CS|XP_IE|XP_PD|XP_PDRV0|XP_PDRV1|XP_PU|XP_SL|YN_CS|YN_IE|YN_PD|YN_PDRV0|YN_PDRV1|YN_PU|YN_SL|YP_CS|YP_IE|YP_PD|YP_PDRV0|YP_PDRV1|YP_PU|YP_SL|ZN_CS|ZN_IE|ZN_PD|ZN_PDRV0|ZN_PDRV1|ZN_PU|ZN_SL|ZP_CS|ZP_IE|ZP_PD|ZP_PDRV0|ZP_PDRV1|ZP_PU|ZP_SL
+ VSS|XN_CS|XN_IE|XN_PD|XN_PDRV0|XN_PDRV1|XN_PU|XN_SL|XP_CS|XP_IE|XP_PD|XP_PDRV0|XP_PDRV1|XP_PU|XP_SL|YN_CS|YN_IE|YN_PD|YN_PDRV0|YN_PDRV1|YN_PU|YN_SL|YP_CS|YP_IE|YP_PD|YP_PDRV0|YP_PDRV1|YP_PU|YP_SL|ZN_CS|ZN_IE|ZN_PD|ZN_PDRV0|ZN_PDRV1|ZN_PU|ZN_SL|ZP_CS|ZP_IE|ZP_PD|ZP_PDRV0|ZP_PDRV1|ZP_PU|ZP_SL
+ nfet_06v0 L=1U W=1U AS=0.44P AD=0.44P PS=2.88U PD=2.88U
M$1001 \$88 \$95
+ VSS|XN_CS|XN_IE|XN_PD|XN_PDRV0|XN_PDRV1|XN_PU|XN_SL|XP_CS|XP_IE|XP_PD|XP_PDRV0|XP_PDRV1|XP_PU|XP_SL|YN_CS|YN_IE|YN_PD|YN_PDRV0|YN_PDRV1|YN_PU|YN_SL|YP_CS|YP_IE|YP_PD|YP_PDRV0|YP_PDRV1|YP_PU|YP_SL|ZN_CS|ZN_IE|ZN_PD|ZN_PDRV0|ZN_PDRV1|ZN_PU|ZN_SL|ZP_CS|ZP_IE|ZP_PD|ZP_PDRV0|ZP_PDRV1|ZP_PU|ZP_SL
+ VSS|XN_CS|XN_IE|XN_PD|XN_PDRV0|XN_PDRV1|XN_PU|XN_SL|XP_CS|XP_IE|XP_PD|XP_PDRV0|XP_PDRV1|XP_PU|XP_SL|YN_CS|YN_IE|YN_PD|YN_PDRV0|YN_PDRV1|YN_PU|YN_SL|YP_CS|YP_IE|YP_PD|YP_PDRV0|YP_PDRV1|YP_PU|YP_SL|ZN_CS|ZN_IE|ZN_PD|ZN_PDRV0|ZN_PDRV1|ZN_PU|ZN_SL|ZP_CS|ZP_IE|ZP_PD|ZP_PDRV0|ZP_PDRV1|ZP_PU|ZP_SL
+ nfet_06v0 L=1U W=5U AS=2.2P AD=1.25P PS=10.88U PD=5.5U
M$1002 \$95 \$96 \$88
+ VSS|XN_CS|XN_IE|XN_PD|XN_PDRV0|XN_PDRV1|XN_PU|XN_SL|XP_CS|XP_IE|XP_PD|XP_PDRV0|XP_PDRV1|XP_PU|XP_SL|YN_CS|YN_IE|YN_PD|YN_PDRV0|YN_PDRV1|YN_PU|YN_SL|YP_CS|YP_IE|YP_PD|YP_PDRV0|YP_PDRV1|YP_PU|YP_SL|ZN_CS|ZN_IE|ZN_PD|ZN_PDRV0|ZN_PDRV1|ZN_PU|ZN_SL|ZP_CS|ZP_IE|ZP_PD|ZP_PDRV0|ZP_PDRV1|ZP_PU|ZP_SL
+ nfet_06v0 L=1U W=5U AS=1.25P AD=2.2P PS=5.5U PD=10.88U
M$1003 \$61 \$123
+ VSS|XN_CS|XN_IE|XN_PD|XN_PDRV0|XN_PDRV1|XN_PU|XN_SL|XP_CS|XP_IE|XP_PD|XP_PDRV0|XP_PDRV1|XP_PU|XP_SL|YN_CS|YN_IE|YN_PD|YN_PDRV0|YN_PDRV1|YN_PU|YN_SL|YP_CS|YP_IE|YP_PD|YP_PDRV0|YP_PDRV1|YP_PU|YP_SL|ZN_CS|ZN_IE|ZN_PD|ZN_PDRV0|ZN_PDRV1|ZN_PU|ZN_SL|ZP_CS|ZP_IE|ZP_PD|ZP_PDRV0|ZP_PDRV1|ZP_PU|ZP_SL
+ VSS|XN_CS|XN_IE|XN_PD|XN_PDRV0|XN_PDRV1|XN_PU|XN_SL|XP_CS|XP_IE|XP_PD|XP_PDRV0|XP_PDRV1|XP_PU|XP_SL|YN_CS|YN_IE|YN_PD|YN_PDRV0|YN_PDRV1|YN_PU|YN_SL|YP_CS|YP_IE|YP_PD|YP_PDRV0|YP_PDRV1|YP_PU|YP_SL|ZN_CS|ZN_IE|ZN_PD|ZN_PDRV0|ZN_PDRV1|ZN_PU|ZN_SL|ZP_CS|ZP_IE|ZP_PD|ZP_PDRV0|ZP_PDRV1|ZP_PU|ZP_SL
+ nfet_06v0 L=1U W=1U AS=0.44P AD=0.25P PS=2.88U PD=1.5U
M$1004 \$101 \$123 \$61
+ VSS|XN_CS|XN_IE|XN_PD|XN_PDRV0|XN_PDRV1|XN_PU|XN_SL|XP_CS|XP_IE|XP_PD|XP_PDRV0|XP_PDRV1|XP_PU|XP_SL|YN_CS|YN_IE|YN_PD|YN_PDRV0|YN_PDRV1|YN_PU|YN_SL|YP_CS|YP_IE|YP_PD|YP_PDRV0|YP_PDRV1|YP_PU|YP_SL|ZN_CS|ZN_IE|ZN_PD|ZN_PDRV0|ZN_PDRV1|ZN_PU|ZN_SL|ZP_CS|ZP_IE|ZP_PD|ZP_PDRV0|ZP_PDRV1|ZP_PU|ZP_SL
+ nfet_06v0 L=1U W=1U AS=0.25P AD=0.44P PS=1.5U PD=2.88U
M$1005 \$62 \$123
+ VSS|XN_CS|XN_IE|XN_PD|XN_PDRV0|XN_PDRV1|XN_PU|XN_SL|XP_CS|XP_IE|XP_PD|XP_PDRV0|XP_PDRV1|XP_PU|XP_SL|YN_CS|YN_IE|YN_PD|YN_PDRV0|YN_PDRV1|YN_PU|YN_SL|YP_CS|YP_IE|YP_PD|YP_PDRV0|YP_PDRV1|YP_PU|YP_SL|ZN_CS|ZN_IE|ZN_PD|ZN_PDRV0|ZN_PDRV1|ZN_PU|ZN_SL|ZP_CS|ZP_IE|ZP_PD|ZP_PDRV0|ZP_PDRV1|ZP_PU|ZP_SL
+ VSS|XN_CS|XN_IE|XN_PD|XN_PDRV0|XN_PDRV1|XN_PU|XN_SL|XP_CS|XP_IE|XP_PD|XP_PDRV0|XP_PDRV1|XP_PU|XP_SL|YN_CS|YN_IE|YN_PD|YN_PDRV0|YN_PDRV1|YN_PU|YN_SL|YP_CS|YP_IE|YP_PD|YP_PDRV0|YP_PDRV1|YP_PU|YP_SL|ZN_CS|ZN_IE|ZN_PD|ZN_PDRV0|ZN_PDRV1|ZN_PU|ZN_SL|ZP_CS|ZP_IE|ZP_PD|ZP_PDRV0|ZP_PDRV1|ZP_PU|ZP_SL
+ nfet_06v0 L=1U W=1U AS=0.44P AD=0.25P PS=2.88U PD=1.5U
M$1006 \$123 \$123 \$62
+ VSS|XN_CS|XN_IE|XN_PD|XN_PDRV0|XN_PDRV1|XN_PU|XN_SL|XP_CS|XP_IE|XP_PD|XP_PDRV0|XP_PDRV1|XP_PU|XP_SL|YN_CS|YN_IE|YN_PD|YN_PDRV0|YN_PDRV1|YN_PU|YN_SL|YP_CS|YP_IE|YP_PD|YP_PDRV0|YP_PDRV1|YP_PU|YP_SL|ZN_CS|ZN_IE|ZN_PD|ZN_PDRV0|ZN_PDRV1|ZN_PU|ZN_SL|ZP_CS|ZP_IE|ZP_PD|ZP_PDRV0|ZP_PDRV1|ZP_PU|ZP_SL
+ nfet_06v0 L=1U W=1U AS=0.25P AD=0.44P PS=1.5U PD=2.88U
M$1007 \$85 \$97
+ VSS|XN_CS|XN_IE|XN_PD|XN_PDRV0|XN_PDRV1|XN_PU|XN_SL|XP_CS|XP_IE|XP_PD|XP_PDRV0|XP_PDRV1|XP_PU|XP_SL|YN_CS|YN_IE|YN_PD|YN_PDRV0|YN_PDRV1|YN_PU|YN_SL|YP_CS|YP_IE|YP_PD|YP_PDRV0|YP_PDRV1|YP_PU|YP_SL|ZN_CS|ZN_IE|ZN_PD|ZN_PDRV0|ZN_PDRV1|ZN_PU|ZN_SL|ZP_CS|ZP_IE|ZP_PD|ZP_PDRV0|ZP_PDRV1|ZP_PU|ZP_SL
+ VSS|XN_CS|XN_IE|XN_PD|XN_PDRV0|XN_PDRV1|XN_PU|XN_SL|XP_CS|XP_IE|XP_PD|XP_PDRV0|XP_PDRV1|XP_PU|XP_SL|YN_CS|YN_IE|YN_PD|YN_PDRV0|YN_PDRV1|YN_PU|YN_SL|YP_CS|YP_IE|YP_PD|YP_PDRV0|YP_PDRV1|YP_PU|YP_SL|ZN_CS|ZN_IE|ZN_PD|ZN_PDRV0|ZN_PDRV1|ZN_PU|ZN_SL|ZP_CS|ZP_IE|ZP_PD|ZP_PDRV0|ZP_PDRV1|ZP_PU|ZP_SL
+ nfet_06v0 L=1U W=5U AS=2.2P AD=1.25P PS=10.88U PD=5.5U
M$1008 \$47 \$98 \$85
+ VSS|XN_CS|XN_IE|XN_PD|XN_PDRV0|XN_PDRV1|XN_PU|XN_SL|XP_CS|XP_IE|XP_PD|XP_PDRV0|XP_PDRV1|XP_PU|XP_SL|YN_CS|YN_IE|YN_PD|YN_PDRV0|YN_PDRV1|YN_PU|YN_SL|YP_CS|YP_IE|YP_PD|YP_PDRV0|YP_PDRV1|YP_PU|YP_SL|ZN_CS|ZN_IE|ZN_PD|ZN_PDRV0|ZN_PDRV1|ZN_PU|ZN_SL|ZP_CS|ZP_IE|ZP_PD|ZP_PDRV0|ZP_PDRV1|ZP_PU|ZP_SL
+ nfet_06v0 L=1U W=5U AS=1.25P AD=2.2P PS=5.5U PD=10.88U
M$1009 \$84 \$97
+ VSS|XN_CS|XN_IE|XN_PD|XN_PDRV0|XN_PDRV1|XN_PU|XN_SL|XP_CS|XP_IE|XP_PD|XP_PDRV0|XP_PDRV1|XP_PU|XP_SL|YN_CS|YN_IE|YN_PD|YN_PDRV0|YN_PDRV1|YN_PU|YN_SL|YP_CS|YP_IE|YP_PD|YP_PDRV0|YP_PDRV1|YP_PU|YP_SL|ZN_CS|ZN_IE|ZN_PD|ZN_PDRV0|ZN_PDRV1|ZN_PU|ZN_SL|ZP_CS|ZP_IE|ZP_PD|ZP_PDRV0|ZP_PDRV1|ZP_PU|ZP_SL
+ VSS|XN_CS|XN_IE|XN_PD|XN_PDRV0|XN_PDRV1|XN_PU|XN_SL|XP_CS|XP_IE|XP_PD|XP_PDRV0|XP_PDRV1|XP_PU|XP_SL|YN_CS|YN_IE|YN_PD|YN_PDRV0|YN_PDRV1|YN_PU|YN_SL|YP_CS|YP_IE|YP_PD|YP_PDRV0|YP_PDRV1|YP_PU|YP_SL|ZN_CS|ZN_IE|ZN_PD|ZN_PDRV0|ZN_PDRV1|ZN_PU|ZN_SL|ZP_CS|ZP_IE|ZP_PD|ZP_PDRV0|ZP_PDRV1|ZP_PU|ZP_SL
+ nfet_06v0 L=1U W=5U AS=2.2P AD=1.25P PS=10.88U PD=5.5U
M$1010 \$47 \$98 \$84
+ VSS|XN_CS|XN_IE|XN_PD|XN_PDRV0|XN_PDRV1|XN_PU|XN_SL|XP_CS|XP_IE|XP_PD|XP_PDRV0|XP_PDRV1|XP_PU|XP_SL|YN_CS|YN_IE|YN_PD|YN_PDRV0|YN_PDRV1|YN_PU|YN_SL|YP_CS|YP_IE|YP_PD|YP_PDRV0|YP_PDRV1|YP_PU|YP_SL|ZN_CS|ZN_IE|ZN_PD|ZN_PDRV0|ZN_PDRV1|ZN_PU|ZN_SL|ZP_CS|ZP_IE|ZP_PD|ZP_PDRV0|ZP_PDRV1|ZP_PU|ZP_SL
+ nfet_06v0 L=1U W=5U AS=1.25P AD=2.2P PS=5.5U PD=10.88U
M$1011 \$48 \$14436 \$47
+ VSS|XN_CS|XN_IE|XN_PD|XN_PDRV0|XN_PDRV1|XN_PU|XN_SL|XP_CS|XP_IE|XP_PD|XP_PDRV0|XP_PDRV1|XP_PU|XP_SL|YN_CS|YN_IE|YN_PD|YN_PDRV0|YN_PDRV1|YN_PU|YN_SL|YP_CS|YP_IE|YP_PD|YP_PDRV0|YP_PDRV1|YP_PU|YP_SL|ZN_CS|ZN_IE|ZN_PD|ZN_PDRV0|ZN_PDRV1|ZN_PU|ZN_SL|ZP_CS|ZP_IE|ZP_PD|ZP_PDRV0|ZP_PDRV1|ZP_PU|ZP_SL
+ nfet_06v0 L=1U W=7.5U AS=3.3P AD=3.3P PS=15.88U PD=15.88U
M$1012 \$49 \$14435 \$47
+ VSS|XN_CS|XN_IE|XN_PD|XN_PDRV0|XN_PDRV1|XN_PU|XN_SL|XP_CS|XP_IE|XP_PD|XP_PDRV0|XP_PDRV1|XP_PU|XP_SL|YN_CS|YN_IE|YN_PD|YN_PDRV0|YN_PDRV1|YN_PU|YN_SL|YP_CS|YP_IE|YP_PD|YP_PDRV0|YP_PDRV1|YP_PU|YP_SL|ZN_CS|ZN_IE|ZN_PD|ZN_PDRV0|ZN_PDRV1|ZN_PU|ZN_SL|ZP_CS|ZP_IE|ZP_PD|ZP_PDRV0|ZP_PDRV1|ZP_PU|ZP_SL
+ nfet_06v0 L=1U W=8.5U AS=3.74P AD=3.74P PS=17.88U PD=17.88U
M$1013 \$50 \$69
+ VSS|XN_CS|XN_IE|XN_PD|XN_PDRV0|XN_PDRV1|XN_PU|XN_SL|XP_CS|XP_IE|XP_PD|XP_PDRV0|XP_PDRV1|XP_PU|XP_SL|YN_CS|YN_IE|YN_PD|YN_PDRV0|YN_PDRV1|YN_PU|YN_SL|YP_CS|YP_IE|YP_PD|YP_PDRV0|YP_PDRV1|YP_PU|YP_SL|ZN_CS|ZN_IE|ZN_PD|ZN_PDRV0|ZN_PDRV1|ZN_PU|ZN_SL|ZP_CS|ZP_IE|ZP_PD|ZP_PDRV0|ZP_PDRV1|ZP_PU|ZP_SL
+ VSS|XN_CS|XN_IE|XN_PD|XN_PDRV0|XN_PDRV1|XN_PU|XN_SL|XP_CS|XP_IE|XP_PD|XP_PDRV0|XP_PDRV1|XP_PU|XP_SL|YN_CS|YN_IE|YN_PD|YN_PDRV0|YN_PDRV1|YN_PU|YN_SL|YP_CS|YP_IE|YP_PD|YP_PDRV0|YP_PDRV1|YP_PU|YP_SL|ZN_CS|ZN_IE|ZN_PD|ZN_PDRV0|ZN_PDRV1|ZN_PU|ZN_SL|ZP_CS|ZP_IE|ZP_PD|ZP_PDRV0|ZP_PDRV1|ZP_PU|ZP_SL
+ nfet_06v0 L=1U W=2.5U AS=1.1P AD=0.825P PS=5.88U PD=3.16U
M$1014 \$69 \$98 \$50
+ VSS|XN_CS|XN_IE|XN_PD|XN_PDRV0|XN_PDRV1|XN_PU|XN_SL|XP_CS|XP_IE|XP_PD|XP_PDRV0|XP_PDRV1|XP_PU|XP_SL|YN_CS|YN_IE|YN_PD|YN_PDRV0|YN_PDRV1|YN_PU|YN_SL|YP_CS|YP_IE|YP_PD|YP_PDRV0|YP_PDRV1|YP_PU|YP_SL|ZN_CS|ZN_IE|ZN_PD|ZN_PDRV0|ZN_PDRV1|ZN_PU|ZN_SL|ZP_CS|ZP_IE|ZP_PD|ZP_PDRV0|ZP_PDRV1|ZP_PU|ZP_SL
+ nfet_06v0 L=1U W=2.5U AS=0.825P AD=1.1P PS=3.16U PD=5.88U
M$1015 \$115 \$69
+ VSS|XN_CS|XN_IE|XN_PD|XN_PDRV0|XN_PDRV1|XN_PU|XN_SL|XP_CS|XP_IE|XP_PD|XP_PDRV0|XP_PDRV1|XP_PU|XP_SL|YN_CS|YN_IE|YN_PD|YN_PDRV0|YN_PDRV1|YN_PU|YN_SL|YP_CS|YP_IE|YP_PD|YP_PDRV0|YP_PDRV1|YP_PU|YP_SL|ZN_CS|ZN_IE|ZN_PD|ZN_PDRV0|ZN_PDRV1|ZN_PU|ZN_SL|ZP_CS|ZP_IE|ZP_PD|ZP_PDRV0|ZP_PDRV1|ZP_PU|ZP_SL
+ VSS|XN_CS|XN_IE|XN_PD|XN_PDRV0|XN_PDRV1|XN_PU|XN_SL|XP_CS|XP_IE|XP_PD|XP_PDRV0|XP_PDRV1|XP_PU|XP_SL|YN_CS|YN_IE|YN_PD|YN_PDRV0|YN_PDRV1|YN_PU|YN_SL|YP_CS|YP_IE|YP_PD|YP_PDRV0|YP_PDRV1|YP_PU|YP_SL|ZN_CS|ZN_IE|ZN_PD|ZN_PDRV0|ZN_PDRV1|ZN_PU|ZN_SL|ZP_CS|ZP_IE|ZP_PD|ZP_PDRV0|ZP_PDRV1|ZP_PU|ZP_SL
+ nfet_06v0 L=1U W=2.5U AS=1.1P AD=0.825P PS=5.88U PD=3.16U
M$1016 \$51 \$98 \$115
+ VSS|XN_CS|XN_IE|XN_PD|XN_PDRV0|XN_PDRV1|XN_PU|XN_SL|XP_CS|XP_IE|XP_PD|XP_PDRV0|XP_PDRV1|XP_PU|XP_SL|YN_CS|YN_IE|YN_PD|YN_PDRV0|YN_PDRV1|YN_PU|YN_SL|YP_CS|YP_IE|YP_PD|YP_PDRV0|YP_PDRV1|YP_PU|YP_SL|ZN_CS|ZN_IE|ZN_PD|ZN_PDRV0|ZN_PDRV1|ZN_PU|ZN_SL|ZP_CS|ZP_IE|ZP_PD|ZP_PDRV0|ZP_PDRV1|ZP_PU|ZP_SL
+ nfet_06v0 L=1U W=2.5U AS=0.825P AD=1.1P PS=3.16U PD=5.88U
M$1017 \$142 \$70 \$69
+ VSS|XN_CS|XN_IE|XN_PD|XN_PDRV0|XN_PDRV1|XN_PU|XN_SL|XP_CS|XP_IE|XP_PD|XP_PDRV0|XP_PDRV1|XP_PU|XP_SL|YN_CS|YN_IE|YN_PD|YN_PDRV0|YN_PDRV1|YN_PU|YN_SL|YP_CS|YP_IE|YP_PD|YP_PDRV0|YP_PDRV1|YP_PU|YP_SL|ZN_CS|ZN_IE|ZN_PD|ZN_PDRV0|ZN_PDRV1|ZN_PU|ZN_SL|ZP_CS|ZP_IE|ZP_PD|ZP_PDRV0|ZP_PDRV1|ZP_PU|ZP_SL
+ nfet_06v0 L=1U W=2U AS=0.88P AD=0.88P PS=4.88U PD=4.88U
M$1018 \$126 \$70 \$51
+ VSS|XN_CS|XN_IE|XN_PD|XN_PDRV0|XN_PDRV1|XN_PU|XN_SL|XP_CS|XP_IE|XP_PD|XP_PDRV0|XP_PDRV1|XP_PU|XP_SL|YN_CS|YN_IE|YN_PD|YN_PDRV0|YN_PDRV1|YN_PU|YN_SL|YP_CS|YP_IE|YP_PD|YP_PDRV0|YP_PDRV1|YP_PU|YP_SL|ZN_CS|ZN_IE|ZN_PD|ZN_PDRV0|ZN_PDRV1|ZN_PU|ZN_SL|ZP_CS|ZP_IE|ZP_PD|ZP_PDRV0|ZP_PDRV1|ZP_PU|ZP_SL
+ nfet_06v0 L=1U W=2U AS=0.88P AD=0.88P PS=4.88U PD=4.88U
M$1019 \$78 \$97
+ VSS|XN_CS|XN_IE|XN_PD|XN_PDRV0|XN_PDRV1|XN_PU|XN_SL|XP_CS|XP_IE|XP_PD|XP_PDRV0|XP_PDRV1|XP_PU|XP_SL|YN_CS|YN_IE|YN_PD|YN_PDRV0|YN_PDRV1|YN_PU|YN_SL|YP_CS|YP_IE|YP_PD|YP_PDRV0|YP_PDRV1|YP_PU|YP_SL|ZN_CS|ZN_IE|ZN_PD|ZN_PDRV0|ZN_PDRV1|ZN_PU|ZN_SL|ZP_CS|ZP_IE|ZP_PD|ZP_PDRV0|ZP_PDRV1|ZP_PU|ZP_SL
+ VSS|XN_CS|XN_IE|XN_PD|XN_PDRV0|XN_PDRV1|XN_PU|XN_SL|XP_CS|XP_IE|XP_PD|XP_PDRV0|XP_PDRV1|XP_PU|XP_SL|YN_CS|YN_IE|YN_PD|YN_PDRV0|YN_PDRV1|YN_PU|YN_SL|YP_CS|YP_IE|YP_PD|YP_PDRV0|YP_PDRV1|YP_PU|YP_SL|ZN_CS|ZN_IE|ZN_PD|ZN_PDRV0|ZN_PDRV1|ZN_PU|ZN_SL|ZP_CS|ZP_IE|ZP_PD|ZP_PDRV0|ZP_PDRV1|ZP_PU|ZP_SL
+ nfet_06v0 L=1U W=5U AS=2.2P AD=1.25P PS=10.88U PD=5.5U
M$1020 \$52 \$98 \$78
+ VSS|XN_CS|XN_IE|XN_PD|XN_PDRV0|XN_PDRV1|XN_PU|XN_SL|XP_CS|XP_IE|XP_PD|XP_PDRV0|XP_PDRV1|XP_PU|XP_SL|YN_CS|YN_IE|YN_PD|YN_PDRV0|YN_PDRV1|YN_PU|YN_SL|YP_CS|YP_IE|YP_PD|YP_PDRV0|YP_PDRV1|YP_PU|YP_SL|ZN_CS|ZN_IE|ZN_PD|ZN_PDRV0|ZN_PDRV1|ZN_PU|ZN_SL|ZP_CS|ZP_IE|ZP_PD|ZP_PDRV0|ZP_PDRV1|ZP_PU|ZP_SL
+ nfet_06v0 L=1U W=5U AS=1.25P AD=2.2P PS=5.5U PD=10.88U
M$1021 \$76 \$53
+ VSS|XN_CS|XN_IE|XN_PD|XN_PDRV0|XN_PDRV1|XN_PU|XN_SL|XP_CS|XP_IE|XP_PD|XP_PDRV0|XP_PDRV1|XP_PU|XP_SL|YN_CS|YN_IE|YN_PD|YN_PDRV0|YN_PDRV1|YN_PU|YN_SL|YP_CS|YP_IE|YP_PD|YP_PDRV0|YP_PDRV1|YP_PU|YP_SL|ZN_CS|ZN_IE|ZN_PD|ZN_PDRV0|ZN_PDRV1|ZN_PU|ZN_SL|ZP_CS|ZP_IE|ZP_PD|ZP_PDRV0|ZP_PDRV1|ZP_PU|ZP_SL
+ VSS|XN_CS|XN_IE|XN_PD|XN_PDRV0|XN_PDRV1|XN_PU|XN_SL|XP_CS|XP_IE|XP_PD|XP_PDRV0|XP_PDRV1|XP_PU|XP_SL|YN_CS|YN_IE|YN_PD|YN_PDRV0|YN_PDRV1|YN_PU|YN_SL|YP_CS|YP_IE|YP_PD|YP_PDRV0|YP_PDRV1|YP_PU|YP_SL|ZN_CS|ZN_IE|ZN_PD|ZN_PDRV0|ZN_PDRV1|ZN_PU|ZN_SL|ZP_CS|ZP_IE|ZP_PD|ZP_PDRV0|ZP_PDRV1|ZP_PU|ZP_SL
+ nfet_06v0 L=1U W=5U AS=2.2P AD=1.25P PS=10.88U PD=5.5U
M$1022 \$53 \$98 \$76
+ VSS|XN_CS|XN_IE|XN_PD|XN_PDRV0|XN_PDRV1|XN_PU|XN_SL|XP_CS|XP_IE|XP_PD|XP_PDRV0|XP_PDRV1|XP_PU|XP_SL|YN_CS|YN_IE|YN_PD|YN_PDRV0|YN_PDRV1|YN_PU|YN_SL|YP_CS|YP_IE|YP_PD|YP_PDRV0|YP_PDRV1|YP_PU|YP_SL|ZN_CS|ZN_IE|ZN_PD|ZN_PDRV0|ZN_PDRV1|ZN_PU|ZN_SL|ZP_CS|ZP_IE|ZP_PD|ZP_PDRV0|ZP_PDRV1|ZP_PU|ZP_SL
+ nfet_06v0 L=1U W=5U AS=1.25P AD=1.65P PS=5.5U PD=5.66U
M$1023 \$70 \$70 \$53
+ VSS|XN_CS|XN_IE|XN_PD|XN_PDRV0|XN_PDRV1|XN_PU|XN_SL|XP_CS|XP_IE|XP_PD|XP_PDRV0|XP_PDRV1|XP_PU|XP_SL|YN_CS|YN_IE|YN_PD|YN_PDRV0|YN_PDRV1|YN_PU|YN_SL|YP_CS|YP_IE|YP_PD|YP_PDRV0|YP_PDRV1|YP_PU|YP_SL|ZN_CS|ZN_IE|ZN_PD|ZN_PDRV0|ZN_PDRV1|ZN_PU|ZN_SL|ZP_CS|ZP_IE|ZP_PD|ZP_PDRV0|ZP_PDRV1|ZP_PU|ZP_SL
+ nfet_06v0 L=1U W=5U AS=1.65P AD=2.2P PS=5.66U PD=10.88U
M$1024 \$54 \$51
+ VSS|XN_CS|XN_IE|XN_PD|XN_PDRV0|XN_PDRV1|XN_PU|XN_SL|XP_CS|XP_IE|XP_PD|XP_PDRV0|XP_PDRV1|XP_PU|XP_SL|YN_CS|YN_IE|YN_PD|YN_PDRV0|YN_PDRV1|YN_PU|YN_SL|YP_CS|YP_IE|YP_PD|YP_PDRV0|YP_PDRV1|YP_PU|YP_SL|ZN_CS|ZN_IE|ZN_PD|ZN_PDRV0|ZN_PDRV1|ZN_PU|ZN_SL|ZP_CS|ZP_IE|ZP_PD|ZP_PDRV0|ZP_PDRV1|ZP_PU|ZP_SL
+ VSS|XN_CS|XN_IE|XN_PD|XN_PDRV0|XN_PDRV1|XN_PU|XN_SL|XP_CS|XP_IE|XP_PD|XP_PDRV0|XP_PDRV1|XP_PU|XP_SL|YN_CS|YN_IE|YN_PD|YN_PDRV0|YN_PDRV1|YN_PU|YN_SL|YP_CS|YP_IE|YP_PD|YP_PDRV0|YP_PDRV1|YP_PU|YP_SL|ZN_CS|ZN_IE|ZN_PD|ZN_PDRV0|ZN_PDRV1|ZN_PU|ZN_SL|ZP_CS|ZP_IE|ZP_PD|ZP_PDRV0|ZP_PDRV1|ZP_PU|ZP_SL
+ nfet_06v0 L=1U W=1U AS=0.44P AD=0.44P PS=2.88U PD=2.88U
M$1025 \$98 \$98
+ VSS|XN_CS|XN_IE|XN_PD|XN_PDRV0|XN_PDRV1|XN_PU|XN_SL|XP_CS|XP_IE|XP_PD|XP_PDRV0|XP_PDRV1|XP_PU|XP_SL|YN_CS|YN_IE|YN_PD|YN_PDRV0|YN_PDRV1|YN_PU|YN_SL|YP_CS|YP_IE|YP_PD|YP_PDRV0|YP_PDRV1|YP_PU|YP_SL|ZN_CS|ZN_IE|ZN_PD|ZN_PDRV0|ZN_PDRV1|ZN_PU|ZN_SL|ZP_CS|ZP_IE|ZP_PD|ZP_PDRV0|ZP_PDRV1|ZP_PU|ZP_SL
+ VSS|XN_CS|XN_IE|XN_PD|XN_PDRV0|XN_PDRV1|XN_PU|XN_SL|XP_CS|XP_IE|XP_PD|XP_PDRV0|XP_PDRV1|XP_PU|XP_SL|YN_CS|YN_IE|YN_PD|YN_PDRV0|YN_PDRV1|YN_PU|YN_SL|YP_CS|YP_IE|YP_PD|YP_PDRV0|YP_PDRV1|YP_PU|YP_SL|ZN_CS|ZN_IE|ZN_PD|ZN_PDRV0|ZN_PDRV1|ZN_PU|ZN_SL|ZP_CS|ZP_IE|ZP_PD|ZP_PDRV0|ZP_PDRV1|ZP_PU|ZP_SL
+ nfet_06v0 L=1U W=1U AS=0.44P AD=0.44P PS=2.88U PD=2.88U
M$1026 \$73 \$97
+ VSS|XN_CS|XN_IE|XN_PD|XN_PDRV0|XN_PDRV1|XN_PU|XN_SL|XP_CS|XP_IE|XP_PD|XP_PDRV0|XP_PDRV1|XP_PU|XP_SL|YN_CS|YN_IE|YN_PD|YN_PDRV0|YN_PDRV1|YN_PU|YN_SL|YP_CS|YP_IE|YP_PD|YP_PDRV0|YP_PDRV1|YP_PU|YP_SL|ZN_CS|ZN_IE|ZN_PD|ZN_PDRV0|ZN_PDRV1|ZN_PU|ZN_SL|ZP_CS|ZP_IE|ZP_PD|ZP_PDRV0|ZP_PDRV1|ZP_PU|ZP_SL
+ VSS|XN_CS|XN_IE|XN_PD|XN_PDRV0|XN_PDRV1|XN_PU|XN_SL|XP_CS|XP_IE|XP_PD|XP_PDRV0|XP_PDRV1|XP_PU|XP_SL|YN_CS|YN_IE|YN_PD|YN_PDRV0|YN_PDRV1|YN_PU|YN_SL|YP_CS|YP_IE|YP_PD|YP_PDRV0|YP_PDRV1|YP_PU|YP_SL|ZN_CS|ZN_IE|ZN_PD|ZN_PDRV0|ZN_PDRV1|ZN_PU|ZN_SL|ZP_CS|ZP_IE|ZP_PD|ZP_PDRV0|ZP_PDRV1|ZP_PU|ZP_SL
+ nfet_06v0 L=1U W=5U AS=2.2P AD=1.25P PS=10.88U PD=5.5U
M$1027 \$97 \$98 \$73
+ VSS|XN_CS|XN_IE|XN_PD|XN_PDRV0|XN_PDRV1|XN_PU|XN_SL|XP_CS|XP_IE|XP_PD|XP_PDRV0|XP_PDRV1|XP_PU|XP_SL|YN_CS|YN_IE|YN_PD|YN_PDRV0|YN_PDRV1|YN_PU|YN_SL|YP_CS|YP_IE|YP_PD|YP_PDRV0|YP_PDRV1|YP_PU|YP_SL|ZN_CS|ZN_IE|ZN_PD|ZN_PDRV0|ZN_PDRV1|ZN_PU|ZN_SL|ZP_CS|ZP_IE|ZP_PD|ZP_PDRV0|ZP_PDRV1|ZP_PU|ZP_SL
+ nfet_06v0 L=1U W=5U AS=1.25P AD=2.2P PS=5.5U PD=10.88U
M$1028 \$56 \$125
+ VSS|XN_CS|XN_IE|XN_PD|XN_PDRV0|XN_PDRV1|XN_PU|XN_SL|XP_CS|XP_IE|XP_PD|XP_PDRV0|XP_PDRV1|XP_PU|XP_SL|YN_CS|YN_IE|YN_PD|YN_PDRV0|YN_PDRV1|YN_PU|YN_SL|YP_CS|YP_IE|YP_PD|YP_PDRV0|YP_PDRV1|YP_PU|YP_SL|ZN_CS|ZN_IE|ZN_PD|ZN_PDRV0|ZN_PDRV1|ZN_PU|ZN_SL|ZP_CS|ZP_IE|ZP_PD|ZP_PDRV0|ZP_PDRV1|ZP_PU|ZP_SL
+ VSS|XN_CS|XN_IE|XN_PD|XN_PDRV0|XN_PDRV1|XN_PU|XN_SL|XP_CS|XP_IE|XP_PD|XP_PDRV0|XP_PDRV1|XP_PU|XP_SL|YN_CS|YN_IE|YN_PD|YN_PDRV0|YN_PDRV1|YN_PU|YN_SL|YP_CS|YP_IE|YP_PD|YP_PDRV0|YP_PDRV1|YP_PU|YP_SL|ZN_CS|ZN_IE|ZN_PD|ZN_PDRV0|ZN_PDRV1|ZN_PU|ZN_SL|ZP_CS|ZP_IE|ZP_PD|ZP_PDRV0|ZP_PDRV1|ZP_PU|ZP_SL
+ nfet_06v0 L=1U W=1U AS=0.44P AD=0.25P PS=2.88U PD=1.5U
M$1029 \$102 \$125 \$56
+ VSS|XN_CS|XN_IE|XN_PD|XN_PDRV0|XN_PDRV1|XN_PU|XN_SL|XP_CS|XP_IE|XP_PD|XP_PDRV0|XP_PDRV1|XP_PU|XP_SL|YN_CS|YN_IE|YN_PD|YN_PDRV0|YN_PDRV1|YN_PU|YN_SL|YP_CS|YP_IE|YP_PD|YP_PDRV0|YP_PDRV1|YP_PU|YP_SL|ZN_CS|ZN_IE|ZN_PD|ZN_PDRV0|ZN_PDRV1|ZN_PU|ZN_SL|ZP_CS|ZP_IE|ZP_PD|ZP_PDRV0|ZP_PDRV1|ZP_PU|ZP_SL
+ nfet_06v0 L=1U W=1U AS=0.25P AD=0.44P PS=1.5U PD=2.88U
M$1030 \$55 \$125
+ VSS|XN_CS|XN_IE|XN_PD|XN_PDRV0|XN_PDRV1|XN_PU|XN_SL|XP_CS|XP_IE|XP_PD|XP_PDRV0|XP_PDRV1|XP_PU|XP_SL|YN_CS|YN_IE|YN_PD|YN_PDRV0|YN_PDRV1|YN_PU|YN_SL|YP_CS|YP_IE|YP_PD|YP_PDRV0|YP_PDRV1|YP_PU|YP_SL|ZN_CS|ZN_IE|ZN_PD|ZN_PDRV0|ZN_PDRV1|ZN_PU|ZN_SL|ZP_CS|ZP_IE|ZP_PD|ZP_PDRV0|ZP_PDRV1|ZP_PU|ZP_SL
+ VSS|XN_CS|XN_IE|XN_PD|XN_PDRV0|XN_PDRV1|XN_PU|XN_SL|XP_CS|XP_IE|XP_PD|XP_PDRV0|XP_PDRV1|XP_PU|XP_SL|YN_CS|YN_IE|YN_PD|YN_PDRV0|YN_PDRV1|YN_PU|YN_SL|YP_CS|YP_IE|YP_PD|YP_PDRV0|YP_PDRV1|YP_PU|YP_SL|ZN_CS|ZN_IE|ZN_PD|ZN_PDRV0|ZN_PDRV1|ZN_PU|ZN_SL|ZP_CS|ZP_IE|ZP_PD|ZP_PDRV0|ZP_PDRV1|ZP_PU|ZP_SL
+ nfet_06v0 L=1U W=1U AS=0.44P AD=0.25P PS=2.88U PD=1.5U
M$1031 \$125 \$125 \$55
+ VSS|XN_CS|XN_IE|XN_PD|XN_PDRV0|XN_PDRV1|XN_PU|XN_SL|XP_CS|XP_IE|XP_PD|XP_PDRV0|XP_PDRV1|XP_PU|XP_SL|YN_CS|YN_IE|YN_PD|YN_PDRV0|YN_PDRV1|YN_PU|YN_SL|YP_CS|YP_IE|YP_PD|YP_PDRV0|YP_PDRV1|YP_PU|YP_SL|ZN_CS|ZN_IE|ZN_PD|ZN_PDRV0|ZN_PDRV1|ZN_PU|ZN_SL|ZP_CS|ZP_IE|ZP_PD|ZP_PDRV0|ZP_PDRV1|ZP_PU|ZP_SL
+ nfet_06v0 L=1U W=1U AS=0.25P AD=0.44P PS=1.5U PD=2.88U
M$1032
+ VSS|XN_CS|XN_IE|XN_PD|XN_PDRV0|XN_PDRV1|XN_PU|XN_SL|XP_CS|XP_IE|XP_PD|XP_PDRV0|XP_PDRV1|XP_PU|XP_SL|YN_CS|YN_IE|YN_PD|YN_PDRV0|YN_PDRV1|YN_PU|YN_SL|YP_CS|YP_IE|YP_PD|YP_PDRV0|YP_PDRV1|YP_PU|YP_SL|ZN_CS|ZN_IE|ZN_PD|ZN_PDRV0|ZN_PDRV1|ZN_PU|ZN_SL|ZP_CS|ZP_IE|ZP_PD|ZP_PDRV0|ZP_PDRV1|ZP_PU|ZP_SL
+ VDD|XN_OE|XP_OE|YN_OE|YP_OE|ZN_OE|ZP_OE
+ VSS|XN_CS|XN_IE|XN_PD|XN_PDRV0|XN_PDRV1|XN_PU|XN_SL|XP_CS|XP_IE|XP_PD|XP_PDRV0|XP_PDRV1|XP_PU|XP_SL|YN_CS|YN_IE|YN_PD|YN_PDRV0|YN_PDRV1|YN_PU|YN_SL|YP_CS|YP_IE|YP_PD|YP_PDRV0|YP_PDRV1|YP_PU|YP_SL|ZN_CS|ZN_IE|ZN_PD|ZN_PDRV0|ZN_PDRV1|ZN_PU|ZN_SL|ZP_CS|ZP_IE|ZP_PD|ZP_PDRV0|ZP_PDRV1|ZP_PU|ZP_SL
+ VSS|XN_CS|XN_IE|XN_PD|XN_PDRV0|XN_PDRV1|XN_PU|XN_SL|XP_CS|XP_IE|XP_PD|XP_PDRV0|XP_PDRV1|XP_PU|XP_SL|YN_CS|YN_IE|YN_PD|YN_PDRV0|YN_PDRV1|YN_PU|YN_SL|YP_CS|YP_IE|YP_PD|YP_PDRV0|YP_PDRV1|YP_PU|YP_SL|ZN_CS|ZN_IE|ZN_PD|ZN_PDRV0|ZN_PDRV1|ZN_PU|ZN_SL|ZP_CS|ZP_IE|ZP_PD|ZP_PDRV0|ZP_PDRV1|ZP_PU|ZP_SL
+ nfet_06v0 L=2U W=18U AS=7.92P AD=7.92P PS=36.88U PD=36.88U
M$1033 \$2483 \$2502
+ VSS|XN_CS|XN_IE|XN_PD|XN_PDRV0|XN_PDRV1|XN_PU|XN_SL|XP_CS|XP_IE|XP_PD|XP_PDRV0|XP_PDRV1|XP_PU|XP_SL|YN_CS|YN_IE|YN_PD|YN_PDRV0|YN_PDRV1|YN_PU|YN_SL|YP_CS|YP_IE|YP_PD|YP_PDRV0|YP_PDRV1|YP_PU|YP_SL|ZN_CS|ZN_IE|ZN_PD|ZN_PDRV0|ZN_PDRV1|ZN_PU|ZN_SL|ZP_CS|ZP_IE|ZP_PD|ZP_PDRV0|ZP_PDRV1|ZP_PU|ZP_SL
+ VSS|XN_CS|XN_IE|XN_PD|XN_PDRV0|XN_PDRV1|XN_PU|XN_SL|XP_CS|XP_IE|XP_PD|XP_PDRV0|XP_PDRV1|XP_PU|XP_SL|YN_CS|YN_IE|YN_PD|YN_PDRV0|YN_PDRV1|YN_PU|YN_SL|YP_CS|YP_IE|YP_PD|YP_PDRV0|YP_PDRV1|YP_PU|YP_SL|ZN_CS|ZN_IE|ZN_PD|ZN_PDRV0|ZN_PDRV1|ZN_PU|ZN_SL|ZP_CS|ZP_IE|ZP_PD|ZP_PDRV0|ZP_PDRV1|ZP_PU|ZP_SL
+ nfet_06v0 L=1U W=5U AS=2.2P AD=1.25P PS=10.88U PD=5.5U
M$1034 \$2434 \$2503 \$2483
+ VSS|XN_CS|XN_IE|XN_PD|XN_PDRV0|XN_PDRV1|XN_PU|XN_SL|XP_CS|XP_IE|XP_PD|XP_PDRV0|XP_PDRV1|XP_PU|XP_SL|YN_CS|YN_IE|YN_PD|YN_PDRV0|YN_PDRV1|YN_PU|YN_SL|YP_CS|YP_IE|YP_PD|YP_PDRV0|YP_PDRV1|YP_PU|YP_SL|ZN_CS|ZN_IE|ZN_PD|ZN_PDRV0|ZN_PDRV1|ZN_PU|ZN_SL|ZP_CS|ZP_IE|ZP_PD|ZP_PDRV0|ZP_PDRV1|ZP_PU|ZP_SL
+ nfet_06v0 L=1U W=5U AS=1.25P AD=2.2P PS=5.5U PD=10.88U
M$1035 \$2484 \$2502
+ VSS|XN_CS|XN_IE|XN_PD|XN_PDRV0|XN_PDRV1|XN_PU|XN_SL|XP_CS|XP_IE|XP_PD|XP_PDRV0|XP_PDRV1|XP_PU|XP_SL|YN_CS|YN_IE|YN_PD|YN_PDRV0|YN_PDRV1|YN_PU|YN_SL|YP_CS|YP_IE|YP_PD|YP_PDRV0|YP_PDRV1|YP_PU|YP_SL|ZN_CS|ZN_IE|ZN_PD|ZN_PDRV0|ZN_PDRV1|ZN_PU|ZN_SL|ZP_CS|ZP_IE|ZP_PD|ZP_PDRV0|ZP_PDRV1|ZP_PU|ZP_SL
+ VSS|XN_CS|XN_IE|XN_PD|XN_PDRV0|XN_PDRV1|XN_PU|XN_SL|XP_CS|XP_IE|XP_PD|XP_PDRV0|XP_PDRV1|XP_PU|XP_SL|YN_CS|YN_IE|YN_PD|YN_PDRV0|YN_PDRV1|YN_PU|YN_SL|YP_CS|YP_IE|YP_PD|YP_PDRV0|YP_PDRV1|YP_PU|YP_SL|ZN_CS|ZN_IE|ZN_PD|ZN_PDRV0|ZN_PDRV1|ZN_PU|ZN_SL|ZP_CS|ZP_IE|ZP_PD|ZP_PDRV0|ZP_PDRV1|ZP_PU|ZP_SL
+ nfet_06v0 L=1U W=5U AS=2.2P AD=1.25P PS=10.88U PD=5.5U
M$1036 \$2434 \$2503 \$2484
+ VSS|XN_CS|XN_IE|XN_PD|XN_PDRV0|XN_PDRV1|XN_PU|XN_SL|XP_CS|XP_IE|XP_PD|XP_PDRV0|XP_PDRV1|XP_PU|XP_SL|YN_CS|YN_IE|YN_PD|YN_PDRV0|YN_PDRV1|YN_PU|YN_SL|YP_CS|YP_IE|YP_PD|YP_PDRV0|YP_PDRV1|YP_PU|YP_SL|ZN_CS|ZN_IE|ZN_PD|ZN_PDRV0|ZN_PDRV1|ZN_PU|ZN_SL|ZP_CS|ZP_IE|ZP_PD|ZP_PDRV0|ZP_PDRV1|ZP_PU|ZP_SL
+ nfet_06v0 L=1U W=5U AS=1.25P AD=2.2P PS=5.5U PD=10.88U
M$1037 \$2435 \$14440 \$2434
+ VSS|XN_CS|XN_IE|XN_PD|XN_PDRV0|XN_PDRV1|XN_PU|XN_SL|XP_CS|XP_IE|XP_PD|XP_PDRV0|XP_PDRV1|XP_PU|XP_SL|YN_CS|YN_IE|YN_PD|YN_PDRV0|YN_PDRV1|YN_PU|YN_SL|YP_CS|YP_IE|YP_PD|YP_PDRV0|YP_PDRV1|YP_PU|YP_SL|ZN_CS|ZN_IE|ZN_PD|ZN_PDRV0|ZN_PDRV1|ZN_PU|ZN_SL|ZP_CS|ZP_IE|ZP_PD|ZP_PDRV0|ZP_PDRV1|ZP_PU|ZP_SL
+ nfet_06v0 L=1U W=7.5U AS=3.3P AD=3.3P PS=15.88U PD=15.88U
M$1038 \$2436 \$14439 \$2434
+ VSS|XN_CS|XN_IE|XN_PD|XN_PDRV0|XN_PDRV1|XN_PU|XN_SL|XP_CS|XP_IE|XP_PD|XP_PDRV0|XP_PDRV1|XP_PU|XP_SL|YN_CS|YN_IE|YN_PD|YN_PDRV0|YN_PDRV1|YN_PU|YN_SL|YP_CS|YP_IE|YP_PD|YP_PDRV0|YP_PDRV1|YP_PU|YP_SL|ZN_CS|ZN_IE|ZN_PD|ZN_PDRV0|ZN_PDRV1|ZN_PU|ZN_SL|ZP_CS|ZP_IE|ZP_PD|ZP_PDRV0|ZP_PDRV1|ZP_PU|ZP_SL
+ nfet_06v0 L=1U W=8.5U AS=3.74P AD=3.74P PS=17.88U PD=17.88U
M$1039 \$2437 \$2478
+ VSS|XN_CS|XN_IE|XN_PD|XN_PDRV0|XN_PDRV1|XN_PU|XN_SL|XP_CS|XP_IE|XP_PD|XP_PDRV0|XP_PDRV1|XP_PU|XP_SL|YN_CS|YN_IE|YN_PD|YN_PDRV0|YN_PDRV1|YN_PU|YN_SL|YP_CS|YP_IE|YP_PD|YP_PDRV0|YP_PDRV1|YP_PU|YP_SL|ZN_CS|ZN_IE|ZN_PD|ZN_PDRV0|ZN_PDRV1|ZN_PU|ZN_SL|ZP_CS|ZP_IE|ZP_PD|ZP_PDRV0|ZP_PDRV1|ZP_PU|ZP_SL
+ VSS|XN_CS|XN_IE|XN_PD|XN_PDRV0|XN_PDRV1|XN_PU|XN_SL|XP_CS|XP_IE|XP_PD|XP_PDRV0|XP_PDRV1|XP_PU|XP_SL|YN_CS|YN_IE|YN_PD|YN_PDRV0|YN_PDRV1|YN_PU|YN_SL|YP_CS|YP_IE|YP_PD|YP_PDRV0|YP_PDRV1|YP_PU|YP_SL|ZN_CS|ZN_IE|ZN_PD|ZN_PDRV0|ZN_PDRV1|ZN_PU|ZN_SL|ZP_CS|ZP_IE|ZP_PD|ZP_PDRV0|ZP_PDRV1|ZP_PU|ZP_SL
+ nfet_06v0 L=1U W=2.5U AS=1.1P AD=0.825P PS=5.88U PD=3.16U
M$1040 \$2478 \$2503 \$2437
+ VSS|XN_CS|XN_IE|XN_PD|XN_PDRV0|XN_PDRV1|XN_PU|XN_SL|XP_CS|XP_IE|XP_PD|XP_PDRV0|XP_PDRV1|XP_PU|XP_SL|YN_CS|YN_IE|YN_PD|YN_PDRV0|YN_PDRV1|YN_PU|YN_SL|YP_CS|YP_IE|YP_PD|YP_PDRV0|YP_PDRV1|YP_PU|YP_SL|ZN_CS|ZN_IE|ZN_PD|ZN_PDRV0|ZN_PDRV1|ZN_PU|ZN_SL|ZP_CS|ZP_IE|ZP_PD|ZP_PDRV0|ZP_PDRV1|ZP_PU|ZP_SL
+ nfet_06v0 L=1U W=2.5U AS=0.825P AD=1.1P PS=3.16U PD=5.88U
M$1041 \$2514 \$2478
+ VSS|XN_CS|XN_IE|XN_PD|XN_PDRV0|XN_PDRV1|XN_PU|XN_SL|XP_CS|XP_IE|XP_PD|XP_PDRV0|XP_PDRV1|XP_PU|XP_SL|YN_CS|YN_IE|YN_PD|YN_PDRV0|YN_PDRV1|YN_PU|YN_SL|YP_CS|YP_IE|YP_PD|YP_PDRV0|YP_PDRV1|YP_PU|YP_SL|ZN_CS|ZN_IE|ZN_PD|ZN_PDRV0|ZN_PDRV1|ZN_PU|ZN_SL|ZP_CS|ZP_IE|ZP_PD|ZP_PDRV0|ZP_PDRV1|ZP_PU|ZP_SL
+ VSS|XN_CS|XN_IE|XN_PD|XN_PDRV0|XN_PDRV1|XN_PU|XN_SL|XP_CS|XP_IE|XP_PD|XP_PDRV0|XP_PDRV1|XP_PU|XP_SL|YN_CS|YN_IE|YN_PD|YN_PDRV0|YN_PDRV1|YN_PU|YN_SL|YP_CS|YP_IE|YP_PD|YP_PDRV0|YP_PDRV1|YP_PU|YP_SL|ZN_CS|ZN_IE|ZN_PD|ZN_PDRV0|ZN_PDRV1|ZN_PU|ZN_SL|ZP_CS|ZP_IE|ZP_PD|ZP_PDRV0|ZP_PDRV1|ZP_PU|ZP_SL
+ nfet_06v0 L=1U W=2.5U AS=1.1P AD=0.825P PS=5.88U PD=3.16U
M$1042 \$2438 \$2503 \$2514
+ VSS|XN_CS|XN_IE|XN_PD|XN_PDRV0|XN_PDRV1|XN_PU|XN_SL|XP_CS|XP_IE|XP_PD|XP_PDRV0|XP_PDRV1|XP_PU|XP_SL|YN_CS|YN_IE|YN_PD|YN_PDRV0|YN_PDRV1|YN_PU|YN_SL|YP_CS|YP_IE|YP_PD|YP_PDRV0|YP_PDRV1|YP_PU|YP_SL|ZN_CS|ZN_IE|ZN_PD|ZN_PDRV0|ZN_PDRV1|ZN_PU|ZN_SL|ZP_CS|ZP_IE|ZP_PD|ZP_PDRV0|ZP_PDRV1|ZP_PU|ZP_SL
+ nfet_06v0 L=1U W=2.5U AS=0.825P AD=1.1P PS=3.16U PD=5.88U
M$1043 \$2547 \$2474 \$2478
+ VSS|XN_CS|XN_IE|XN_PD|XN_PDRV0|XN_PDRV1|XN_PU|XN_SL|XP_CS|XP_IE|XP_PD|XP_PDRV0|XP_PDRV1|XP_PU|XP_SL|YN_CS|YN_IE|YN_PD|YN_PDRV0|YN_PDRV1|YN_PU|YN_SL|YP_CS|YP_IE|YP_PD|YP_PDRV0|YP_PDRV1|YP_PU|YP_SL|ZN_CS|ZN_IE|ZN_PD|ZN_PDRV0|ZN_PDRV1|ZN_PU|ZN_SL|ZP_CS|ZP_IE|ZP_PD|ZP_PDRV0|ZP_PDRV1|ZP_PU|ZP_SL
+ nfet_06v0 L=1U W=2U AS=0.88P AD=0.88P PS=4.88U PD=4.88U
M$1044 \$2531 \$2474 \$2438
+ VSS|XN_CS|XN_IE|XN_PD|XN_PDRV0|XN_PDRV1|XN_PU|XN_SL|XP_CS|XP_IE|XP_PD|XP_PDRV0|XP_PDRV1|XP_PU|XP_SL|YN_CS|YN_IE|YN_PD|YN_PDRV0|YN_PDRV1|YN_PU|YN_SL|YP_CS|YP_IE|YP_PD|YP_PDRV0|YP_PDRV1|YP_PU|YP_SL|ZN_CS|ZN_IE|ZN_PD|ZN_PDRV0|ZN_PDRV1|ZN_PU|ZN_SL|ZP_CS|ZP_IE|ZP_PD|ZP_PDRV0|ZP_PDRV1|ZP_PU|ZP_SL
+ nfet_06v0 L=1U W=2U AS=0.88P AD=0.88P PS=4.88U PD=4.88U
M$1045 \$2486 \$2502
+ VSS|XN_CS|XN_IE|XN_PD|XN_PDRV0|XN_PDRV1|XN_PU|XN_SL|XP_CS|XP_IE|XP_PD|XP_PDRV0|XP_PDRV1|XP_PU|XP_SL|YN_CS|YN_IE|YN_PD|YN_PDRV0|YN_PDRV1|YN_PU|YN_SL|YP_CS|YP_IE|YP_PD|YP_PDRV0|YP_PDRV1|YP_PU|YP_SL|ZN_CS|ZN_IE|ZN_PD|ZN_PDRV0|ZN_PDRV1|ZN_PU|ZN_SL|ZP_CS|ZP_IE|ZP_PD|ZP_PDRV0|ZP_PDRV1|ZP_PU|ZP_SL
+ VSS|XN_CS|XN_IE|XN_PD|XN_PDRV0|XN_PDRV1|XN_PU|XN_SL|XP_CS|XP_IE|XP_PD|XP_PDRV0|XP_PDRV1|XP_PU|XP_SL|YN_CS|YN_IE|YN_PD|YN_PDRV0|YN_PDRV1|YN_PU|YN_SL|YP_CS|YP_IE|YP_PD|YP_PDRV0|YP_PDRV1|YP_PU|YP_SL|ZN_CS|ZN_IE|ZN_PD|ZN_PDRV0|ZN_PDRV1|ZN_PU|ZN_SL|ZP_CS|ZP_IE|ZP_PD|ZP_PDRV0|ZP_PDRV1|ZP_PU|ZP_SL
+ nfet_06v0 L=1U W=5U AS=2.2P AD=1.25P PS=10.88U PD=5.5U
M$1046 \$2439 \$2503 \$2486
+ VSS|XN_CS|XN_IE|XN_PD|XN_PDRV0|XN_PDRV1|XN_PU|XN_SL|XP_CS|XP_IE|XP_PD|XP_PDRV0|XP_PDRV1|XP_PU|XP_SL|YN_CS|YN_IE|YN_PD|YN_PDRV0|YN_PDRV1|YN_PU|YN_SL|YP_CS|YP_IE|YP_PD|YP_PDRV0|YP_PDRV1|YP_PU|YP_SL|ZN_CS|ZN_IE|ZN_PD|ZN_PDRV0|ZN_PDRV1|ZN_PU|ZN_SL|ZP_CS|ZP_IE|ZP_PD|ZP_PDRV0|ZP_PDRV1|ZP_PU|ZP_SL
+ nfet_06v0 L=1U W=5U AS=1.25P AD=2.2P PS=5.5U PD=10.88U
M$1047 \$2488 \$2440
+ VSS|XN_CS|XN_IE|XN_PD|XN_PDRV0|XN_PDRV1|XN_PU|XN_SL|XP_CS|XP_IE|XP_PD|XP_PDRV0|XP_PDRV1|XP_PU|XP_SL|YN_CS|YN_IE|YN_PD|YN_PDRV0|YN_PDRV1|YN_PU|YN_SL|YP_CS|YP_IE|YP_PD|YP_PDRV0|YP_PDRV1|YP_PU|YP_SL|ZN_CS|ZN_IE|ZN_PD|ZN_PDRV0|ZN_PDRV1|ZN_PU|ZN_SL|ZP_CS|ZP_IE|ZP_PD|ZP_PDRV0|ZP_PDRV1|ZP_PU|ZP_SL
+ VSS|XN_CS|XN_IE|XN_PD|XN_PDRV0|XN_PDRV1|XN_PU|XN_SL|XP_CS|XP_IE|XP_PD|XP_PDRV0|XP_PDRV1|XP_PU|XP_SL|YN_CS|YN_IE|YN_PD|YN_PDRV0|YN_PDRV1|YN_PU|YN_SL|YP_CS|YP_IE|YP_PD|YP_PDRV0|YP_PDRV1|YP_PU|YP_SL|ZN_CS|ZN_IE|ZN_PD|ZN_PDRV0|ZN_PDRV1|ZN_PU|ZN_SL|ZP_CS|ZP_IE|ZP_PD|ZP_PDRV0|ZP_PDRV1|ZP_PU|ZP_SL
+ nfet_06v0 L=1U W=5U AS=2.2P AD=1.25P PS=10.88U PD=5.5U
M$1048 \$2440 \$2503 \$2488
+ VSS|XN_CS|XN_IE|XN_PD|XN_PDRV0|XN_PDRV1|XN_PU|XN_SL|XP_CS|XP_IE|XP_PD|XP_PDRV0|XP_PDRV1|XP_PU|XP_SL|YN_CS|YN_IE|YN_PD|YN_PDRV0|YN_PDRV1|YN_PU|YN_SL|YP_CS|YP_IE|YP_PD|YP_PDRV0|YP_PDRV1|YP_PU|YP_SL|ZN_CS|ZN_IE|ZN_PD|ZN_PDRV0|ZN_PDRV1|ZN_PU|ZN_SL|ZP_CS|ZP_IE|ZP_PD|ZP_PDRV0|ZP_PDRV1|ZP_PU|ZP_SL
+ nfet_06v0 L=1U W=5U AS=1.25P AD=1.65P PS=5.5U PD=5.66U
M$1049 \$2474 \$2474 \$2440
+ VSS|XN_CS|XN_IE|XN_PD|XN_PDRV0|XN_PDRV1|XN_PU|XN_SL|XP_CS|XP_IE|XP_PD|XP_PDRV0|XP_PDRV1|XP_PU|XP_SL|YN_CS|YN_IE|YN_PD|YN_PDRV0|YN_PDRV1|YN_PU|YN_SL|YP_CS|YP_IE|YP_PD|YP_PDRV0|YP_PDRV1|YP_PU|YP_SL|ZN_CS|ZN_IE|ZN_PD|ZN_PDRV0|ZN_PDRV1|ZN_PU|ZN_SL|ZP_CS|ZP_IE|ZP_PD|ZP_PDRV0|ZP_PDRV1|ZP_PU|ZP_SL
+ nfet_06v0 L=1U W=5U AS=1.65P AD=2.2P PS=5.66U PD=10.88U
M$1050 \$2441 \$2438
+ VSS|XN_CS|XN_IE|XN_PD|XN_PDRV0|XN_PDRV1|XN_PU|XN_SL|XP_CS|XP_IE|XP_PD|XP_PDRV0|XP_PDRV1|XP_PU|XP_SL|YN_CS|YN_IE|YN_PD|YN_PDRV0|YN_PDRV1|YN_PU|YN_SL|YP_CS|YP_IE|YP_PD|YP_PDRV0|YP_PDRV1|YP_PU|YP_SL|ZN_CS|ZN_IE|ZN_PD|ZN_PDRV0|ZN_PDRV1|ZN_PU|ZN_SL|ZP_CS|ZP_IE|ZP_PD|ZP_PDRV0|ZP_PDRV1|ZP_PU|ZP_SL
+ VSS|XN_CS|XN_IE|XN_PD|XN_PDRV0|XN_PDRV1|XN_PU|XN_SL|XP_CS|XP_IE|XP_PD|XP_PDRV0|XP_PDRV1|XP_PU|XP_SL|YN_CS|YN_IE|YN_PD|YN_PDRV0|YN_PDRV1|YN_PU|YN_SL|YP_CS|YP_IE|YP_PD|YP_PDRV0|YP_PDRV1|YP_PU|YP_SL|ZN_CS|ZN_IE|ZN_PD|ZN_PDRV0|ZN_PDRV1|ZN_PU|ZN_SL|ZP_CS|ZP_IE|ZP_PD|ZP_PDRV0|ZP_PDRV1|ZP_PU|ZP_SL
+ nfet_06v0 L=1U W=1U AS=0.44P AD=0.44P PS=2.88U PD=2.88U
M$1051 \$2503 \$2503
+ VSS|XN_CS|XN_IE|XN_PD|XN_PDRV0|XN_PDRV1|XN_PU|XN_SL|XP_CS|XP_IE|XP_PD|XP_PDRV0|XP_PDRV1|XP_PU|XP_SL|YN_CS|YN_IE|YN_PD|YN_PDRV0|YN_PDRV1|YN_PU|YN_SL|YP_CS|YP_IE|YP_PD|YP_PDRV0|YP_PDRV1|YP_PU|YP_SL|ZN_CS|ZN_IE|ZN_PD|ZN_PDRV0|ZN_PDRV1|ZN_PU|ZN_SL|ZP_CS|ZP_IE|ZP_PD|ZP_PDRV0|ZP_PDRV1|ZP_PU|ZP_SL
+ VSS|XN_CS|XN_IE|XN_PD|XN_PDRV0|XN_PDRV1|XN_PU|XN_SL|XP_CS|XP_IE|XP_PD|XP_PDRV0|XP_PDRV1|XP_PU|XP_SL|YN_CS|YN_IE|YN_PD|YN_PDRV0|YN_PDRV1|YN_PU|YN_SL|YP_CS|YP_IE|YP_PD|YP_PDRV0|YP_PDRV1|YP_PU|YP_SL|ZN_CS|ZN_IE|ZN_PD|ZN_PDRV0|ZN_PDRV1|ZN_PU|ZN_SL|ZP_CS|ZP_IE|ZP_PD|ZP_PDRV0|ZP_PDRV1|ZP_PU|ZP_SL
+ nfet_06v0 L=1U W=1U AS=0.44P AD=0.44P PS=2.88U PD=2.88U
M$1052 \$2489 \$2502
+ VSS|XN_CS|XN_IE|XN_PD|XN_PDRV0|XN_PDRV1|XN_PU|XN_SL|XP_CS|XP_IE|XP_PD|XP_PDRV0|XP_PDRV1|XP_PU|XP_SL|YN_CS|YN_IE|YN_PD|YN_PDRV0|YN_PDRV1|YN_PU|YN_SL|YP_CS|YP_IE|YP_PD|YP_PDRV0|YP_PDRV1|YP_PU|YP_SL|ZN_CS|ZN_IE|ZN_PD|ZN_PDRV0|ZN_PDRV1|ZN_PU|ZN_SL|ZP_CS|ZP_IE|ZP_PD|ZP_PDRV0|ZP_PDRV1|ZP_PU|ZP_SL
+ VSS|XN_CS|XN_IE|XN_PD|XN_PDRV0|XN_PDRV1|XN_PU|XN_SL|XP_CS|XP_IE|XP_PD|XP_PDRV0|XP_PDRV1|XP_PU|XP_SL|YN_CS|YN_IE|YN_PD|YN_PDRV0|YN_PDRV1|YN_PU|YN_SL|YP_CS|YP_IE|YP_PD|YP_PDRV0|YP_PDRV1|YP_PU|YP_SL|ZN_CS|ZN_IE|ZN_PD|ZN_PDRV0|ZN_PDRV1|ZN_PU|ZN_SL|ZP_CS|ZP_IE|ZP_PD|ZP_PDRV0|ZP_PDRV1|ZP_PU|ZP_SL
+ nfet_06v0 L=1U W=5U AS=2.2P AD=1.25P PS=10.88U PD=5.5U
M$1053 \$2502 \$2503 \$2489
+ VSS|XN_CS|XN_IE|XN_PD|XN_PDRV0|XN_PDRV1|XN_PU|XN_SL|XP_CS|XP_IE|XP_PD|XP_PDRV0|XP_PDRV1|XP_PU|XP_SL|YN_CS|YN_IE|YN_PD|YN_PDRV0|YN_PDRV1|YN_PU|YN_SL|YP_CS|YP_IE|YP_PD|YP_PDRV0|YP_PDRV1|YP_PU|YP_SL|ZN_CS|ZN_IE|ZN_PD|ZN_PDRV0|ZN_PDRV1|ZN_PU|ZN_SL|ZP_CS|ZP_IE|ZP_PD|ZP_PDRV0|ZP_PDRV1|ZP_PU|ZP_SL
+ nfet_06v0 L=1U W=5U AS=1.25P AD=2.2P PS=5.5U PD=10.88U
M$1054 \$2468 \$2530
+ VSS|XN_CS|XN_IE|XN_PD|XN_PDRV0|XN_PDRV1|XN_PU|XN_SL|XP_CS|XP_IE|XP_PD|XP_PDRV0|XP_PDRV1|XP_PU|XP_SL|YN_CS|YN_IE|YN_PD|YN_PDRV0|YN_PDRV1|YN_PU|YN_SL|YP_CS|YP_IE|YP_PD|YP_PDRV0|YP_PDRV1|YP_PU|YP_SL|ZN_CS|ZN_IE|ZN_PD|ZN_PDRV0|ZN_PDRV1|ZN_PU|ZN_SL|ZP_CS|ZP_IE|ZP_PD|ZP_PDRV0|ZP_PDRV1|ZP_PU|ZP_SL
+ VSS|XN_CS|XN_IE|XN_PD|XN_PDRV0|XN_PDRV1|XN_PU|XN_SL|XP_CS|XP_IE|XP_PD|XP_PDRV0|XP_PDRV1|XP_PU|XP_SL|YN_CS|YN_IE|YN_PD|YN_PDRV0|YN_PDRV1|YN_PU|YN_SL|YP_CS|YP_IE|YP_PD|YP_PDRV0|YP_PDRV1|YP_PU|YP_SL|ZN_CS|ZN_IE|ZN_PD|ZN_PDRV0|ZN_PDRV1|ZN_PU|ZN_SL|ZP_CS|ZP_IE|ZP_PD|ZP_PDRV0|ZP_PDRV1|ZP_PU|ZP_SL
+ nfet_06v0 L=1U W=1U AS=0.44P AD=0.25P PS=2.88U PD=1.5U
M$1055 \$2510 \$2530 \$2468
+ VSS|XN_CS|XN_IE|XN_PD|XN_PDRV0|XN_PDRV1|XN_PU|XN_SL|XP_CS|XP_IE|XP_PD|XP_PDRV0|XP_PDRV1|XP_PU|XP_SL|YN_CS|YN_IE|YN_PD|YN_PDRV0|YN_PDRV1|YN_PU|YN_SL|YP_CS|YP_IE|YP_PD|YP_PDRV0|YP_PDRV1|YP_PU|YP_SL|ZN_CS|ZN_IE|ZN_PD|ZN_PDRV0|ZN_PDRV1|ZN_PU|ZN_SL|ZP_CS|ZP_IE|ZP_PD|ZP_PDRV0|ZP_PDRV1|ZP_PU|ZP_SL
+ nfet_06v0 L=1U W=1U AS=0.25P AD=0.44P PS=1.5U PD=2.88U
M$1056 \$2469 \$2530
+ VSS|XN_CS|XN_IE|XN_PD|XN_PDRV0|XN_PDRV1|XN_PU|XN_SL|XP_CS|XP_IE|XP_PD|XP_PDRV0|XP_PDRV1|XP_PU|XP_SL|YN_CS|YN_IE|YN_PD|YN_PDRV0|YN_PDRV1|YN_PU|YN_SL|YP_CS|YP_IE|YP_PD|YP_PDRV0|YP_PDRV1|YP_PU|YP_SL|ZN_CS|ZN_IE|ZN_PD|ZN_PDRV0|ZN_PDRV1|ZN_PU|ZN_SL|ZP_CS|ZP_IE|ZP_PD|ZP_PDRV0|ZP_PDRV1|ZP_PU|ZP_SL
+ VSS|XN_CS|XN_IE|XN_PD|XN_PDRV0|XN_PDRV1|XN_PU|XN_SL|XP_CS|XP_IE|XP_PD|XP_PDRV0|XP_PDRV1|XP_PU|XP_SL|YN_CS|YN_IE|YN_PD|YN_PDRV0|YN_PDRV1|YN_PU|YN_SL|YP_CS|YP_IE|YP_PD|YP_PDRV0|YP_PDRV1|YP_PU|YP_SL|ZN_CS|ZN_IE|ZN_PD|ZN_PDRV0|ZN_PDRV1|ZN_PU|ZN_SL|ZP_CS|ZP_IE|ZP_PD|ZP_PDRV0|ZP_PDRV1|ZP_PU|ZP_SL
+ nfet_06v0 L=1U W=1U AS=0.44P AD=0.25P PS=2.88U PD=1.5U
M$1057 \$2530 \$2530 \$2469
+ VSS|XN_CS|XN_IE|XN_PD|XN_PDRV0|XN_PDRV1|XN_PU|XN_SL|XP_CS|XP_IE|XP_PD|XP_PDRV0|XP_PDRV1|XP_PU|XP_SL|YN_CS|YN_IE|YN_PD|YN_PDRV0|YN_PDRV1|YN_PU|YN_SL|YP_CS|YP_IE|YP_PD|YP_PDRV0|YP_PDRV1|YP_PU|YP_SL|ZN_CS|ZN_IE|ZN_PD|ZN_PDRV0|ZN_PDRV1|ZN_PU|ZN_SL|ZP_CS|ZP_IE|ZP_PD|ZP_PDRV0|ZP_PDRV1|ZP_PU|ZP_SL
+ nfet_06v0 L=1U W=1U AS=0.25P AD=0.44P PS=1.5U PD=2.88U
M$1058
+ VSS|XN_CS|XN_IE|XN_PD|XN_PDRV0|XN_PDRV1|XN_PU|XN_SL|XP_CS|XP_IE|XP_PD|XP_PDRV0|XP_PDRV1|XP_PU|XP_SL|YN_CS|YN_IE|YN_PD|YN_PDRV0|YN_PDRV1|YN_PU|YN_SL|YP_CS|YP_IE|YP_PD|YP_PDRV0|YP_PDRV1|YP_PU|YP_SL|ZN_CS|ZN_IE|ZN_PD|ZN_PDRV0|ZN_PDRV1|ZN_PU|ZN_SL|ZP_CS|ZP_IE|ZP_PD|ZP_PDRV0|ZP_PDRV1|ZP_PU|ZP_SL
+ VDD|XN_OE|XP_OE|YN_OE|YP_OE|ZN_OE|ZP_OE
+ VSS|XN_CS|XN_IE|XN_PD|XN_PDRV0|XN_PDRV1|XN_PU|XN_SL|XP_CS|XP_IE|XP_PD|XP_PDRV0|XP_PDRV1|XP_PU|XP_SL|YN_CS|YN_IE|YN_PD|YN_PDRV0|YN_PDRV1|YN_PU|YN_SL|YP_CS|YP_IE|YP_PD|YP_PDRV0|YP_PDRV1|YP_PU|YP_SL|ZN_CS|ZN_IE|ZN_PD|ZN_PDRV0|ZN_PDRV1|ZN_PU|ZN_SL|ZP_CS|ZP_IE|ZP_PD|ZP_PDRV0|ZP_PDRV1|ZP_PU|ZP_SL
+ VSS|XN_CS|XN_IE|XN_PD|XN_PDRV0|XN_PDRV1|XN_PU|XN_SL|XP_CS|XP_IE|XP_PD|XP_PDRV0|XP_PDRV1|XP_PU|XP_SL|YN_CS|YN_IE|YN_PD|YN_PDRV0|YN_PDRV1|YN_PU|YN_SL|YP_CS|YP_IE|YP_PD|YP_PDRV0|YP_PDRV1|YP_PU|YP_SL|ZN_CS|ZN_IE|ZN_PD|ZN_PDRV0|ZN_PDRV1|ZN_PU|ZN_SL|ZP_CS|ZP_IE|ZP_PD|ZP_PDRV0|ZP_PDRV1|ZP_PU|ZP_SL
+ nfet_06v0 L=2U W=18U AS=7.92P AD=7.92P PS=36.88U PD=36.88U
M$1059
+ VSS|XN_CS|XN_IE|XN_PD|XN_PDRV0|XN_PDRV1|XN_PU|XN_SL|XP_CS|XP_IE|XP_PD|XP_PDRV0|XP_PDRV1|XP_PU|XP_SL|YN_CS|YN_IE|YN_PD|YN_PDRV0|YN_PDRV1|YN_PU|YN_SL|YP_CS|YP_IE|YP_PD|YP_PDRV0|YP_PDRV1|YP_PU|YP_SL|ZN_CS|ZN_IE|ZN_PD|ZN_PDRV0|ZN_PDRV1|ZN_PU|ZN_SL|ZP_CS|ZP_IE|ZP_PD|ZP_PDRV0|ZP_PDRV1|ZP_PU|ZP_SL
+ VDD|XN_OE|XP_OE|YN_OE|YP_OE|ZN_OE|ZP_OE
+ VSS|XN_CS|XN_IE|XN_PD|XN_PDRV0|XN_PDRV1|XN_PU|XN_SL|XP_CS|XP_IE|XP_PD|XP_PDRV0|XP_PDRV1|XP_PU|XP_SL|YN_CS|YN_IE|YN_PD|YN_PDRV0|YN_PDRV1|YN_PU|YN_SL|YP_CS|YP_IE|YP_PD|YP_PDRV0|YP_PDRV1|YP_PU|YP_SL|ZN_CS|ZN_IE|ZN_PD|ZN_PDRV0|ZN_PDRV1|ZN_PU|ZN_SL|ZP_CS|ZP_IE|ZP_PD|ZP_PDRV0|ZP_PDRV1|ZP_PU|ZP_SL
+ VSS|XN_CS|XN_IE|XN_PD|XN_PDRV0|XN_PDRV1|XN_PU|XN_SL|XP_CS|XP_IE|XP_PD|XP_PDRV0|XP_PDRV1|XP_PU|XP_SL|YN_CS|YN_IE|YN_PD|YN_PDRV0|YN_PDRV1|YN_PU|YN_SL|YP_CS|YP_IE|YP_PD|YP_PDRV0|YP_PDRV1|YP_PU|YP_SL|ZN_CS|ZN_IE|ZN_PD|ZN_PDRV0|ZN_PDRV1|ZN_PU|ZN_SL|ZP_CS|ZP_IE|ZP_PD|ZP_PDRV0|ZP_PDRV1|ZP_PU|ZP_SL
+ nfet_06v0 L=2U W=18U AS=7.92P AD=7.92P PS=36.88U PD=36.88U
M$1060 \$2490 \$2504
+ VSS|XN_CS|XN_IE|XN_PD|XN_PDRV0|XN_PDRV1|XN_PU|XN_SL|XP_CS|XP_IE|XP_PD|XP_PDRV0|XP_PDRV1|XP_PU|XP_SL|YN_CS|YN_IE|YN_PD|YN_PDRV0|YN_PDRV1|YN_PU|YN_SL|YP_CS|YP_IE|YP_PD|YP_PDRV0|YP_PDRV1|YP_PU|YP_SL|ZN_CS|ZN_IE|ZN_PD|ZN_PDRV0|ZN_PDRV1|ZN_PU|ZN_SL|ZP_CS|ZP_IE|ZP_PD|ZP_PDRV0|ZP_PDRV1|ZP_PU|ZP_SL
+ VSS|XN_CS|XN_IE|XN_PD|XN_PDRV0|XN_PDRV1|XN_PU|XN_SL|XP_CS|XP_IE|XP_PD|XP_PDRV0|XP_PDRV1|XP_PU|XP_SL|YN_CS|YN_IE|YN_PD|YN_PDRV0|YN_PDRV1|YN_PU|YN_SL|YP_CS|YP_IE|YP_PD|YP_PDRV0|YP_PDRV1|YP_PU|YP_SL|ZN_CS|ZN_IE|ZN_PD|ZN_PDRV0|ZN_PDRV1|ZN_PU|ZN_SL|ZP_CS|ZP_IE|ZP_PD|ZP_PDRV0|ZP_PDRV1|ZP_PU|ZP_SL
+ nfet_06v0 L=1U W=5U AS=2.2P AD=1.25P PS=10.88U PD=5.5U
M$1061 \$2442 \$2505 \$2490
+ VSS|XN_CS|XN_IE|XN_PD|XN_PDRV0|XN_PDRV1|XN_PU|XN_SL|XP_CS|XP_IE|XP_PD|XP_PDRV0|XP_PDRV1|XP_PU|XP_SL|YN_CS|YN_IE|YN_PD|YN_PDRV0|YN_PDRV1|YN_PU|YN_SL|YP_CS|YP_IE|YP_PD|YP_PDRV0|YP_PDRV1|YP_PU|YP_SL|ZN_CS|ZN_IE|ZN_PD|ZN_PDRV0|ZN_PDRV1|ZN_PU|ZN_SL|ZP_CS|ZP_IE|ZP_PD|ZP_PDRV0|ZP_PDRV1|ZP_PU|ZP_SL
+ nfet_06v0 L=1U W=5U AS=1.25P AD=2.2P PS=5.5U PD=10.88U
M$1062 \$2491 \$2504
+ VSS|XN_CS|XN_IE|XN_PD|XN_PDRV0|XN_PDRV1|XN_PU|XN_SL|XP_CS|XP_IE|XP_PD|XP_PDRV0|XP_PDRV1|XP_PU|XP_SL|YN_CS|YN_IE|YN_PD|YN_PDRV0|YN_PDRV1|YN_PU|YN_SL|YP_CS|YP_IE|YP_PD|YP_PDRV0|YP_PDRV1|YP_PU|YP_SL|ZN_CS|ZN_IE|ZN_PD|ZN_PDRV0|ZN_PDRV1|ZN_PU|ZN_SL|ZP_CS|ZP_IE|ZP_PD|ZP_PDRV0|ZP_PDRV1|ZP_PU|ZP_SL
+ VSS|XN_CS|XN_IE|XN_PD|XN_PDRV0|XN_PDRV1|XN_PU|XN_SL|XP_CS|XP_IE|XP_PD|XP_PDRV0|XP_PDRV1|XP_PU|XP_SL|YN_CS|YN_IE|YN_PD|YN_PDRV0|YN_PDRV1|YN_PU|YN_SL|YP_CS|YP_IE|YP_PD|YP_PDRV0|YP_PDRV1|YP_PU|YP_SL|ZN_CS|ZN_IE|ZN_PD|ZN_PDRV0|ZN_PDRV1|ZN_PU|ZN_SL|ZP_CS|ZP_IE|ZP_PD|ZP_PDRV0|ZP_PDRV1|ZP_PU|ZP_SL
+ nfet_06v0 L=1U W=5U AS=2.2P AD=1.25P PS=10.88U PD=5.5U
M$1063 \$2442 \$2505 \$2491
+ VSS|XN_CS|XN_IE|XN_PD|XN_PDRV0|XN_PDRV1|XN_PU|XN_SL|XP_CS|XP_IE|XP_PD|XP_PDRV0|XP_PDRV1|XP_PU|XP_SL|YN_CS|YN_IE|YN_PD|YN_PDRV0|YN_PDRV1|YN_PU|YN_SL|YP_CS|YP_IE|YP_PD|YP_PDRV0|YP_PDRV1|YP_PU|YP_SL|ZN_CS|ZN_IE|ZN_PD|ZN_PDRV0|ZN_PDRV1|ZN_PU|ZN_SL|ZP_CS|ZP_IE|ZP_PD|ZP_PDRV0|ZP_PDRV1|ZP_PU|ZP_SL
+ nfet_06v0 L=1U W=5U AS=1.25P AD=2.2P PS=5.5U PD=10.88U
M$1064 \$2443 \$2549 \$2442
+ VSS|XN_CS|XN_IE|XN_PD|XN_PDRV0|XN_PDRV1|XN_PU|XN_SL|XP_CS|XP_IE|XP_PD|XP_PDRV0|XP_PDRV1|XP_PU|XP_SL|YN_CS|YN_IE|YN_PD|YN_PDRV0|YN_PDRV1|YN_PU|YN_SL|YP_CS|YP_IE|YP_PD|YP_PDRV0|YP_PDRV1|YP_PU|YP_SL|ZN_CS|ZN_IE|ZN_PD|ZN_PDRV0|ZN_PDRV1|ZN_PU|ZN_SL|ZP_CS|ZP_IE|ZP_PD|ZP_PDRV0|ZP_PDRV1|ZP_PU|ZP_SL
+ nfet_06v0 L=1U W=7.5U AS=3.3P AD=3.3P PS=15.88U PD=15.88U
M$1065 \$2444 S4N \$2442
+ VSS|XN_CS|XN_IE|XN_PD|XN_PDRV0|XN_PDRV1|XN_PU|XN_SL|XP_CS|XP_IE|XP_PD|XP_PDRV0|XP_PDRV1|XP_PU|XP_SL|YN_CS|YN_IE|YN_PD|YN_PDRV0|YN_PDRV1|YN_PU|YN_SL|YP_CS|YP_IE|YP_PD|YP_PDRV0|YP_PDRV1|YP_PU|YP_SL|ZN_CS|ZN_IE|ZN_PD|ZN_PDRV0|ZN_PDRV1|ZN_PU|ZN_SL|ZP_CS|ZP_IE|ZP_PD|ZP_PDRV0|ZP_PDRV1|ZP_PU|ZP_SL
+ nfet_06v0 L=1U W=8.5U AS=3.74P AD=3.74P PS=17.88U PD=17.88U
M$1066 \$2445 \$2479
+ VSS|XN_CS|XN_IE|XN_PD|XN_PDRV0|XN_PDRV1|XN_PU|XN_SL|XP_CS|XP_IE|XP_PD|XP_PDRV0|XP_PDRV1|XP_PU|XP_SL|YN_CS|YN_IE|YN_PD|YN_PDRV0|YN_PDRV1|YN_PU|YN_SL|YP_CS|YP_IE|YP_PD|YP_PDRV0|YP_PDRV1|YP_PU|YP_SL|ZN_CS|ZN_IE|ZN_PD|ZN_PDRV0|ZN_PDRV1|ZN_PU|ZN_SL|ZP_CS|ZP_IE|ZP_PD|ZP_PDRV0|ZP_PDRV1|ZP_PU|ZP_SL
+ VSS|XN_CS|XN_IE|XN_PD|XN_PDRV0|XN_PDRV1|XN_PU|XN_SL|XP_CS|XP_IE|XP_PD|XP_PDRV0|XP_PDRV1|XP_PU|XP_SL|YN_CS|YN_IE|YN_PD|YN_PDRV0|YN_PDRV1|YN_PU|YN_SL|YP_CS|YP_IE|YP_PD|YP_PDRV0|YP_PDRV1|YP_PU|YP_SL|ZN_CS|ZN_IE|ZN_PD|ZN_PDRV0|ZN_PDRV1|ZN_PU|ZN_SL|ZP_CS|ZP_IE|ZP_PD|ZP_PDRV0|ZP_PDRV1|ZP_PU|ZP_SL
+ nfet_06v0 L=1U W=2.5U AS=1.1P AD=0.825P PS=5.88U PD=3.16U
M$1067 \$2479 \$2505 \$2445
+ VSS|XN_CS|XN_IE|XN_PD|XN_PDRV0|XN_PDRV1|XN_PU|XN_SL|XP_CS|XP_IE|XP_PD|XP_PDRV0|XP_PDRV1|XP_PU|XP_SL|YN_CS|YN_IE|YN_PD|YN_PDRV0|YN_PDRV1|YN_PU|YN_SL|YP_CS|YP_IE|YP_PD|YP_PDRV0|YP_PDRV1|YP_PU|YP_SL|ZN_CS|ZN_IE|ZN_PD|ZN_PDRV0|ZN_PDRV1|ZN_PU|ZN_SL|ZP_CS|ZP_IE|ZP_PD|ZP_PDRV0|ZP_PDRV1|ZP_PU|ZP_SL
+ nfet_06v0 L=1U W=2.5U AS=0.825P AD=1.1P PS=3.16U PD=5.88U
M$1068 \$2518 \$2479
+ VSS|XN_CS|XN_IE|XN_PD|XN_PDRV0|XN_PDRV1|XN_PU|XN_SL|XP_CS|XP_IE|XP_PD|XP_PDRV0|XP_PDRV1|XP_PU|XP_SL|YN_CS|YN_IE|YN_PD|YN_PDRV0|YN_PDRV1|YN_PU|YN_SL|YP_CS|YP_IE|YP_PD|YP_PDRV0|YP_PDRV1|YP_PU|YP_SL|ZN_CS|ZN_IE|ZN_PD|ZN_PDRV0|ZN_PDRV1|ZN_PU|ZN_SL|ZP_CS|ZP_IE|ZP_PD|ZP_PDRV0|ZP_PDRV1|ZP_PU|ZP_SL
+ VSS|XN_CS|XN_IE|XN_PD|XN_PDRV0|XN_PDRV1|XN_PU|XN_SL|XP_CS|XP_IE|XP_PD|XP_PDRV0|XP_PDRV1|XP_PU|XP_SL|YN_CS|YN_IE|YN_PD|YN_PDRV0|YN_PDRV1|YN_PU|YN_SL|YP_CS|YP_IE|YP_PD|YP_PDRV0|YP_PDRV1|YP_PU|YP_SL|ZN_CS|ZN_IE|ZN_PD|ZN_PDRV0|ZN_PDRV1|ZN_PU|ZN_SL|ZP_CS|ZP_IE|ZP_PD|ZP_PDRV0|ZP_PDRV1|ZP_PU|ZP_SL
+ nfet_06v0 L=1U W=2.5U AS=1.1P AD=0.825P PS=5.88U PD=3.16U
M$1069 \$2446 \$2505 \$2518
+ VSS|XN_CS|XN_IE|XN_PD|XN_PDRV0|XN_PDRV1|XN_PU|XN_SL|XP_CS|XP_IE|XP_PD|XP_PDRV0|XP_PDRV1|XP_PU|XP_SL|YN_CS|YN_IE|YN_PD|YN_PDRV0|YN_PDRV1|YN_PU|YN_SL|YP_CS|YP_IE|YP_PD|YP_PDRV0|YP_PDRV1|YP_PU|YP_SL|ZN_CS|ZN_IE|ZN_PD|ZN_PDRV0|ZN_PDRV1|ZN_PU|ZN_SL|ZP_CS|ZP_IE|ZP_PD|ZP_PDRV0|ZP_PDRV1|ZP_PU|ZP_SL
+ nfet_06v0 L=1U W=2.5U AS=0.825P AD=1.1P PS=3.16U PD=5.88U
M$1070 \$2550 \$2475 \$2479
+ VSS|XN_CS|XN_IE|XN_PD|XN_PDRV0|XN_PDRV1|XN_PU|XN_SL|XP_CS|XP_IE|XP_PD|XP_PDRV0|XP_PDRV1|XP_PU|XP_SL|YN_CS|YN_IE|YN_PD|YN_PDRV0|YN_PDRV1|YN_PU|YN_SL|YP_CS|YP_IE|YP_PD|YP_PDRV0|YP_PDRV1|YP_PU|YP_SL|ZN_CS|ZN_IE|ZN_PD|ZN_PDRV0|ZN_PDRV1|ZN_PU|ZN_SL|ZP_CS|ZP_IE|ZP_PD|ZP_PDRV0|ZP_PDRV1|ZP_PU|ZP_SL
+ nfet_06v0 L=1U W=2U AS=0.88P AD=0.88P PS=4.88U PD=4.88U
M$1071 \$2533 \$2475 \$2446
+ VSS|XN_CS|XN_IE|XN_PD|XN_PDRV0|XN_PDRV1|XN_PU|XN_SL|XP_CS|XP_IE|XP_PD|XP_PDRV0|XP_PDRV1|XP_PU|XP_SL|YN_CS|YN_IE|YN_PD|YN_PDRV0|YN_PDRV1|YN_PU|YN_SL|YP_CS|YP_IE|YP_PD|YP_PDRV0|YP_PDRV1|YP_PU|YP_SL|ZN_CS|ZN_IE|ZN_PD|ZN_PDRV0|ZN_PDRV1|ZN_PU|ZN_SL|ZP_CS|ZP_IE|ZP_PD|ZP_PDRV0|ZP_PDRV1|ZP_PU|ZP_SL
+ nfet_06v0 L=1U W=2U AS=0.88P AD=0.88P PS=4.88U PD=4.88U
M$1072 \$2492 \$2504
+ VSS|XN_CS|XN_IE|XN_PD|XN_PDRV0|XN_PDRV1|XN_PU|XN_SL|XP_CS|XP_IE|XP_PD|XP_PDRV0|XP_PDRV1|XP_PU|XP_SL|YN_CS|YN_IE|YN_PD|YN_PDRV0|YN_PDRV1|YN_PU|YN_SL|YP_CS|YP_IE|YP_PD|YP_PDRV0|YP_PDRV1|YP_PU|YP_SL|ZN_CS|ZN_IE|ZN_PD|ZN_PDRV0|ZN_PDRV1|ZN_PU|ZN_SL|ZP_CS|ZP_IE|ZP_PD|ZP_PDRV0|ZP_PDRV1|ZP_PU|ZP_SL
+ VSS|XN_CS|XN_IE|XN_PD|XN_PDRV0|XN_PDRV1|XN_PU|XN_SL|XP_CS|XP_IE|XP_PD|XP_PDRV0|XP_PDRV1|XP_PU|XP_SL|YN_CS|YN_IE|YN_PD|YN_PDRV0|YN_PDRV1|YN_PU|YN_SL|YP_CS|YP_IE|YP_PD|YP_PDRV0|YP_PDRV1|YP_PU|YP_SL|ZN_CS|ZN_IE|ZN_PD|ZN_PDRV0|ZN_PDRV1|ZN_PU|ZN_SL|ZP_CS|ZP_IE|ZP_PD|ZP_PDRV0|ZP_PDRV1|ZP_PU|ZP_SL
+ nfet_06v0 L=1U W=5U AS=2.2P AD=1.25P PS=10.88U PD=5.5U
M$1073 \$2447 \$2505 \$2492
+ VSS|XN_CS|XN_IE|XN_PD|XN_PDRV0|XN_PDRV1|XN_PU|XN_SL|XP_CS|XP_IE|XP_PD|XP_PDRV0|XP_PDRV1|XP_PU|XP_SL|YN_CS|YN_IE|YN_PD|YN_PDRV0|YN_PDRV1|YN_PU|YN_SL|YP_CS|YP_IE|YP_PD|YP_PDRV0|YP_PDRV1|YP_PU|YP_SL|ZN_CS|ZN_IE|ZN_PD|ZN_PDRV0|ZN_PDRV1|ZN_PU|ZN_SL|ZP_CS|ZP_IE|ZP_PD|ZP_PDRV0|ZP_PDRV1|ZP_PU|ZP_SL
+ nfet_06v0 L=1U W=5U AS=1.25P AD=2.2P PS=5.5U PD=10.88U
M$1074 \$2493 \$2448
+ VSS|XN_CS|XN_IE|XN_PD|XN_PDRV0|XN_PDRV1|XN_PU|XN_SL|XP_CS|XP_IE|XP_PD|XP_PDRV0|XP_PDRV1|XP_PU|XP_SL|YN_CS|YN_IE|YN_PD|YN_PDRV0|YN_PDRV1|YN_PU|YN_SL|YP_CS|YP_IE|YP_PD|YP_PDRV0|YP_PDRV1|YP_PU|YP_SL|ZN_CS|ZN_IE|ZN_PD|ZN_PDRV0|ZN_PDRV1|ZN_PU|ZN_SL|ZP_CS|ZP_IE|ZP_PD|ZP_PDRV0|ZP_PDRV1|ZP_PU|ZP_SL
+ VSS|XN_CS|XN_IE|XN_PD|XN_PDRV0|XN_PDRV1|XN_PU|XN_SL|XP_CS|XP_IE|XP_PD|XP_PDRV0|XP_PDRV1|XP_PU|XP_SL|YN_CS|YN_IE|YN_PD|YN_PDRV0|YN_PDRV1|YN_PU|YN_SL|YP_CS|YP_IE|YP_PD|YP_PDRV0|YP_PDRV1|YP_PU|YP_SL|ZN_CS|ZN_IE|ZN_PD|ZN_PDRV0|ZN_PDRV1|ZN_PU|ZN_SL|ZP_CS|ZP_IE|ZP_PD|ZP_PDRV0|ZP_PDRV1|ZP_PU|ZP_SL
+ nfet_06v0 L=1U W=5U AS=2.2P AD=1.25P PS=10.88U PD=5.5U
M$1075 \$2448 \$2505 \$2493
+ VSS|XN_CS|XN_IE|XN_PD|XN_PDRV0|XN_PDRV1|XN_PU|XN_SL|XP_CS|XP_IE|XP_PD|XP_PDRV0|XP_PDRV1|XP_PU|XP_SL|YN_CS|YN_IE|YN_PD|YN_PDRV0|YN_PDRV1|YN_PU|YN_SL|YP_CS|YP_IE|YP_PD|YP_PDRV0|YP_PDRV1|YP_PU|YP_SL|ZN_CS|ZN_IE|ZN_PD|ZN_PDRV0|ZN_PDRV1|ZN_PU|ZN_SL|ZP_CS|ZP_IE|ZP_PD|ZP_PDRV0|ZP_PDRV1|ZP_PU|ZP_SL
+ nfet_06v0 L=1U W=5U AS=1.25P AD=1.65P PS=5.5U PD=5.66U
M$1076 \$2475 \$2475 \$2448
+ VSS|XN_CS|XN_IE|XN_PD|XN_PDRV0|XN_PDRV1|XN_PU|XN_SL|XP_CS|XP_IE|XP_PD|XP_PDRV0|XP_PDRV1|XP_PU|XP_SL|YN_CS|YN_IE|YN_PD|YN_PDRV0|YN_PDRV1|YN_PU|YN_SL|YP_CS|YP_IE|YP_PD|YP_PDRV0|YP_PDRV1|YP_PU|YP_SL|ZN_CS|ZN_IE|ZN_PD|ZN_PDRV0|ZN_PDRV1|ZN_PU|ZN_SL|ZP_CS|ZP_IE|ZP_PD|ZP_PDRV0|ZP_PDRV1|ZP_PU|ZP_SL
+ nfet_06v0 L=1U W=5U AS=1.65P AD=2.2P PS=5.66U PD=10.88U
M$1077 \$2449 \$2446
+ VSS|XN_CS|XN_IE|XN_PD|XN_PDRV0|XN_PDRV1|XN_PU|XN_SL|XP_CS|XP_IE|XP_PD|XP_PDRV0|XP_PDRV1|XP_PU|XP_SL|YN_CS|YN_IE|YN_PD|YN_PDRV0|YN_PDRV1|YN_PU|YN_SL|YP_CS|YP_IE|YP_PD|YP_PDRV0|YP_PDRV1|YP_PU|YP_SL|ZN_CS|ZN_IE|ZN_PD|ZN_PDRV0|ZN_PDRV1|ZN_PU|ZN_SL|ZP_CS|ZP_IE|ZP_PD|ZP_PDRV0|ZP_PDRV1|ZP_PU|ZP_SL
+ VSS|XN_CS|XN_IE|XN_PD|XN_PDRV0|XN_PDRV1|XN_PU|XN_SL|XP_CS|XP_IE|XP_PD|XP_PDRV0|XP_PDRV1|XP_PU|XP_SL|YN_CS|YN_IE|YN_PD|YN_PDRV0|YN_PDRV1|YN_PU|YN_SL|YP_CS|YP_IE|YP_PD|YP_PDRV0|YP_PDRV1|YP_PU|YP_SL|ZN_CS|ZN_IE|ZN_PD|ZN_PDRV0|ZN_PDRV1|ZN_PU|ZN_SL|ZP_CS|ZP_IE|ZP_PD|ZP_PDRV0|ZP_PDRV1|ZP_PU|ZP_SL
+ nfet_06v0 L=1U W=1U AS=0.44P AD=0.44P PS=2.88U PD=2.88U
M$1078 \$2505 \$2505
+ VSS|XN_CS|XN_IE|XN_PD|XN_PDRV0|XN_PDRV1|XN_PU|XN_SL|XP_CS|XP_IE|XP_PD|XP_PDRV0|XP_PDRV1|XP_PU|XP_SL|YN_CS|YN_IE|YN_PD|YN_PDRV0|YN_PDRV1|YN_PU|YN_SL|YP_CS|YP_IE|YP_PD|YP_PDRV0|YP_PDRV1|YP_PU|YP_SL|ZN_CS|ZN_IE|ZN_PD|ZN_PDRV0|ZN_PDRV1|ZN_PU|ZN_SL|ZP_CS|ZP_IE|ZP_PD|ZP_PDRV0|ZP_PDRV1|ZP_PU|ZP_SL
+ VSS|XN_CS|XN_IE|XN_PD|XN_PDRV0|XN_PDRV1|XN_PU|XN_SL|XP_CS|XP_IE|XP_PD|XP_PDRV0|XP_PDRV1|XP_PU|XP_SL|YN_CS|YN_IE|YN_PD|YN_PDRV0|YN_PDRV1|YN_PU|YN_SL|YP_CS|YP_IE|YP_PD|YP_PDRV0|YP_PDRV1|YP_PU|YP_SL|ZN_CS|ZN_IE|ZN_PD|ZN_PDRV0|ZN_PDRV1|ZN_PU|ZN_SL|ZP_CS|ZP_IE|ZP_PD|ZP_PDRV0|ZP_PDRV1|ZP_PU|ZP_SL
+ nfet_06v0 L=1U W=1U AS=0.44P AD=0.44P PS=2.88U PD=2.88U
M$1079 \$2495 \$2504
+ VSS|XN_CS|XN_IE|XN_PD|XN_PDRV0|XN_PDRV1|XN_PU|XN_SL|XP_CS|XP_IE|XP_PD|XP_PDRV0|XP_PDRV1|XP_PU|XP_SL|YN_CS|YN_IE|YN_PD|YN_PDRV0|YN_PDRV1|YN_PU|YN_SL|YP_CS|YP_IE|YP_PD|YP_PDRV0|YP_PDRV1|YP_PU|YP_SL|ZN_CS|ZN_IE|ZN_PD|ZN_PDRV0|ZN_PDRV1|ZN_PU|ZN_SL|ZP_CS|ZP_IE|ZP_PD|ZP_PDRV0|ZP_PDRV1|ZP_PU|ZP_SL
+ VSS|XN_CS|XN_IE|XN_PD|XN_PDRV0|XN_PDRV1|XN_PU|XN_SL|XP_CS|XP_IE|XP_PD|XP_PDRV0|XP_PDRV1|XP_PU|XP_SL|YN_CS|YN_IE|YN_PD|YN_PDRV0|YN_PDRV1|YN_PU|YN_SL|YP_CS|YP_IE|YP_PD|YP_PDRV0|YP_PDRV1|YP_PU|YP_SL|ZN_CS|ZN_IE|ZN_PD|ZN_PDRV0|ZN_PDRV1|ZN_PU|ZN_SL|ZP_CS|ZP_IE|ZP_PD|ZP_PDRV0|ZP_PDRV1|ZP_PU|ZP_SL
+ nfet_06v0 L=1U W=5U AS=2.2P AD=1.25P PS=10.88U PD=5.5U
M$1080 \$2504 \$2505 \$2495
+ VSS|XN_CS|XN_IE|XN_PD|XN_PDRV0|XN_PDRV1|XN_PU|XN_SL|XP_CS|XP_IE|XP_PD|XP_PDRV0|XP_PDRV1|XP_PU|XP_SL|YN_CS|YN_IE|YN_PD|YN_PDRV0|YN_PDRV1|YN_PU|YN_SL|YP_CS|YP_IE|YP_PD|YP_PDRV0|YP_PDRV1|YP_PU|YP_SL|ZN_CS|ZN_IE|ZN_PD|ZN_PDRV0|ZN_PDRV1|ZN_PU|ZN_SL|ZP_CS|ZP_IE|ZP_PD|ZP_PDRV0|ZP_PDRV1|ZP_PU|ZP_SL
+ nfet_06v0 L=1U W=5U AS=1.25P AD=2.2P PS=5.5U PD=10.88U
M$1081 \$2470 \$2532
+ VSS|XN_CS|XN_IE|XN_PD|XN_PDRV0|XN_PDRV1|XN_PU|XN_SL|XP_CS|XP_IE|XP_PD|XP_PDRV0|XP_PDRV1|XP_PU|XP_SL|YN_CS|YN_IE|YN_PD|YN_PDRV0|YN_PDRV1|YN_PU|YN_SL|YP_CS|YP_IE|YP_PD|YP_PDRV0|YP_PDRV1|YP_PU|YP_SL|ZN_CS|ZN_IE|ZN_PD|ZN_PDRV0|ZN_PDRV1|ZN_PU|ZN_SL|ZP_CS|ZP_IE|ZP_PD|ZP_PDRV0|ZP_PDRV1|ZP_PU|ZP_SL
+ VSS|XN_CS|XN_IE|XN_PD|XN_PDRV0|XN_PDRV1|XN_PU|XN_SL|XP_CS|XP_IE|XP_PD|XP_PDRV0|XP_PDRV1|XP_PU|XP_SL|YN_CS|YN_IE|YN_PD|YN_PDRV0|YN_PDRV1|YN_PU|YN_SL|YP_CS|YP_IE|YP_PD|YP_PDRV0|YP_PDRV1|YP_PU|YP_SL|ZN_CS|ZN_IE|ZN_PD|ZN_PDRV0|ZN_PDRV1|ZN_PU|ZN_SL|ZP_CS|ZP_IE|ZP_PD|ZP_PDRV0|ZP_PDRV1|ZP_PU|ZP_SL
+ nfet_06v0 L=1U W=1U AS=0.44P AD=0.25P PS=2.88U PD=1.5U
M$1082 \$2511 \$2532 \$2470
+ VSS|XN_CS|XN_IE|XN_PD|XN_PDRV0|XN_PDRV1|XN_PU|XN_SL|XP_CS|XP_IE|XP_PD|XP_PDRV0|XP_PDRV1|XP_PU|XP_SL|YN_CS|YN_IE|YN_PD|YN_PDRV0|YN_PDRV1|YN_PU|YN_SL|YP_CS|YP_IE|YP_PD|YP_PDRV0|YP_PDRV1|YP_PU|YP_SL|ZN_CS|ZN_IE|ZN_PD|ZN_PDRV0|ZN_PDRV1|ZN_PU|ZN_SL|ZP_CS|ZP_IE|ZP_PD|ZP_PDRV0|ZP_PDRV1|ZP_PU|ZP_SL
+ nfet_06v0 L=1U W=1U AS=0.25P AD=0.44P PS=1.5U PD=2.88U
M$1083 \$2471 \$2532
+ VSS|XN_CS|XN_IE|XN_PD|XN_PDRV0|XN_PDRV1|XN_PU|XN_SL|XP_CS|XP_IE|XP_PD|XP_PDRV0|XP_PDRV1|XP_PU|XP_SL|YN_CS|YN_IE|YN_PD|YN_PDRV0|YN_PDRV1|YN_PU|YN_SL|YP_CS|YP_IE|YP_PD|YP_PDRV0|YP_PDRV1|YP_PU|YP_SL|ZN_CS|ZN_IE|ZN_PD|ZN_PDRV0|ZN_PDRV1|ZN_PU|ZN_SL|ZP_CS|ZP_IE|ZP_PD|ZP_PDRV0|ZP_PDRV1|ZP_PU|ZP_SL
+ VSS|XN_CS|XN_IE|XN_PD|XN_PDRV0|XN_PDRV1|XN_PU|XN_SL|XP_CS|XP_IE|XP_PD|XP_PDRV0|XP_PDRV1|XP_PU|XP_SL|YN_CS|YN_IE|YN_PD|YN_PDRV0|YN_PDRV1|YN_PU|YN_SL|YP_CS|YP_IE|YP_PD|YP_PDRV0|YP_PDRV1|YP_PU|YP_SL|ZN_CS|ZN_IE|ZN_PD|ZN_PDRV0|ZN_PDRV1|ZN_PU|ZN_SL|ZP_CS|ZP_IE|ZP_PD|ZP_PDRV0|ZP_PDRV1|ZP_PU|ZP_SL
+ nfet_06v0 L=1U W=1U AS=0.44P AD=0.25P PS=2.88U PD=1.5U
M$1084 \$2532 \$2532 \$2471
+ VSS|XN_CS|XN_IE|XN_PD|XN_PDRV0|XN_PDRV1|XN_PU|XN_SL|XP_CS|XP_IE|XP_PD|XP_PDRV0|XP_PDRV1|XP_PU|XP_SL|YN_CS|YN_IE|YN_PD|YN_PDRV0|YN_PDRV1|YN_PU|YN_SL|YP_CS|YP_IE|YP_PD|YP_PDRV0|YP_PDRV1|YP_PU|YP_SL|ZN_CS|ZN_IE|ZN_PD|ZN_PDRV0|ZN_PDRV1|ZN_PU|ZN_SL|ZP_CS|ZP_IE|ZP_PD|ZP_PDRV0|ZP_PDRV1|ZP_PU|ZP_SL
+ nfet_06v0 L=1U W=1U AS=0.25P AD=0.44P PS=1.5U PD=2.88U
M$1085
+ VSS|XN_CS|XN_IE|XN_PD|XN_PDRV0|XN_PDRV1|XN_PU|XN_SL|XP_CS|XP_IE|XP_PD|XP_PDRV0|XP_PDRV1|XP_PU|XP_SL|YN_CS|YN_IE|YN_PD|YN_PDRV0|YN_PDRV1|YN_PU|YN_SL|YP_CS|YP_IE|YP_PD|YP_PDRV0|YP_PDRV1|YP_PU|YP_SL|ZN_CS|ZN_IE|ZN_PD|ZN_PDRV0|ZN_PDRV1|ZN_PU|ZN_SL|ZP_CS|ZP_IE|ZP_PD|ZP_PDRV0|ZP_PDRV1|ZP_PU|ZP_SL
+ VDD|XN_OE|XP_OE|YN_OE|YP_OE|ZN_OE|ZP_OE
+ VSS|XN_CS|XN_IE|XN_PD|XN_PDRV0|XN_PDRV1|XN_PU|XN_SL|XP_CS|XP_IE|XP_PD|XP_PDRV0|XP_PDRV1|XP_PU|XP_SL|YN_CS|YN_IE|YN_PD|YN_PDRV0|YN_PDRV1|YN_PU|YN_SL|YP_CS|YP_IE|YP_PD|YP_PDRV0|YP_PDRV1|YP_PU|YP_SL|ZN_CS|ZN_IE|ZN_PD|ZN_PDRV0|ZN_PDRV1|ZN_PU|ZN_SL|ZP_CS|ZP_IE|ZP_PD|ZP_PDRV0|ZP_PDRV1|ZP_PU|ZP_SL
+ VSS|XN_CS|XN_IE|XN_PD|XN_PDRV0|XN_PDRV1|XN_PU|XN_SL|XP_CS|XP_IE|XP_PD|XP_PDRV0|XP_PDRV1|XP_PU|XP_SL|YN_CS|YN_IE|YN_PD|YN_PDRV0|YN_PDRV1|YN_PU|YN_SL|YP_CS|YP_IE|YP_PD|YP_PDRV0|YP_PDRV1|YP_PU|YP_SL|ZN_CS|ZN_IE|ZN_PD|ZN_PDRV0|ZN_PDRV1|ZN_PU|ZN_SL|ZP_CS|ZP_IE|ZP_PD|ZP_PDRV0|ZP_PDRV1|ZP_PU|ZP_SL
+ nfet_06v0 L=2U W=18U AS=7.92P AD=7.92P PS=36.88U PD=36.88U
M$1086
+ VSS|XN_CS|XN_IE|XN_PD|XN_PDRV0|XN_PDRV1|XN_PU|XN_SL|XP_CS|XP_IE|XP_PD|XP_PDRV0|XP_PDRV1|XP_PU|XP_SL|YN_CS|YN_IE|YN_PD|YN_PDRV0|YN_PDRV1|YN_PU|YN_SL|YP_CS|YP_IE|YP_PD|YP_PDRV0|YP_PDRV1|YP_PU|YP_SL|ZN_CS|ZN_IE|ZN_PD|ZN_PDRV0|ZN_PDRV1|ZN_PU|ZN_SL|ZP_CS|ZP_IE|ZP_PD|ZP_PDRV0|ZP_PDRV1|ZP_PU|ZP_SL
+ VDD|XN_OE|XP_OE|YN_OE|YP_OE|ZN_OE|ZP_OE
+ VSS|XN_CS|XN_IE|XN_PD|XN_PDRV0|XN_PDRV1|XN_PU|XN_SL|XP_CS|XP_IE|XP_PD|XP_PDRV0|XP_PDRV1|XP_PU|XP_SL|YN_CS|YN_IE|YN_PD|YN_PDRV0|YN_PDRV1|YN_PU|YN_SL|YP_CS|YP_IE|YP_PD|YP_PDRV0|YP_PDRV1|YP_PU|YP_SL|ZN_CS|ZN_IE|ZN_PD|ZN_PDRV0|ZN_PDRV1|ZN_PU|ZN_SL|ZP_CS|ZP_IE|ZP_PD|ZP_PDRV0|ZP_PDRV1|ZP_PU|ZP_SL
+ VSS|XN_CS|XN_IE|XN_PD|XN_PDRV0|XN_PDRV1|XN_PU|XN_SL|XP_CS|XP_IE|XP_PD|XP_PDRV0|XP_PDRV1|XP_PU|XP_SL|YN_CS|YN_IE|YN_PD|YN_PDRV0|YN_PDRV1|YN_PU|YN_SL|YP_CS|YP_IE|YP_PD|YP_PDRV0|YP_PDRV1|YP_PU|YP_SL|ZN_CS|ZN_IE|ZN_PD|ZN_PDRV0|ZN_PDRV1|ZN_PU|ZN_SL|ZP_CS|ZP_IE|ZP_PD|ZP_PDRV0|ZP_PDRV1|ZP_PU|ZP_SL
+ nfet_06v0 L=2U W=18U AS=7.92P AD=7.92P PS=36.88U PD=36.88U
M$1087 \$2497 \$2506
+ VSS|XN_CS|XN_IE|XN_PD|XN_PDRV0|XN_PDRV1|XN_PU|XN_SL|XP_CS|XP_IE|XP_PD|XP_PDRV0|XP_PDRV1|XP_PU|XP_SL|YN_CS|YN_IE|YN_PD|YN_PDRV0|YN_PDRV1|YN_PU|YN_SL|YP_CS|YP_IE|YP_PD|YP_PDRV0|YP_PDRV1|YP_PU|YP_SL|ZN_CS|ZN_IE|ZN_PD|ZN_PDRV0|ZN_PDRV1|ZN_PU|ZN_SL|ZP_CS|ZP_IE|ZP_PD|ZP_PDRV0|ZP_PDRV1|ZP_PU|ZP_SL
+ VSS|XN_CS|XN_IE|XN_PD|XN_PDRV0|XN_PDRV1|XN_PU|XN_SL|XP_CS|XP_IE|XP_PD|XP_PDRV0|XP_PDRV1|XP_PU|XP_SL|YN_CS|YN_IE|YN_PD|YN_PDRV0|YN_PDRV1|YN_PU|YN_SL|YP_CS|YP_IE|YP_PD|YP_PDRV0|YP_PDRV1|YP_PU|YP_SL|ZN_CS|ZN_IE|ZN_PD|ZN_PDRV0|ZN_PDRV1|ZN_PU|ZN_SL|ZP_CS|ZP_IE|ZP_PD|ZP_PDRV0|ZP_PDRV1|ZP_PU|ZP_SL
+ nfet_06v0 L=1U W=5U AS=2.2P AD=1.25P PS=10.88U PD=5.5U
M$1088 \$2450 \$2507 \$2497
+ VSS|XN_CS|XN_IE|XN_PD|XN_PDRV0|XN_PDRV1|XN_PU|XN_SL|XP_CS|XP_IE|XP_PD|XP_PDRV0|XP_PDRV1|XP_PU|XP_SL|YN_CS|YN_IE|YN_PD|YN_PDRV0|YN_PDRV1|YN_PU|YN_SL|YP_CS|YP_IE|YP_PD|YP_PDRV0|YP_PDRV1|YP_PU|YP_SL|ZN_CS|ZN_IE|ZN_PD|ZN_PDRV0|ZN_PDRV1|ZN_PU|ZN_SL|ZP_CS|ZP_IE|ZP_PD|ZP_PDRV0|ZP_PDRV1|ZP_PU|ZP_SL
+ nfet_06v0 L=1U W=5U AS=1.25P AD=2.2P PS=5.5U PD=10.88U
M$1089 \$2498 \$2506
+ VSS|XN_CS|XN_IE|XN_PD|XN_PDRV0|XN_PDRV1|XN_PU|XN_SL|XP_CS|XP_IE|XP_PD|XP_PDRV0|XP_PDRV1|XP_PU|XP_SL|YN_CS|YN_IE|YN_PD|YN_PDRV0|YN_PDRV1|YN_PU|YN_SL|YP_CS|YP_IE|YP_PD|YP_PDRV0|YP_PDRV1|YP_PU|YP_SL|ZN_CS|ZN_IE|ZN_PD|ZN_PDRV0|ZN_PDRV1|ZN_PU|ZN_SL|ZP_CS|ZP_IE|ZP_PD|ZP_PDRV0|ZP_PDRV1|ZP_PU|ZP_SL
+ VSS|XN_CS|XN_IE|XN_PD|XN_PDRV0|XN_PDRV1|XN_PU|XN_SL|XP_CS|XP_IE|XP_PD|XP_PDRV0|XP_PDRV1|XP_PU|XP_SL|YN_CS|YN_IE|YN_PD|YN_PDRV0|YN_PDRV1|YN_PU|YN_SL|YP_CS|YP_IE|YP_PD|YP_PDRV0|YP_PDRV1|YP_PU|YP_SL|ZN_CS|ZN_IE|ZN_PD|ZN_PDRV0|ZN_PDRV1|ZN_PU|ZN_SL|ZP_CS|ZP_IE|ZP_PD|ZP_PDRV0|ZP_PDRV1|ZP_PU|ZP_SL
+ nfet_06v0 L=1U W=5U AS=2.2P AD=1.25P PS=10.88U PD=5.5U
M$1090 \$2450 \$2507 \$2498
+ VSS|XN_CS|XN_IE|XN_PD|XN_PDRV0|XN_PDRV1|XN_PU|XN_SL|XP_CS|XP_IE|XP_PD|XP_PDRV0|XP_PDRV1|XP_PU|XP_SL|YN_CS|YN_IE|YN_PD|YN_PDRV0|YN_PDRV1|YN_PU|YN_SL|YP_CS|YP_IE|YP_PD|YP_PDRV0|YP_PDRV1|YP_PU|YP_SL|ZN_CS|ZN_IE|ZN_PD|ZN_PDRV0|ZN_PDRV1|ZN_PU|ZN_SL|ZP_CS|ZP_IE|ZP_PD|ZP_PDRV0|ZP_PDRV1|ZP_PU|ZP_SL
+ nfet_06v0 L=1U W=5U AS=1.25P AD=2.2P PS=5.5U PD=10.88U
M$1091 \$2451 S4P \$2450
+ VSS|XN_CS|XN_IE|XN_PD|XN_PDRV0|XN_PDRV1|XN_PU|XN_SL|XP_CS|XP_IE|XP_PD|XP_PDRV0|XP_PDRV1|XP_PU|XP_SL|YN_CS|YN_IE|YN_PD|YN_PDRV0|YN_PDRV1|YN_PU|YN_SL|YP_CS|YP_IE|YP_PD|YP_PDRV0|YP_PDRV1|YP_PU|YP_SL|ZN_CS|ZN_IE|ZN_PD|ZN_PDRV0|ZN_PDRV1|ZN_PU|ZN_SL|ZP_CS|ZP_IE|ZP_PD|ZP_PDRV0|ZP_PDRV1|ZP_PU|ZP_SL
+ nfet_06v0 L=1U W=7.5U AS=3.3P AD=3.3P PS=15.88U PD=15.88U
M$1092 \$2452 S4N \$2450
+ VSS|XN_CS|XN_IE|XN_PD|XN_PDRV0|XN_PDRV1|XN_PU|XN_SL|XP_CS|XP_IE|XP_PD|XP_PDRV0|XP_PDRV1|XP_PU|XP_SL|YN_CS|YN_IE|YN_PD|YN_PDRV0|YN_PDRV1|YN_PU|YN_SL|YP_CS|YP_IE|YP_PD|YP_PDRV0|YP_PDRV1|YP_PU|YP_SL|ZN_CS|ZN_IE|ZN_PD|ZN_PDRV0|ZN_PDRV1|ZN_PU|ZN_SL|ZP_CS|ZP_IE|ZP_PD|ZP_PDRV0|ZP_PDRV1|ZP_PU|ZP_SL
+ nfet_06v0 L=1U W=8.5U AS=3.74P AD=3.74P PS=17.88U PD=17.88U
M$1093 \$2453 \$2480
+ VSS|XN_CS|XN_IE|XN_PD|XN_PDRV0|XN_PDRV1|XN_PU|XN_SL|XP_CS|XP_IE|XP_PD|XP_PDRV0|XP_PDRV1|XP_PU|XP_SL|YN_CS|YN_IE|YN_PD|YN_PDRV0|YN_PDRV1|YN_PU|YN_SL|YP_CS|YP_IE|YP_PD|YP_PDRV0|YP_PDRV1|YP_PU|YP_SL|ZN_CS|ZN_IE|ZN_PD|ZN_PDRV0|ZN_PDRV1|ZN_PU|ZN_SL|ZP_CS|ZP_IE|ZP_PD|ZP_PDRV0|ZP_PDRV1|ZP_PU|ZP_SL
+ VSS|XN_CS|XN_IE|XN_PD|XN_PDRV0|XN_PDRV1|XN_PU|XN_SL|XP_CS|XP_IE|XP_PD|XP_PDRV0|XP_PDRV1|XP_PU|XP_SL|YN_CS|YN_IE|YN_PD|YN_PDRV0|YN_PDRV1|YN_PU|YN_SL|YP_CS|YP_IE|YP_PD|YP_PDRV0|YP_PDRV1|YP_PU|YP_SL|ZN_CS|ZN_IE|ZN_PD|ZN_PDRV0|ZN_PDRV1|ZN_PU|ZN_SL|ZP_CS|ZP_IE|ZP_PD|ZP_PDRV0|ZP_PDRV1|ZP_PU|ZP_SL
+ nfet_06v0 L=1U W=2.5U AS=1.1P AD=0.825P PS=5.88U PD=3.16U
M$1094 \$2480 \$2507 \$2453
+ VSS|XN_CS|XN_IE|XN_PD|XN_PDRV0|XN_PDRV1|XN_PU|XN_SL|XP_CS|XP_IE|XP_PD|XP_PDRV0|XP_PDRV1|XP_PU|XP_SL|YN_CS|YN_IE|YN_PD|YN_PDRV0|YN_PDRV1|YN_PU|YN_SL|YP_CS|YP_IE|YP_PD|YP_PDRV0|YP_PDRV1|YP_PU|YP_SL|ZN_CS|ZN_IE|ZN_PD|ZN_PDRV0|ZN_PDRV1|ZN_PU|ZN_SL|ZP_CS|ZP_IE|ZP_PD|ZP_PDRV0|ZP_PDRV1|ZP_PU|ZP_SL
+ nfet_06v0 L=1U W=2.5U AS=0.825P AD=1.1P PS=3.16U PD=5.88U
M$1095 \$2522 \$2480
+ VSS|XN_CS|XN_IE|XN_PD|XN_PDRV0|XN_PDRV1|XN_PU|XN_SL|XP_CS|XP_IE|XP_PD|XP_PDRV0|XP_PDRV1|XP_PU|XP_SL|YN_CS|YN_IE|YN_PD|YN_PDRV0|YN_PDRV1|YN_PU|YN_SL|YP_CS|YP_IE|YP_PD|YP_PDRV0|YP_PDRV1|YP_PU|YP_SL|ZN_CS|ZN_IE|ZN_PD|ZN_PDRV0|ZN_PDRV1|ZN_PU|ZN_SL|ZP_CS|ZP_IE|ZP_PD|ZP_PDRV0|ZP_PDRV1|ZP_PU|ZP_SL
+ VSS|XN_CS|XN_IE|XN_PD|XN_PDRV0|XN_PDRV1|XN_PU|XN_SL|XP_CS|XP_IE|XP_PD|XP_PDRV0|XP_PDRV1|XP_PU|XP_SL|YN_CS|YN_IE|YN_PD|YN_PDRV0|YN_PDRV1|YN_PU|YN_SL|YP_CS|YP_IE|YP_PD|YP_PDRV0|YP_PDRV1|YP_PU|YP_SL|ZN_CS|ZN_IE|ZN_PD|ZN_PDRV0|ZN_PDRV1|ZN_PU|ZN_SL|ZP_CS|ZP_IE|ZP_PD|ZP_PDRV0|ZP_PDRV1|ZP_PU|ZP_SL
+ nfet_06v0 L=1U W=2.5U AS=1.1P AD=0.825P PS=5.88U PD=3.16U
M$1096 \$2454 \$2507 \$2522
+ VSS|XN_CS|XN_IE|XN_PD|XN_PDRV0|XN_PDRV1|XN_PU|XN_SL|XP_CS|XP_IE|XP_PD|XP_PDRV0|XP_PDRV1|XP_PU|XP_SL|YN_CS|YN_IE|YN_PD|YN_PDRV0|YN_PDRV1|YN_PU|YN_SL|YP_CS|YP_IE|YP_PD|YP_PDRV0|YP_PDRV1|YP_PU|YP_SL|ZN_CS|ZN_IE|ZN_PD|ZN_PDRV0|ZN_PDRV1|ZN_PU|ZN_SL|ZP_CS|ZP_IE|ZP_PD|ZP_PDRV0|ZP_PDRV1|ZP_PU|ZP_SL
+ nfet_06v0 L=1U W=2.5U AS=0.825P AD=1.1P PS=3.16U PD=5.88U
M$1097 \$2552 \$2476 \$2480
+ VSS|XN_CS|XN_IE|XN_PD|XN_PDRV0|XN_PDRV1|XN_PU|XN_SL|XP_CS|XP_IE|XP_PD|XP_PDRV0|XP_PDRV1|XP_PU|XP_SL|YN_CS|YN_IE|YN_PD|YN_PDRV0|YN_PDRV1|YN_PU|YN_SL|YP_CS|YP_IE|YP_PD|YP_PDRV0|YP_PDRV1|YP_PU|YP_SL|ZN_CS|ZN_IE|ZN_PD|ZN_PDRV0|ZN_PDRV1|ZN_PU|ZN_SL|ZP_CS|ZP_IE|ZP_PD|ZP_PDRV0|ZP_PDRV1|ZP_PU|ZP_SL
+ nfet_06v0 L=1U W=2U AS=0.88P AD=0.88P PS=4.88U PD=4.88U
M$1098 \$2535 \$2476 \$2454
+ VSS|XN_CS|XN_IE|XN_PD|XN_PDRV0|XN_PDRV1|XN_PU|XN_SL|XP_CS|XP_IE|XP_PD|XP_PDRV0|XP_PDRV1|XP_PU|XP_SL|YN_CS|YN_IE|YN_PD|YN_PDRV0|YN_PDRV1|YN_PU|YN_SL|YP_CS|YP_IE|YP_PD|YP_PDRV0|YP_PDRV1|YP_PU|YP_SL|ZN_CS|ZN_IE|ZN_PD|ZN_PDRV0|ZN_PDRV1|ZN_PU|ZN_SL|ZP_CS|ZP_IE|ZP_PD|ZP_PDRV0|ZP_PDRV1|ZP_PU|ZP_SL
+ nfet_06v0 L=1U W=2U AS=0.88P AD=0.88P PS=4.88U PD=4.88U
M$1099 \$2500 \$2506
+ VSS|XN_CS|XN_IE|XN_PD|XN_PDRV0|XN_PDRV1|XN_PU|XN_SL|XP_CS|XP_IE|XP_PD|XP_PDRV0|XP_PDRV1|XP_PU|XP_SL|YN_CS|YN_IE|YN_PD|YN_PDRV0|YN_PDRV1|YN_PU|YN_SL|YP_CS|YP_IE|YP_PD|YP_PDRV0|YP_PDRV1|YP_PU|YP_SL|ZN_CS|ZN_IE|ZN_PD|ZN_PDRV0|ZN_PDRV1|ZN_PU|ZN_SL|ZP_CS|ZP_IE|ZP_PD|ZP_PDRV0|ZP_PDRV1|ZP_PU|ZP_SL
+ VSS|XN_CS|XN_IE|XN_PD|XN_PDRV0|XN_PDRV1|XN_PU|XN_SL|XP_CS|XP_IE|XP_PD|XP_PDRV0|XP_PDRV1|XP_PU|XP_SL|YN_CS|YN_IE|YN_PD|YN_PDRV0|YN_PDRV1|YN_PU|YN_SL|YP_CS|YP_IE|YP_PD|YP_PDRV0|YP_PDRV1|YP_PU|YP_SL|ZN_CS|ZN_IE|ZN_PD|ZN_PDRV0|ZN_PDRV1|ZN_PU|ZN_SL|ZP_CS|ZP_IE|ZP_PD|ZP_PDRV0|ZP_PDRV1|ZP_PU|ZP_SL
+ nfet_06v0 L=1U W=5U AS=2.2P AD=1.25P PS=10.88U PD=5.5U
M$1100 \$2455 \$2507 \$2500
+ VSS|XN_CS|XN_IE|XN_PD|XN_PDRV0|XN_PDRV1|XN_PU|XN_SL|XP_CS|XP_IE|XP_PD|XP_PDRV0|XP_PDRV1|XP_PU|XP_SL|YN_CS|YN_IE|YN_PD|YN_PDRV0|YN_PDRV1|YN_PU|YN_SL|YP_CS|YP_IE|YP_PD|YP_PDRV0|YP_PDRV1|YP_PU|YP_SL|ZN_CS|ZN_IE|ZN_PD|ZN_PDRV0|ZN_PDRV1|ZN_PU|ZN_SL|ZP_CS|ZP_IE|ZP_PD|ZP_PDRV0|ZP_PDRV1|ZP_PU|ZP_SL
+ nfet_06v0 L=1U W=5U AS=1.25P AD=2.2P PS=5.5U PD=10.88U
M$1101 \$2501 \$2456
+ VSS|XN_CS|XN_IE|XN_PD|XN_PDRV0|XN_PDRV1|XN_PU|XN_SL|XP_CS|XP_IE|XP_PD|XP_PDRV0|XP_PDRV1|XP_PU|XP_SL|YN_CS|YN_IE|YN_PD|YN_PDRV0|YN_PDRV1|YN_PU|YN_SL|YP_CS|YP_IE|YP_PD|YP_PDRV0|YP_PDRV1|YP_PU|YP_SL|ZN_CS|ZN_IE|ZN_PD|ZN_PDRV0|ZN_PDRV1|ZN_PU|ZN_SL|ZP_CS|ZP_IE|ZP_PD|ZP_PDRV0|ZP_PDRV1|ZP_PU|ZP_SL
+ VSS|XN_CS|XN_IE|XN_PD|XN_PDRV0|XN_PDRV1|XN_PU|XN_SL|XP_CS|XP_IE|XP_PD|XP_PDRV0|XP_PDRV1|XP_PU|XP_SL|YN_CS|YN_IE|YN_PD|YN_PDRV0|YN_PDRV1|YN_PU|YN_SL|YP_CS|YP_IE|YP_PD|YP_PDRV0|YP_PDRV1|YP_PU|YP_SL|ZN_CS|ZN_IE|ZN_PD|ZN_PDRV0|ZN_PDRV1|ZN_PU|ZN_SL|ZP_CS|ZP_IE|ZP_PD|ZP_PDRV0|ZP_PDRV1|ZP_PU|ZP_SL
+ nfet_06v0 L=1U W=5U AS=2.2P AD=1.25P PS=10.88U PD=5.5U
M$1102 \$2456 \$2507 \$2501
+ VSS|XN_CS|XN_IE|XN_PD|XN_PDRV0|XN_PDRV1|XN_PU|XN_SL|XP_CS|XP_IE|XP_PD|XP_PDRV0|XP_PDRV1|XP_PU|XP_SL|YN_CS|YN_IE|YN_PD|YN_PDRV0|YN_PDRV1|YN_PU|YN_SL|YP_CS|YP_IE|YP_PD|YP_PDRV0|YP_PDRV1|YP_PU|YP_SL|ZN_CS|ZN_IE|ZN_PD|ZN_PDRV0|ZN_PDRV1|ZN_PU|ZN_SL|ZP_CS|ZP_IE|ZP_PD|ZP_PDRV0|ZP_PDRV1|ZP_PU|ZP_SL
+ nfet_06v0 L=1U W=5U AS=1.25P AD=1.65P PS=5.5U PD=5.66U
M$1103 \$2476 \$2476 \$2456
+ VSS|XN_CS|XN_IE|XN_PD|XN_PDRV0|XN_PDRV1|XN_PU|XN_SL|XP_CS|XP_IE|XP_PD|XP_PDRV0|XP_PDRV1|XP_PU|XP_SL|YN_CS|YN_IE|YN_PD|YN_PDRV0|YN_PDRV1|YN_PU|YN_SL|YP_CS|YP_IE|YP_PD|YP_PDRV0|YP_PDRV1|YP_PU|YP_SL|ZN_CS|ZN_IE|ZN_PD|ZN_PDRV0|ZN_PDRV1|ZN_PU|ZN_SL|ZP_CS|ZP_IE|ZP_PD|ZP_PDRV0|ZP_PDRV1|ZP_PU|ZP_SL
+ nfet_06v0 L=1U W=5U AS=1.65P AD=2.2P PS=5.66U PD=10.88U
M$1104 \$2457 \$2454
+ VSS|XN_CS|XN_IE|XN_PD|XN_PDRV0|XN_PDRV1|XN_PU|XN_SL|XP_CS|XP_IE|XP_PD|XP_PDRV0|XP_PDRV1|XP_PU|XP_SL|YN_CS|YN_IE|YN_PD|YN_PDRV0|YN_PDRV1|YN_PU|YN_SL|YP_CS|YP_IE|YP_PD|YP_PDRV0|YP_PDRV1|YP_PU|YP_SL|ZN_CS|ZN_IE|ZN_PD|ZN_PDRV0|ZN_PDRV1|ZN_PU|ZN_SL|ZP_CS|ZP_IE|ZP_PD|ZP_PDRV0|ZP_PDRV1|ZP_PU|ZP_SL
+ VSS|XN_CS|XN_IE|XN_PD|XN_PDRV0|XN_PDRV1|XN_PU|XN_SL|XP_CS|XP_IE|XP_PD|XP_PDRV0|XP_PDRV1|XP_PU|XP_SL|YN_CS|YN_IE|YN_PD|YN_PDRV0|YN_PDRV1|YN_PU|YN_SL|YP_CS|YP_IE|YP_PD|YP_PDRV0|YP_PDRV1|YP_PU|YP_SL|ZN_CS|ZN_IE|ZN_PD|ZN_PDRV0|ZN_PDRV1|ZN_PU|ZN_SL|ZP_CS|ZP_IE|ZP_PD|ZP_PDRV0|ZP_PDRV1|ZP_PU|ZP_SL
+ nfet_06v0 L=1U W=1U AS=0.44P AD=0.44P PS=2.88U PD=2.88U
M$1105 \$2507 \$2507
+ VSS|XN_CS|XN_IE|XN_PD|XN_PDRV0|XN_PDRV1|XN_PU|XN_SL|XP_CS|XP_IE|XP_PD|XP_PDRV0|XP_PDRV1|XP_PU|XP_SL|YN_CS|YN_IE|YN_PD|YN_PDRV0|YN_PDRV1|YN_PU|YN_SL|YP_CS|YP_IE|YP_PD|YP_PDRV0|YP_PDRV1|YP_PU|YP_SL|ZN_CS|ZN_IE|ZN_PD|ZN_PDRV0|ZN_PDRV1|ZN_PU|ZN_SL|ZP_CS|ZP_IE|ZP_PD|ZP_PDRV0|ZP_PDRV1|ZP_PU|ZP_SL
+ VSS|XN_CS|XN_IE|XN_PD|XN_PDRV0|XN_PDRV1|XN_PU|XN_SL|XP_CS|XP_IE|XP_PD|XP_PDRV0|XP_PDRV1|XP_PU|XP_SL|YN_CS|YN_IE|YN_PD|YN_PDRV0|YN_PDRV1|YN_PU|YN_SL|YP_CS|YP_IE|YP_PD|YP_PDRV0|YP_PDRV1|YP_PU|YP_SL|ZN_CS|ZN_IE|ZN_PD|ZN_PDRV0|ZN_PDRV1|ZN_PU|ZN_SL|ZP_CS|ZP_IE|ZP_PD|ZP_PDRV0|ZP_PDRV1|ZP_PU|ZP_SL
+ nfet_06v0 L=1U W=1U AS=0.44P AD=0.44P PS=2.88U PD=2.88U
M$1106 \$2499 \$2506
+ VSS|XN_CS|XN_IE|XN_PD|XN_PDRV0|XN_PDRV1|XN_PU|XN_SL|XP_CS|XP_IE|XP_PD|XP_PDRV0|XP_PDRV1|XP_PU|XP_SL|YN_CS|YN_IE|YN_PD|YN_PDRV0|YN_PDRV1|YN_PU|YN_SL|YP_CS|YP_IE|YP_PD|YP_PDRV0|YP_PDRV1|YP_PU|YP_SL|ZN_CS|ZN_IE|ZN_PD|ZN_PDRV0|ZN_PDRV1|ZN_PU|ZN_SL|ZP_CS|ZP_IE|ZP_PD|ZP_PDRV0|ZP_PDRV1|ZP_PU|ZP_SL
+ VSS|XN_CS|XN_IE|XN_PD|XN_PDRV0|XN_PDRV1|XN_PU|XN_SL|XP_CS|XP_IE|XP_PD|XP_PDRV0|XP_PDRV1|XP_PU|XP_SL|YN_CS|YN_IE|YN_PD|YN_PDRV0|YN_PDRV1|YN_PU|YN_SL|YP_CS|YP_IE|YP_PD|YP_PDRV0|YP_PDRV1|YP_PU|YP_SL|ZN_CS|ZN_IE|ZN_PD|ZN_PDRV0|ZN_PDRV1|ZN_PU|ZN_SL|ZP_CS|ZP_IE|ZP_PD|ZP_PDRV0|ZP_PDRV1|ZP_PU|ZP_SL
+ nfet_06v0 L=1U W=5U AS=2.2P AD=1.25P PS=10.88U PD=5.5U
M$1107 \$2506 \$2507 \$2499
+ VSS|XN_CS|XN_IE|XN_PD|XN_PDRV0|XN_PDRV1|XN_PU|XN_SL|XP_CS|XP_IE|XP_PD|XP_PDRV0|XP_PDRV1|XP_PU|XP_SL|YN_CS|YN_IE|YN_PD|YN_PDRV0|YN_PDRV1|YN_PU|YN_SL|YP_CS|YP_IE|YP_PD|YP_PDRV0|YP_PDRV1|YP_PU|YP_SL|ZN_CS|ZN_IE|ZN_PD|ZN_PDRV0|ZN_PDRV1|ZN_PU|ZN_SL|ZP_CS|ZP_IE|ZP_PD|ZP_PDRV0|ZP_PDRV1|ZP_PU|ZP_SL
+ nfet_06v0 L=1U W=5U AS=1.25P AD=2.2P PS=5.5U PD=10.88U
M$1108 \$2472 \$2534
+ VSS|XN_CS|XN_IE|XN_PD|XN_PDRV0|XN_PDRV1|XN_PU|XN_SL|XP_CS|XP_IE|XP_PD|XP_PDRV0|XP_PDRV1|XP_PU|XP_SL|YN_CS|YN_IE|YN_PD|YN_PDRV0|YN_PDRV1|YN_PU|YN_SL|YP_CS|YP_IE|YP_PD|YP_PDRV0|YP_PDRV1|YP_PU|YP_SL|ZN_CS|ZN_IE|ZN_PD|ZN_PDRV0|ZN_PDRV1|ZN_PU|ZN_SL|ZP_CS|ZP_IE|ZP_PD|ZP_PDRV0|ZP_PDRV1|ZP_PU|ZP_SL
+ VSS|XN_CS|XN_IE|XN_PD|XN_PDRV0|XN_PDRV1|XN_PU|XN_SL|XP_CS|XP_IE|XP_PD|XP_PDRV0|XP_PDRV1|XP_PU|XP_SL|YN_CS|YN_IE|YN_PD|YN_PDRV0|YN_PDRV1|YN_PU|YN_SL|YP_CS|YP_IE|YP_PD|YP_PDRV0|YP_PDRV1|YP_PU|YP_SL|ZN_CS|ZN_IE|ZN_PD|ZN_PDRV0|ZN_PDRV1|ZN_PU|ZN_SL|ZP_CS|ZP_IE|ZP_PD|ZP_PDRV0|ZP_PDRV1|ZP_PU|ZP_SL
+ nfet_06v0 L=1U W=1U AS=0.44P AD=0.25P PS=2.88U PD=1.5U
M$1109 \$2512 \$2534 \$2472
+ VSS|XN_CS|XN_IE|XN_PD|XN_PDRV0|XN_PDRV1|XN_PU|XN_SL|XP_CS|XP_IE|XP_PD|XP_PDRV0|XP_PDRV1|XP_PU|XP_SL|YN_CS|YN_IE|YN_PD|YN_PDRV0|YN_PDRV1|YN_PU|YN_SL|YP_CS|YP_IE|YP_PD|YP_PDRV0|YP_PDRV1|YP_PU|YP_SL|ZN_CS|ZN_IE|ZN_PD|ZN_PDRV0|ZN_PDRV1|ZN_PU|ZN_SL|ZP_CS|ZP_IE|ZP_PD|ZP_PDRV0|ZP_PDRV1|ZP_PU|ZP_SL
+ nfet_06v0 L=1U W=1U AS=0.25P AD=0.44P PS=1.5U PD=2.88U
M$1110 \$2473 \$2534
+ VSS|XN_CS|XN_IE|XN_PD|XN_PDRV0|XN_PDRV1|XN_PU|XN_SL|XP_CS|XP_IE|XP_PD|XP_PDRV0|XP_PDRV1|XP_PU|XP_SL|YN_CS|YN_IE|YN_PD|YN_PDRV0|YN_PDRV1|YN_PU|YN_SL|YP_CS|YP_IE|YP_PD|YP_PDRV0|YP_PDRV1|YP_PU|YP_SL|ZN_CS|ZN_IE|ZN_PD|ZN_PDRV0|ZN_PDRV1|ZN_PU|ZN_SL|ZP_CS|ZP_IE|ZP_PD|ZP_PDRV0|ZP_PDRV1|ZP_PU|ZP_SL
+ VSS|XN_CS|XN_IE|XN_PD|XN_PDRV0|XN_PDRV1|XN_PU|XN_SL|XP_CS|XP_IE|XP_PD|XP_PDRV0|XP_PDRV1|XP_PU|XP_SL|YN_CS|YN_IE|YN_PD|YN_PDRV0|YN_PDRV1|YN_PU|YN_SL|YP_CS|YP_IE|YP_PD|YP_PDRV0|YP_PDRV1|YP_PU|YP_SL|ZN_CS|ZN_IE|ZN_PD|ZN_PDRV0|ZN_PDRV1|ZN_PU|ZN_SL|ZP_CS|ZP_IE|ZP_PD|ZP_PDRV0|ZP_PDRV1|ZP_PU|ZP_SL
+ nfet_06v0 L=1U W=1U AS=0.44P AD=0.25P PS=2.88U PD=1.5U
M$1111 \$2534 \$2534 \$2473
+ VSS|XN_CS|XN_IE|XN_PD|XN_PDRV0|XN_PDRV1|XN_PU|XN_SL|XP_CS|XP_IE|XP_PD|XP_PDRV0|XP_PDRV1|XP_PU|XP_SL|YN_CS|YN_IE|YN_PD|YN_PDRV0|YN_PDRV1|YN_PU|YN_SL|YP_CS|YP_IE|YP_PD|YP_PDRV0|YP_PDRV1|YP_PU|YP_SL|ZN_CS|ZN_IE|ZN_PD|ZN_PDRV0|ZN_PDRV1|ZN_PU|ZN_SL|ZP_CS|ZP_IE|ZP_PD|ZP_PDRV0|ZP_PDRV1|ZP_PU|ZP_SL
+ nfet_06v0 L=1U W=1U AS=0.25P AD=0.44P PS=1.5U PD=2.88U
M$1112
+ VSS|XN_CS|XN_IE|XN_PD|XN_PDRV0|XN_PDRV1|XN_PU|XN_SL|XP_CS|XP_IE|XP_PD|XP_PDRV0|XP_PDRV1|XP_PU|XP_SL|YN_CS|YN_IE|YN_PD|YN_PDRV0|YN_PDRV1|YN_PU|YN_SL|YP_CS|YP_IE|YP_PD|YP_PDRV0|YP_PDRV1|YP_PU|YP_SL|ZN_CS|ZN_IE|ZN_PD|ZN_PDRV0|ZN_PDRV1|ZN_PU|ZN_SL|ZP_CS|ZP_IE|ZP_PD|ZP_PDRV0|ZP_PDRV1|ZP_PU|ZP_SL
+ VDD|XN_OE|XP_OE|YN_OE|YP_OE|ZN_OE|ZP_OE
+ VSS|XN_CS|XN_IE|XN_PD|XN_PDRV0|XN_PDRV1|XN_PU|XN_SL|XP_CS|XP_IE|XP_PD|XP_PDRV0|XP_PDRV1|XP_PU|XP_SL|YN_CS|YN_IE|YN_PD|YN_PDRV0|YN_PDRV1|YN_PU|YN_SL|YP_CS|YP_IE|YP_PD|YP_PDRV0|YP_PDRV1|YP_PU|YP_SL|ZN_CS|ZN_IE|ZN_PD|ZN_PDRV0|ZN_PDRV1|ZN_PU|ZN_SL|ZP_CS|ZP_IE|ZP_PD|ZP_PDRV0|ZP_PDRV1|ZP_PU|ZP_SL
+ VSS|XN_CS|XN_IE|XN_PD|XN_PDRV0|XN_PDRV1|XN_PU|XN_SL|XP_CS|XP_IE|XP_PD|XP_PDRV0|XP_PDRV1|XP_PU|XP_SL|YN_CS|YN_IE|YN_PD|YN_PDRV0|YN_PDRV1|YN_PU|YN_SL|YP_CS|YP_IE|YP_PD|YP_PDRV0|YP_PDRV1|YP_PU|YP_SL|ZN_CS|ZN_IE|ZN_PD|ZN_PDRV0|ZN_PDRV1|ZN_PU|ZN_SL|ZP_CS|ZP_IE|ZP_PD|ZP_PDRV0|ZP_PDRV1|ZP_PU|ZP_SL
+ nfet_06v0 L=2U W=18U AS=7.92P AD=7.92P PS=36.88U PD=36.88U
M$1113
+ VSS|XN_CS|XN_IE|XN_PD|XN_PDRV0|XN_PDRV1|XN_PU|XN_SL|XP_CS|XP_IE|XP_PD|XP_PDRV0|XP_PDRV1|XP_PU|XP_SL|YN_CS|YN_IE|YN_PD|YN_PDRV0|YN_PDRV1|YN_PU|YN_SL|YP_CS|YP_IE|YP_PD|YP_PDRV0|YP_PDRV1|YP_PU|YP_SL|ZN_CS|ZN_IE|ZN_PD|ZN_PDRV0|ZN_PDRV1|ZN_PU|ZN_SL|ZP_CS|ZP_IE|ZP_PD|ZP_PDRV0|ZP_PDRV1|ZP_PU|ZP_SL
+ VDD|XN_OE|XP_OE|YN_OE|YP_OE|ZN_OE|ZP_OE
+ VSS|XN_CS|XN_IE|XN_PD|XN_PDRV0|XN_PDRV1|XN_PU|XN_SL|XP_CS|XP_IE|XP_PD|XP_PDRV0|XP_PDRV1|XP_PU|XP_SL|YN_CS|YN_IE|YN_PD|YN_PDRV0|YN_PDRV1|YN_PU|YN_SL|YP_CS|YP_IE|YP_PD|YP_PDRV0|YP_PDRV1|YP_PU|YP_SL|ZN_CS|ZN_IE|ZN_PD|ZN_PDRV0|ZN_PDRV1|ZN_PU|ZN_SL|ZP_CS|ZP_IE|ZP_PD|ZP_PDRV0|ZP_PDRV1|ZP_PU|ZP_SL
+ VSS|XN_CS|XN_IE|XN_PD|XN_PDRV0|XN_PDRV1|XN_PU|XN_SL|XP_CS|XP_IE|XP_PD|XP_PDRV0|XP_PDRV1|XP_PU|XP_SL|YN_CS|YN_IE|YN_PD|YN_PDRV0|YN_PDRV1|YN_PU|YN_SL|YP_CS|YP_IE|YP_PD|YP_PDRV0|YP_PDRV1|YP_PU|YP_SL|ZN_CS|ZN_IE|ZN_PD|ZN_PDRV0|ZN_PDRV1|ZN_PU|ZN_SL|ZP_CS|ZP_IE|ZP_PD|ZP_PDRV0|ZP_PDRV1|ZP_PU|ZP_SL
+ nfet_06v0 L=2U W=18U AS=7.92P AD=7.92P PS=36.88U PD=36.88U
M$1114 \$2496 \$2508
+ VSS|XN_CS|XN_IE|XN_PD|XN_PDRV0|XN_PDRV1|XN_PU|XN_SL|XP_CS|XP_IE|XP_PD|XP_PDRV0|XP_PDRV1|XP_PU|XP_SL|YN_CS|YN_IE|YN_PD|YN_PDRV0|YN_PDRV1|YN_PU|YN_SL|YP_CS|YP_IE|YP_PD|YP_PDRV0|YP_PDRV1|YP_PU|YP_SL|ZN_CS|ZN_IE|ZN_PD|ZN_PDRV0|ZN_PDRV1|ZN_PU|ZN_SL|ZP_CS|ZP_IE|ZP_PD|ZP_PDRV0|ZP_PDRV1|ZP_PU|ZP_SL
+ VSS|XN_CS|XN_IE|XN_PD|XN_PDRV0|XN_PDRV1|XN_PU|XN_SL|XP_CS|XP_IE|XP_PD|XP_PDRV0|XP_PDRV1|XP_PU|XP_SL|YN_CS|YN_IE|YN_PD|YN_PDRV0|YN_PDRV1|YN_PU|YN_SL|YP_CS|YP_IE|YP_PD|YP_PDRV0|YP_PDRV1|YP_PU|YP_SL|ZN_CS|ZN_IE|ZN_PD|ZN_PDRV0|ZN_PDRV1|ZN_PU|ZN_SL|ZP_CS|ZP_IE|ZP_PD|ZP_PDRV0|ZP_PDRV1|ZP_PU|ZP_SL
+ nfet_06v0 L=1U W=5U AS=2.2P AD=1.25P PS=10.88U PD=5.5U
M$1115 \$2458 \$2509 \$2496
+ VSS|XN_CS|XN_IE|XN_PD|XN_PDRV0|XN_PDRV1|XN_PU|XN_SL|XP_CS|XP_IE|XP_PD|XP_PDRV0|XP_PDRV1|XP_PU|XP_SL|YN_CS|YN_IE|YN_PD|YN_PDRV0|YN_PDRV1|YN_PU|YN_SL|YP_CS|YP_IE|YP_PD|YP_PDRV0|YP_PDRV1|YP_PU|YP_SL|ZN_CS|ZN_IE|ZN_PD|ZN_PDRV0|ZN_PDRV1|ZN_PU|ZN_SL|ZP_CS|ZP_IE|ZP_PD|ZP_PDRV0|ZP_PDRV1|ZP_PU|ZP_SL
+ nfet_06v0 L=1U W=5U AS=1.25P AD=2.2P PS=5.5U PD=10.88U
M$1116 \$2494 \$2508
+ VSS|XN_CS|XN_IE|XN_PD|XN_PDRV0|XN_PDRV1|XN_PU|XN_SL|XP_CS|XP_IE|XP_PD|XP_PDRV0|XP_PDRV1|XP_PU|XP_SL|YN_CS|YN_IE|YN_PD|YN_PDRV0|YN_PDRV1|YN_PU|YN_SL|YP_CS|YP_IE|YP_PD|YP_PDRV0|YP_PDRV1|YP_PU|YP_SL|ZN_CS|ZN_IE|ZN_PD|ZN_PDRV0|ZN_PDRV1|ZN_PU|ZN_SL|ZP_CS|ZP_IE|ZP_PD|ZP_PDRV0|ZP_PDRV1|ZP_PU|ZP_SL
+ VSS|XN_CS|XN_IE|XN_PD|XN_PDRV0|XN_PDRV1|XN_PU|XN_SL|XP_CS|XP_IE|XP_PD|XP_PDRV0|XP_PDRV1|XP_PU|XP_SL|YN_CS|YN_IE|YN_PD|YN_PDRV0|YN_PDRV1|YN_PU|YN_SL|YP_CS|YP_IE|YP_PD|YP_PDRV0|YP_PDRV1|YP_PU|YP_SL|ZN_CS|ZN_IE|ZN_PD|ZN_PDRV0|ZN_PDRV1|ZN_PU|ZN_SL|ZP_CS|ZP_IE|ZP_PD|ZP_PDRV0|ZP_PDRV1|ZP_PU|ZP_SL
+ nfet_06v0 L=1U W=5U AS=2.2P AD=1.25P PS=10.88U PD=5.5U
M$1117 \$2458 \$2509 \$2494
+ VSS|XN_CS|XN_IE|XN_PD|XN_PDRV0|XN_PDRV1|XN_PU|XN_SL|XP_CS|XP_IE|XP_PD|XP_PDRV0|XP_PDRV1|XP_PU|XP_SL|YN_CS|YN_IE|YN_PD|YN_PDRV0|YN_PDRV1|YN_PU|YN_SL|YP_CS|YP_IE|YP_PD|YP_PDRV0|YP_PDRV1|YP_PU|YP_SL|ZN_CS|ZN_IE|ZN_PD|ZN_PDRV0|ZN_PDRV1|ZN_PU|ZN_SL|ZP_CS|ZP_IE|ZP_PD|ZP_PDRV0|ZP_PDRV1|ZP_PU|ZP_SL
+ nfet_06v0 L=1U W=5U AS=1.25P AD=2.2P PS=5.5U PD=10.88U
M$1118 \$2459 \$14436 \$2458
+ VSS|XN_CS|XN_IE|XN_PD|XN_PDRV0|XN_PDRV1|XN_PU|XN_SL|XP_CS|XP_IE|XP_PD|XP_PDRV0|XP_PDRV1|XP_PU|XP_SL|YN_CS|YN_IE|YN_PD|YN_PDRV0|YN_PDRV1|YN_PU|YN_SL|YP_CS|YP_IE|YP_PD|YP_PDRV0|YP_PDRV1|YP_PU|YP_SL|ZN_CS|ZN_IE|ZN_PD|ZN_PDRV0|ZN_PDRV1|ZN_PU|ZN_SL|ZP_CS|ZP_IE|ZP_PD|ZP_PDRV0|ZP_PDRV1|ZP_PU|ZP_SL
+ nfet_06v0 L=1U W=7.5U AS=3.3P AD=3.3P PS=15.88U PD=15.88U
M$1119 \$2460 \$14435 \$2458
+ VSS|XN_CS|XN_IE|XN_PD|XN_PDRV0|XN_PDRV1|XN_PU|XN_SL|XP_CS|XP_IE|XP_PD|XP_PDRV0|XP_PDRV1|XP_PU|XP_SL|YN_CS|YN_IE|YN_PD|YN_PDRV0|YN_PDRV1|YN_PU|YN_SL|YP_CS|YP_IE|YP_PD|YP_PDRV0|YP_PDRV1|YP_PU|YP_SL|ZN_CS|ZN_IE|ZN_PD|ZN_PDRV0|ZN_PDRV1|ZN_PU|ZN_SL|ZP_CS|ZP_IE|ZP_PD|ZP_PDRV0|ZP_PDRV1|ZP_PU|ZP_SL
+ nfet_06v0 L=1U W=8.5U AS=3.74P AD=3.74P PS=17.88U PD=17.88U
M$1120 \$2461 \$2481
+ VSS|XN_CS|XN_IE|XN_PD|XN_PDRV0|XN_PDRV1|XN_PU|XN_SL|XP_CS|XP_IE|XP_PD|XP_PDRV0|XP_PDRV1|XP_PU|XP_SL|YN_CS|YN_IE|YN_PD|YN_PDRV0|YN_PDRV1|YN_PU|YN_SL|YP_CS|YP_IE|YP_PD|YP_PDRV0|YP_PDRV1|YP_PU|YP_SL|ZN_CS|ZN_IE|ZN_PD|ZN_PDRV0|ZN_PDRV1|ZN_PU|ZN_SL|ZP_CS|ZP_IE|ZP_PD|ZP_PDRV0|ZP_PDRV1|ZP_PU|ZP_SL
+ VSS|XN_CS|XN_IE|XN_PD|XN_PDRV0|XN_PDRV1|XN_PU|XN_SL|XP_CS|XP_IE|XP_PD|XP_PDRV0|XP_PDRV1|XP_PU|XP_SL|YN_CS|YN_IE|YN_PD|YN_PDRV0|YN_PDRV1|YN_PU|YN_SL|YP_CS|YP_IE|YP_PD|YP_PDRV0|YP_PDRV1|YP_PU|YP_SL|ZN_CS|ZN_IE|ZN_PD|ZN_PDRV0|ZN_PDRV1|ZN_PU|ZN_SL|ZP_CS|ZP_IE|ZP_PD|ZP_PDRV0|ZP_PDRV1|ZP_PU|ZP_SL
+ nfet_06v0 L=1U W=2.5U AS=1.1P AD=0.825P PS=5.88U PD=3.16U
M$1121 \$2481 \$2509 \$2461
+ VSS|XN_CS|XN_IE|XN_PD|XN_PDRV0|XN_PDRV1|XN_PU|XN_SL|XP_CS|XP_IE|XP_PD|XP_PDRV0|XP_PDRV1|XP_PU|XP_SL|YN_CS|YN_IE|YN_PD|YN_PDRV0|YN_PDRV1|YN_PU|YN_SL|YP_CS|YP_IE|YP_PD|YP_PDRV0|YP_PDRV1|YP_PU|YP_SL|ZN_CS|ZN_IE|ZN_PD|ZN_PDRV0|ZN_PDRV1|ZN_PU|ZN_SL|ZP_CS|ZP_IE|ZP_PD|ZP_PDRV0|ZP_PDRV1|ZP_PU|ZP_SL
+ nfet_06v0 L=1U W=2.5U AS=0.825P AD=1.1P PS=3.16U PD=5.88U
M$1122 \$2526 \$2481
+ VSS|XN_CS|XN_IE|XN_PD|XN_PDRV0|XN_PDRV1|XN_PU|XN_SL|XP_CS|XP_IE|XP_PD|XP_PDRV0|XP_PDRV1|XP_PU|XP_SL|YN_CS|YN_IE|YN_PD|YN_PDRV0|YN_PDRV1|YN_PU|YN_SL|YP_CS|YP_IE|YP_PD|YP_PDRV0|YP_PDRV1|YP_PU|YP_SL|ZN_CS|ZN_IE|ZN_PD|ZN_PDRV0|ZN_PDRV1|ZN_PU|ZN_SL|ZP_CS|ZP_IE|ZP_PD|ZP_PDRV0|ZP_PDRV1|ZP_PU|ZP_SL
+ VSS|XN_CS|XN_IE|XN_PD|XN_PDRV0|XN_PDRV1|XN_PU|XN_SL|XP_CS|XP_IE|XP_PD|XP_PDRV0|XP_PDRV1|XP_PU|XP_SL|YN_CS|YN_IE|YN_PD|YN_PDRV0|YN_PDRV1|YN_PU|YN_SL|YP_CS|YP_IE|YP_PD|YP_PDRV0|YP_PDRV1|YP_PU|YP_SL|ZN_CS|ZN_IE|ZN_PD|ZN_PDRV0|ZN_PDRV1|ZN_PU|ZN_SL|ZP_CS|ZP_IE|ZP_PD|ZP_PDRV0|ZP_PDRV1|ZP_PU|ZP_SL
+ nfet_06v0 L=1U W=2.5U AS=1.1P AD=0.825P PS=5.88U PD=3.16U
M$1123 \$2462 \$2509 \$2526
+ VSS|XN_CS|XN_IE|XN_PD|XN_PDRV0|XN_PDRV1|XN_PU|XN_SL|XP_CS|XP_IE|XP_PD|XP_PDRV0|XP_PDRV1|XP_PU|XP_SL|YN_CS|YN_IE|YN_PD|YN_PDRV0|YN_PDRV1|YN_PU|YN_SL|YP_CS|YP_IE|YP_PD|YP_PDRV0|YP_PDRV1|YP_PU|YP_SL|ZN_CS|ZN_IE|ZN_PD|ZN_PDRV0|ZN_PDRV1|ZN_PU|ZN_SL|ZP_CS|ZP_IE|ZP_PD|ZP_PDRV0|ZP_PDRV1|ZP_PU|ZP_SL
+ nfet_06v0 L=1U W=2.5U AS=0.825P AD=1.1P PS=3.16U PD=5.88U
M$1124 \$2554 \$2477 \$2481
+ VSS|XN_CS|XN_IE|XN_PD|XN_PDRV0|XN_PDRV1|XN_PU|XN_SL|XP_CS|XP_IE|XP_PD|XP_PDRV0|XP_PDRV1|XP_PU|XP_SL|YN_CS|YN_IE|YN_PD|YN_PDRV0|YN_PDRV1|YN_PU|YN_SL|YP_CS|YP_IE|YP_PD|YP_PDRV0|YP_PDRV1|YP_PU|YP_SL|ZN_CS|ZN_IE|ZN_PD|ZN_PDRV0|ZN_PDRV1|ZN_PU|ZN_SL|ZP_CS|ZP_IE|ZP_PD|ZP_PDRV0|ZP_PDRV1|ZP_PU|ZP_SL
+ nfet_06v0 L=1U W=2U AS=0.88P AD=0.88P PS=4.88U PD=4.88U
M$1125 \$2537 \$2477 \$2462
+ VSS|XN_CS|XN_IE|XN_PD|XN_PDRV0|XN_PDRV1|XN_PU|XN_SL|XP_CS|XP_IE|XP_PD|XP_PDRV0|XP_PDRV1|XP_PU|XP_SL|YN_CS|YN_IE|YN_PD|YN_PDRV0|YN_PDRV1|YN_PU|YN_SL|YP_CS|YP_IE|YP_PD|YP_PDRV0|YP_PDRV1|YP_PU|YP_SL|ZN_CS|ZN_IE|ZN_PD|ZN_PDRV0|ZN_PDRV1|ZN_PU|ZN_SL|ZP_CS|ZP_IE|ZP_PD|ZP_PDRV0|ZP_PDRV1|ZP_PU|ZP_SL
+ nfet_06v0 L=1U W=2U AS=0.88P AD=0.88P PS=4.88U PD=4.88U
M$1126 \$2487 \$2508
+ VSS|XN_CS|XN_IE|XN_PD|XN_PDRV0|XN_PDRV1|XN_PU|XN_SL|XP_CS|XP_IE|XP_PD|XP_PDRV0|XP_PDRV1|XP_PU|XP_SL|YN_CS|YN_IE|YN_PD|YN_PDRV0|YN_PDRV1|YN_PU|YN_SL|YP_CS|YP_IE|YP_PD|YP_PDRV0|YP_PDRV1|YP_PU|YP_SL|ZN_CS|ZN_IE|ZN_PD|ZN_PDRV0|ZN_PDRV1|ZN_PU|ZN_SL|ZP_CS|ZP_IE|ZP_PD|ZP_PDRV0|ZP_PDRV1|ZP_PU|ZP_SL
+ VSS|XN_CS|XN_IE|XN_PD|XN_PDRV0|XN_PDRV1|XN_PU|XN_SL|XP_CS|XP_IE|XP_PD|XP_PDRV0|XP_PDRV1|XP_PU|XP_SL|YN_CS|YN_IE|YN_PD|YN_PDRV0|YN_PDRV1|YN_PU|YN_SL|YP_CS|YP_IE|YP_PD|YP_PDRV0|YP_PDRV1|YP_PU|YP_SL|ZN_CS|ZN_IE|ZN_PD|ZN_PDRV0|ZN_PDRV1|ZN_PU|ZN_SL|ZP_CS|ZP_IE|ZP_PD|ZP_PDRV0|ZP_PDRV1|ZP_PU|ZP_SL
+ nfet_06v0 L=1U W=5U AS=2.2P AD=1.25P PS=10.88U PD=5.5U
M$1127 \$2463 \$2509 \$2487
+ VSS|XN_CS|XN_IE|XN_PD|XN_PDRV0|XN_PDRV1|XN_PU|XN_SL|XP_CS|XP_IE|XP_PD|XP_PDRV0|XP_PDRV1|XP_PU|XP_SL|YN_CS|YN_IE|YN_PD|YN_PDRV0|YN_PDRV1|YN_PU|YN_SL|YP_CS|YP_IE|YP_PD|YP_PDRV0|YP_PDRV1|YP_PU|YP_SL|ZN_CS|ZN_IE|ZN_PD|ZN_PDRV0|ZN_PDRV1|ZN_PU|ZN_SL|ZP_CS|ZP_IE|ZP_PD|ZP_PDRV0|ZP_PDRV1|ZP_PU|ZP_SL
+ nfet_06v0 L=1U W=5U AS=1.25P AD=2.2P PS=5.5U PD=10.88U
M$1128 \$2485 \$2464
+ VSS|XN_CS|XN_IE|XN_PD|XN_PDRV0|XN_PDRV1|XN_PU|XN_SL|XP_CS|XP_IE|XP_PD|XP_PDRV0|XP_PDRV1|XP_PU|XP_SL|YN_CS|YN_IE|YN_PD|YN_PDRV0|YN_PDRV1|YN_PU|YN_SL|YP_CS|YP_IE|YP_PD|YP_PDRV0|YP_PDRV1|YP_PU|YP_SL|ZN_CS|ZN_IE|ZN_PD|ZN_PDRV0|ZN_PDRV1|ZN_PU|ZN_SL|ZP_CS|ZP_IE|ZP_PD|ZP_PDRV0|ZP_PDRV1|ZP_PU|ZP_SL
+ VSS|XN_CS|XN_IE|XN_PD|XN_PDRV0|XN_PDRV1|XN_PU|XN_SL|XP_CS|XP_IE|XP_PD|XP_PDRV0|XP_PDRV1|XP_PU|XP_SL|YN_CS|YN_IE|YN_PD|YN_PDRV0|YN_PDRV1|YN_PU|YN_SL|YP_CS|YP_IE|YP_PD|YP_PDRV0|YP_PDRV1|YP_PU|YP_SL|ZN_CS|ZN_IE|ZN_PD|ZN_PDRV0|ZN_PDRV1|ZN_PU|ZN_SL|ZP_CS|ZP_IE|ZP_PD|ZP_PDRV0|ZP_PDRV1|ZP_PU|ZP_SL
+ nfet_06v0 L=1U W=5U AS=2.2P AD=1.25P PS=10.88U PD=5.5U
M$1129 \$2464 \$2509 \$2485
+ VSS|XN_CS|XN_IE|XN_PD|XN_PDRV0|XN_PDRV1|XN_PU|XN_SL|XP_CS|XP_IE|XP_PD|XP_PDRV0|XP_PDRV1|XP_PU|XP_SL|YN_CS|YN_IE|YN_PD|YN_PDRV0|YN_PDRV1|YN_PU|YN_SL|YP_CS|YP_IE|YP_PD|YP_PDRV0|YP_PDRV1|YP_PU|YP_SL|ZN_CS|ZN_IE|ZN_PD|ZN_PDRV0|ZN_PDRV1|ZN_PU|ZN_SL|ZP_CS|ZP_IE|ZP_PD|ZP_PDRV0|ZP_PDRV1|ZP_PU|ZP_SL
+ nfet_06v0 L=1U W=5U AS=1.25P AD=1.65P PS=5.5U PD=5.66U
M$1130 \$2477 \$2477 \$2464
+ VSS|XN_CS|XN_IE|XN_PD|XN_PDRV0|XN_PDRV1|XN_PU|XN_SL|XP_CS|XP_IE|XP_PD|XP_PDRV0|XP_PDRV1|XP_PU|XP_SL|YN_CS|YN_IE|YN_PD|YN_PDRV0|YN_PDRV1|YN_PU|YN_SL|YP_CS|YP_IE|YP_PD|YP_PDRV0|YP_PDRV1|YP_PU|YP_SL|ZN_CS|ZN_IE|ZN_PD|ZN_PDRV0|ZN_PDRV1|ZN_PU|ZN_SL|ZP_CS|ZP_IE|ZP_PD|ZP_PDRV0|ZP_PDRV1|ZP_PU|ZP_SL
+ nfet_06v0 L=1U W=5U AS=1.65P AD=2.2P PS=5.66U PD=10.88U
M$1131 \$2465 \$2462
+ VSS|XN_CS|XN_IE|XN_PD|XN_PDRV0|XN_PDRV1|XN_PU|XN_SL|XP_CS|XP_IE|XP_PD|XP_PDRV0|XP_PDRV1|XP_PU|XP_SL|YN_CS|YN_IE|YN_PD|YN_PDRV0|YN_PDRV1|YN_PU|YN_SL|YP_CS|YP_IE|YP_PD|YP_PDRV0|YP_PDRV1|YP_PU|YP_SL|ZN_CS|ZN_IE|ZN_PD|ZN_PDRV0|ZN_PDRV1|ZN_PU|ZN_SL|ZP_CS|ZP_IE|ZP_PD|ZP_PDRV0|ZP_PDRV1|ZP_PU|ZP_SL
+ VSS|XN_CS|XN_IE|XN_PD|XN_PDRV0|XN_PDRV1|XN_PU|XN_SL|XP_CS|XP_IE|XP_PD|XP_PDRV0|XP_PDRV1|XP_PU|XP_SL|YN_CS|YN_IE|YN_PD|YN_PDRV0|YN_PDRV1|YN_PU|YN_SL|YP_CS|YP_IE|YP_PD|YP_PDRV0|YP_PDRV1|YP_PU|YP_SL|ZN_CS|ZN_IE|ZN_PD|ZN_PDRV0|ZN_PDRV1|ZN_PU|ZN_SL|ZP_CS|ZP_IE|ZP_PD|ZP_PDRV0|ZP_PDRV1|ZP_PU|ZP_SL
+ nfet_06v0 L=1U W=1U AS=0.44P AD=0.44P PS=2.88U PD=2.88U
M$1132 \$2509 \$2509
+ VSS|XN_CS|XN_IE|XN_PD|XN_PDRV0|XN_PDRV1|XN_PU|XN_SL|XP_CS|XP_IE|XP_PD|XP_PDRV0|XP_PDRV1|XP_PU|XP_SL|YN_CS|YN_IE|YN_PD|YN_PDRV0|YN_PDRV1|YN_PU|YN_SL|YP_CS|YP_IE|YP_PD|YP_PDRV0|YP_PDRV1|YP_PU|YP_SL|ZN_CS|ZN_IE|ZN_PD|ZN_PDRV0|ZN_PDRV1|ZN_PU|ZN_SL|ZP_CS|ZP_IE|ZP_PD|ZP_PDRV0|ZP_PDRV1|ZP_PU|ZP_SL
+ VSS|XN_CS|XN_IE|XN_PD|XN_PDRV0|XN_PDRV1|XN_PU|XN_SL|XP_CS|XP_IE|XP_PD|XP_PDRV0|XP_PDRV1|XP_PU|XP_SL|YN_CS|YN_IE|YN_PD|YN_PDRV0|YN_PDRV1|YN_PU|YN_SL|YP_CS|YP_IE|YP_PD|YP_PDRV0|YP_PDRV1|YP_PU|YP_SL|ZN_CS|ZN_IE|ZN_PD|ZN_PDRV0|ZN_PDRV1|ZN_PU|ZN_SL|ZP_CS|ZP_IE|ZP_PD|ZP_PDRV0|ZP_PDRV1|ZP_PU|ZP_SL
+ nfet_06v0 L=1U W=1U AS=0.44P AD=0.44P PS=2.88U PD=2.88U
M$1133 \$2482 \$2508
+ VSS|XN_CS|XN_IE|XN_PD|XN_PDRV0|XN_PDRV1|XN_PU|XN_SL|XP_CS|XP_IE|XP_PD|XP_PDRV0|XP_PDRV1|XP_PU|XP_SL|YN_CS|YN_IE|YN_PD|YN_PDRV0|YN_PDRV1|YN_PU|YN_SL|YP_CS|YP_IE|YP_PD|YP_PDRV0|YP_PDRV1|YP_PU|YP_SL|ZN_CS|ZN_IE|ZN_PD|ZN_PDRV0|ZN_PDRV1|ZN_PU|ZN_SL|ZP_CS|ZP_IE|ZP_PD|ZP_PDRV0|ZP_PDRV1|ZP_PU|ZP_SL
+ VSS|XN_CS|XN_IE|XN_PD|XN_PDRV0|XN_PDRV1|XN_PU|XN_SL|XP_CS|XP_IE|XP_PD|XP_PDRV0|XP_PDRV1|XP_PU|XP_SL|YN_CS|YN_IE|YN_PD|YN_PDRV0|YN_PDRV1|YN_PU|YN_SL|YP_CS|YP_IE|YP_PD|YP_PDRV0|YP_PDRV1|YP_PU|YP_SL|ZN_CS|ZN_IE|ZN_PD|ZN_PDRV0|ZN_PDRV1|ZN_PU|ZN_SL|ZP_CS|ZP_IE|ZP_PD|ZP_PDRV0|ZP_PDRV1|ZP_PU|ZP_SL
+ nfet_06v0 L=1U W=5U AS=2.2P AD=1.25P PS=10.88U PD=5.5U
M$1134 \$2508 \$2509 \$2482
+ VSS|XN_CS|XN_IE|XN_PD|XN_PDRV0|XN_PDRV1|XN_PU|XN_SL|XP_CS|XP_IE|XP_PD|XP_PDRV0|XP_PDRV1|XP_PU|XP_SL|YN_CS|YN_IE|YN_PD|YN_PDRV0|YN_PDRV1|YN_PU|YN_SL|YP_CS|YP_IE|YP_PD|YP_PDRV0|YP_PDRV1|YP_PU|YP_SL|ZN_CS|ZN_IE|ZN_PD|ZN_PDRV0|ZN_PDRV1|ZN_PU|ZN_SL|ZP_CS|ZP_IE|ZP_PD|ZP_PDRV0|ZP_PDRV1|ZP_PU|ZP_SL
+ nfet_06v0 L=1U W=5U AS=1.25P AD=2.2P PS=5.5U PD=10.88U
M$1135 \$2467 \$2536
+ VSS|XN_CS|XN_IE|XN_PD|XN_PDRV0|XN_PDRV1|XN_PU|XN_SL|XP_CS|XP_IE|XP_PD|XP_PDRV0|XP_PDRV1|XP_PU|XP_SL|YN_CS|YN_IE|YN_PD|YN_PDRV0|YN_PDRV1|YN_PU|YN_SL|YP_CS|YP_IE|YP_PD|YP_PDRV0|YP_PDRV1|YP_PU|YP_SL|ZN_CS|ZN_IE|ZN_PD|ZN_PDRV0|ZN_PDRV1|ZN_PU|ZN_SL|ZP_CS|ZP_IE|ZP_PD|ZP_PDRV0|ZP_PDRV1|ZP_PU|ZP_SL
+ VSS|XN_CS|XN_IE|XN_PD|XN_PDRV0|XN_PDRV1|XN_PU|XN_SL|XP_CS|XP_IE|XP_PD|XP_PDRV0|XP_PDRV1|XP_PU|XP_SL|YN_CS|YN_IE|YN_PD|YN_PDRV0|YN_PDRV1|YN_PU|YN_SL|YP_CS|YP_IE|YP_PD|YP_PDRV0|YP_PDRV1|YP_PU|YP_SL|ZN_CS|ZN_IE|ZN_PD|ZN_PDRV0|ZN_PDRV1|ZN_PU|ZN_SL|ZP_CS|ZP_IE|ZP_PD|ZP_PDRV0|ZP_PDRV1|ZP_PU|ZP_SL
+ nfet_06v0 L=1U W=1U AS=0.44P AD=0.25P PS=2.88U PD=1.5U
M$1136 \$2513 \$2536 \$2467
+ VSS|XN_CS|XN_IE|XN_PD|XN_PDRV0|XN_PDRV1|XN_PU|XN_SL|XP_CS|XP_IE|XP_PD|XP_PDRV0|XP_PDRV1|XP_PU|XP_SL|YN_CS|YN_IE|YN_PD|YN_PDRV0|YN_PDRV1|YN_PU|YN_SL|YP_CS|YP_IE|YP_PD|YP_PDRV0|YP_PDRV1|YP_PU|YP_SL|ZN_CS|ZN_IE|ZN_PD|ZN_PDRV0|ZN_PDRV1|ZN_PU|ZN_SL|ZP_CS|ZP_IE|ZP_PD|ZP_PDRV0|ZP_PDRV1|ZP_PU|ZP_SL
+ nfet_06v0 L=1U W=1U AS=0.25P AD=0.44P PS=1.5U PD=2.88U
M$1137 \$2466 \$2536
+ VSS|XN_CS|XN_IE|XN_PD|XN_PDRV0|XN_PDRV1|XN_PU|XN_SL|XP_CS|XP_IE|XP_PD|XP_PDRV0|XP_PDRV1|XP_PU|XP_SL|YN_CS|YN_IE|YN_PD|YN_PDRV0|YN_PDRV1|YN_PU|YN_SL|YP_CS|YP_IE|YP_PD|YP_PDRV0|YP_PDRV1|YP_PU|YP_SL|ZN_CS|ZN_IE|ZN_PD|ZN_PDRV0|ZN_PDRV1|ZN_PU|ZN_SL|ZP_CS|ZP_IE|ZP_PD|ZP_PDRV0|ZP_PDRV1|ZP_PU|ZP_SL
+ VSS|XN_CS|XN_IE|XN_PD|XN_PDRV0|XN_PDRV1|XN_PU|XN_SL|XP_CS|XP_IE|XP_PD|XP_PDRV0|XP_PDRV1|XP_PU|XP_SL|YN_CS|YN_IE|YN_PD|YN_PDRV0|YN_PDRV1|YN_PU|YN_SL|YP_CS|YP_IE|YP_PD|YP_PDRV0|YP_PDRV1|YP_PU|YP_SL|ZN_CS|ZN_IE|ZN_PD|ZN_PDRV0|ZN_PDRV1|ZN_PU|ZN_SL|ZP_CS|ZP_IE|ZP_PD|ZP_PDRV0|ZP_PDRV1|ZP_PU|ZP_SL
+ nfet_06v0 L=1U W=1U AS=0.44P AD=0.25P PS=2.88U PD=1.5U
M$1138 \$2536 \$2536 \$2466
+ VSS|XN_CS|XN_IE|XN_PD|XN_PDRV0|XN_PDRV1|XN_PU|XN_SL|XP_CS|XP_IE|XP_PD|XP_PDRV0|XP_PDRV1|XP_PU|XP_SL|YN_CS|YN_IE|YN_PD|YN_PDRV0|YN_PDRV1|YN_PU|YN_SL|YP_CS|YP_IE|YP_PD|YP_PDRV0|YP_PDRV1|YP_PU|YP_SL|ZN_CS|ZN_IE|ZN_PD|ZN_PDRV0|ZN_PDRV1|ZN_PU|ZN_SL|ZP_CS|ZP_IE|ZP_PD|ZP_PDRV0|ZP_PDRV1|ZP_PU|ZP_SL
+ nfet_06v0 L=1U W=1U AS=0.25P AD=0.44P PS=1.5U PD=2.88U
M$1139
+ VSS|XN_CS|XN_IE|XN_PD|XN_PDRV0|XN_PDRV1|XN_PU|XN_SL|XP_CS|XP_IE|XP_PD|XP_PDRV0|XP_PDRV1|XP_PU|XP_SL|YN_CS|YN_IE|YN_PD|YN_PDRV0|YN_PDRV1|YN_PU|YN_SL|YP_CS|YP_IE|YP_PD|YP_PDRV0|YP_PDRV1|YP_PU|YP_SL|ZN_CS|ZN_IE|ZN_PD|ZN_PDRV0|ZN_PDRV1|ZN_PU|ZN_SL|ZP_CS|ZP_IE|ZP_PD|ZP_PDRV0|ZP_PDRV1|ZP_PU|ZP_SL
+ VDD|XN_OE|XP_OE|YN_OE|YP_OE|ZN_OE|ZP_OE
+ VSS|XN_CS|XN_IE|XN_PD|XN_PDRV0|XN_PDRV1|XN_PU|XN_SL|XP_CS|XP_IE|XP_PD|XP_PDRV0|XP_PDRV1|XP_PU|XP_SL|YN_CS|YN_IE|YN_PD|YN_PDRV0|YN_PDRV1|YN_PU|YN_SL|YP_CS|YP_IE|YP_PD|YP_PDRV0|YP_PDRV1|YP_PU|YP_SL|ZN_CS|ZN_IE|ZN_PD|ZN_PDRV0|ZN_PDRV1|ZN_PU|ZN_SL|ZP_CS|ZP_IE|ZP_PD|ZP_PDRV0|ZP_PDRV1|ZP_PU|ZP_SL
+ VSS|XN_CS|XN_IE|XN_PD|XN_PDRV0|XN_PDRV1|XN_PU|XN_SL|XP_CS|XP_IE|XP_PD|XP_PDRV0|XP_PDRV1|XP_PU|XP_SL|YN_CS|YN_IE|YN_PD|YN_PDRV0|YN_PDRV1|YN_PU|YN_SL|YP_CS|YP_IE|YP_PD|YP_PDRV0|YP_PDRV1|YP_PU|YP_SL|ZN_CS|ZN_IE|ZN_PD|ZN_PDRV0|ZN_PDRV1|ZN_PU|ZN_SL|ZP_CS|ZP_IE|ZP_PD|ZP_PDRV0|ZP_PDRV1|ZP_PU|ZP_SL
+ nfet_06v0 L=2U W=18U AS=7.92P AD=7.92P PS=36.88U PD=36.88U
M$1140
+ VSS|XN_CS|XN_IE|XN_PD|XN_PDRV0|XN_PDRV1|XN_PU|XN_SL|XP_CS|XP_IE|XP_PD|XP_PDRV0|XP_PDRV1|XP_PU|XP_SL|YN_CS|YN_IE|YN_PD|YN_PDRV0|YN_PDRV1|YN_PU|YN_SL|YP_CS|YP_IE|YP_PD|YP_PDRV0|YP_PDRV1|YP_PU|YP_SL|ZN_CS|ZN_IE|ZN_PD|ZN_PDRV0|ZN_PDRV1|ZN_PU|ZN_SL|ZP_CS|ZP_IE|ZP_PD|ZP_PDRV0|ZP_PDRV1|ZP_PU|ZP_SL
+ VDD|XN_OE|XP_OE|YN_OE|YP_OE|ZN_OE|ZP_OE
+ VSS|XN_CS|XN_IE|XN_PD|XN_PDRV0|XN_PDRV1|XN_PU|XN_SL|XP_CS|XP_IE|XP_PD|XP_PDRV0|XP_PDRV1|XP_PU|XP_SL|YN_CS|YN_IE|YN_PD|YN_PDRV0|YN_PDRV1|YN_PU|YN_SL|YP_CS|YP_IE|YP_PD|YP_PDRV0|YP_PDRV1|YP_PU|YP_SL|ZN_CS|ZN_IE|ZN_PD|ZN_PDRV0|ZN_PDRV1|ZN_PU|ZN_SL|ZP_CS|ZP_IE|ZP_PD|ZP_PDRV0|ZP_PDRV1|ZP_PU|ZP_SL
+ VSS|XN_CS|XN_IE|XN_PD|XN_PDRV0|XN_PDRV1|XN_PU|XN_SL|XP_CS|XP_IE|XP_PD|XP_PDRV0|XP_PDRV1|XP_PU|XP_SL|YN_CS|YN_IE|YN_PD|YN_PDRV0|YN_PDRV1|YN_PU|YN_SL|YP_CS|YP_IE|YP_PD|YP_PDRV0|YP_PDRV1|YP_PU|YP_SL|ZN_CS|ZN_IE|ZN_PD|ZN_PDRV0|ZN_PDRV1|ZN_PU|ZN_SL|ZP_CS|ZP_IE|ZP_PD|ZP_PDRV0|ZP_PDRV1|ZP_PU|ZP_SL
+ nfet_06v0 L=2U W=18U AS=7.92P AD=7.92P PS=36.88U PD=36.88U
M$1141
+ VSS|XN_CS|XN_IE|XN_PD|XN_PDRV0|XN_PDRV1|XN_PU|XN_SL|XP_CS|XP_IE|XP_PD|XP_PDRV0|XP_PDRV1|XP_PU|XP_SL|YN_CS|YN_IE|YN_PD|YN_PDRV0|YN_PDRV1|YN_PU|YN_SL|YP_CS|YP_IE|YP_PD|YP_PDRV0|YP_PDRV1|YP_PU|YP_SL|ZN_CS|ZN_IE|ZN_PD|ZN_PDRV0|ZN_PDRV1|ZN_PU|ZN_SL|ZP_CS|ZP_IE|ZP_PD|ZP_PDRV0|ZP_PDRV1|ZP_PU|ZP_SL
+ VDD|XN_OE|XP_OE|YN_OE|YP_OE|ZN_OE|ZP_OE
+ VSS|XN_CS|XN_IE|XN_PD|XN_PDRV0|XN_PDRV1|XN_PU|XN_SL|XP_CS|XP_IE|XP_PD|XP_PDRV0|XP_PDRV1|XP_PU|XP_SL|YN_CS|YN_IE|YN_PD|YN_PDRV0|YN_PDRV1|YN_PU|YN_SL|YP_CS|YP_IE|YP_PD|YP_PDRV0|YP_PDRV1|YP_PU|YP_SL|ZN_CS|ZN_IE|ZN_PD|ZN_PDRV0|ZN_PDRV1|ZN_PU|ZN_SL|ZP_CS|ZP_IE|ZP_PD|ZP_PDRV0|ZP_PDRV1|ZP_PU|ZP_SL
+ VSS|XN_CS|XN_IE|XN_PD|XN_PDRV0|XN_PDRV1|XN_PU|XN_SL|XP_CS|XP_IE|XP_PD|XP_PDRV0|XP_PDRV1|XP_PU|XP_SL|YN_CS|YN_IE|YN_PD|YN_PDRV0|YN_PDRV1|YN_PU|YN_SL|YP_CS|YP_IE|YP_PD|YP_PDRV0|YP_PDRV1|YP_PU|YP_SL|ZN_CS|ZN_IE|ZN_PD|ZN_PDRV0|ZN_PDRV1|ZN_PU|ZN_SL|ZP_CS|ZP_IE|ZP_PD|ZP_PDRV0|ZP_PDRV1|ZP_PU|ZP_SL
+ nfet_06v0 L=2U W=18U AS=7.92P AD=7.92P PS=36.88U PD=36.88U
M$1142
+ VSS|XN_CS|XN_IE|XN_PD|XN_PDRV0|XN_PDRV1|XN_PU|XN_SL|XP_CS|XP_IE|XP_PD|XP_PDRV0|XP_PDRV1|XP_PU|XP_SL|YN_CS|YN_IE|YN_PD|YN_PDRV0|YN_PDRV1|YN_PU|YN_SL|YP_CS|YP_IE|YP_PD|YP_PDRV0|YP_PDRV1|YP_PU|YP_SL|ZN_CS|ZN_IE|ZN_PD|ZN_PDRV0|ZN_PDRV1|ZN_PU|ZN_SL|ZP_CS|ZP_IE|ZP_PD|ZP_PDRV0|ZP_PDRV1|ZP_PU|ZP_SL
+ VDD|XN_OE|XP_OE|YN_OE|YP_OE|ZN_OE|ZP_OE
+ VSS|XN_CS|XN_IE|XN_PD|XN_PDRV0|XN_PDRV1|XN_PU|XN_SL|XP_CS|XP_IE|XP_PD|XP_PDRV0|XP_PDRV1|XP_PU|XP_SL|YN_CS|YN_IE|YN_PD|YN_PDRV0|YN_PDRV1|YN_PU|YN_SL|YP_CS|YP_IE|YP_PD|YP_PDRV0|YP_PDRV1|YP_PU|YP_SL|ZN_CS|ZN_IE|ZN_PD|ZN_PDRV0|ZN_PDRV1|ZN_PU|ZN_SL|ZP_CS|ZP_IE|ZP_PD|ZP_PDRV0|ZP_PDRV1|ZP_PU|ZP_SL
+ VSS|XN_CS|XN_IE|XN_PD|XN_PDRV0|XN_PDRV1|XN_PU|XN_SL|XP_CS|XP_IE|XP_PD|XP_PDRV0|XP_PDRV1|XP_PU|XP_SL|YN_CS|YN_IE|YN_PD|YN_PDRV0|YN_PDRV1|YN_PU|YN_SL|YP_CS|YP_IE|YP_PD|YP_PDRV0|YP_PDRV1|YP_PU|YP_SL|ZN_CS|ZN_IE|ZN_PD|ZN_PDRV0|ZN_PDRV1|ZN_PU|ZN_SL|ZP_CS|ZP_IE|ZP_PD|ZP_PDRV0|ZP_PDRV1|ZP_PU|ZP_SL
+ nfet_06v0 L=2U W=18U AS=7.92P AD=7.92P PS=36.88U PD=36.88U
M$1143 \$4897 \$4917
+ VSS|XN_CS|XN_IE|XN_PD|XN_PDRV0|XN_PDRV1|XN_PU|XN_SL|XP_CS|XP_IE|XP_PD|XP_PDRV0|XP_PDRV1|XP_PU|XP_SL|YN_CS|YN_IE|YN_PD|YN_PDRV0|YN_PDRV1|YN_PU|YN_SL|YP_CS|YP_IE|YP_PD|YP_PDRV0|YP_PDRV1|YP_PU|YP_SL|ZN_CS|ZN_IE|ZN_PD|ZN_PDRV0|ZN_PDRV1|ZN_PU|ZN_SL|ZP_CS|ZP_IE|ZP_PD|ZP_PDRV0|ZP_PDRV1|ZP_PU|ZP_SL
+ VSS|XN_CS|XN_IE|XN_PD|XN_PDRV0|XN_PDRV1|XN_PU|XN_SL|XP_CS|XP_IE|XP_PD|XP_PDRV0|XP_PDRV1|XP_PU|XP_SL|YN_CS|YN_IE|YN_PD|YN_PDRV0|YN_PDRV1|YN_PU|YN_SL|YP_CS|YP_IE|YP_PD|YP_PDRV0|YP_PDRV1|YP_PU|YP_SL|ZN_CS|ZN_IE|ZN_PD|ZN_PDRV0|ZN_PDRV1|ZN_PU|ZN_SL|ZP_CS|ZP_IE|ZP_PD|ZP_PDRV0|ZP_PDRV1|ZP_PU|ZP_SL
+ nfet_06v0 L=1U W=5U AS=2.2P AD=1.25P PS=10.88U PD=5.5U
M$1144 \$4849 \$4918 \$4897
+ VSS|XN_CS|XN_IE|XN_PD|XN_PDRV0|XN_PDRV1|XN_PU|XN_SL|XP_CS|XP_IE|XP_PD|XP_PDRV0|XP_PDRV1|XP_PU|XP_SL|YN_CS|YN_IE|YN_PD|YN_PDRV0|YN_PDRV1|YN_PU|YN_SL|YP_CS|YP_IE|YP_PD|YP_PDRV0|YP_PDRV1|YP_PU|YP_SL|ZN_CS|ZN_IE|ZN_PD|ZN_PDRV0|ZN_PDRV1|ZN_PU|ZN_SL|ZP_CS|ZP_IE|ZP_PD|ZP_PDRV0|ZP_PDRV1|ZP_PU|ZP_SL
+ nfet_06v0 L=1U W=5U AS=1.25P AD=2.2P PS=5.5U PD=10.88U
M$1145 \$4898 \$4917
+ VSS|XN_CS|XN_IE|XN_PD|XN_PDRV0|XN_PDRV1|XN_PU|XN_SL|XP_CS|XP_IE|XP_PD|XP_PDRV0|XP_PDRV1|XP_PU|XP_SL|YN_CS|YN_IE|YN_PD|YN_PDRV0|YN_PDRV1|YN_PU|YN_SL|YP_CS|YP_IE|YP_PD|YP_PDRV0|YP_PDRV1|YP_PU|YP_SL|ZN_CS|ZN_IE|ZN_PD|ZN_PDRV0|ZN_PDRV1|ZN_PU|ZN_SL|ZP_CS|ZP_IE|ZP_PD|ZP_PDRV0|ZP_PDRV1|ZP_PU|ZP_SL
+ VSS|XN_CS|XN_IE|XN_PD|XN_PDRV0|XN_PDRV1|XN_PU|XN_SL|XP_CS|XP_IE|XP_PD|XP_PDRV0|XP_PDRV1|XP_PU|XP_SL|YN_CS|YN_IE|YN_PD|YN_PDRV0|YN_PDRV1|YN_PU|YN_SL|YP_CS|YP_IE|YP_PD|YP_PDRV0|YP_PDRV1|YP_PU|YP_SL|ZN_CS|ZN_IE|ZN_PD|ZN_PDRV0|ZN_PDRV1|ZN_PU|ZN_SL|ZP_CS|ZP_IE|ZP_PD|ZP_PDRV0|ZP_PDRV1|ZP_PU|ZP_SL
+ nfet_06v0 L=1U W=5U AS=2.2P AD=1.25P PS=10.88U PD=5.5U
M$1146 \$4849 \$4918 \$4898
+ VSS|XN_CS|XN_IE|XN_PD|XN_PDRV0|XN_PDRV1|XN_PU|XN_SL|XP_CS|XP_IE|XP_PD|XP_PDRV0|XP_PDRV1|XP_PU|XP_SL|YN_CS|YN_IE|YN_PD|YN_PDRV0|YN_PDRV1|YN_PU|YN_SL|YP_CS|YP_IE|YP_PD|YP_PDRV0|YP_PDRV1|YP_PU|YP_SL|ZN_CS|ZN_IE|ZN_PD|ZN_PDRV0|ZN_PDRV1|ZN_PU|ZN_SL|ZP_CS|ZP_IE|ZP_PD|ZP_PDRV0|ZP_PDRV1|ZP_PU|ZP_SL
+ nfet_06v0 L=1U W=5U AS=1.25P AD=2.2P PS=5.5U PD=10.88U
M$1147 \$4850 \$14437 \$4849
+ VSS|XN_CS|XN_IE|XN_PD|XN_PDRV0|XN_PDRV1|XN_PU|XN_SL|XP_CS|XP_IE|XP_PD|XP_PDRV0|XP_PDRV1|XP_PU|XP_SL|YN_CS|YN_IE|YN_PD|YN_PDRV0|YN_PDRV1|YN_PU|YN_SL|YP_CS|YP_IE|YP_PD|YP_PDRV0|YP_PDRV1|YP_PU|YP_SL|ZN_CS|ZN_IE|ZN_PD|ZN_PDRV0|ZN_PDRV1|ZN_PU|ZN_SL|ZP_CS|ZP_IE|ZP_PD|ZP_PDRV0|ZP_PDRV1|ZP_PU|ZP_SL
+ nfet_06v0 L=1U W=7.5U AS=3.3P AD=3.3P PS=15.88U PD=15.88U
M$1148 \$4851 \$14438 \$4849
+ VSS|XN_CS|XN_IE|XN_PD|XN_PDRV0|XN_PDRV1|XN_PU|XN_SL|XP_CS|XP_IE|XP_PD|XP_PDRV0|XP_PDRV1|XP_PU|XP_SL|YN_CS|YN_IE|YN_PD|YN_PDRV0|YN_PDRV1|YN_PU|YN_SL|YP_CS|YP_IE|YP_PD|YP_PDRV0|YP_PDRV1|YP_PU|YP_SL|ZN_CS|ZN_IE|ZN_PD|ZN_PDRV0|ZN_PDRV1|ZN_PU|ZN_SL|ZP_CS|ZP_IE|ZP_PD|ZP_PDRV0|ZP_PDRV1|ZP_PU|ZP_SL
+ nfet_06v0 L=1U W=8.5U AS=3.74P AD=3.74P PS=17.88U PD=17.88U
M$1149 \$4852 \$4889
+ VSS|XN_CS|XN_IE|XN_PD|XN_PDRV0|XN_PDRV1|XN_PU|XN_SL|XP_CS|XP_IE|XP_PD|XP_PDRV0|XP_PDRV1|XP_PU|XP_SL|YN_CS|YN_IE|YN_PD|YN_PDRV0|YN_PDRV1|YN_PU|YN_SL|YP_CS|YP_IE|YP_PD|YP_PDRV0|YP_PDRV1|YP_PU|YP_SL|ZN_CS|ZN_IE|ZN_PD|ZN_PDRV0|ZN_PDRV1|ZN_PU|ZN_SL|ZP_CS|ZP_IE|ZP_PD|ZP_PDRV0|ZP_PDRV1|ZP_PU|ZP_SL
+ VSS|XN_CS|XN_IE|XN_PD|XN_PDRV0|XN_PDRV1|XN_PU|XN_SL|XP_CS|XP_IE|XP_PD|XP_PDRV0|XP_PDRV1|XP_PU|XP_SL|YN_CS|YN_IE|YN_PD|YN_PDRV0|YN_PDRV1|YN_PU|YN_SL|YP_CS|YP_IE|YP_PD|YP_PDRV0|YP_PDRV1|YP_PU|YP_SL|ZN_CS|ZN_IE|ZN_PD|ZN_PDRV0|ZN_PDRV1|ZN_PU|ZN_SL|ZP_CS|ZP_IE|ZP_PD|ZP_PDRV0|ZP_PDRV1|ZP_PU|ZP_SL
+ nfet_06v0 L=1U W=2.5U AS=1.1P AD=0.825P PS=5.88U PD=3.16U
M$1150 \$4889 \$4918 \$4852
+ VSS|XN_CS|XN_IE|XN_PD|XN_PDRV0|XN_PDRV1|XN_PU|XN_SL|XP_CS|XP_IE|XP_PD|XP_PDRV0|XP_PDRV1|XP_PU|XP_SL|YN_CS|YN_IE|YN_PD|YN_PDRV0|YN_PDRV1|YN_PU|YN_SL|YP_CS|YP_IE|YP_PD|YP_PDRV0|YP_PDRV1|YP_PU|YP_SL|ZN_CS|ZN_IE|ZN_PD|ZN_PDRV0|ZN_PDRV1|ZN_PU|ZN_SL|ZP_CS|ZP_IE|ZP_PD|ZP_PDRV0|ZP_PDRV1|ZP_PU|ZP_SL
+ nfet_06v0 L=1U W=2.5U AS=0.825P AD=1.1P PS=3.16U PD=5.88U
M$1151 \$4929 \$4889
+ VSS|XN_CS|XN_IE|XN_PD|XN_PDRV0|XN_PDRV1|XN_PU|XN_SL|XP_CS|XP_IE|XP_PD|XP_PDRV0|XP_PDRV1|XP_PU|XP_SL|YN_CS|YN_IE|YN_PD|YN_PDRV0|YN_PDRV1|YN_PU|YN_SL|YP_CS|YP_IE|YP_PD|YP_PDRV0|YP_PDRV1|YP_PU|YP_SL|ZN_CS|ZN_IE|ZN_PD|ZN_PDRV0|ZN_PDRV1|ZN_PU|ZN_SL|ZP_CS|ZP_IE|ZP_PD|ZP_PDRV0|ZP_PDRV1|ZP_PU|ZP_SL
+ VSS|XN_CS|XN_IE|XN_PD|XN_PDRV0|XN_PDRV1|XN_PU|XN_SL|XP_CS|XP_IE|XP_PD|XP_PDRV0|XP_PDRV1|XP_PU|XP_SL|YN_CS|YN_IE|YN_PD|YN_PDRV0|YN_PDRV1|YN_PU|YN_SL|YP_CS|YP_IE|YP_PD|YP_PDRV0|YP_PDRV1|YP_PU|YP_SL|ZN_CS|ZN_IE|ZN_PD|ZN_PDRV0|ZN_PDRV1|ZN_PU|ZN_SL|ZP_CS|ZP_IE|ZP_PD|ZP_PDRV0|ZP_PDRV1|ZP_PU|ZP_SL
+ nfet_06v0 L=1U W=2.5U AS=1.1P AD=0.825P PS=5.88U PD=3.16U
M$1152 \$4853 \$4918 \$4929
+ VSS|XN_CS|XN_IE|XN_PD|XN_PDRV0|XN_PDRV1|XN_PU|XN_SL|XP_CS|XP_IE|XP_PD|XP_PDRV0|XP_PDRV1|XP_PU|XP_SL|YN_CS|YN_IE|YN_PD|YN_PDRV0|YN_PDRV1|YN_PU|YN_SL|YP_CS|YP_IE|YP_PD|YP_PDRV0|YP_PDRV1|YP_PU|YP_SL|ZN_CS|ZN_IE|ZN_PD|ZN_PDRV0|ZN_PDRV1|ZN_PU|ZN_SL|ZP_CS|ZP_IE|ZP_PD|ZP_PDRV0|ZP_PDRV1|ZP_PU|ZP_SL
+ nfet_06v0 L=1U W=2.5U AS=0.825P AD=1.1P PS=3.16U PD=5.88U
M$1153 \$4962 \$4890 \$4889
+ VSS|XN_CS|XN_IE|XN_PD|XN_PDRV0|XN_PDRV1|XN_PU|XN_SL|XP_CS|XP_IE|XP_PD|XP_PDRV0|XP_PDRV1|XP_PU|XP_SL|YN_CS|YN_IE|YN_PD|YN_PDRV0|YN_PDRV1|YN_PU|YN_SL|YP_CS|YP_IE|YP_PD|YP_PDRV0|YP_PDRV1|YP_PU|YP_SL|ZN_CS|ZN_IE|ZN_PD|ZN_PDRV0|ZN_PDRV1|ZN_PU|ZN_SL|ZP_CS|ZP_IE|ZP_PD|ZP_PDRV0|ZP_PDRV1|ZP_PU|ZP_SL
+ nfet_06v0 L=1U W=2U AS=0.88P AD=0.88P PS=4.88U PD=4.88U
M$1154 \$4951 \$4890 \$4853
+ VSS|XN_CS|XN_IE|XN_PD|XN_PDRV0|XN_PDRV1|XN_PU|XN_SL|XP_CS|XP_IE|XP_PD|XP_PDRV0|XP_PDRV1|XP_PU|XP_SL|YN_CS|YN_IE|YN_PD|YN_PDRV0|YN_PDRV1|YN_PU|YN_SL|YP_CS|YP_IE|YP_PD|YP_PDRV0|YP_PDRV1|YP_PU|YP_SL|ZN_CS|ZN_IE|ZN_PD|ZN_PDRV0|ZN_PDRV1|ZN_PU|ZN_SL|ZP_CS|ZP_IE|ZP_PD|ZP_PDRV0|ZP_PDRV1|ZP_PU|ZP_SL
+ nfet_06v0 L=1U W=2U AS=0.88P AD=0.88P PS=4.88U PD=4.88U
M$1155 \$4900 \$4917
+ VSS|XN_CS|XN_IE|XN_PD|XN_PDRV0|XN_PDRV1|XN_PU|XN_SL|XP_CS|XP_IE|XP_PD|XP_PDRV0|XP_PDRV1|XP_PU|XP_SL|YN_CS|YN_IE|YN_PD|YN_PDRV0|YN_PDRV1|YN_PU|YN_SL|YP_CS|YP_IE|YP_PD|YP_PDRV0|YP_PDRV1|YP_PU|YP_SL|ZN_CS|ZN_IE|ZN_PD|ZN_PDRV0|ZN_PDRV1|ZN_PU|ZN_SL|ZP_CS|ZP_IE|ZP_PD|ZP_PDRV0|ZP_PDRV1|ZP_PU|ZP_SL
+ VSS|XN_CS|XN_IE|XN_PD|XN_PDRV0|XN_PDRV1|XN_PU|XN_SL|XP_CS|XP_IE|XP_PD|XP_PDRV0|XP_PDRV1|XP_PU|XP_SL|YN_CS|YN_IE|YN_PD|YN_PDRV0|YN_PDRV1|YN_PU|YN_SL|YP_CS|YP_IE|YP_PD|YP_PDRV0|YP_PDRV1|YP_PU|YP_SL|ZN_CS|ZN_IE|ZN_PD|ZN_PDRV0|ZN_PDRV1|ZN_PU|ZN_SL|ZP_CS|ZP_IE|ZP_PD|ZP_PDRV0|ZP_PDRV1|ZP_PU|ZP_SL
+ nfet_06v0 L=1U W=5U AS=2.2P AD=1.25P PS=10.88U PD=5.5U
M$1156 \$4854 \$4918 \$4900
+ VSS|XN_CS|XN_IE|XN_PD|XN_PDRV0|XN_PDRV1|XN_PU|XN_SL|XP_CS|XP_IE|XP_PD|XP_PDRV0|XP_PDRV1|XP_PU|XP_SL|YN_CS|YN_IE|YN_PD|YN_PDRV0|YN_PDRV1|YN_PU|YN_SL|YP_CS|YP_IE|YP_PD|YP_PDRV0|YP_PDRV1|YP_PU|YP_SL|ZN_CS|ZN_IE|ZN_PD|ZN_PDRV0|ZN_PDRV1|ZN_PU|ZN_SL|ZP_CS|ZP_IE|ZP_PD|ZP_PDRV0|ZP_PDRV1|ZP_PU|ZP_SL
+ nfet_06v0 L=1U W=5U AS=1.25P AD=2.2P PS=5.5U PD=10.88U
M$1157 \$4901 \$4855
+ VSS|XN_CS|XN_IE|XN_PD|XN_PDRV0|XN_PDRV1|XN_PU|XN_SL|XP_CS|XP_IE|XP_PD|XP_PDRV0|XP_PDRV1|XP_PU|XP_SL|YN_CS|YN_IE|YN_PD|YN_PDRV0|YN_PDRV1|YN_PU|YN_SL|YP_CS|YP_IE|YP_PD|YP_PDRV0|YP_PDRV1|YP_PU|YP_SL|ZN_CS|ZN_IE|ZN_PD|ZN_PDRV0|ZN_PDRV1|ZN_PU|ZN_SL|ZP_CS|ZP_IE|ZP_PD|ZP_PDRV0|ZP_PDRV1|ZP_PU|ZP_SL
+ VSS|XN_CS|XN_IE|XN_PD|XN_PDRV0|XN_PDRV1|XN_PU|XN_SL|XP_CS|XP_IE|XP_PD|XP_PDRV0|XP_PDRV1|XP_PU|XP_SL|YN_CS|YN_IE|YN_PD|YN_PDRV0|YN_PDRV1|YN_PU|YN_SL|YP_CS|YP_IE|YP_PD|YP_PDRV0|YP_PDRV1|YP_PU|YP_SL|ZN_CS|ZN_IE|ZN_PD|ZN_PDRV0|ZN_PDRV1|ZN_PU|ZN_SL|ZP_CS|ZP_IE|ZP_PD|ZP_PDRV0|ZP_PDRV1|ZP_PU|ZP_SL
+ nfet_06v0 L=1U W=5U AS=2.2P AD=1.25P PS=10.88U PD=5.5U
M$1158 \$4855 \$4918 \$4901
+ VSS|XN_CS|XN_IE|XN_PD|XN_PDRV0|XN_PDRV1|XN_PU|XN_SL|XP_CS|XP_IE|XP_PD|XP_PDRV0|XP_PDRV1|XP_PU|XP_SL|YN_CS|YN_IE|YN_PD|YN_PDRV0|YN_PDRV1|YN_PU|YN_SL|YP_CS|YP_IE|YP_PD|YP_PDRV0|YP_PDRV1|YP_PU|YP_SL|ZN_CS|ZN_IE|ZN_PD|ZN_PDRV0|ZN_PDRV1|ZN_PU|ZN_SL|ZP_CS|ZP_IE|ZP_PD|ZP_PDRV0|ZP_PDRV1|ZP_PU|ZP_SL
+ nfet_06v0 L=1U W=5U AS=1.25P AD=1.65P PS=5.5U PD=5.66U
M$1159 \$4890 \$4890 \$4855
+ VSS|XN_CS|XN_IE|XN_PD|XN_PDRV0|XN_PDRV1|XN_PU|XN_SL|XP_CS|XP_IE|XP_PD|XP_PDRV0|XP_PDRV1|XP_PU|XP_SL|YN_CS|YN_IE|YN_PD|YN_PDRV0|YN_PDRV1|YN_PU|YN_SL|YP_CS|YP_IE|YP_PD|YP_PDRV0|YP_PDRV1|YP_PU|YP_SL|ZN_CS|ZN_IE|ZN_PD|ZN_PDRV0|ZN_PDRV1|ZN_PU|ZN_SL|ZP_CS|ZP_IE|ZP_PD|ZP_PDRV0|ZP_PDRV1|ZP_PU|ZP_SL
+ nfet_06v0 L=1U W=5U AS=1.65P AD=2.2P PS=5.66U PD=10.88U
M$1160 \$4856 \$4853
+ VSS|XN_CS|XN_IE|XN_PD|XN_PDRV0|XN_PDRV1|XN_PU|XN_SL|XP_CS|XP_IE|XP_PD|XP_PDRV0|XP_PDRV1|XP_PU|XP_SL|YN_CS|YN_IE|YN_PD|YN_PDRV0|YN_PDRV1|YN_PU|YN_SL|YP_CS|YP_IE|YP_PD|YP_PDRV0|YP_PDRV1|YP_PU|YP_SL|ZN_CS|ZN_IE|ZN_PD|ZN_PDRV0|ZN_PDRV1|ZN_PU|ZN_SL|ZP_CS|ZP_IE|ZP_PD|ZP_PDRV0|ZP_PDRV1|ZP_PU|ZP_SL
+ VSS|XN_CS|XN_IE|XN_PD|XN_PDRV0|XN_PDRV1|XN_PU|XN_SL|XP_CS|XP_IE|XP_PD|XP_PDRV0|XP_PDRV1|XP_PU|XP_SL|YN_CS|YN_IE|YN_PD|YN_PDRV0|YN_PDRV1|YN_PU|YN_SL|YP_CS|YP_IE|YP_PD|YP_PDRV0|YP_PDRV1|YP_PU|YP_SL|ZN_CS|ZN_IE|ZN_PD|ZN_PDRV0|ZN_PDRV1|ZN_PU|ZN_SL|ZP_CS|ZP_IE|ZP_PD|ZP_PDRV0|ZP_PDRV1|ZP_PU|ZP_SL
+ nfet_06v0 L=1U W=1U AS=0.44P AD=0.44P PS=2.88U PD=2.88U
M$1161 \$4918 \$4918
+ VSS|XN_CS|XN_IE|XN_PD|XN_PDRV0|XN_PDRV1|XN_PU|XN_SL|XP_CS|XP_IE|XP_PD|XP_PDRV0|XP_PDRV1|XP_PU|XP_SL|YN_CS|YN_IE|YN_PD|YN_PDRV0|YN_PDRV1|YN_PU|YN_SL|YP_CS|YP_IE|YP_PD|YP_PDRV0|YP_PDRV1|YP_PU|YP_SL|ZN_CS|ZN_IE|ZN_PD|ZN_PDRV0|ZN_PDRV1|ZN_PU|ZN_SL|ZP_CS|ZP_IE|ZP_PD|ZP_PDRV0|ZP_PDRV1|ZP_PU|ZP_SL
+ VSS|XN_CS|XN_IE|XN_PD|XN_PDRV0|XN_PDRV1|XN_PU|XN_SL|XP_CS|XP_IE|XP_PD|XP_PDRV0|XP_PDRV1|XP_PU|XP_SL|YN_CS|YN_IE|YN_PD|YN_PDRV0|YN_PDRV1|YN_PU|YN_SL|YP_CS|YP_IE|YP_PD|YP_PDRV0|YP_PDRV1|YP_PU|YP_SL|ZN_CS|ZN_IE|ZN_PD|ZN_PDRV0|ZN_PDRV1|ZN_PU|ZN_SL|ZP_CS|ZP_IE|ZP_PD|ZP_PDRV0|ZP_PDRV1|ZP_PU|ZP_SL
+ nfet_06v0 L=1U W=1U AS=0.44P AD=0.44P PS=2.88U PD=2.88U
M$1162 \$4903 \$4917
+ VSS|XN_CS|XN_IE|XN_PD|XN_PDRV0|XN_PDRV1|XN_PU|XN_SL|XP_CS|XP_IE|XP_PD|XP_PDRV0|XP_PDRV1|XP_PU|XP_SL|YN_CS|YN_IE|YN_PD|YN_PDRV0|YN_PDRV1|YN_PU|YN_SL|YP_CS|YP_IE|YP_PD|YP_PDRV0|YP_PDRV1|YP_PU|YP_SL|ZN_CS|ZN_IE|ZN_PD|ZN_PDRV0|ZN_PDRV1|ZN_PU|ZN_SL|ZP_CS|ZP_IE|ZP_PD|ZP_PDRV0|ZP_PDRV1|ZP_PU|ZP_SL
+ VSS|XN_CS|XN_IE|XN_PD|XN_PDRV0|XN_PDRV1|XN_PU|XN_SL|XP_CS|XP_IE|XP_PD|XP_PDRV0|XP_PDRV1|XP_PU|XP_SL|YN_CS|YN_IE|YN_PD|YN_PDRV0|YN_PDRV1|YN_PU|YN_SL|YP_CS|YP_IE|YP_PD|YP_PDRV0|YP_PDRV1|YP_PU|YP_SL|ZN_CS|ZN_IE|ZN_PD|ZN_PDRV0|ZN_PDRV1|ZN_PU|ZN_SL|ZP_CS|ZP_IE|ZP_PD|ZP_PDRV0|ZP_PDRV1|ZP_PU|ZP_SL
+ nfet_06v0 L=1U W=5U AS=2.2P AD=1.25P PS=10.88U PD=5.5U
M$1163 \$4917 \$4918 \$4903
+ VSS|XN_CS|XN_IE|XN_PD|XN_PDRV0|XN_PDRV1|XN_PU|XN_SL|XP_CS|XP_IE|XP_PD|XP_PDRV0|XP_PDRV1|XP_PU|XP_SL|YN_CS|YN_IE|YN_PD|YN_PDRV0|YN_PDRV1|YN_PU|YN_SL|YP_CS|YP_IE|YP_PD|YP_PDRV0|YP_PDRV1|YP_PU|YP_SL|ZN_CS|ZN_IE|ZN_PD|ZN_PDRV0|ZN_PDRV1|ZN_PU|ZN_SL|ZP_CS|ZP_IE|ZP_PD|ZP_PDRV0|ZP_PDRV1|ZP_PU|ZP_SL
+ nfet_06v0 L=1U W=5U AS=1.25P AD=2.2P PS=5.5U PD=10.88U
M$1164 \$4882 \$4945
+ VSS|XN_CS|XN_IE|XN_PD|XN_PDRV0|XN_PDRV1|XN_PU|XN_SL|XP_CS|XP_IE|XP_PD|XP_PDRV0|XP_PDRV1|XP_PU|XP_SL|YN_CS|YN_IE|YN_PD|YN_PDRV0|YN_PDRV1|YN_PU|YN_SL|YP_CS|YP_IE|YP_PD|YP_PDRV0|YP_PDRV1|YP_PU|YP_SL|ZN_CS|ZN_IE|ZN_PD|ZN_PDRV0|ZN_PDRV1|ZN_PU|ZN_SL|ZP_CS|ZP_IE|ZP_PD|ZP_PDRV0|ZP_PDRV1|ZP_PU|ZP_SL
+ VSS|XN_CS|XN_IE|XN_PD|XN_PDRV0|XN_PDRV1|XN_PU|XN_SL|XP_CS|XP_IE|XP_PD|XP_PDRV0|XP_PDRV1|XP_PU|XP_SL|YN_CS|YN_IE|YN_PD|YN_PDRV0|YN_PDRV1|YN_PU|YN_SL|YP_CS|YP_IE|YP_PD|YP_PDRV0|YP_PDRV1|YP_PU|YP_SL|ZN_CS|ZN_IE|ZN_PD|ZN_PDRV0|ZN_PDRV1|ZN_PU|ZN_SL|ZP_CS|ZP_IE|ZP_PD|ZP_PDRV0|ZP_PDRV1|ZP_PU|ZP_SL
+ nfet_06v0 L=1U W=1U AS=0.44P AD=0.25P PS=2.88U PD=1.5U
M$1165 \$4925 \$4945 \$4882
+ VSS|XN_CS|XN_IE|XN_PD|XN_PDRV0|XN_PDRV1|XN_PU|XN_SL|XP_CS|XP_IE|XP_PD|XP_PDRV0|XP_PDRV1|XP_PU|XP_SL|YN_CS|YN_IE|YN_PD|YN_PDRV0|YN_PDRV1|YN_PU|YN_SL|YP_CS|YP_IE|YP_PD|YP_PDRV0|YP_PDRV1|YP_PU|YP_SL|ZN_CS|ZN_IE|ZN_PD|ZN_PDRV0|ZN_PDRV1|ZN_PU|ZN_SL|ZP_CS|ZP_IE|ZP_PD|ZP_PDRV0|ZP_PDRV1|ZP_PU|ZP_SL
+ nfet_06v0 L=1U W=1U AS=0.25P AD=0.44P PS=1.5U PD=2.88U
M$1166 \$4884 \$4945
+ VSS|XN_CS|XN_IE|XN_PD|XN_PDRV0|XN_PDRV1|XN_PU|XN_SL|XP_CS|XP_IE|XP_PD|XP_PDRV0|XP_PDRV1|XP_PU|XP_SL|YN_CS|YN_IE|YN_PD|YN_PDRV0|YN_PDRV1|YN_PU|YN_SL|YP_CS|YP_IE|YP_PD|YP_PDRV0|YP_PDRV1|YP_PU|YP_SL|ZN_CS|ZN_IE|ZN_PD|ZN_PDRV0|ZN_PDRV1|ZN_PU|ZN_SL|ZP_CS|ZP_IE|ZP_PD|ZP_PDRV0|ZP_PDRV1|ZP_PU|ZP_SL
+ VSS|XN_CS|XN_IE|XN_PD|XN_PDRV0|XN_PDRV1|XN_PU|XN_SL|XP_CS|XP_IE|XP_PD|XP_PDRV0|XP_PDRV1|XP_PU|XP_SL|YN_CS|YN_IE|YN_PD|YN_PDRV0|YN_PDRV1|YN_PU|YN_SL|YP_CS|YP_IE|YP_PD|YP_PDRV0|YP_PDRV1|YP_PU|YP_SL|ZN_CS|ZN_IE|ZN_PD|ZN_PDRV0|ZN_PDRV1|ZN_PU|ZN_SL|ZP_CS|ZP_IE|ZP_PD|ZP_PDRV0|ZP_PDRV1|ZP_PU|ZP_SL
+ nfet_06v0 L=1U W=1U AS=0.44P AD=0.25P PS=2.88U PD=1.5U
M$1167 \$4945 \$4945 \$4884
+ VSS|XN_CS|XN_IE|XN_PD|XN_PDRV0|XN_PDRV1|XN_PU|XN_SL|XP_CS|XP_IE|XP_PD|XP_PDRV0|XP_PDRV1|XP_PU|XP_SL|YN_CS|YN_IE|YN_PD|YN_PDRV0|YN_PDRV1|YN_PU|YN_SL|YP_CS|YP_IE|YP_PD|YP_PDRV0|YP_PDRV1|YP_PU|YP_SL|ZN_CS|ZN_IE|ZN_PD|ZN_PDRV0|ZN_PDRV1|ZN_PU|ZN_SL|ZP_CS|ZP_IE|ZP_PD|ZP_PDRV0|ZP_PDRV1|ZP_PU|ZP_SL
+ nfet_06v0 L=1U W=1U AS=0.25P AD=0.44P PS=1.5U PD=2.88U
M$1168
+ VSS|XN_CS|XN_IE|XN_PD|XN_PDRV0|XN_PDRV1|XN_PU|XN_SL|XP_CS|XP_IE|XP_PD|XP_PDRV0|XP_PDRV1|XP_PU|XP_SL|YN_CS|YN_IE|YN_PD|YN_PDRV0|YN_PDRV1|YN_PU|YN_SL|YP_CS|YP_IE|YP_PD|YP_PDRV0|YP_PDRV1|YP_PU|YP_SL|ZN_CS|ZN_IE|ZN_PD|ZN_PDRV0|ZN_PDRV1|ZN_PU|ZN_SL|ZP_CS|ZP_IE|ZP_PD|ZP_PDRV0|ZP_PDRV1|ZP_PU|ZP_SL
+ VDD|XN_OE|XP_OE|YN_OE|YP_OE|ZN_OE|ZP_OE
+ VSS|XN_CS|XN_IE|XN_PD|XN_PDRV0|XN_PDRV1|XN_PU|XN_SL|XP_CS|XP_IE|XP_PD|XP_PDRV0|XP_PDRV1|XP_PU|XP_SL|YN_CS|YN_IE|YN_PD|YN_PDRV0|YN_PDRV1|YN_PU|YN_SL|YP_CS|YP_IE|YP_PD|YP_PDRV0|YP_PDRV1|YP_PU|YP_SL|ZN_CS|ZN_IE|ZN_PD|ZN_PDRV0|ZN_PDRV1|ZN_PU|ZN_SL|ZP_CS|ZP_IE|ZP_PD|ZP_PDRV0|ZP_PDRV1|ZP_PU|ZP_SL
+ VSS|XN_CS|XN_IE|XN_PD|XN_PDRV0|XN_PDRV1|XN_PU|XN_SL|XP_CS|XP_IE|XP_PD|XP_PDRV0|XP_PDRV1|XP_PU|XP_SL|YN_CS|YN_IE|YN_PD|YN_PDRV0|YN_PDRV1|YN_PU|YN_SL|YP_CS|YP_IE|YP_PD|YP_PDRV0|YP_PDRV1|YP_PU|YP_SL|ZN_CS|ZN_IE|ZN_PD|ZN_PDRV0|ZN_PDRV1|ZN_PU|ZN_SL|ZP_CS|ZP_IE|ZP_PD|ZP_PDRV0|ZP_PDRV1|ZP_PU|ZP_SL
+ nfet_06v0 L=2U W=18U AS=7.92P AD=7.92P PS=36.88U PD=36.88U
M$1169
+ VSS|XN_CS|XN_IE|XN_PD|XN_PDRV0|XN_PDRV1|XN_PU|XN_SL|XP_CS|XP_IE|XP_PD|XP_PDRV0|XP_PDRV1|XP_PU|XP_SL|YN_CS|YN_IE|YN_PD|YN_PDRV0|YN_PDRV1|YN_PU|YN_SL|YP_CS|YP_IE|YP_PD|YP_PDRV0|YP_PDRV1|YP_PU|YP_SL|ZN_CS|ZN_IE|ZN_PD|ZN_PDRV0|ZN_PDRV1|ZN_PU|ZN_SL|ZP_CS|ZP_IE|ZP_PD|ZP_PDRV0|ZP_PDRV1|ZP_PU|ZP_SL
+ VDD|XN_OE|XP_OE|YN_OE|YP_OE|ZN_OE|ZP_OE
+ VSS|XN_CS|XN_IE|XN_PD|XN_PDRV0|XN_PDRV1|XN_PU|XN_SL|XP_CS|XP_IE|XP_PD|XP_PDRV0|XP_PDRV1|XP_PU|XP_SL|YN_CS|YN_IE|YN_PD|YN_PDRV0|YN_PDRV1|YN_PU|YN_SL|YP_CS|YP_IE|YP_PD|YP_PDRV0|YP_PDRV1|YP_PU|YP_SL|ZN_CS|ZN_IE|ZN_PD|ZN_PDRV0|ZN_PDRV1|ZN_PU|ZN_SL|ZP_CS|ZP_IE|ZP_PD|ZP_PDRV0|ZP_PDRV1|ZP_PU|ZP_SL
+ VSS|XN_CS|XN_IE|XN_PD|XN_PDRV0|XN_PDRV1|XN_PU|XN_SL|XP_CS|XP_IE|XP_PD|XP_PDRV0|XP_PDRV1|XP_PU|XP_SL|YN_CS|YN_IE|YN_PD|YN_PDRV0|YN_PDRV1|YN_PU|YN_SL|YP_CS|YP_IE|YP_PD|YP_PDRV0|YP_PDRV1|YP_PU|YP_SL|ZN_CS|ZN_IE|ZN_PD|ZN_PDRV0|ZN_PDRV1|ZN_PU|ZN_SL|ZP_CS|ZP_IE|ZP_PD|ZP_PDRV0|ZP_PDRV1|ZP_PU|ZP_SL
+ nfet_06v0 L=2U W=18U AS=7.92P AD=7.92P PS=36.88U PD=36.88U
M$1170 \$4905 \$4919
+ VSS|XN_CS|XN_IE|XN_PD|XN_PDRV0|XN_PDRV1|XN_PU|XN_SL|XP_CS|XP_IE|XP_PD|XP_PDRV0|XP_PDRV1|XP_PU|XP_SL|YN_CS|YN_IE|YN_PD|YN_PDRV0|YN_PDRV1|YN_PU|YN_SL|YP_CS|YP_IE|YP_PD|YP_PDRV0|YP_PDRV1|YP_PU|YP_SL|ZN_CS|ZN_IE|ZN_PD|ZN_PDRV0|ZN_PDRV1|ZN_PU|ZN_SL|ZP_CS|ZP_IE|ZP_PD|ZP_PDRV0|ZP_PDRV1|ZP_PU|ZP_SL
+ VSS|XN_CS|XN_IE|XN_PD|XN_PDRV0|XN_PDRV1|XN_PU|XN_SL|XP_CS|XP_IE|XP_PD|XP_PDRV0|XP_PDRV1|XP_PU|XP_SL|YN_CS|YN_IE|YN_PD|YN_PDRV0|YN_PDRV1|YN_PU|YN_SL|YP_CS|YP_IE|YP_PD|YP_PDRV0|YP_PDRV1|YP_PU|YP_SL|ZN_CS|ZN_IE|ZN_PD|ZN_PDRV0|ZN_PDRV1|ZN_PU|ZN_SL|ZP_CS|ZP_IE|ZP_PD|ZP_PDRV0|ZP_PDRV1|ZP_PU|ZP_SL
+ nfet_06v0 L=1U W=5U AS=2.2P AD=1.25P PS=10.88U PD=5.5U
M$1171 \$4857 \$4920 \$4905
+ VSS|XN_CS|XN_IE|XN_PD|XN_PDRV0|XN_PDRV1|XN_PU|XN_SL|XP_CS|XP_IE|XP_PD|XP_PDRV0|XP_PDRV1|XP_PU|XP_SL|YN_CS|YN_IE|YN_PD|YN_PDRV0|YN_PDRV1|YN_PU|YN_SL|YP_CS|YP_IE|YP_PD|YP_PDRV0|YP_PDRV1|YP_PU|YP_SL|ZN_CS|ZN_IE|ZN_PD|ZN_PDRV0|ZN_PDRV1|ZN_PU|ZN_SL|ZP_CS|ZP_IE|ZP_PD|ZP_PDRV0|ZP_PDRV1|ZP_PU|ZP_SL
+ nfet_06v0 L=1U W=5U AS=1.25P AD=2.2P PS=5.5U PD=10.88U
M$1172 \$4906 \$4919
+ VSS|XN_CS|XN_IE|XN_PD|XN_PDRV0|XN_PDRV1|XN_PU|XN_SL|XP_CS|XP_IE|XP_PD|XP_PDRV0|XP_PDRV1|XP_PU|XP_SL|YN_CS|YN_IE|YN_PD|YN_PDRV0|YN_PDRV1|YN_PU|YN_SL|YP_CS|YP_IE|YP_PD|YP_PDRV0|YP_PDRV1|YP_PU|YP_SL|ZN_CS|ZN_IE|ZN_PD|ZN_PDRV0|ZN_PDRV1|ZN_PU|ZN_SL|ZP_CS|ZP_IE|ZP_PD|ZP_PDRV0|ZP_PDRV1|ZP_PU|ZP_SL
+ VSS|XN_CS|XN_IE|XN_PD|XN_PDRV0|XN_PDRV1|XN_PU|XN_SL|XP_CS|XP_IE|XP_PD|XP_PDRV0|XP_PDRV1|XP_PU|XP_SL|YN_CS|YN_IE|YN_PD|YN_PDRV0|YN_PDRV1|YN_PU|YN_SL|YP_CS|YP_IE|YP_PD|YP_PDRV0|YP_PDRV1|YP_PU|YP_SL|ZN_CS|ZN_IE|ZN_PD|ZN_PDRV0|ZN_PDRV1|ZN_PU|ZN_SL|ZP_CS|ZP_IE|ZP_PD|ZP_PDRV0|ZP_PDRV1|ZP_PU|ZP_SL
+ nfet_06v0 L=1U W=5U AS=2.2P AD=1.25P PS=10.88U PD=5.5U
M$1173 \$4857 \$4920 \$4906
+ VSS|XN_CS|XN_IE|XN_PD|XN_PDRV0|XN_PDRV1|XN_PU|XN_SL|XP_CS|XP_IE|XP_PD|XP_PDRV0|XP_PDRV1|XP_PU|XP_SL|YN_CS|YN_IE|YN_PD|YN_PDRV0|YN_PDRV1|YN_PU|YN_SL|YP_CS|YP_IE|YP_PD|YP_PDRV0|YP_PDRV1|YP_PU|YP_SL|ZN_CS|ZN_IE|ZN_PD|ZN_PDRV0|ZN_PDRV1|ZN_PU|ZN_SL|ZP_CS|ZP_IE|ZP_PD|ZP_PDRV0|ZP_PDRV1|ZP_PU|ZP_SL
+ nfet_06v0 L=1U W=5U AS=1.25P AD=2.2P PS=5.5U PD=10.88U
M$1174 \$4858 \$14437 \$4857
+ VSS|XN_CS|XN_IE|XN_PD|XN_PDRV0|XN_PDRV1|XN_PU|XN_SL|XP_CS|XP_IE|XP_PD|XP_PDRV0|XP_PDRV1|XP_PU|XP_SL|YN_CS|YN_IE|YN_PD|YN_PDRV0|YN_PDRV1|YN_PU|YN_SL|YP_CS|YP_IE|YP_PD|YP_PDRV0|YP_PDRV1|YP_PU|YP_SL|ZN_CS|ZN_IE|ZN_PD|ZN_PDRV0|ZN_PDRV1|ZN_PU|ZN_SL|ZP_CS|ZP_IE|ZP_PD|ZP_PDRV0|ZP_PDRV1|ZP_PU|ZP_SL
+ nfet_06v0 L=1U W=7.5U AS=3.3P AD=3.3P PS=15.88U PD=15.88U
M$1175 \$4859 \$14438 \$4857
+ VSS|XN_CS|XN_IE|XN_PD|XN_PDRV0|XN_PDRV1|XN_PU|XN_SL|XP_CS|XP_IE|XP_PD|XP_PDRV0|XP_PDRV1|XP_PU|XP_SL|YN_CS|YN_IE|YN_PD|YN_PDRV0|YN_PDRV1|YN_PU|YN_SL|YP_CS|YP_IE|YP_PD|YP_PDRV0|YP_PDRV1|YP_PU|YP_SL|ZN_CS|ZN_IE|ZN_PD|ZN_PDRV0|ZN_PDRV1|ZN_PU|ZN_SL|ZP_CS|ZP_IE|ZP_PD|ZP_PDRV0|ZP_PDRV1|ZP_PU|ZP_SL
+ nfet_06v0 L=1U W=8.5U AS=3.74P AD=3.74P PS=17.88U PD=17.88U
M$1176 \$4860 \$4891
+ VSS|XN_CS|XN_IE|XN_PD|XN_PDRV0|XN_PDRV1|XN_PU|XN_SL|XP_CS|XP_IE|XP_PD|XP_PDRV0|XP_PDRV1|XP_PU|XP_SL|YN_CS|YN_IE|YN_PD|YN_PDRV0|YN_PDRV1|YN_PU|YN_SL|YP_CS|YP_IE|YP_PD|YP_PDRV0|YP_PDRV1|YP_PU|YP_SL|ZN_CS|ZN_IE|ZN_PD|ZN_PDRV0|ZN_PDRV1|ZN_PU|ZN_SL|ZP_CS|ZP_IE|ZP_PD|ZP_PDRV0|ZP_PDRV1|ZP_PU|ZP_SL
+ VSS|XN_CS|XN_IE|XN_PD|XN_PDRV0|XN_PDRV1|XN_PU|XN_SL|XP_CS|XP_IE|XP_PD|XP_PDRV0|XP_PDRV1|XP_PU|XP_SL|YN_CS|YN_IE|YN_PD|YN_PDRV0|YN_PDRV1|YN_PU|YN_SL|YP_CS|YP_IE|YP_PD|YP_PDRV0|YP_PDRV1|YP_PU|YP_SL|ZN_CS|ZN_IE|ZN_PD|ZN_PDRV0|ZN_PDRV1|ZN_PU|ZN_SL|ZP_CS|ZP_IE|ZP_PD|ZP_PDRV0|ZP_PDRV1|ZP_PU|ZP_SL
+ nfet_06v0 L=1U W=2.5U AS=1.1P AD=0.825P PS=5.88U PD=3.16U
M$1177 \$4891 \$4920 \$4860
+ VSS|XN_CS|XN_IE|XN_PD|XN_PDRV0|XN_PDRV1|XN_PU|XN_SL|XP_CS|XP_IE|XP_PD|XP_PDRV0|XP_PDRV1|XP_PU|XP_SL|YN_CS|YN_IE|YN_PD|YN_PDRV0|YN_PDRV1|YN_PU|YN_SL|YP_CS|YP_IE|YP_PD|YP_PDRV0|YP_PDRV1|YP_PU|YP_SL|ZN_CS|ZN_IE|ZN_PD|ZN_PDRV0|ZN_PDRV1|ZN_PU|ZN_SL|ZP_CS|ZP_IE|ZP_PD|ZP_PDRV0|ZP_PDRV1|ZP_PU|ZP_SL
+ nfet_06v0 L=1U W=2.5U AS=0.825P AD=1.1P PS=3.16U PD=5.88U
M$1178 \$4933 \$4891
+ VSS|XN_CS|XN_IE|XN_PD|XN_PDRV0|XN_PDRV1|XN_PU|XN_SL|XP_CS|XP_IE|XP_PD|XP_PDRV0|XP_PDRV1|XP_PU|XP_SL|YN_CS|YN_IE|YN_PD|YN_PDRV0|YN_PDRV1|YN_PU|YN_SL|YP_CS|YP_IE|YP_PD|YP_PDRV0|YP_PDRV1|YP_PU|YP_SL|ZN_CS|ZN_IE|ZN_PD|ZN_PDRV0|ZN_PDRV1|ZN_PU|ZN_SL|ZP_CS|ZP_IE|ZP_PD|ZP_PDRV0|ZP_PDRV1|ZP_PU|ZP_SL
+ VSS|XN_CS|XN_IE|XN_PD|XN_PDRV0|XN_PDRV1|XN_PU|XN_SL|XP_CS|XP_IE|XP_PD|XP_PDRV0|XP_PDRV1|XP_PU|XP_SL|YN_CS|YN_IE|YN_PD|YN_PDRV0|YN_PDRV1|YN_PU|YN_SL|YP_CS|YP_IE|YP_PD|YP_PDRV0|YP_PDRV1|YP_PU|YP_SL|ZN_CS|ZN_IE|ZN_PD|ZN_PDRV0|ZN_PDRV1|ZN_PU|ZN_SL|ZP_CS|ZP_IE|ZP_PD|ZP_PDRV0|ZP_PDRV1|ZP_PU|ZP_SL
+ nfet_06v0 L=1U W=2.5U AS=1.1P AD=0.825P PS=5.88U PD=3.16U
M$1179 \$4861 \$4920 \$4933
+ VSS|XN_CS|XN_IE|XN_PD|XN_PDRV0|XN_PDRV1|XN_PU|XN_SL|XP_CS|XP_IE|XP_PD|XP_PDRV0|XP_PDRV1|XP_PU|XP_SL|YN_CS|YN_IE|YN_PD|YN_PDRV0|YN_PDRV1|YN_PU|YN_SL|YP_CS|YP_IE|YP_PD|YP_PDRV0|YP_PDRV1|YP_PU|YP_SL|ZN_CS|ZN_IE|ZN_PD|ZN_PDRV0|ZN_PDRV1|ZN_PU|ZN_SL|ZP_CS|ZP_IE|ZP_PD|ZP_PDRV0|ZP_PDRV1|ZP_PU|ZP_SL
+ nfet_06v0 L=1U W=2.5U AS=0.825P AD=1.1P PS=3.16U PD=5.88U
M$1180 \$4964 \$4892 \$4891
+ VSS|XN_CS|XN_IE|XN_PD|XN_PDRV0|XN_PDRV1|XN_PU|XN_SL|XP_CS|XP_IE|XP_PD|XP_PDRV0|XP_PDRV1|XP_PU|XP_SL|YN_CS|YN_IE|YN_PD|YN_PDRV0|YN_PDRV1|YN_PU|YN_SL|YP_CS|YP_IE|YP_PD|YP_PDRV0|YP_PDRV1|YP_PU|YP_SL|ZN_CS|ZN_IE|ZN_PD|ZN_PDRV0|ZN_PDRV1|ZN_PU|ZN_SL|ZP_CS|ZP_IE|ZP_PD|ZP_PDRV0|ZP_PDRV1|ZP_PU|ZP_SL
+ nfet_06v0 L=1U W=2U AS=0.88P AD=0.88P PS=4.88U PD=4.88U
M$1181 \$4954 \$4892 \$4861
+ VSS|XN_CS|XN_IE|XN_PD|XN_PDRV0|XN_PDRV1|XN_PU|XN_SL|XP_CS|XP_IE|XP_PD|XP_PDRV0|XP_PDRV1|XP_PU|XP_SL|YN_CS|YN_IE|YN_PD|YN_PDRV0|YN_PDRV1|YN_PU|YN_SL|YP_CS|YP_IE|YP_PD|YP_PDRV0|YP_PDRV1|YP_PU|YP_SL|ZN_CS|ZN_IE|ZN_PD|ZN_PDRV0|ZN_PDRV1|ZN_PU|ZN_SL|ZP_CS|ZP_IE|ZP_PD|ZP_PDRV0|ZP_PDRV1|ZP_PU|ZP_SL
+ nfet_06v0 L=1U W=2U AS=0.88P AD=0.88P PS=4.88U PD=4.88U
M$1182 \$4907 \$4919
+ VSS|XN_CS|XN_IE|XN_PD|XN_PDRV0|XN_PDRV1|XN_PU|XN_SL|XP_CS|XP_IE|XP_PD|XP_PDRV0|XP_PDRV1|XP_PU|XP_SL|YN_CS|YN_IE|YN_PD|YN_PDRV0|YN_PDRV1|YN_PU|YN_SL|YP_CS|YP_IE|YP_PD|YP_PDRV0|YP_PDRV1|YP_PU|YP_SL|ZN_CS|ZN_IE|ZN_PD|ZN_PDRV0|ZN_PDRV1|ZN_PU|ZN_SL|ZP_CS|ZP_IE|ZP_PD|ZP_PDRV0|ZP_PDRV1|ZP_PU|ZP_SL
+ VSS|XN_CS|XN_IE|XN_PD|XN_PDRV0|XN_PDRV1|XN_PU|XN_SL|XP_CS|XP_IE|XP_PD|XP_PDRV0|XP_PDRV1|XP_PU|XP_SL|YN_CS|YN_IE|YN_PD|YN_PDRV0|YN_PDRV1|YN_PU|YN_SL|YP_CS|YP_IE|YP_PD|YP_PDRV0|YP_PDRV1|YP_PU|YP_SL|ZN_CS|ZN_IE|ZN_PD|ZN_PDRV0|ZN_PDRV1|ZN_PU|ZN_SL|ZP_CS|ZP_IE|ZP_PD|ZP_PDRV0|ZP_PDRV1|ZP_PU|ZP_SL
+ nfet_06v0 L=1U W=5U AS=2.2P AD=1.25P PS=10.88U PD=5.5U
M$1183 \$4862 \$4920 \$4907
+ VSS|XN_CS|XN_IE|XN_PD|XN_PDRV0|XN_PDRV1|XN_PU|XN_SL|XP_CS|XP_IE|XP_PD|XP_PDRV0|XP_PDRV1|XP_PU|XP_SL|YN_CS|YN_IE|YN_PD|YN_PDRV0|YN_PDRV1|YN_PU|YN_SL|YP_CS|YP_IE|YP_PD|YP_PDRV0|YP_PDRV1|YP_PU|YP_SL|ZN_CS|ZN_IE|ZN_PD|ZN_PDRV0|ZN_PDRV1|ZN_PU|ZN_SL|ZP_CS|ZP_IE|ZP_PD|ZP_PDRV0|ZP_PDRV1|ZP_PU|ZP_SL
+ nfet_06v0 L=1U W=5U AS=1.25P AD=2.2P PS=5.5U PD=10.88U
M$1184 \$4908 \$4863
+ VSS|XN_CS|XN_IE|XN_PD|XN_PDRV0|XN_PDRV1|XN_PU|XN_SL|XP_CS|XP_IE|XP_PD|XP_PDRV0|XP_PDRV1|XP_PU|XP_SL|YN_CS|YN_IE|YN_PD|YN_PDRV0|YN_PDRV1|YN_PU|YN_SL|YP_CS|YP_IE|YP_PD|YP_PDRV0|YP_PDRV1|YP_PU|YP_SL|ZN_CS|ZN_IE|ZN_PD|ZN_PDRV0|ZN_PDRV1|ZN_PU|ZN_SL|ZP_CS|ZP_IE|ZP_PD|ZP_PDRV0|ZP_PDRV1|ZP_PU|ZP_SL
+ VSS|XN_CS|XN_IE|XN_PD|XN_PDRV0|XN_PDRV1|XN_PU|XN_SL|XP_CS|XP_IE|XP_PD|XP_PDRV0|XP_PDRV1|XP_PU|XP_SL|YN_CS|YN_IE|YN_PD|YN_PDRV0|YN_PDRV1|YN_PU|YN_SL|YP_CS|YP_IE|YP_PD|YP_PDRV0|YP_PDRV1|YP_PU|YP_SL|ZN_CS|ZN_IE|ZN_PD|ZN_PDRV0|ZN_PDRV1|ZN_PU|ZN_SL|ZP_CS|ZP_IE|ZP_PD|ZP_PDRV0|ZP_PDRV1|ZP_PU|ZP_SL
+ nfet_06v0 L=1U W=5U AS=2.2P AD=1.25P PS=10.88U PD=5.5U
M$1185 \$4863 \$4920 \$4908
+ VSS|XN_CS|XN_IE|XN_PD|XN_PDRV0|XN_PDRV1|XN_PU|XN_SL|XP_CS|XP_IE|XP_PD|XP_PDRV0|XP_PDRV1|XP_PU|XP_SL|YN_CS|YN_IE|YN_PD|YN_PDRV0|YN_PDRV1|YN_PU|YN_SL|YP_CS|YP_IE|YP_PD|YP_PDRV0|YP_PDRV1|YP_PU|YP_SL|ZN_CS|ZN_IE|ZN_PD|ZN_PDRV0|ZN_PDRV1|ZN_PU|ZN_SL|ZP_CS|ZP_IE|ZP_PD|ZP_PDRV0|ZP_PDRV1|ZP_PU|ZP_SL
+ nfet_06v0 L=1U W=5U AS=1.25P AD=1.65P PS=5.5U PD=5.66U
M$1186 \$4892 \$4892 \$4863
+ VSS|XN_CS|XN_IE|XN_PD|XN_PDRV0|XN_PDRV1|XN_PU|XN_SL|XP_CS|XP_IE|XP_PD|XP_PDRV0|XP_PDRV1|XP_PU|XP_SL|YN_CS|YN_IE|YN_PD|YN_PDRV0|YN_PDRV1|YN_PU|YN_SL|YP_CS|YP_IE|YP_PD|YP_PDRV0|YP_PDRV1|YP_PU|YP_SL|ZN_CS|ZN_IE|ZN_PD|ZN_PDRV0|ZN_PDRV1|ZN_PU|ZN_SL|ZP_CS|ZP_IE|ZP_PD|ZP_PDRV0|ZP_PDRV1|ZP_PU|ZP_SL
+ nfet_06v0 L=1U W=5U AS=1.65P AD=2.2P PS=5.66U PD=10.88U
M$1187 \$4864 \$4861
+ VSS|XN_CS|XN_IE|XN_PD|XN_PDRV0|XN_PDRV1|XN_PU|XN_SL|XP_CS|XP_IE|XP_PD|XP_PDRV0|XP_PDRV1|XP_PU|XP_SL|YN_CS|YN_IE|YN_PD|YN_PDRV0|YN_PDRV1|YN_PU|YN_SL|YP_CS|YP_IE|YP_PD|YP_PDRV0|YP_PDRV1|YP_PU|YP_SL|ZN_CS|ZN_IE|ZN_PD|ZN_PDRV0|ZN_PDRV1|ZN_PU|ZN_SL|ZP_CS|ZP_IE|ZP_PD|ZP_PDRV0|ZP_PDRV1|ZP_PU|ZP_SL
+ VSS|XN_CS|XN_IE|XN_PD|XN_PDRV0|XN_PDRV1|XN_PU|XN_SL|XP_CS|XP_IE|XP_PD|XP_PDRV0|XP_PDRV1|XP_PU|XP_SL|YN_CS|YN_IE|YN_PD|YN_PDRV0|YN_PDRV1|YN_PU|YN_SL|YP_CS|YP_IE|YP_PD|YP_PDRV0|YP_PDRV1|YP_PU|YP_SL|ZN_CS|ZN_IE|ZN_PD|ZN_PDRV0|ZN_PDRV1|ZN_PU|ZN_SL|ZP_CS|ZP_IE|ZP_PD|ZP_PDRV0|ZP_PDRV1|ZP_PU|ZP_SL
+ nfet_06v0 L=1U W=1U AS=0.44P AD=0.44P PS=2.88U PD=2.88U
M$1188 \$4920 \$4920
+ VSS|XN_CS|XN_IE|XN_PD|XN_PDRV0|XN_PDRV1|XN_PU|XN_SL|XP_CS|XP_IE|XP_PD|XP_PDRV0|XP_PDRV1|XP_PU|XP_SL|YN_CS|YN_IE|YN_PD|YN_PDRV0|YN_PDRV1|YN_PU|YN_SL|YP_CS|YP_IE|YP_PD|YP_PDRV0|YP_PDRV1|YP_PU|YP_SL|ZN_CS|ZN_IE|ZN_PD|ZN_PDRV0|ZN_PDRV1|ZN_PU|ZN_SL|ZP_CS|ZP_IE|ZP_PD|ZP_PDRV0|ZP_PDRV1|ZP_PU|ZP_SL
+ VSS|XN_CS|XN_IE|XN_PD|XN_PDRV0|XN_PDRV1|XN_PU|XN_SL|XP_CS|XP_IE|XP_PD|XP_PDRV0|XP_PDRV1|XP_PU|XP_SL|YN_CS|YN_IE|YN_PD|YN_PDRV0|YN_PDRV1|YN_PU|YN_SL|YP_CS|YP_IE|YP_PD|YP_PDRV0|YP_PDRV1|YP_PU|YP_SL|ZN_CS|ZN_IE|ZN_PD|ZN_PDRV0|ZN_PDRV1|ZN_PU|ZN_SL|ZP_CS|ZP_IE|ZP_PD|ZP_PDRV0|ZP_PDRV1|ZP_PU|ZP_SL
+ nfet_06v0 L=1U W=1U AS=0.44P AD=0.44P PS=2.88U PD=2.88U
M$1189 \$4909 \$4919
+ VSS|XN_CS|XN_IE|XN_PD|XN_PDRV0|XN_PDRV1|XN_PU|XN_SL|XP_CS|XP_IE|XP_PD|XP_PDRV0|XP_PDRV1|XP_PU|XP_SL|YN_CS|YN_IE|YN_PD|YN_PDRV0|YN_PDRV1|YN_PU|YN_SL|YP_CS|YP_IE|YP_PD|YP_PDRV0|YP_PDRV1|YP_PU|YP_SL|ZN_CS|ZN_IE|ZN_PD|ZN_PDRV0|ZN_PDRV1|ZN_PU|ZN_SL|ZP_CS|ZP_IE|ZP_PD|ZP_PDRV0|ZP_PDRV1|ZP_PU|ZP_SL
+ VSS|XN_CS|XN_IE|XN_PD|XN_PDRV0|XN_PDRV1|XN_PU|XN_SL|XP_CS|XP_IE|XP_PD|XP_PDRV0|XP_PDRV1|XP_PU|XP_SL|YN_CS|YN_IE|YN_PD|YN_PDRV0|YN_PDRV1|YN_PU|YN_SL|YP_CS|YP_IE|YP_PD|YP_PDRV0|YP_PDRV1|YP_PU|YP_SL|ZN_CS|ZN_IE|ZN_PD|ZN_PDRV0|ZN_PDRV1|ZN_PU|ZN_SL|ZP_CS|ZP_IE|ZP_PD|ZP_PDRV0|ZP_PDRV1|ZP_PU|ZP_SL
+ nfet_06v0 L=1U W=5U AS=2.2P AD=1.25P PS=10.88U PD=5.5U
M$1190 \$4919 \$4920 \$4909
+ VSS|XN_CS|XN_IE|XN_PD|XN_PDRV0|XN_PDRV1|XN_PU|XN_SL|XP_CS|XP_IE|XP_PD|XP_PDRV0|XP_PDRV1|XP_PU|XP_SL|YN_CS|YN_IE|YN_PD|YN_PDRV0|YN_PDRV1|YN_PU|YN_SL|YP_CS|YP_IE|YP_PD|YP_PDRV0|YP_PDRV1|YP_PU|YP_SL|ZN_CS|ZN_IE|ZN_PD|ZN_PDRV0|ZN_PDRV1|ZN_PU|ZN_SL|ZP_CS|ZP_IE|ZP_PD|ZP_PDRV0|ZP_PDRV1|ZP_PU|ZP_SL
+ nfet_06v0 L=1U W=5U AS=1.25P AD=2.2P PS=5.5U PD=10.88U
M$1191 \$4885 \$4946
+ VSS|XN_CS|XN_IE|XN_PD|XN_PDRV0|XN_PDRV1|XN_PU|XN_SL|XP_CS|XP_IE|XP_PD|XP_PDRV0|XP_PDRV1|XP_PU|XP_SL|YN_CS|YN_IE|YN_PD|YN_PDRV0|YN_PDRV1|YN_PU|YN_SL|YP_CS|YP_IE|YP_PD|YP_PDRV0|YP_PDRV1|YP_PU|YP_SL|ZN_CS|ZN_IE|ZN_PD|ZN_PDRV0|ZN_PDRV1|ZN_PU|ZN_SL|ZP_CS|ZP_IE|ZP_PD|ZP_PDRV0|ZP_PDRV1|ZP_PU|ZP_SL
+ VSS|XN_CS|XN_IE|XN_PD|XN_PDRV0|XN_PDRV1|XN_PU|XN_SL|XP_CS|XP_IE|XP_PD|XP_PDRV0|XP_PDRV1|XP_PU|XP_SL|YN_CS|YN_IE|YN_PD|YN_PDRV0|YN_PDRV1|YN_PU|YN_SL|YP_CS|YP_IE|YP_PD|YP_PDRV0|YP_PDRV1|YP_PU|YP_SL|ZN_CS|ZN_IE|ZN_PD|ZN_PDRV0|ZN_PDRV1|ZN_PU|ZN_SL|ZP_CS|ZP_IE|ZP_PD|ZP_PDRV0|ZP_PDRV1|ZP_PU|ZP_SL
+ nfet_06v0 L=1U W=1U AS=0.44P AD=0.25P PS=2.88U PD=1.5U
M$1192 \$4926 \$4946 \$4885
+ VSS|XN_CS|XN_IE|XN_PD|XN_PDRV0|XN_PDRV1|XN_PU|XN_SL|XP_CS|XP_IE|XP_PD|XP_PDRV0|XP_PDRV1|XP_PU|XP_SL|YN_CS|YN_IE|YN_PD|YN_PDRV0|YN_PDRV1|YN_PU|YN_SL|YP_CS|YP_IE|YP_PD|YP_PDRV0|YP_PDRV1|YP_PU|YP_SL|ZN_CS|ZN_IE|ZN_PD|ZN_PDRV0|ZN_PDRV1|ZN_PU|ZN_SL|ZP_CS|ZP_IE|ZP_PD|ZP_PDRV0|ZP_PDRV1|ZP_PU|ZP_SL
+ nfet_06v0 L=1U W=1U AS=0.25P AD=0.44P PS=1.5U PD=2.88U
M$1193 \$4886 \$4946
+ VSS|XN_CS|XN_IE|XN_PD|XN_PDRV0|XN_PDRV1|XN_PU|XN_SL|XP_CS|XP_IE|XP_PD|XP_PDRV0|XP_PDRV1|XP_PU|XP_SL|YN_CS|YN_IE|YN_PD|YN_PDRV0|YN_PDRV1|YN_PU|YN_SL|YP_CS|YP_IE|YP_PD|YP_PDRV0|YP_PDRV1|YP_PU|YP_SL|ZN_CS|ZN_IE|ZN_PD|ZN_PDRV0|ZN_PDRV1|ZN_PU|ZN_SL|ZP_CS|ZP_IE|ZP_PD|ZP_PDRV0|ZP_PDRV1|ZP_PU|ZP_SL
+ VSS|XN_CS|XN_IE|XN_PD|XN_PDRV0|XN_PDRV1|XN_PU|XN_SL|XP_CS|XP_IE|XP_PD|XP_PDRV0|XP_PDRV1|XP_PU|XP_SL|YN_CS|YN_IE|YN_PD|YN_PDRV0|YN_PDRV1|YN_PU|YN_SL|YP_CS|YP_IE|YP_PD|YP_PDRV0|YP_PDRV1|YP_PU|YP_SL|ZN_CS|ZN_IE|ZN_PD|ZN_PDRV0|ZN_PDRV1|ZN_PU|ZN_SL|ZP_CS|ZP_IE|ZP_PD|ZP_PDRV0|ZP_PDRV1|ZP_PU|ZP_SL
+ nfet_06v0 L=1U W=1U AS=0.44P AD=0.25P PS=2.88U PD=1.5U
M$1194 \$4946 \$4946 \$4886
+ VSS|XN_CS|XN_IE|XN_PD|XN_PDRV0|XN_PDRV1|XN_PU|XN_SL|XP_CS|XP_IE|XP_PD|XP_PDRV0|XP_PDRV1|XP_PU|XP_SL|YN_CS|YN_IE|YN_PD|YN_PDRV0|YN_PDRV1|YN_PU|YN_SL|YP_CS|YP_IE|YP_PD|YP_PDRV0|YP_PDRV1|YP_PU|YP_SL|ZN_CS|ZN_IE|ZN_PD|ZN_PDRV0|ZN_PDRV1|ZN_PU|ZN_SL|ZP_CS|ZP_IE|ZP_PD|ZP_PDRV0|ZP_PDRV1|ZP_PU|ZP_SL
+ nfet_06v0 L=1U W=1U AS=0.25P AD=0.44P PS=1.5U PD=2.88U
M$1195
+ VSS|XN_CS|XN_IE|XN_PD|XN_PDRV0|XN_PDRV1|XN_PU|XN_SL|XP_CS|XP_IE|XP_PD|XP_PDRV0|XP_PDRV1|XP_PU|XP_SL|YN_CS|YN_IE|YN_PD|YN_PDRV0|YN_PDRV1|YN_PU|YN_SL|YP_CS|YP_IE|YP_PD|YP_PDRV0|YP_PDRV1|YP_PU|YP_SL|ZN_CS|ZN_IE|ZN_PD|ZN_PDRV0|ZN_PDRV1|ZN_PU|ZN_SL|ZP_CS|ZP_IE|ZP_PD|ZP_PDRV0|ZP_PDRV1|ZP_PU|ZP_SL
+ VDD|XN_OE|XP_OE|YN_OE|YP_OE|ZN_OE|ZP_OE
+ VSS|XN_CS|XN_IE|XN_PD|XN_PDRV0|XN_PDRV1|XN_PU|XN_SL|XP_CS|XP_IE|XP_PD|XP_PDRV0|XP_PDRV1|XP_PU|XP_SL|YN_CS|YN_IE|YN_PD|YN_PDRV0|YN_PDRV1|YN_PU|YN_SL|YP_CS|YP_IE|YP_PD|YP_PDRV0|YP_PDRV1|YP_PU|YP_SL|ZN_CS|ZN_IE|ZN_PD|ZN_PDRV0|ZN_PDRV1|ZN_PU|ZN_SL|ZP_CS|ZP_IE|ZP_PD|ZP_PDRV0|ZP_PDRV1|ZP_PU|ZP_SL
+ VSS|XN_CS|XN_IE|XN_PD|XN_PDRV0|XN_PDRV1|XN_PU|XN_SL|XP_CS|XP_IE|XP_PD|XP_PDRV0|XP_PDRV1|XP_PU|XP_SL|YN_CS|YN_IE|YN_PD|YN_PDRV0|YN_PDRV1|YN_PU|YN_SL|YP_CS|YP_IE|YP_PD|YP_PDRV0|YP_PDRV1|YP_PU|YP_SL|ZN_CS|ZN_IE|ZN_PD|ZN_PDRV0|ZN_PDRV1|ZN_PU|ZN_SL|ZP_CS|ZP_IE|ZP_PD|ZP_PDRV0|ZP_PDRV1|ZP_PU|ZP_SL
+ nfet_06v0 L=2U W=18U AS=7.92P AD=7.92P PS=36.88U PD=36.88U
M$1196
+ VSS|XN_CS|XN_IE|XN_PD|XN_PDRV0|XN_PDRV1|XN_PU|XN_SL|XP_CS|XP_IE|XP_PD|XP_PDRV0|XP_PDRV1|XP_PU|XP_SL|YN_CS|YN_IE|YN_PD|YN_PDRV0|YN_PDRV1|YN_PU|YN_SL|YP_CS|YP_IE|YP_PD|YP_PDRV0|YP_PDRV1|YP_PU|YP_SL|ZN_CS|ZN_IE|ZN_PD|ZN_PDRV0|ZN_PDRV1|ZN_PU|ZN_SL|ZP_CS|ZP_IE|ZP_PD|ZP_PDRV0|ZP_PDRV1|ZP_PU|ZP_SL
+ VDD|XN_OE|XP_OE|YN_OE|YP_OE|ZN_OE|ZP_OE
+ VSS|XN_CS|XN_IE|XN_PD|XN_PDRV0|XN_PDRV1|XN_PU|XN_SL|XP_CS|XP_IE|XP_PD|XP_PDRV0|XP_PDRV1|XP_PU|XP_SL|YN_CS|YN_IE|YN_PD|YN_PDRV0|YN_PDRV1|YN_PU|YN_SL|YP_CS|YP_IE|YP_PD|YP_PDRV0|YP_PDRV1|YP_PU|YP_SL|ZN_CS|ZN_IE|ZN_PD|ZN_PDRV0|ZN_PDRV1|ZN_PU|ZN_SL|ZP_CS|ZP_IE|ZP_PD|ZP_PDRV0|ZP_PDRV1|ZP_PU|ZP_SL
+ VSS|XN_CS|XN_IE|XN_PD|XN_PDRV0|XN_PDRV1|XN_PU|XN_SL|XP_CS|XP_IE|XP_PD|XP_PDRV0|XP_PDRV1|XP_PU|XP_SL|YN_CS|YN_IE|YN_PD|YN_PDRV0|YN_PDRV1|YN_PU|YN_SL|YP_CS|YP_IE|YP_PD|YP_PDRV0|YP_PDRV1|YP_PU|YP_SL|ZN_CS|ZN_IE|ZN_PD|ZN_PDRV0|ZN_PDRV1|ZN_PU|ZN_SL|ZP_CS|ZP_IE|ZP_PD|ZP_PDRV0|ZP_PDRV1|ZP_PU|ZP_SL
+ nfet_06v0 L=2U W=18U AS=7.92P AD=7.92P PS=36.88U PD=36.88U
M$1197 \$4912 \$4921
+ VSS|XN_CS|XN_IE|XN_PD|XN_PDRV0|XN_PDRV1|XN_PU|XN_SL|XP_CS|XP_IE|XP_PD|XP_PDRV0|XP_PDRV1|XP_PU|XP_SL|YN_CS|YN_IE|YN_PD|YN_PDRV0|YN_PDRV1|YN_PU|YN_SL|YP_CS|YP_IE|YP_PD|YP_PDRV0|YP_PDRV1|YP_PU|YP_SL|ZN_CS|ZN_IE|ZN_PD|ZN_PDRV0|ZN_PDRV1|ZN_PU|ZN_SL|ZP_CS|ZP_IE|ZP_PD|ZP_PDRV0|ZP_PDRV1|ZP_PU|ZP_SL
+ VSS|XN_CS|XN_IE|XN_PD|XN_PDRV0|XN_PDRV1|XN_PU|XN_SL|XP_CS|XP_IE|XP_PD|XP_PDRV0|XP_PDRV1|XP_PU|XP_SL|YN_CS|YN_IE|YN_PD|YN_PDRV0|YN_PDRV1|YN_PU|YN_SL|YP_CS|YP_IE|YP_PD|YP_PDRV0|YP_PDRV1|YP_PU|YP_SL|ZN_CS|ZN_IE|ZN_PD|ZN_PDRV0|ZN_PDRV1|ZN_PU|ZN_SL|ZP_CS|ZP_IE|ZP_PD|ZP_PDRV0|ZP_PDRV1|ZP_PU|ZP_SL
+ nfet_06v0 L=1U W=5U AS=2.2P AD=1.25P PS=10.88U PD=5.5U
M$1198 \$4865 \$4922 \$4912
+ VSS|XN_CS|XN_IE|XN_PD|XN_PDRV0|XN_PDRV1|XN_PU|XN_SL|XP_CS|XP_IE|XP_PD|XP_PDRV0|XP_PDRV1|XP_PU|XP_SL|YN_CS|YN_IE|YN_PD|YN_PDRV0|YN_PDRV1|YN_PU|YN_SL|YP_CS|YP_IE|YP_PD|YP_PDRV0|YP_PDRV1|YP_PU|YP_SL|ZN_CS|ZN_IE|ZN_PD|ZN_PDRV0|ZN_PDRV1|ZN_PU|ZN_SL|ZP_CS|ZP_IE|ZP_PD|ZP_PDRV0|ZP_PDRV1|ZP_PU|ZP_SL
+ nfet_06v0 L=1U W=5U AS=1.25P AD=2.2P PS=5.5U PD=10.88U
M$1199 \$4913 \$4921
+ VSS|XN_CS|XN_IE|XN_PD|XN_PDRV0|XN_PDRV1|XN_PU|XN_SL|XP_CS|XP_IE|XP_PD|XP_PDRV0|XP_PDRV1|XP_PU|XP_SL|YN_CS|YN_IE|YN_PD|YN_PDRV0|YN_PDRV1|YN_PU|YN_SL|YP_CS|YP_IE|YP_PD|YP_PDRV0|YP_PDRV1|YP_PU|YP_SL|ZN_CS|ZN_IE|ZN_PD|ZN_PDRV0|ZN_PDRV1|ZN_PU|ZN_SL|ZP_CS|ZP_IE|ZP_PD|ZP_PDRV0|ZP_PDRV1|ZP_PU|ZP_SL
+ VSS|XN_CS|XN_IE|XN_PD|XN_PDRV0|XN_PDRV1|XN_PU|XN_SL|XP_CS|XP_IE|XP_PD|XP_PDRV0|XP_PDRV1|XP_PU|XP_SL|YN_CS|YN_IE|YN_PD|YN_PDRV0|YN_PDRV1|YN_PU|YN_SL|YP_CS|YP_IE|YP_PD|YP_PDRV0|YP_PDRV1|YP_PU|YP_SL|ZN_CS|ZN_IE|ZN_PD|ZN_PDRV0|ZN_PDRV1|ZN_PU|ZN_SL|ZP_CS|ZP_IE|ZP_PD|ZP_PDRV0|ZP_PDRV1|ZP_PU|ZP_SL
+ nfet_06v0 L=1U W=5U AS=2.2P AD=1.25P PS=10.88U PD=5.5U
M$1200 \$4865 \$4922 \$4913
+ VSS|XN_CS|XN_IE|XN_PD|XN_PDRV0|XN_PDRV1|XN_PU|XN_SL|XP_CS|XP_IE|XP_PD|XP_PDRV0|XP_PDRV1|XP_PU|XP_SL|YN_CS|YN_IE|YN_PD|YN_PDRV0|YN_PDRV1|YN_PU|YN_SL|YP_CS|YP_IE|YP_PD|YP_PDRV0|YP_PDRV1|YP_PU|YP_SL|ZN_CS|ZN_IE|ZN_PD|ZN_PDRV0|ZN_PDRV1|ZN_PU|ZN_SL|ZP_CS|ZP_IE|ZP_PD|ZP_PDRV0|ZP_PDRV1|ZP_PU|ZP_SL
+ nfet_06v0 L=1U W=5U AS=1.25P AD=2.2P PS=5.5U PD=10.88U
M$1201 \$4866 S4P \$4865
+ VSS|XN_CS|XN_IE|XN_PD|XN_PDRV0|XN_PDRV1|XN_PU|XN_SL|XP_CS|XP_IE|XP_PD|XP_PDRV0|XP_PDRV1|XP_PU|XP_SL|YN_CS|YN_IE|YN_PD|YN_PDRV0|YN_PDRV1|YN_PU|YN_SL|YP_CS|YP_IE|YP_PD|YP_PDRV0|YP_PDRV1|YP_PU|YP_SL|ZN_CS|ZN_IE|ZN_PD|ZN_PDRV0|ZN_PDRV1|ZN_PU|ZN_SL|ZP_CS|ZP_IE|ZP_PD|ZP_PDRV0|ZP_PDRV1|ZP_PU|ZP_SL
+ nfet_06v0 L=1U W=7.5U AS=3.3P AD=3.3P PS=15.88U PD=15.88U
M$1202 \$4867 S4N \$4865
+ VSS|XN_CS|XN_IE|XN_PD|XN_PDRV0|XN_PDRV1|XN_PU|XN_SL|XP_CS|XP_IE|XP_PD|XP_PDRV0|XP_PDRV1|XP_PU|XP_SL|YN_CS|YN_IE|YN_PD|YN_PDRV0|YN_PDRV1|YN_PU|YN_SL|YP_CS|YP_IE|YP_PD|YP_PDRV0|YP_PDRV1|YP_PU|YP_SL|ZN_CS|ZN_IE|ZN_PD|ZN_PDRV0|ZN_PDRV1|ZN_PU|ZN_SL|ZP_CS|ZP_IE|ZP_PD|ZP_PDRV0|ZP_PDRV1|ZP_PU|ZP_SL
+ nfet_06v0 L=1U W=8.5U AS=3.74P AD=3.74P PS=17.88U PD=17.88U
M$1203 \$4868 \$4893
+ VSS|XN_CS|XN_IE|XN_PD|XN_PDRV0|XN_PDRV1|XN_PU|XN_SL|XP_CS|XP_IE|XP_PD|XP_PDRV0|XP_PDRV1|XP_PU|XP_SL|YN_CS|YN_IE|YN_PD|YN_PDRV0|YN_PDRV1|YN_PU|YN_SL|YP_CS|YP_IE|YP_PD|YP_PDRV0|YP_PDRV1|YP_PU|YP_SL|ZN_CS|ZN_IE|ZN_PD|ZN_PDRV0|ZN_PDRV1|ZN_PU|ZN_SL|ZP_CS|ZP_IE|ZP_PD|ZP_PDRV0|ZP_PDRV1|ZP_PU|ZP_SL
+ VSS|XN_CS|XN_IE|XN_PD|XN_PDRV0|XN_PDRV1|XN_PU|XN_SL|XP_CS|XP_IE|XP_PD|XP_PDRV0|XP_PDRV1|XP_PU|XP_SL|YN_CS|YN_IE|YN_PD|YN_PDRV0|YN_PDRV1|YN_PU|YN_SL|YP_CS|YP_IE|YP_PD|YP_PDRV0|YP_PDRV1|YP_PU|YP_SL|ZN_CS|ZN_IE|ZN_PD|ZN_PDRV0|ZN_PDRV1|ZN_PU|ZN_SL|ZP_CS|ZP_IE|ZP_PD|ZP_PDRV0|ZP_PDRV1|ZP_PU|ZP_SL
+ nfet_06v0 L=1U W=2.5U AS=1.1P AD=0.825P PS=5.88U PD=3.16U
M$1204 \$4893 \$4922 \$4868
+ VSS|XN_CS|XN_IE|XN_PD|XN_PDRV0|XN_PDRV1|XN_PU|XN_SL|XP_CS|XP_IE|XP_PD|XP_PDRV0|XP_PDRV1|XP_PU|XP_SL|YN_CS|YN_IE|YN_PD|YN_PDRV0|YN_PDRV1|YN_PU|YN_SL|YP_CS|YP_IE|YP_PD|YP_PDRV0|YP_PDRV1|YP_PU|YP_SL|ZN_CS|ZN_IE|ZN_PD|ZN_PDRV0|ZN_PDRV1|ZN_PU|ZN_SL|ZP_CS|ZP_IE|ZP_PD|ZP_PDRV0|ZP_PDRV1|ZP_PU|ZP_SL
+ nfet_06v0 L=1U W=2.5U AS=0.825P AD=1.1P PS=3.16U PD=5.88U
M$1205 \$4937 \$4893
+ VSS|XN_CS|XN_IE|XN_PD|XN_PDRV0|XN_PDRV1|XN_PU|XN_SL|XP_CS|XP_IE|XP_PD|XP_PDRV0|XP_PDRV1|XP_PU|XP_SL|YN_CS|YN_IE|YN_PD|YN_PDRV0|YN_PDRV1|YN_PU|YN_SL|YP_CS|YP_IE|YP_PD|YP_PDRV0|YP_PDRV1|YP_PU|YP_SL|ZN_CS|ZN_IE|ZN_PD|ZN_PDRV0|ZN_PDRV1|ZN_PU|ZN_SL|ZP_CS|ZP_IE|ZP_PD|ZP_PDRV0|ZP_PDRV1|ZP_PU|ZP_SL
+ VSS|XN_CS|XN_IE|XN_PD|XN_PDRV0|XN_PDRV1|XN_PU|XN_SL|XP_CS|XP_IE|XP_PD|XP_PDRV0|XP_PDRV1|XP_PU|XP_SL|YN_CS|YN_IE|YN_PD|YN_PDRV0|YN_PDRV1|YN_PU|YN_SL|YP_CS|YP_IE|YP_PD|YP_PDRV0|YP_PDRV1|YP_PU|YP_SL|ZN_CS|ZN_IE|ZN_PD|ZN_PDRV0|ZN_PDRV1|ZN_PU|ZN_SL|ZP_CS|ZP_IE|ZP_PD|ZP_PDRV0|ZP_PDRV1|ZP_PU|ZP_SL
+ nfet_06v0 L=1U W=2.5U AS=1.1P AD=0.825P PS=5.88U PD=3.16U
M$1206 \$4869 \$4922 \$4937
+ VSS|XN_CS|XN_IE|XN_PD|XN_PDRV0|XN_PDRV1|XN_PU|XN_SL|XP_CS|XP_IE|XP_PD|XP_PDRV0|XP_PDRV1|XP_PU|XP_SL|YN_CS|YN_IE|YN_PD|YN_PDRV0|YN_PDRV1|YN_PU|YN_SL|YP_CS|YP_IE|YP_PD|YP_PDRV0|YP_PDRV1|YP_PU|YP_SL|ZN_CS|ZN_IE|ZN_PD|ZN_PDRV0|ZN_PDRV1|ZN_PU|ZN_SL|ZP_CS|ZP_IE|ZP_PD|ZP_PDRV0|ZP_PDRV1|ZP_PU|ZP_SL
+ nfet_06v0 L=1U W=2.5U AS=0.825P AD=1.1P PS=3.16U PD=5.88U
M$1207 \$4966 \$4894 \$4893
+ VSS|XN_CS|XN_IE|XN_PD|XN_PDRV0|XN_PDRV1|XN_PU|XN_SL|XP_CS|XP_IE|XP_PD|XP_PDRV0|XP_PDRV1|XP_PU|XP_SL|YN_CS|YN_IE|YN_PD|YN_PDRV0|YN_PDRV1|YN_PU|YN_SL|YP_CS|YP_IE|YP_PD|YP_PDRV0|YP_PDRV1|YP_PU|YP_SL|ZN_CS|ZN_IE|ZN_PD|ZN_PDRV0|ZN_PDRV1|ZN_PU|ZN_SL|ZP_CS|ZP_IE|ZP_PD|ZP_PDRV0|ZP_PDRV1|ZP_PU|ZP_SL
+ nfet_06v0 L=1U W=2U AS=0.88P AD=0.88P PS=4.88U PD=4.88U
M$1208 \$4957 \$4894 \$4869
+ VSS|XN_CS|XN_IE|XN_PD|XN_PDRV0|XN_PDRV1|XN_PU|XN_SL|XP_CS|XP_IE|XP_PD|XP_PDRV0|XP_PDRV1|XP_PU|XP_SL|YN_CS|YN_IE|YN_PD|YN_PDRV0|YN_PDRV1|YN_PU|YN_SL|YP_CS|YP_IE|YP_PD|YP_PDRV0|YP_PDRV1|YP_PU|YP_SL|ZN_CS|ZN_IE|ZN_PD|ZN_PDRV0|ZN_PDRV1|ZN_PU|ZN_SL|ZP_CS|ZP_IE|ZP_PD|ZP_PDRV0|ZP_PDRV1|ZP_PU|ZP_SL
+ nfet_06v0 L=1U W=2U AS=0.88P AD=0.88P PS=4.88U PD=4.88U
M$1209 \$4915 \$4921
+ VSS|XN_CS|XN_IE|XN_PD|XN_PDRV0|XN_PDRV1|XN_PU|XN_SL|XP_CS|XP_IE|XP_PD|XP_PDRV0|XP_PDRV1|XP_PU|XP_SL|YN_CS|YN_IE|YN_PD|YN_PDRV0|YN_PDRV1|YN_PU|YN_SL|YP_CS|YP_IE|YP_PD|YP_PDRV0|YP_PDRV1|YP_PU|YP_SL|ZN_CS|ZN_IE|ZN_PD|ZN_PDRV0|ZN_PDRV1|ZN_PU|ZN_SL|ZP_CS|ZP_IE|ZP_PD|ZP_PDRV0|ZP_PDRV1|ZP_PU|ZP_SL
+ VSS|XN_CS|XN_IE|XN_PD|XN_PDRV0|XN_PDRV1|XN_PU|XN_SL|XP_CS|XP_IE|XP_PD|XP_PDRV0|XP_PDRV1|XP_PU|XP_SL|YN_CS|YN_IE|YN_PD|YN_PDRV0|YN_PDRV1|YN_PU|YN_SL|YP_CS|YP_IE|YP_PD|YP_PDRV0|YP_PDRV1|YP_PU|YP_SL|ZN_CS|ZN_IE|ZN_PD|ZN_PDRV0|ZN_PDRV1|ZN_PU|ZN_SL|ZP_CS|ZP_IE|ZP_PD|ZP_PDRV0|ZP_PDRV1|ZP_PU|ZP_SL
+ nfet_06v0 L=1U W=5U AS=2.2P AD=1.25P PS=10.88U PD=5.5U
M$1210 \$4870 \$4922 \$4915
+ VSS|XN_CS|XN_IE|XN_PD|XN_PDRV0|XN_PDRV1|XN_PU|XN_SL|XP_CS|XP_IE|XP_PD|XP_PDRV0|XP_PDRV1|XP_PU|XP_SL|YN_CS|YN_IE|YN_PD|YN_PDRV0|YN_PDRV1|YN_PU|YN_SL|YP_CS|YP_IE|YP_PD|YP_PDRV0|YP_PDRV1|YP_PU|YP_SL|ZN_CS|ZN_IE|ZN_PD|ZN_PDRV0|ZN_PDRV1|ZN_PU|ZN_SL|ZP_CS|ZP_IE|ZP_PD|ZP_PDRV0|ZP_PDRV1|ZP_PU|ZP_SL
+ nfet_06v0 L=1U W=5U AS=1.25P AD=2.2P PS=5.5U PD=10.88U
M$1211 \$4916 \$4871
+ VSS|XN_CS|XN_IE|XN_PD|XN_PDRV0|XN_PDRV1|XN_PU|XN_SL|XP_CS|XP_IE|XP_PD|XP_PDRV0|XP_PDRV1|XP_PU|XP_SL|YN_CS|YN_IE|YN_PD|YN_PDRV0|YN_PDRV1|YN_PU|YN_SL|YP_CS|YP_IE|YP_PD|YP_PDRV0|YP_PDRV1|YP_PU|YP_SL|ZN_CS|ZN_IE|ZN_PD|ZN_PDRV0|ZN_PDRV1|ZN_PU|ZN_SL|ZP_CS|ZP_IE|ZP_PD|ZP_PDRV0|ZP_PDRV1|ZP_PU|ZP_SL
+ VSS|XN_CS|XN_IE|XN_PD|XN_PDRV0|XN_PDRV1|XN_PU|XN_SL|XP_CS|XP_IE|XP_PD|XP_PDRV0|XP_PDRV1|XP_PU|XP_SL|YN_CS|YN_IE|YN_PD|YN_PDRV0|YN_PDRV1|YN_PU|YN_SL|YP_CS|YP_IE|YP_PD|YP_PDRV0|YP_PDRV1|YP_PU|YP_SL|ZN_CS|ZN_IE|ZN_PD|ZN_PDRV0|ZN_PDRV1|ZN_PU|ZN_SL|ZP_CS|ZP_IE|ZP_PD|ZP_PDRV0|ZP_PDRV1|ZP_PU|ZP_SL
+ nfet_06v0 L=1U W=5U AS=2.2P AD=1.25P PS=10.88U PD=5.5U
M$1212 \$4871 \$4922 \$4916
+ VSS|XN_CS|XN_IE|XN_PD|XN_PDRV0|XN_PDRV1|XN_PU|XN_SL|XP_CS|XP_IE|XP_PD|XP_PDRV0|XP_PDRV1|XP_PU|XP_SL|YN_CS|YN_IE|YN_PD|YN_PDRV0|YN_PDRV1|YN_PU|YN_SL|YP_CS|YP_IE|YP_PD|YP_PDRV0|YP_PDRV1|YP_PU|YP_SL|ZN_CS|ZN_IE|ZN_PD|ZN_PDRV0|ZN_PDRV1|ZN_PU|ZN_SL|ZP_CS|ZP_IE|ZP_PD|ZP_PDRV0|ZP_PDRV1|ZP_PU|ZP_SL
+ nfet_06v0 L=1U W=5U AS=1.25P AD=1.65P PS=5.5U PD=5.66U
M$1213 \$4894 \$4894 \$4871
+ VSS|XN_CS|XN_IE|XN_PD|XN_PDRV0|XN_PDRV1|XN_PU|XN_SL|XP_CS|XP_IE|XP_PD|XP_PDRV0|XP_PDRV1|XP_PU|XP_SL|YN_CS|YN_IE|YN_PD|YN_PDRV0|YN_PDRV1|YN_PU|YN_SL|YP_CS|YP_IE|YP_PD|YP_PDRV0|YP_PDRV1|YP_PU|YP_SL|ZN_CS|ZN_IE|ZN_PD|ZN_PDRV0|ZN_PDRV1|ZN_PU|ZN_SL|ZP_CS|ZP_IE|ZP_PD|ZP_PDRV0|ZP_PDRV1|ZP_PU|ZP_SL
+ nfet_06v0 L=1U W=5U AS=1.65P AD=2.2P PS=5.66U PD=10.88U
M$1214 \$4872 \$4869
+ VSS|XN_CS|XN_IE|XN_PD|XN_PDRV0|XN_PDRV1|XN_PU|XN_SL|XP_CS|XP_IE|XP_PD|XP_PDRV0|XP_PDRV1|XP_PU|XP_SL|YN_CS|YN_IE|YN_PD|YN_PDRV0|YN_PDRV1|YN_PU|YN_SL|YP_CS|YP_IE|YP_PD|YP_PDRV0|YP_PDRV1|YP_PU|YP_SL|ZN_CS|ZN_IE|ZN_PD|ZN_PDRV0|ZN_PDRV1|ZN_PU|ZN_SL|ZP_CS|ZP_IE|ZP_PD|ZP_PDRV0|ZP_PDRV1|ZP_PU|ZP_SL
+ VSS|XN_CS|XN_IE|XN_PD|XN_PDRV0|XN_PDRV1|XN_PU|XN_SL|XP_CS|XP_IE|XP_PD|XP_PDRV0|XP_PDRV1|XP_PU|XP_SL|YN_CS|YN_IE|YN_PD|YN_PDRV0|YN_PDRV1|YN_PU|YN_SL|YP_CS|YP_IE|YP_PD|YP_PDRV0|YP_PDRV1|YP_PU|YP_SL|ZN_CS|ZN_IE|ZN_PD|ZN_PDRV0|ZN_PDRV1|ZN_PU|ZN_SL|ZP_CS|ZP_IE|ZP_PD|ZP_PDRV0|ZP_PDRV1|ZP_PU|ZP_SL
+ nfet_06v0 L=1U W=1U AS=0.44P AD=0.44P PS=2.88U PD=2.88U
M$1215 \$4922 \$4922
+ VSS|XN_CS|XN_IE|XN_PD|XN_PDRV0|XN_PDRV1|XN_PU|XN_SL|XP_CS|XP_IE|XP_PD|XP_PDRV0|XP_PDRV1|XP_PU|XP_SL|YN_CS|YN_IE|YN_PD|YN_PDRV0|YN_PDRV1|YN_PU|YN_SL|YP_CS|YP_IE|YP_PD|YP_PDRV0|YP_PDRV1|YP_PU|YP_SL|ZN_CS|ZN_IE|ZN_PD|ZN_PDRV0|ZN_PDRV1|ZN_PU|ZN_SL|ZP_CS|ZP_IE|ZP_PD|ZP_PDRV0|ZP_PDRV1|ZP_PU|ZP_SL
+ VSS|XN_CS|XN_IE|XN_PD|XN_PDRV0|XN_PDRV1|XN_PU|XN_SL|XP_CS|XP_IE|XP_PD|XP_PDRV0|XP_PDRV1|XP_PU|XP_SL|YN_CS|YN_IE|YN_PD|YN_PDRV0|YN_PDRV1|YN_PU|YN_SL|YP_CS|YP_IE|YP_PD|YP_PDRV0|YP_PDRV1|YP_PU|YP_SL|ZN_CS|ZN_IE|ZN_PD|ZN_PDRV0|ZN_PDRV1|ZN_PU|ZN_SL|ZP_CS|ZP_IE|ZP_PD|ZP_PDRV0|ZP_PDRV1|ZP_PU|ZP_SL
+ nfet_06v0 L=1U W=1U AS=0.44P AD=0.44P PS=2.88U PD=2.88U
M$1216 \$4914 \$4921
+ VSS|XN_CS|XN_IE|XN_PD|XN_PDRV0|XN_PDRV1|XN_PU|XN_SL|XP_CS|XP_IE|XP_PD|XP_PDRV0|XP_PDRV1|XP_PU|XP_SL|YN_CS|YN_IE|YN_PD|YN_PDRV0|YN_PDRV1|YN_PU|YN_SL|YP_CS|YP_IE|YP_PD|YP_PDRV0|YP_PDRV1|YP_PU|YP_SL|ZN_CS|ZN_IE|ZN_PD|ZN_PDRV0|ZN_PDRV1|ZN_PU|ZN_SL|ZP_CS|ZP_IE|ZP_PD|ZP_PDRV0|ZP_PDRV1|ZP_PU|ZP_SL
+ VSS|XN_CS|XN_IE|XN_PD|XN_PDRV0|XN_PDRV1|XN_PU|XN_SL|XP_CS|XP_IE|XP_PD|XP_PDRV0|XP_PDRV1|XP_PU|XP_SL|YN_CS|YN_IE|YN_PD|YN_PDRV0|YN_PDRV1|YN_PU|YN_SL|YP_CS|YP_IE|YP_PD|YP_PDRV0|YP_PDRV1|YP_PU|YP_SL|ZN_CS|ZN_IE|ZN_PD|ZN_PDRV0|ZN_PDRV1|ZN_PU|ZN_SL|ZP_CS|ZP_IE|ZP_PD|ZP_PDRV0|ZP_PDRV1|ZP_PU|ZP_SL
+ nfet_06v0 L=1U W=5U AS=2.2P AD=1.25P PS=10.88U PD=5.5U
M$1217 \$4921 \$4922 \$4914
+ VSS|XN_CS|XN_IE|XN_PD|XN_PDRV0|XN_PDRV1|XN_PU|XN_SL|XP_CS|XP_IE|XP_PD|XP_PDRV0|XP_PDRV1|XP_PU|XP_SL|YN_CS|YN_IE|YN_PD|YN_PDRV0|YN_PDRV1|YN_PU|YN_SL|YP_CS|YP_IE|YP_PD|YP_PDRV0|YP_PDRV1|YP_PU|YP_SL|ZN_CS|ZN_IE|ZN_PD|ZN_PDRV0|ZN_PDRV1|ZN_PU|ZN_SL|ZP_CS|ZP_IE|ZP_PD|ZP_PDRV0|ZP_PDRV1|ZP_PU|ZP_SL
+ nfet_06v0 L=1U W=5U AS=1.25P AD=2.2P PS=5.5U PD=10.88U
M$1218 \$4887 \$4947
+ VSS|XN_CS|XN_IE|XN_PD|XN_PDRV0|XN_PDRV1|XN_PU|XN_SL|XP_CS|XP_IE|XP_PD|XP_PDRV0|XP_PDRV1|XP_PU|XP_SL|YN_CS|YN_IE|YN_PD|YN_PDRV0|YN_PDRV1|YN_PU|YN_SL|YP_CS|YP_IE|YP_PD|YP_PDRV0|YP_PDRV1|YP_PU|YP_SL|ZN_CS|ZN_IE|ZN_PD|ZN_PDRV0|ZN_PDRV1|ZN_PU|ZN_SL|ZP_CS|ZP_IE|ZP_PD|ZP_PDRV0|ZP_PDRV1|ZP_PU|ZP_SL
+ VSS|XN_CS|XN_IE|XN_PD|XN_PDRV0|XN_PDRV1|XN_PU|XN_SL|XP_CS|XP_IE|XP_PD|XP_PDRV0|XP_PDRV1|XP_PU|XP_SL|YN_CS|YN_IE|YN_PD|YN_PDRV0|YN_PDRV1|YN_PU|YN_SL|YP_CS|YP_IE|YP_PD|YP_PDRV0|YP_PDRV1|YP_PU|YP_SL|ZN_CS|ZN_IE|ZN_PD|ZN_PDRV0|ZN_PDRV1|ZN_PU|ZN_SL|ZP_CS|ZP_IE|ZP_PD|ZP_PDRV0|ZP_PDRV1|ZP_PU|ZP_SL
+ nfet_06v0 L=1U W=1U AS=0.44P AD=0.25P PS=2.88U PD=1.5U
M$1219 \$4927 \$4947 \$4887
+ VSS|XN_CS|XN_IE|XN_PD|XN_PDRV0|XN_PDRV1|XN_PU|XN_SL|XP_CS|XP_IE|XP_PD|XP_PDRV0|XP_PDRV1|XP_PU|XP_SL|YN_CS|YN_IE|YN_PD|YN_PDRV0|YN_PDRV1|YN_PU|YN_SL|YP_CS|YP_IE|YP_PD|YP_PDRV0|YP_PDRV1|YP_PU|YP_SL|ZN_CS|ZN_IE|ZN_PD|ZN_PDRV0|ZN_PDRV1|ZN_PU|ZN_SL|ZP_CS|ZP_IE|ZP_PD|ZP_PDRV0|ZP_PDRV1|ZP_PU|ZP_SL
+ nfet_06v0 L=1U W=1U AS=0.25P AD=0.44P PS=1.5U PD=2.88U
M$1220 \$4888 \$4947
+ VSS|XN_CS|XN_IE|XN_PD|XN_PDRV0|XN_PDRV1|XN_PU|XN_SL|XP_CS|XP_IE|XP_PD|XP_PDRV0|XP_PDRV1|XP_PU|XP_SL|YN_CS|YN_IE|YN_PD|YN_PDRV0|YN_PDRV1|YN_PU|YN_SL|YP_CS|YP_IE|YP_PD|YP_PDRV0|YP_PDRV1|YP_PU|YP_SL|ZN_CS|ZN_IE|ZN_PD|ZN_PDRV0|ZN_PDRV1|ZN_PU|ZN_SL|ZP_CS|ZP_IE|ZP_PD|ZP_PDRV0|ZP_PDRV1|ZP_PU|ZP_SL
+ VSS|XN_CS|XN_IE|XN_PD|XN_PDRV0|XN_PDRV1|XN_PU|XN_SL|XP_CS|XP_IE|XP_PD|XP_PDRV0|XP_PDRV1|XP_PU|XP_SL|YN_CS|YN_IE|YN_PD|YN_PDRV0|YN_PDRV1|YN_PU|YN_SL|YP_CS|YP_IE|YP_PD|YP_PDRV0|YP_PDRV1|YP_PU|YP_SL|ZN_CS|ZN_IE|ZN_PD|ZN_PDRV0|ZN_PDRV1|ZN_PU|ZN_SL|ZP_CS|ZP_IE|ZP_PD|ZP_PDRV0|ZP_PDRV1|ZP_PU|ZP_SL
+ nfet_06v0 L=1U W=1U AS=0.44P AD=0.25P PS=2.88U PD=1.5U
M$1221 \$4947 \$4947 \$4888
+ VSS|XN_CS|XN_IE|XN_PD|XN_PDRV0|XN_PDRV1|XN_PU|XN_SL|XP_CS|XP_IE|XP_PD|XP_PDRV0|XP_PDRV1|XP_PU|XP_SL|YN_CS|YN_IE|YN_PD|YN_PDRV0|YN_PDRV1|YN_PU|YN_SL|YP_CS|YP_IE|YP_PD|YP_PDRV0|YP_PDRV1|YP_PU|YP_SL|ZN_CS|ZN_IE|ZN_PD|ZN_PDRV0|ZN_PDRV1|ZN_PU|ZN_SL|ZP_CS|ZP_IE|ZP_PD|ZP_PDRV0|ZP_PDRV1|ZP_PU|ZP_SL
+ nfet_06v0 L=1U W=1U AS=0.25P AD=0.44P PS=1.5U PD=2.88U
M$1222
+ VSS|XN_CS|XN_IE|XN_PD|XN_PDRV0|XN_PDRV1|XN_PU|XN_SL|XP_CS|XP_IE|XP_PD|XP_PDRV0|XP_PDRV1|XP_PU|XP_SL|YN_CS|YN_IE|YN_PD|YN_PDRV0|YN_PDRV1|YN_PU|YN_SL|YP_CS|YP_IE|YP_PD|YP_PDRV0|YP_PDRV1|YP_PU|YP_SL|ZN_CS|ZN_IE|ZN_PD|ZN_PDRV0|ZN_PDRV1|ZN_PU|ZN_SL|ZP_CS|ZP_IE|ZP_PD|ZP_PDRV0|ZP_PDRV1|ZP_PU|ZP_SL
+ VDD|XN_OE|XP_OE|YN_OE|YP_OE|ZN_OE|ZP_OE
+ VSS|XN_CS|XN_IE|XN_PD|XN_PDRV0|XN_PDRV1|XN_PU|XN_SL|XP_CS|XP_IE|XP_PD|XP_PDRV0|XP_PDRV1|XP_PU|XP_SL|YN_CS|YN_IE|YN_PD|YN_PDRV0|YN_PDRV1|YN_PU|YN_SL|YP_CS|YP_IE|YP_PD|YP_PDRV0|YP_PDRV1|YP_PU|YP_SL|ZN_CS|ZN_IE|ZN_PD|ZN_PDRV0|ZN_PDRV1|ZN_PU|ZN_SL|ZP_CS|ZP_IE|ZP_PD|ZP_PDRV0|ZP_PDRV1|ZP_PU|ZP_SL
+ VSS|XN_CS|XN_IE|XN_PD|XN_PDRV0|XN_PDRV1|XN_PU|XN_SL|XP_CS|XP_IE|XP_PD|XP_PDRV0|XP_PDRV1|XP_PU|XP_SL|YN_CS|YN_IE|YN_PD|YN_PDRV0|YN_PDRV1|YN_PU|YN_SL|YP_CS|YP_IE|YP_PD|YP_PDRV0|YP_PDRV1|YP_PU|YP_SL|ZN_CS|ZN_IE|ZN_PD|ZN_PDRV0|ZN_PDRV1|ZN_PU|ZN_SL|ZP_CS|ZP_IE|ZP_PD|ZP_PDRV0|ZP_PDRV1|ZP_PU|ZP_SL
+ nfet_06v0 L=2U W=18U AS=7.92P AD=7.92P PS=36.88U PD=36.88U
M$1223
+ VSS|XN_CS|XN_IE|XN_PD|XN_PDRV0|XN_PDRV1|XN_PU|XN_SL|XP_CS|XP_IE|XP_PD|XP_PDRV0|XP_PDRV1|XP_PU|XP_SL|YN_CS|YN_IE|YN_PD|YN_PDRV0|YN_PDRV1|YN_PU|YN_SL|YP_CS|YP_IE|YP_PD|YP_PDRV0|YP_PDRV1|YP_PU|YP_SL|ZN_CS|ZN_IE|ZN_PD|ZN_PDRV0|ZN_PDRV1|ZN_PU|ZN_SL|ZP_CS|ZP_IE|ZP_PD|ZP_PDRV0|ZP_PDRV1|ZP_PU|ZP_SL
+ VDD|XN_OE|XP_OE|YN_OE|YP_OE|ZN_OE|ZP_OE
+ VSS|XN_CS|XN_IE|XN_PD|XN_PDRV0|XN_PDRV1|XN_PU|XN_SL|XP_CS|XP_IE|XP_PD|XP_PDRV0|XP_PDRV1|XP_PU|XP_SL|YN_CS|YN_IE|YN_PD|YN_PDRV0|YN_PDRV1|YN_PU|YN_SL|YP_CS|YP_IE|YP_PD|YP_PDRV0|YP_PDRV1|YP_PU|YP_SL|ZN_CS|ZN_IE|ZN_PD|ZN_PDRV0|ZN_PDRV1|ZN_PU|ZN_SL|ZP_CS|ZP_IE|ZP_PD|ZP_PDRV0|ZP_PDRV1|ZP_PU|ZP_SL
+ VSS|XN_CS|XN_IE|XN_PD|XN_PDRV0|XN_PDRV1|XN_PU|XN_SL|XP_CS|XP_IE|XP_PD|XP_PDRV0|XP_PDRV1|XP_PU|XP_SL|YN_CS|YN_IE|YN_PD|YN_PDRV0|YN_PDRV1|YN_PU|YN_SL|YP_CS|YP_IE|YP_PD|YP_PDRV0|YP_PDRV1|YP_PU|YP_SL|ZN_CS|ZN_IE|ZN_PD|ZN_PDRV0|ZN_PDRV1|ZN_PU|ZN_SL|ZP_CS|ZP_IE|ZP_PD|ZP_PDRV0|ZP_PDRV1|ZP_PU|ZP_SL
+ nfet_06v0 L=2U W=18U AS=7.92P AD=7.92P PS=36.88U PD=36.88U
M$1224 \$4911 \$4923
+ VSS|XN_CS|XN_IE|XN_PD|XN_PDRV0|XN_PDRV1|XN_PU|XN_SL|XP_CS|XP_IE|XP_PD|XP_PDRV0|XP_PDRV1|XP_PU|XP_SL|YN_CS|YN_IE|YN_PD|YN_PDRV0|YN_PDRV1|YN_PU|YN_SL|YP_CS|YP_IE|YP_PD|YP_PDRV0|YP_PDRV1|YP_PU|YP_SL|ZN_CS|ZN_IE|ZN_PD|ZN_PDRV0|ZN_PDRV1|ZN_PU|ZN_SL|ZP_CS|ZP_IE|ZP_PD|ZP_PDRV0|ZP_PDRV1|ZP_PU|ZP_SL
+ VSS|XN_CS|XN_IE|XN_PD|XN_PDRV0|XN_PDRV1|XN_PU|XN_SL|XP_CS|XP_IE|XP_PD|XP_PDRV0|XP_PDRV1|XP_PU|XP_SL|YN_CS|YN_IE|YN_PD|YN_PDRV0|YN_PDRV1|YN_PU|YN_SL|YP_CS|YP_IE|YP_PD|YP_PDRV0|YP_PDRV1|YP_PU|YP_SL|ZN_CS|ZN_IE|ZN_PD|ZN_PDRV0|ZN_PDRV1|ZN_PU|ZN_SL|ZP_CS|ZP_IE|ZP_PD|ZP_PDRV0|ZP_PDRV1|ZP_PU|ZP_SL
+ nfet_06v0 L=1U W=5U AS=2.2P AD=1.25P PS=10.88U PD=5.5U
M$1225 \$4873 \$4924 \$4911
+ VSS|XN_CS|XN_IE|XN_PD|XN_PDRV0|XN_PDRV1|XN_PU|XN_SL|XP_CS|XP_IE|XP_PD|XP_PDRV0|XP_PDRV1|XP_PU|XP_SL|YN_CS|YN_IE|YN_PD|YN_PDRV0|YN_PDRV1|YN_PU|YN_SL|YP_CS|YP_IE|YP_PD|YP_PDRV0|YP_PDRV1|YP_PU|YP_SL|ZN_CS|ZN_IE|ZN_PD|ZN_PDRV0|ZN_PDRV1|ZN_PU|ZN_SL|ZP_CS|ZP_IE|ZP_PD|ZP_PDRV0|ZP_PDRV1|ZP_PU|ZP_SL
+ nfet_06v0 L=1U W=5U AS=1.25P AD=2.2P PS=5.5U PD=10.88U
M$1226 \$4910 \$4923
+ VSS|XN_CS|XN_IE|XN_PD|XN_PDRV0|XN_PDRV1|XN_PU|XN_SL|XP_CS|XP_IE|XP_PD|XP_PDRV0|XP_PDRV1|XP_PU|XP_SL|YN_CS|YN_IE|YN_PD|YN_PDRV0|YN_PDRV1|YN_PU|YN_SL|YP_CS|YP_IE|YP_PD|YP_PDRV0|YP_PDRV1|YP_PU|YP_SL|ZN_CS|ZN_IE|ZN_PD|ZN_PDRV0|ZN_PDRV1|ZN_PU|ZN_SL|ZP_CS|ZP_IE|ZP_PD|ZP_PDRV0|ZP_PDRV1|ZP_PU|ZP_SL
+ VSS|XN_CS|XN_IE|XN_PD|XN_PDRV0|XN_PDRV1|XN_PU|XN_SL|XP_CS|XP_IE|XP_PD|XP_PDRV0|XP_PDRV1|XP_PU|XP_SL|YN_CS|YN_IE|YN_PD|YN_PDRV0|YN_PDRV1|YN_PU|YN_SL|YP_CS|YP_IE|YP_PD|YP_PDRV0|YP_PDRV1|YP_PU|YP_SL|ZN_CS|ZN_IE|ZN_PD|ZN_PDRV0|ZN_PDRV1|ZN_PU|ZN_SL|ZP_CS|ZP_IE|ZP_PD|ZP_PDRV0|ZP_PDRV1|ZP_PU|ZP_SL
+ nfet_06v0 L=1U W=5U AS=2.2P AD=1.25P PS=10.88U PD=5.5U
M$1227 \$4873 \$4924 \$4910
+ VSS|XN_CS|XN_IE|XN_PD|XN_PDRV0|XN_PDRV1|XN_PU|XN_SL|XP_CS|XP_IE|XP_PD|XP_PDRV0|XP_PDRV1|XP_PU|XP_SL|YN_CS|YN_IE|YN_PD|YN_PDRV0|YN_PDRV1|YN_PU|YN_SL|YP_CS|YP_IE|YP_PD|YP_PDRV0|YP_PDRV1|YP_PU|YP_SL|ZN_CS|ZN_IE|ZN_PD|ZN_PDRV0|ZN_PDRV1|ZN_PU|ZN_SL|ZP_CS|ZP_IE|ZP_PD|ZP_PDRV0|ZP_PDRV1|ZP_PU|ZP_SL
+ nfet_06v0 L=1U W=5U AS=1.25P AD=2.2P PS=5.5U PD=10.88U
M$1228 \$4874 \$14440 \$4873
+ VSS|XN_CS|XN_IE|XN_PD|XN_PDRV0|XN_PDRV1|XN_PU|XN_SL|XP_CS|XP_IE|XP_PD|XP_PDRV0|XP_PDRV1|XP_PU|XP_SL|YN_CS|YN_IE|YN_PD|YN_PDRV0|YN_PDRV1|YN_PU|YN_SL|YP_CS|YP_IE|YP_PD|YP_PDRV0|YP_PDRV1|YP_PU|YP_SL|ZN_CS|ZN_IE|ZN_PD|ZN_PDRV0|ZN_PDRV1|ZN_PU|ZN_SL|ZP_CS|ZP_IE|ZP_PD|ZP_PDRV0|ZP_PDRV1|ZP_PU|ZP_SL
+ nfet_06v0 L=1U W=7.5U AS=3.3P AD=3.3P PS=15.88U PD=15.88U
M$1229 \$4875 \$14439 \$4873
+ VSS|XN_CS|XN_IE|XN_PD|XN_PDRV0|XN_PDRV1|XN_PU|XN_SL|XP_CS|XP_IE|XP_PD|XP_PDRV0|XP_PDRV1|XP_PU|XP_SL|YN_CS|YN_IE|YN_PD|YN_PDRV0|YN_PDRV1|YN_PU|YN_SL|YP_CS|YP_IE|YP_PD|YP_PDRV0|YP_PDRV1|YP_PU|YP_SL|ZN_CS|ZN_IE|ZN_PD|ZN_PDRV0|ZN_PDRV1|ZN_PU|ZN_SL|ZP_CS|ZP_IE|ZP_PD|ZP_PDRV0|ZP_PDRV1|ZP_PU|ZP_SL
+ nfet_06v0 L=1U W=8.5U AS=3.74P AD=3.74P PS=17.88U PD=17.88U
M$1230 \$4876 \$4895
+ VSS|XN_CS|XN_IE|XN_PD|XN_PDRV0|XN_PDRV1|XN_PU|XN_SL|XP_CS|XP_IE|XP_PD|XP_PDRV0|XP_PDRV1|XP_PU|XP_SL|YN_CS|YN_IE|YN_PD|YN_PDRV0|YN_PDRV1|YN_PU|YN_SL|YP_CS|YP_IE|YP_PD|YP_PDRV0|YP_PDRV1|YP_PU|YP_SL|ZN_CS|ZN_IE|ZN_PD|ZN_PDRV0|ZN_PDRV1|ZN_PU|ZN_SL|ZP_CS|ZP_IE|ZP_PD|ZP_PDRV0|ZP_PDRV1|ZP_PU|ZP_SL
+ VSS|XN_CS|XN_IE|XN_PD|XN_PDRV0|XN_PDRV1|XN_PU|XN_SL|XP_CS|XP_IE|XP_PD|XP_PDRV0|XP_PDRV1|XP_PU|XP_SL|YN_CS|YN_IE|YN_PD|YN_PDRV0|YN_PDRV1|YN_PU|YN_SL|YP_CS|YP_IE|YP_PD|YP_PDRV0|YP_PDRV1|YP_PU|YP_SL|ZN_CS|ZN_IE|ZN_PD|ZN_PDRV0|ZN_PDRV1|ZN_PU|ZN_SL|ZP_CS|ZP_IE|ZP_PD|ZP_PDRV0|ZP_PDRV1|ZP_PU|ZP_SL
+ nfet_06v0 L=1U W=2.5U AS=1.1P AD=0.825P PS=5.88U PD=3.16U
M$1231 \$4895 \$4924 \$4876
+ VSS|XN_CS|XN_IE|XN_PD|XN_PDRV0|XN_PDRV1|XN_PU|XN_SL|XP_CS|XP_IE|XP_PD|XP_PDRV0|XP_PDRV1|XP_PU|XP_SL|YN_CS|YN_IE|YN_PD|YN_PDRV0|YN_PDRV1|YN_PU|YN_SL|YP_CS|YP_IE|YP_PD|YP_PDRV0|YP_PDRV1|YP_PU|YP_SL|ZN_CS|ZN_IE|ZN_PD|ZN_PDRV0|ZN_PDRV1|ZN_PU|ZN_SL|ZP_CS|ZP_IE|ZP_PD|ZP_PDRV0|ZP_PDRV1|ZP_PU|ZP_SL
+ nfet_06v0 L=1U W=2.5U AS=0.825P AD=1.1P PS=3.16U PD=5.88U
M$1232 \$4941 \$4895
+ VSS|XN_CS|XN_IE|XN_PD|XN_PDRV0|XN_PDRV1|XN_PU|XN_SL|XP_CS|XP_IE|XP_PD|XP_PDRV0|XP_PDRV1|XP_PU|XP_SL|YN_CS|YN_IE|YN_PD|YN_PDRV0|YN_PDRV1|YN_PU|YN_SL|YP_CS|YP_IE|YP_PD|YP_PDRV0|YP_PDRV1|YP_PU|YP_SL|ZN_CS|ZN_IE|ZN_PD|ZN_PDRV0|ZN_PDRV1|ZN_PU|ZN_SL|ZP_CS|ZP_IE|ZP_PD|ZP_PDRV0|ZP_PDRV1|ZP_PU|ZP_SL
+ VSS|XN_CS|XN_IE|XN_PD|XN_PDRV0|XN_PDRV1|XN_PU|XN_SL|XP_CS|XP_IE|XP_PD|XP_PDRV0|XP_PDRV1|XP_PU|XP_SL|YN_CS|YN_IE|YN_PD|YN_PDRV0|YN_PDRV1|YN_PU|YN_SL|YP_CS|YP_IE|YP_PD|YP_PDRV0|YP_PDRV1|YP_PU|YP_SL|ZN_CS|ZN_IE|ZN_PD|ZN_PDRV0|ZN_PDRV1|ZN_PU|ZN_SL|ZP_CS|ZP_IE|ZP_PD|ZP_PDRV0|ZP_PDRV1|ZP_PU|ZP_SL
+ nfet_06v0 L=1U W=2.5U AS=1.1P AD=0.825P PS=5.88U PD=3.16U
M$1233 \$4877 \$4924 \$4941
+ VSS|XN_CS|XN_IE|XN_PD|XN_PDRV0|XN_PDRV1|XN_PU|XN_SL|XP_CS|XP_IE|XP_PD|XP_PDRV0|XP_PDRV1|XP_PU|XP_SL|YN_CS|YN_IE|YN_PD|YN_PDRV0|YN_PDRV1|YN_PU|YN_SL|YP_CS|YP_IE|YP_PD|YP_PDRV0|YP_PDRV1|YP_PU|YP_SL|ZN_CS|ZN_IE|ZN_PD|ZN_PDRV0|ZN_PDRV1|ZN_PU|ZN_SL|ZP_CS|ZP_IE|ZP_PD|ZP_PDRV0|ZP_PDRV1|ZP_PU|ZP_SL
+ nfet_06v0 L=1U W=2.5U AS=0.825P AD=1.1P PS=3.16U PD=5.88U
M$1234 \$4968 \$4896 \$4895
+ VSS|XN_CS|XN_IE|XN_PD|XN_PDRV0|XN_PDRV1|XN_PU|XN_SL|XP_CS|XP_IE|XP_PD|XP_PDRV0|XP_PDRV1|XP_PU|XP_SL|YN_CS|YN_IE|YN_PD|YN_PDRV0|YN_PDRV1|YN_PU|YN_SL|YP_CS|YP_IE|YP_PD|YP_PDRV0|YP_PDRV1|YP_PU|YP_SL|ZN_CS|ZN_IE|ZN_PD|ZN_PDRV0|ZN_PDRV1|ZN_PU|ZN_SL|ZP_CS|ZP_IE|ZP_PD|ZP_PDRV0|ZP_PDRV1|ZP_PU|ZP_SL
+ nfet_06v0 L=1U W=2U AS=0.88P AD=0.88P PS=4.88U PD=4.88U
M$1235 \$4960 \$4896 \$4877
+ VSS|XN_CS|XN_IE|XN_PD|XN_PDRV0|XN_PDRV1|XN_PU|XN_SL|XP_CS|XP_IE|XP_PD|XP_PDRV0|XP_PDRV1|XP_PU|XP_SL|YN_CS|YN_IE|YN_PD|YN_PDRV0|YN_PDRV1|YN_PU|YN_SL|YP_CS|YP_IE|YP_PD|YP_PDRV0|YP_PDRV1|YP_PU|YP_SL|ZN_CS|ZN_IE|ZN_PD|ZN_PDRV0|ZN_PDRV1|ZN_PU|ZN_SL|ZP_CS|ZP_IE|ZP_PD|ZP_PDRV0|ZP_PDRV1|ZP_PU|ZP_SL
+ nfet_06v0 L=1U W=2U AS=0.88P AD=0.88P PS=4.88U PD=4.88U
M$1236 \$4904 \$4923
+ VSS|XN_CS|XN_IE|XN_PD|XN_PDRV0|XN_PDRV1|XN_PU|XN_SL|XP_CS|XP_IE|XP_PD|XP_PDRV0|XP_PDRV1|XP_PU|XP_SL|YN_CS|YN_IE|YN_PD|YN_PDRV0|YN_PDRV1|YN_PU|YN_SL|YP_CS|YP_IE|YP_PD|YP_PDRV0|YP_PDRV1|YP_PU|YP_SL|ZN_CS|ZN_IE|ZN_PD|ZN_PDRV0|ZN_PDRV1|ZN_PU|ZN_SL|ZP_CS|ZP_IE|ZP_PD|ZP_PDRV0|ZP_PDRV1|ZP_PU|ZP_SL
+ VSS|XN_CS|XN_IE|XN_PD|XN_PDRV0|XN_PDRV1|XN_PU|XN_SL|XP_CS|XP_IE|XP_PD|XP_PDRV0|XP_PDRV1|XP_PU|XP_SL|YN_CS|YN_IE|YN_PD|YN_PDRV0|YN_PDRV1|YN_PU|YN_SL|YP_CS|YP_IE|YP_PD|YP_PDRV0|YP_PDRV1|YP_PU|YP_SL|ZN_CS|ZN_IE|ZN_PD|ZN_PDRV0|ZN_PDRV1|ZN_PU|ZN_SL|ZP_CS|ZP_IE|ZP_PD|ZP_PDRV0|ZP_PDRV1|ZP_PU|ZP_SL
+ nfet_06v0 L=1U W=5U AS=2.2P AD=1.25P PS=10.88U PD=5.5U
M$1237 \$4878 \$4924 \$4904
+ VSS|XN_CS|XN_IE|XN_PD|XN_PDRV0|XN_PDRV1|XN_PU|XN_SL|XP_CS|XP_IE|XP_PD|XP_PDRV0|XP_PDRV1|XP_PU|XP_SL|YN_CS|YN_IE|YN_PD|YN_PDRV0|YN_PDRV1|YN_PU|YN_SL|YP_CS|YP_IE|YP_PD|YP_PDRV0|YP_PDRV1|YP_PU|YP_SL|ZN_CS|ZN_IE|ZN_PD|ZN_PDRV0|ZN_PDRV1|ZN_PU|ZN_SL|ZP_CS|ZP_IE|ZP_PD|ZP_PDRV0|ZP_PDRV1|ZP_PU|ZP_SL
+ nfet_06v0 L=1U W=5U AS=1.25P AD=2.2P PS=5.5U PD=10.88U
M$1238 \$4902 \$4879
+ VSS|XN_CS|XN_IE|XN_PD|XN_PDRV0|XN_PDRV1|XN_PU|XN_SL|XP_CS|XP_IE|XP_PD|XP_PDRV0|XP_PDRV1|XP_PU|XP_SL|YN_CS|YN_IE|YN_PD|YN_PDRV0|YN_PDRV1|YN_PU|YN_SL|YP_CS|YP_IE|YP_PD|YP_PDRV0|YP_PDRV1|YP_PU|YP_SL|ZN_CS|ZN_IE|ZN_PD|ZN_PDRV0|ZN_PDRV1|ZN_PU|ZN_SL|ZP_CS|ZP_IE|ZP_PD|ZP_PDRV0|ZP_PDRV1|ZP_PU|ZP_SL
+ VSS|XN_CS|XN_IE|XN_PD|XN_PDRV0|XN_PDRV1|XN_PU|XN_SL|XP_CS|XP_IE|XP_PD|XP_PDRV0|XP_PDRV1|XP_PU|XP_SL|YN_CS|YN_IE|YN_PD|YN_PDRV0|YN_PDRV1|YN_PU|YN_SL|YP_CS|YP_IE|YP_PD|YP_PDRV0|YP_PDRV1|YP_PU|YP_SL|ZN_CS|ZN_IE|ZN_PD|ZN_PDRV0|ZN_PDRV1|ZN_PU|ZN_SL|ZP_CS|ZP_IE|ZP_PD|ZP_PDRV0|ZP_PDRV1|ZP_PU|ZP_SL
+ nfet_06v0 L=1U W=5U AS=2.2P AD=1.25P PS=10.88U PD=5.5U
M$1239 \$4879 \$4924 \$4902
+ VSS|XN_CS|XN_IE|XN_PD|XN_PDRV0|XN_PDRV1|XN_PU|XN_SL|XP_CS|XP_IE|XP_PD|XP_PDRV0|XP_PDRV1|XP_PU|XP_SL|YN_CS|YN_IE|YN_PD|YN_PDRV0|YN_PDRV1|YN_PU|YN_SL|YP_CS|YP_IE|YP_PD|YP_PDRV0|YP_PDRV1|YP_PU|YP_SL|ZN_CS|ZN_IE|ZN_PD|ZN_PDRV0|ZN_PDRV1|ZN_PU|ZN_SL|ZP_CS|ZP_IE|ZP_PD|ZP_PDRV0|ZP_PDRV1|ZP_PU|ZP_SL
+ nfet_06v0 L=1U W=5U AS=1.25P AD=1.65P PS=5.5U PD=5.66U
M$1240 \$4896 \$4896 \$4879
+ VSS|XN_CS|XN_IE|XN_PD|XN_PDRV0|XN_PDRV1|XN_PU|XN_SL|XP_CS|XP_IE|XP_PD|XP_PDRV0|XP_PDRV1|XP_PU|XP_SL|YN_CS|YN_IE|YN_PD|YN_PDRV0|YN_PDRV1|YN_PU|YN_SL|YP_CS|YP_IE|YP_PD|YP_PDRV0|YP_PDRV1|YP_PU|YP_SL|ZN_CS|ZN_IE|ZN_PD|ZN_PDRV0|ZN_PDRV1|ZN_PU|ZN_SL|ZP_CS|ZP_IE|ZP_PD|ZP_PDRV0|ZP_PDRV1|ZP_PU|ZP_SL
+ nfet_06v0 L=1U W=5U AS=1.65P AD=2.2P PS=5.66U PD=10.88U
M$1241 \$4880 \$4877
+ VSS|XN_CS|XN_IE|XN_PD|XN_PDRV0|XN_PDRV1|XN_PU|XN_SL|XP_CS|XP_IE|XP_PD|XP_PDRV0|XP_PDRV1|XP_PU|XP_SL|YN_CS|YN_IE|YN_PD|YN_PDRV0|YN_PDRV1|YN_PU|YN_SL|YP_CS|YP_IE|YP_PD|YP_PDRV0|YP_PDRV1|YP_PU|YP_SL|ZN_CS|ZN_IE|ZN_PD|ZN_PDRV0|ZN_PDRV1|ZN_PU|ZN_SL|ZP_CS|ZP_IE|ZP_PD|ZP_PDRV0|ZP_PDRV1|ZP_PU|ZP_SL
+ VSS|XN_CS|XN_IE|XN_PD|XN_PDRV0|XN_PDRV1|XN_PU|XN_SL|XP_CS|XP_IE|XP_PD|XP_PDRV0|XP_PDRV1|XP_PU|XP_SL|YN_CS|YN_IE|YN_PD|YN_PDRV0|YN_PDRV1|YN_PU|YN_SL|YP_CS|YP_IE|YP_PD|YP_PDRV0|YP_PDRV1|YP_PU|YP_SL|ZN_CS|ZN_IE|ZN_PD|ZN_PDRV0|ZN_PDRV1|ZN_PU|ZN_SL|ZP_CS|ZP_IE|ZP_PD|ZP_PDRV0|ZP_PDRV1|ZP_PU|ZP_SL
+ nfet_06v0 L=1U W=1U AS=0.44P AD=0.44P PS=2.88U PD=2.88U
M$1242 \$4924 \$4924
+ VSS|XN_CS|XN_IE|XN_PD|XN_PDRV0|XN_PDRV1|XN_PU|XN_SL|XP_CS|XP_IE|XP_PD|XP_PDRV0|XP_PDRV1|XP_PU|XP_SL|YN_CS|YN_IE|YN_PD|YN_PDRV0|YN_PDRV1|YN_PU|YN_SL|YP_CS|YP_IE|YP_PD|YP_PDRV0|YP_PDRV1|YP_PU|YP_SL|ZN_CS|ZN_IE|ZN_PD|ZN_PDRV0|ZN_PDRV1|ZN_PU|ZN_SL|ZP_CS|ZP_IE|ZP_PD|ZP_PDRV0|ZP_PDRV1|ZP_PU|ZP_SL
+ VSS|XN_CS|XN_IE|XN_PD|XN_PDRV0|XN_PDRV1|XN_PU|XN_SL|XP_CS|XP_IE|XP_PD|XP_PDRV0|XP_PDRV1|XP_PU|XP_SL|YN_CS|YN_IE|YN_PD|YN_PDRV0|YN_PDRV1|YN_PU|YN_SL|YP_CS|YP_IE|YP_PD|YP_PDRV0|YP_PDRV1|YP_PU|YP_SL|ZN_CS|ZN_IE|ZN_PD|ZN_PDRV0|ZN_PDRV1|ZN_PU|ZN_SL|ZP_CS|ZP_IE|ZP_PD|ZP_PDRV0|ZP_PDRV1|ZP_PU|ZP_SL
+ nfet_06v0 L=1U W=1U AS=0.44P AD=0.44P PS=2.88U PD=2.88U
M$1243 \$4899 \$4923
+ VSS|XN_CS|XN_IE|XN_PD|XN_PDRV0|XN_PDRV1|XN_PU|XN_SL|XP_CS|XP_IE|XP_PD|XP_PDRV0|XP_PDRV1|XP_PU|XP_SL|YN_CS|YN_IE|YN_PD|YN_PDRV0|YN_PDRV1|YN_PU|YN_SL|YP_CS|YP_IE|YP_PD|YP_PDRV0|YP_PDRV1|YP_PU|YP_SL|ZN_CS|ZN_IE|ZN_PD|ZN_PDRV0|ZN_PDRV1|ZN_PU|ZN_SL|ZP_CS|ZP_IE|ZP_PD|ZP_PDRV0|ZP_PDRV1|ZP_PU|ZP_SL
+ VSS|XN_CS|XN_IE|XN_PD|XN_PDRV0|XN_PDRV1|XN_PU|XN_SL|XP_CS|XP_IE|XP_PD|XP_PDRV0|XP_PDRV1|XP_PU|XP_SL|YN_CS|YN_IE|YN_PD|YN_PDRV0|YN_PDRV1|YN_PU|YN_SL|YP_CS|YP_IE|YP_PD|YP_PDRV0|YP_PDRV1|YP_PU|YP_SL|ZN_CS|ZN_IE|ZN_PD|ZN_PDRV0|ZN_PDRV1|ZN_PU|ZN_SL|ZP_CS|ZP_IE|ZP_PD|ZP_PDRV0|ZP_PDRV1|ZP_PU|ZP_SL
+ nfet_06v0 L=1U W=5U AS=2.2P AD=1.25P PS=10.88U PD=5.5U
M$1244 \$4923 \$4924 \$4899
+ VSS|XN_CS|XN_IE|XN_PD|XN_PDRV0|XN_PDRV1|XN_PU|XN_SL|XP_CS|XP_IE|XP_PD|XP_PDRV0|XP_PDRV1|XP_PU|XP_SL|YN_CS|YN_IE|YN_PD|YN_PDRV0|YN_PDRV1|YN_PU|YN_SL|YP_CS|YP_IE|YP_PD|YP_PDRV0|YP_PDRV1|YP_PU|YP_SL|ZN_CS|ZN_IE|ZN_PD|ZN_PDRV0|ZN_PDRV1|ZN_PU|ZN_SL|ZP_CS|ZP_IE|ZP_PD|ZP_PDRV0|ZP_PDRV1|ZP_PU|ZP_SL
+ nfet_06v0 L=1U W=5U AS=1.25P AD=2.2P PS=5.5U PD=10.88U
M$1245 \$4883 \$4948
+ VSS|XN_CS|XN_IE|XN_PD|XN_PDRV0|XN_PDRV1|XN_PU|XN_SL|XP_CS|XP_IE|XP_PD|XP_PDRV0|XP_PDRV1|XP_PU|XP_SL|YN_CS|YN_IE|YN_PD|YN_PDRV0|YN_PDRV1|YN_PU|YN_SL|YP_CS|YP_IE|YP_PD|YP_PDRV0|YP_PDRV1|YP_PU|YP_SL|ZN_CS|ZN_IE|ZN_PD|ZN_PDRV0|ZN_PDRV1|ZN_PU|ZN_SL|ZP_CS|ZP_IE|ZP_PD|ZP_PDRV0|ZP_PDRV1|ZP_PU|ZP_SL
+ VSS|XN_CS|XN_IE|XN_PD|XN_PDRV0|XN_PDRV1|XN_PU|XN_SL|XP_CS|XP_IE|XP_PD|XP_PDRV0|XP_PDRV1|XP_PU|XP_SL|YN_CS|YN_IE|YN_PD|YN_PDRV0|YN_PDRV1|YN_PU|YN_SL|YP_CS|YP_IE|YP_PD|YP_PDRV0|YP_PDRV1|YP_PU|YP_SL|ZN_CS|ZN_IE|ZN_PD|ZN_PDRV0|ZN_PDRV1|ZN_PU|ZN_SL|ZP_CS|ZP_IE|ZP_PD|ZP_PDRV0|ZP_PDRV1|ZP_PU|ZP_SL
+ nfet_06v0 L=1U W=1U AS=0.44P AD=0.25P PS=2.88U PD=1.5U
M$1246 \$4928 \$4948 \$4883
+ VSS|XN_CS|XN_IE|XN_PD|XN_PDRV0|XN_PDRV1|XN_PU|XN_SL|XP_CS|XP_IE|XP_PD|XP_PDRV0|XP_PDRV1|XP_PU|XP_SL|YN_CS|YN_IE|YN_PD|YN_PDRV0|YN_PDRV1|YN_PU|YN_SL|YP_CS|YP_IE|YP_PD|YP_PDRV0|YP_PDRV1|YP_PU|YP_SL|ZN_CS|ZN_IE|ZN_PD|ZN_PDRV0|ZN_PDRV1|ZN_PU|ZN_SL|ZP_CS|ZP_IE|ZP_PD|ZP_PDRV0|ZP_PDRV1|ZP_PU|ZP_SL
+ nfet_06v0 L=1U W=1U AS=0.25P AD=0.44P PS=1.5U PD=2.88U
M$1247 \$4881 \$4948
+ VSS|XN_CS|XN_IE|XN_PD|XN_PDRV0|XN_PDRV1|XN_PU|XN_SL|XP_CS|XP_IE|XP_PD|XP_PDRV0|XP_PDRV1|XP_PU|XP_SL|YN_CS|YN_IE|YN_PD|YN_PDRV0|YN_PDRV1|YN_PU|YN_SL|YP_CS|YP_IE|YP_PD|YP_PDRV0|YP_PDRV1|YP_PU|YP_SL|ZN_CS|ZN_IE|ZN_PD|ZN_PDRV0|ZN_PDRV1|ZN_PU|ZN_SL|ZP_CS|ZP_IE|ZP_PD|ZP_PDRV0|ZP_PDRV1|ZP_PU|ZP_SL
+ VSS|XN_CS|XN_IE|XN_PD|XN_PDRV0|XN_PDRV1|XN_PU|XN_SL|XP_CS|XP_IE|XP_PD|XP_PDRV0|XP_PDRV1|XP_PU|XP_SL|YN_CS|YN_IE|YN_PD|YN_PDRV0|YN_PDRV1|YN_PU|YN_SL|YP_CS|YP_IE|YP_PD|YP_PDRV0|YP_PDRV1|YP_PU|YP_SL|ZN_CS|ZN_IE|ZN_PD|ZN_PDRV0|ZN_PDRV1|ZN_PU|ZN_SL|ZP_CS|ZP_IE|ZP_PD|ZP_PDRV0|ZP_PDRV1|ZP_PU|ZP_SL
+ nfet_06v0 L=1U W=1U AS=0.44P AD=0.25P PS=2.88U PD=1.5U
M$1248 \$4948 \$4948 \$4881
+ VSS|XN_CS|XN_IE|XN_PD|XN_PDRV0|XN_PDRV1|XN_PU|XN_SL|XP_CS|XP_IE|XP_PD|XP_PDRV0|XP_PDRV1|XP_PU|XP_SL|YN_CS|YN_IE|YN_PD|YN_PDRV0|YN_PDRV1|YN_PU|YN_SL|YP_CS|YP_IE|YP_PD|YP_PDRV0|YP_PDRV1|YP_PU|YP_SL|ZN_CS|ZN_IE|ZN_PD|ZN_PDRV0|ZN_PDRV1|ZN_PU|ZN_SL|ZP_CS|ZP_IE|ZP_PD|ZP_PDRV0|ZP_PDRV1|ZP_PU|ZP_SL
+ nfet_06v0 L=1U W=1U AS=0.25P AD=0.44P PS=1.5U PD=2.88U
M$1249
+ VSS|XN_CS|XN_IE|XN_PD|XN_PDRV0|XN_PDRV1|XN_PU|XN_SL|XP_CS|XP_IE|XP_PD|XP_PDRV0|XP_PDRV1|XP_PU|XP_SL|YN_CS|YN_IE|YN_PD|YN_PDRV0|YN_PDRV1|YN_PU|YN_SL|YP_CS|YP_IE|YP_PD|YP_PDRV0|YP_PDRV1|YP_PU|YP_SL|ZN_CS|ZN_IE|ZN_PD|ZN_PDRV0|ZN_PDRV1|ZN_PU|ZN_SL|ZP_CS|ZP_IE|ZP_PD|ZP_PDRV0|ZP_PDRV1|ZP_PU|ZP_SL
+ VDD|XN_OE|XP_OE|YN_OE|YP_OE|ZN_OE|ZP_OE
+ VSS|XN_CS|XN_IE|XN_PD|XN_PDRV0|XN_PDRV1|XN_PU|XN_SL|XP_CS|XP_IE|XP_PD|XP_PDRV0|XP_PDRV1|XP_PU|XP_SL|YN_CS|YN_IE|YN_PD|YN_PDRV0|YN_PDRV1|YN_PU|YN_SL|YP_CS|YP_IE|YP_PD|YP_PDRV0|YP_PDRV1|YP_PU|YP_SL|ZN_CS|ZN_IE|ZN_PD|ZN_PDRV0|ZN_PDRV1|ZN_PU|ZN_SL|ZP_CS|ZP_IE|ZP_PD|ZP_PDRV0|ZP_PDRV1|ZP_PU|ZP_SL
+ VSS|XN_CS|XN_IE|XN_PD|XN_PDRV0|XN_PDRV1|XN_PU|XN_SL|XP_CS|XP_IE|XP_PD|XP_PDRV0|XP_PDRV1|XP_PU|XP_SL|YN_CS|YN_IE|YN_PD|YN_PDRV0|YN_PDRV1|YN_PU|YN_SL|YP_CS|YP_IE|YP_PD|YP_PDRV0|YP_PDRV1|YP_PU|YP_SL|ZN_CS|ZN_IE|ZN_PD|ZN_PDRV0|ZN_PDRV1|ZN_PU|ZN_SL|ZP_CS|ZP_IE|ZP_PD|ZP_PDRV0|ZP_PDRV1|ZP_PU|ZP_SL
+ nfet_06v0 L=2U W=18U AS=7.92P AD=7.92P PS=36.88U PD=36.88U
M$1250
+ VSS|XN_CS|XN_IE|XN_PD|XN_PDRV0|XN_PDRV1|XN_PU|XN_SL|XP_CS|XP_IE|XP_PD|XP_PDRV0|XP_PDRV1|XP_PU|XP_SL|YN_CS|YN_IE|YN_PD|YN_PDRV0|YN_PDRV1|YN_PU|YN_SL|YP_CS|YP_IE|YP_PD|YP_PDRV0|YP_PDRV1|YP_PU|YP_SL|ZN_CS|ZN_IE|ZN_PD|ZN_PDRV0|ZN_PDRV1|ZN_PU|ZN_SL|ZP_CS|ZP_IE|ZP_PD|ZP_PDRV0|ZP_PDRV1|ZP_PU|ZP_SL
+ VDD|XN_OE|XP_OE|YN_OE|YP_OE|ZN_OE|ZP_OE
+ VSS|XN_CS|XN_IE|XN_PD|XN_PDRV0|XN_PDRV1|XN_PU|XN_SL|XP_CS|XP_IE|XP_PD|XP_PDRV0|XP_PDRV1|XP_PU|XP_SL|YN_CS|YN_IE|YN_PD|YN_PDRV0|YN_PDRV1|YN_PU|YN_SL|YP_CS|YP_IE|YP_PD|YP_PDRV0|YP_PDRV1|YP_PU|YP_SL|ZN_CS|ZN_IE|ZN_PD|ZN_PDRV0|ZN_PDRV1|ZN_PU|ZN_SL|ZP_CS|ZP_IE|ZP_PD|ZP_PDRV0|ZP_PDRV1|ZP_PU|ZP_SL
+ VSS|XN_CS|XN_IE|XN_PD|XN_PDRV0|XN_PDRV1|XN_PU|XN_SL|XP_CS|XP_IE|XP_PD|XP_PDRV0|XP_PDRV1|XP_PU|XP_SL|YN_CS|YN_IE|YN_PD|YN_PDRV0|YN_PDRV1|YN_PU|YN_SL|YP_CS|YP_IE|YP_PD|YP_PDRV0|YP_PDRV1|YP_PU|YP_SL|ZN_CS|ZN_IE|ZN_PD|ZN_PDRV0|ZN_PDRV1|ZN_PU|ZN_SL|ZP_CS|ZP_IE|ZP_PD|ZP_PDRV0|ZP_PDRV1|ZP_PU|ZP_SL
+ nfet_06v0 L=2U W=18U AS=7.92P AD=7.92P PS=36.88U PD=36.88U
M$1251
+ VSS|XN_CS|XN_IE|XN_PD|XN_PDRV0|XN_PDRV1|XN_PU|XN_SL|XP_CS|XP_IE|XP_PD|XP_PDRV0|XP_PDRV1|XP_PU|XP_SL|YN_CS|YN_IE|YN_PD|YN_PDRV0|YN_PDRV1|YN_PU|YN_SL|YP_CS|YP_IE|YP_PD|YP_PDRV0|YP_PDRV1|YP_PU|YP_SL|ZN_CS|ZN_IE|ZN_PD|ZN_PDRV0|ZN_PDRV1|ZN_PU|ZN_SL|ZP_CS|ZP_IE|ZP_PD|ZP_PDRV0|ZP_PDRV1|ZP_PU|ZP_SL
+ VDD|XN_OE|XP_OE|YN_OE|YP_OE|ZN_OE|ZP_OE
+ VSS|XN_CS|XN_IE|XN_PD|XN_PDRV0|XN_PDRV1|XN_PU|XN_SL|XP_CS|XP_IE|XP_PD|XP_PDRV0|XP_PDRV1|XP_PU|XP_SL|YN_CS|YN_IE|YN_PD|YN_PDRV0|YN_PDRV1|YN_PU|YN_SL|YP_CS|YP_IE|YP_PD|YP_PDRV0|YP_PDRV1|YP_PU|YP_SL|ZN_CS|ZN_IE|ZN_PD|ZN_PDRV0|ZN_PDRV1|ZN_PU|ZN_SL|ZP_CS|ZP_IE|ZP_PD|ZP_PDRV0|ZP_PDRV1|ZP_PU|ZP_SL
+ VSS|XN_CS|XN_IE|XN_PD|XN_PDRV0|XN_PDRV1|XN_PU|XN_SL|XP_CS|XP_IE|XP_PD|XP_PDRV0|XP_PDRV1|XP_PU|XP_SL|YN_CS|YN_IE|YN_PD|YN_PDRV0|YN_PDRV1|YN_PU|YN_SL|YP_CS|YP_IE|YP_PD|YP_PDRV0|YP_PDRV1|YP_PU|YP_SL|ZN_CS|ZN_IE|ZN_PD|ZN_PDRV0|ZN_PDRV1|ZN_PU|ZN_SL|ZP_CS|ZP_IE|ZP_PD|ZP_PDRV0|ZP_PDRV1|ZP_PU|ZP_SL
+ nfet_06v0 L=2U W=18U AS=7.92P AD=7.92P PS=36.88U PD=36.88U
M$1252
+ VSS|XN_CS|XN_IE|XN_PD|XN_PDRV0|XN_PDRV1|XN_PU|XN_SL|XP_CS|XP_IE|XP_PD|XP_PDRV0|XP_PDRV1|XP_PU|XP_SL|YN_CS|YN_IE|YN_PD|YN_PDRV0|YN_PDRV1|YN_PU|YN_SL|YP_CS|YP_IE|YP_PD|YP_PDRV0|YP_PDRV1|YP_PU|YP_SL|ZN_CS|ZN_IE|ZN_PD|ZN_PDRV0|ZN_PDRV1|ZN_PU|ZN_SL|ZP_CS|ZP_IE|ZP_PD|ZP_PDRV0|ZP_PDRV1|ZP_PU|ZP_SL
+ VDD|XN_OE|XP_OE|YN_OE|YP_OE|ZN_OE|ZP_OE
+ VSS|XN_CS|XN_IE|XN_PD|XN_PDRV0|XN_PDRV1|XN_PU|XN_SL|XP_CS|XP_IE|XP_PD|XP_PDRV0|XP_PDRV1|XP_PU|XP_SL|YN_CS|YN_IE|YN_PD|YN_PDRV0|YN_PDRV1|YN_PU|YN_SL|YP_CS|YP_IE|YP_PD|YP_PDRV0|YP_PDRV1|YP_PU|YP_SL|ZN_CS|ZN_IE|ZN_PD|ZN_PDRV0|ZN_PDRV1|ZN_PU|ZN_SL|ZP_CS|ZP_IE|ZP_PD|ZP_PDRV0|ZP_PDRV1|ZP_PU|ZP_SL
+ VSS|XN_CS|XN_IE|XN_PD|XN_PDRV0|XN_PDRV1|XN_PU|XN_SL|XP_CS|XP_IE|XP_PD|XP_PDRV0|XP_PDRV1|XP_PU|XP_SL|YN_CS|YN_IE|YN_PD|YN_PDRV0|YN_PDRV1|YN_PU|YN_SL|YP_CS|YP_IE|YP_PD|YP_PDRV0|YP_PDRV1|YP_PU|YP_SL|ZN_CS|ZN_IE|ZN_PD|ZN_PDRV0|ZN_PDRV1|ZN_PU|ZN_SL|ZP_CS|ZP_IE|ZP_PD|ZP_PDRV0|ZP_PDRV1|ZP_PU|ZP_SL
+ nfet_06v0 L=2U W=18U AS=7.92P AD=7.92P PS=36.88U PD=36.88U
M$1253 \$7278 \$7278
+ VSS|XN_CS|XN_IE|XN_PD|XN_PDRV0|XN_PDRV1|XN_PU|XN_SL|XP_CS|XP_IE|XP_PD|XP_PDRV0|XP_PDRV1|XP_PU|XP_SL|YN_CS|YN_IE|YN_PD|YN_PDRV0|YN_PDRV1|YN_PU|YN_SL|YP_CS|YP_IE|YP_PD|YP_PDRV0|YP_PDRV1|YP_PU|YP_SL|ZN_CS|ZN_IE|ZN_PD|ZN_PDRV0|ZN_PDRV1|ZN_PU|ZN_SL|ZP_CS|ZP_IE|ZP_PD|ZP_PDRV0|ZP_PDRV1|ZP_PU|ZP_SL
+ VSS|XN_CS|XN_IE|XN_PD|XN_PDRV0|XN_PDRV1|XN_PU|XN_SL|XP_CS|XP_IE|XP_PD|XP_PDRV0|XP_PDRV1|XP_PU|XP_SL|YN_CS|YN_IE|YN_PD|YN_PDRV0|YN_PDRV1|YN_PU|YN_SL|YP_CS|YP_IE|YP_PD|YP_PDRV0|YP_PDRV1|YP_PU|YP_SL|ZN_CS|ZN_IE|ZN_PD|ZN_PDRV0|ZN_PDRV1|ZN_PU|ZN_SL|ZP_CS|ZP_IE|ZP_PD|ZP_PDRV0|ZP_PDRV1|ZP_PU|ZP_SL
+ nfet_06v0 L=1U W=1U AS=0.44P AD=0.44P PS=2.88U PD=2.88U
M$1254 \$7323 \$7263
+ VSS|XN_CS|XN_IE|XN_PD|XN_PDRV0|XN_PDRV1|XN_PU|XN_SL|XP_CS|XP_IE|XP_PD|XP_PDRV0|XP_PDRV1|XP_PU|XP_SL|YN_CS|YN_IE|YN_PD|YN_PDRV0|YN_PDRV1|YN_PU|YN_SL|YP_CS|YP_IE|YP_PD|YP_PDRV0|YP_PDRV1|YP_PU|YP_SL|ZN_CS|ZN_IE|ZN_PD|ZN_PDRV0|ZN_PDRV1|ZN_PU|ZN_SL|ZP_CS|ZP_IE|ZP_PD|ZP_PDRV0|ZP_PDRV1|ZP_PU|ZP_SL
+ VSS|XN_CS|XN_IE|XN_PD|XN_PDRV0|XN_PDRV1|XN_PU|XN_SL|XP_CS|XP_IE|XP_PD|XP_PDRV0|XP_PDRV1|XP_PU|XP_SL|YN_CS|YN_IE|YN_PD|YN_PDRV0|YN_PDRV1|YN_PU|YN_SL|YP_CS|YP_IE|YP_PD|YP_PDRV0|YP_PDRV1|YP_PU|YP_SL|ZN_CS|ZN_IE|ZN_PD|ZN_PDRV0|ZN_PDRV1|ZN_PU|ZN_SL|ZP_CS|ZP_IE|ZP_PD|ZP_PDRV0|ZP_PDRV1|ZP_PU|ZP_SL
+ nfet_06v0 L=1U W=5U AS=2.2P AD=1.25P PS=10.88U PD=5.5U
M$1255 \$7263 \$7278 \$7323
+ VSS|XN_CS|XN_IE|XN_PD|XN_PDRV0|XN_PDRV1|XN_PU|XN_SL|XP_CS|XP_IE|XP_PD|XP_PDRV0|XP_PDRV1|XP_PU|XP_SL|YN_CS|YN_IE|YN_PD|YN_PDRV0|YN_PDRV1|YN_PU|YN_SL|YP_CS|YP_IE|YP_PD|YP_PDRV0|YP_PDRV1|YP_PU|YP_SL|ZN_CS|ZN_IE|ZN_PD|ZN_PDRV0|ZN_PDRV1|ZN_PU|ZN_SL|ZP_CS|ZP_IE|ZP_PD|ZP_PDRV0|ZP_PDRV1|ZP_PU|ZP_SL
+ nfet_06v0 L=1U W=5U AS=1.25P AD=2.2P PS=5.5U PD=10.88U
M$1256 \$7309 \$7898
+ VSS|XN_CS|XN_IE|XN_PD|XN_PDRV0|XN_PDRV1|XN_PU|XN_SL|XP_CS|XP_IE|XP_PD|XP_PDRV0|XP_PDRV1|XP_PU|XP_SL|YN_CS|YN_IE|YN_PD|YN_PDRV0|YN_PDRV1|YN_PU|YN_SL|YP_CS|YP_IE|YP_PD|YP_PDRV0|YP_PDRV1|YP_PU|YP_SL|ZN_CS|ZN_IE|ZN_PD|ZN_PDRV0|ZN_PDRV1|ZN_PU|ZN_SL|ZP_CS|ZP_IE|ZP_PD|ZP_PDRV0|ZP_PDRV1|ZP_PU|ZP_SL
+ VSS|XN_CS|XN_IE|XN_PD|XN_PDRV0|XN_PDRV1|XN_PU|XN_SL|XP_CS|XP_IE|XP_PD|XP_PDRV0|XP_PDRV1|XP_PU|XP_SL|YN_CS|YN_IE|YN_PD|YN_PDRV0|YN_PDRV1|YN_PU|YN_SL|YP_CS|YP_IE|YP_PD|YP_PDRV0|YP_PDRV1|YP_PU|YP_SL|ZN_CS|ZN_IE|ZN_PD|ZN_PDRV0|ZN_PDRV1|ZN_PU|ZN_SL|ZP_CS|ZP_IE|ZP_PD|ZP_PDRV0|ZP_PDRV1|ZP_PU|ZP_SL
+ nfet_06v0 L=1U W=1U AS=0.44P AD=0.25P PS=2.88U PD=1.5U
M$1257 \$7897 \$7898 \$7309
+ VSS|XN_CS|XN_IE|XN_PD|XN_PDRV0|XN_PDRV1|XN_PU|XN_SL|XP_CS|XP_IE|XP_PD|XP_PDRV0|XP_PDRV1|XP_PU|XP_SL|YN_CS|YN_IE|YN_PD|YN_PDRV0|YN_PDRV1|YN_PU|YN_SL|YP_CS|YP_IE|YP_PD|YP_PDRV0|YP_PDRV1|YP_PU|YP_SL|ZN_CS|ZN_IE|ZN_PD|ZN_PDRV0|ZN_PDRV1|ZN_PU|ZN_SL|ZP_CS|ZP_IE|ZP_PD|ZP_PDRV0|ZP_PDRV1|ZP_PU|ZP_SL
+ nfet_06v0 L=1U W=1U AS=0.25P AD=0.44P PS=1.5U PD=2.88U
M$1258 \$7310 \$7898
+ VSS|XN_CS|XN_IE|XN_PD|XN_PDRV0|XN_PDRV1|XN_PU|XN_SL|XP_CS|XP_IE|XP_PD|XP_PDRV0|XP_PDRV1|XP_PU|XP_SL|YN_CS|YN_IE|YN_PD|YN_PDRV0|YN_PDRV1|YN_PU|YN_SL|YP_CS|YP_IE|YP_PD|YP_PDRV0|YP_PDRV1|YP_PU|YP_SL|ZN_CS|ZN_IE|ZN_PD|ZN_PDRV0|ZN_PDRV1|ZN_PU|ZN_SL|ZP_CS|ZP_IE|ZP_PD|ZP_PDRV0|ZP_PDRV1|ZP_PU|ZP_SL
+ VSS|XN_CS|XN_IE|XN_PD|XN_PDRV0|XN_PDRV1|XN_PU|XN_SL|XP_CS|XP_IE|XP_PD|XP_PDRV0|XP_PDRV1|XP_PU|XP_SL|YN_CS|YN_IE|YN_PD|YN_PDRV0|YN_PDRV1|YN_PU|YN_SL|YP_CS|YP_IE|YP_PD|YP_PDRV0|YP_PDRV1|YP_PU|YP_SL|ZN_CS|ZN_IE|ZN_PD|ZN_PDRV0|ZN_PDRV1|ZN_PU|ZN_SL|ZP_CS|ZP_IE|ZP_PD|ZP_PDRV0|ZP_PDRV1|ZP_PU|ZP_SL
+ nfet_06v0 L=1U W=1U AS=0.44P AD=0.25P PS=2.88U PD=1.5U
M$1259 \$7898 \$7898 \$7310
+ VSS|XN_CS|XN_IE|XN_PD|XN_PDRV0|XN_PDRV1|XN_PU|XN_SL|XP_CS|XP_IE|XP_PD|XP_PDRV0|XP_PDRV1|XP_PU|XP_SL|YN_CS|YN_IE|YN_PD|YN_PDRV0|YN_PDRV1|YN_PU|YN_SL|YP_CS|YP_IE|YP_PD|YP_PDRV0|YP_PDRV1|YP_PU|YP_SL|ZN_CS|ZN_IE|ZN_PD|ZN_PDRV0|ZN_PDRV1|ZN_PU|ZN_SL|ZP_CS|ZP_IE|ZP_PD|ZP_PDRV0|ZP_PDRV1|ZP_PU|ZP_SL
+ nfet_06v0 L=1U W=1U AS=0.25P AD=0.44P PS=1.5U PD=2.88U
M$1260 \$7324 \$7263
+ VSS|XN_CS|XN_IE|XN_PD|XN_PDRV0|XN_PDRV1|XN_PU|XN_SL|XP_CS|XP_IE|XP_PD|XP_PDRV0|XP_PDRV1|XP_PU|XP_SL|YN_CS|YN_IE|YN_PD|YN_PDRV0|YN_PDRV1|YN_PU|YN_SL|YP_CS|YP_IE|YP_PD|YP_PDRV0|YP_PDRV1|YP_PU|YP_SL|ZN_CS|ZN_IE|ZN_PD|ZN_PDRV0|ZN_PDRV1|ZN_PU|ZN_SL|ZP_CS|ZP_IE|ZP_PD|ZP_PDRV0|ZP_PDRV1|ZP_PU|ZP_SL
+ VSS|XN_CS|XN_IE|XN_PD|XN_PDRV0|XN_PDRV1|XN_PU|XN_SL|XP_CS|XP_IE|XP_PD|XP_PDRV0|XP_PDRV1|XP_PU|XP_SL|YN_CS|YN_IE|YN_PD|YN_PDRV0|YN_PDRV1|YN_PU|YN_SL|YP_CS|YP_IE|YP_PD|YP_PDRV0|YP_PDRV1|YP_PU|YP_SL|ZN_CS|ZN_IE|ZN_PD|ZN_PDRV0|ZN_PDRV1|ZN_PU|ZN_SL|ZP_CS|ZP_IE|ZP_PD|ZP_PDRV0|ZP_PDRV1|ZP_PU|ZP_SL
+ nfet_06v0 L=1U W=5U AS=2.2P AD=1.25P PS=10.88U PD=5.5U
M$1261 \$7279 \$7278 \$7324
+ VSS|XN_CS|XN_IE|XN_PD|XN_PDRV0|XN_PDRV1|XN_PU|XN_SL|XP_CS|XP_IE|XP_PD|XP_PDRV0|XP_PDRV1|XP_PU|XP_SL|YN_CS|YN_IE|YN_PD|YN_PDRV0|YN_PDRV1|YN_PU|YN_SL|YP_CS|YP_IE|YP_PD|YP_PDRV0|YP_PDRV1|YP_PU|YP_SL|ZN_CS|ZN_IE|ZN_PD|ZN_PDRV0|ZN_PDRV1|ZN_PU|ZN_SL|ZP_CS|ZP_IE|ZP_PD|ZP_PDRV0|ZP_PDRV1|ZP_PU|ZP_SL
+ nfet_06v0 L=1U W=5U AS=1.25P AD=1.65P PS=5.5U PD=5.66U
M$1262 \$7325 \$7278 \$7279
+ VSS|XN_CS|XN_IE|XN_PD|XN_PDRV0|XN_PDRV1|XN_PU|XN_SL|XP_CS|XP_IE|XP_PD|XP_PDRV0|XP_PDRV1|XP_PU|XP_SL|YN_CS|YN_IE|YN_PD|YN_PDRV0|YN_PDRV1|YN_PU|YN_SL|YP_CS|YP_IE|YP_PD|YP_PDRV0|YP_PDRV1|YP_PU|YP_SL|ZN_CS|ZN_IE|ZN_PD|ZN_PDRV0|ZN_PDRV1|ZN_PU|ZN_SL|ZP_CS|ZP_IE|ZP_PD|ZP_PDRV0|ZP_PDRV1|ZP_PU|ZP_SL
+ nfet_06v0 L=1U W=5U AS=1.65P AD=1.25P PS=5.66U PD=5.5U
M$1263
+ VSS|XN_CS|XN_IE|XN_PD|XN_PDRV0|XN_PDRV1|XN_PU|XN_SL|XP_CS|XP_IE|XP_PD|XP_PDRV0|XP_PDRV1|XP_PU|XP_SL|YN_CS|YN_IE|YN_PD|YN_PDRV0|YN_PDRV1|YN_PU|YN_SL|YP_CS|YP_IE|YP_PD|YP_PDRV0|YP_PDRV1|YP_PU|YP_SL|ZN_CS|ZN_IE|ZN_PD|ZN_PDRV0|ZN_PDRV1|ZN_PU|ZN_SL|ZP_CS|ZP_IE|ZP_PD|ZP_PDRV0|ZP_PDRV1|ZP_PU|ZP_SL
+ \$7263 \$7325
+ VSS|XN_CS|XN_IE|XN_PD|XN_PDRV0|XN_PDRV1|XN_PU|XN_SL|XP_CS|XP_IE|XP_PD|XP_PDRV0|XP_PDRV1|XP_PU|XP_SL|YN_CS|YN_IE|YN_PD|YN_PDRV0|YN_PDRV1|YN_PU|YN_SL|YP_CS|YP_IE|YP_PD|YP_PDRV0|YP_PDRV1|YP_PU|YP_SL|ZN_CS|ZN_IE|ZN_PD|ZN_PDRV0|ZN_PDRV1|ZN_PU|ZN_SL|ZP_CS|ZP_IE|ZP_PD|ZP_PDRV0|ZP_PDRV1|ZP_PU|ZP_SL
+ nfet_06v0 L=1U W=5U AS=1.25P AD=2.2P PS=5.5U PD=10.88U
M$1264 \$7280 \$30 \$7279
+ VSS|XN_CS|XN_IE|XN_PD|XN_PDRV0|XN_PDRV1|XN_PU|XN_SL|XP_CS|XP_IE|XP_PD|XP_PDRV0|XP_PDRV1|XP_PU|XP_SL|YN_CS|YN_IE|YN_PD|YN_PDRV0|YN_PDRV1|YN_PU|YN_SL|YP_CS|YP_IE|YP_PD|YP_PDRV0|YP_PDRV1|YP_PU|YP_SL|ZN_CS|ZN_IE|ZN_PD|ZN_PDRV0|ZN_PDRV1|ZN_PU|ZN_SL|ZP_CS|ZP_IE|ZP_PD|ZP_PDRV0|ZP_PDRV1|ZP_PU|ZP_SL
+ nfet_06v0 L=1U W=5U AS=2.2P AD=1.3P PS=10.88U PD=5.52U
M$1265 \$7279 \$30 \$7280
+ VSS|XN_CS|XN_IE|XN_PD|XN_PDRV0|XN_PDRV1|XN_PU|XN_SL|XP_CS|XP_IE|XP_PD|XP_PDRV0|XP_PDRV1|XP_PU|XP_SL|YN_CS|YN_IE|YN_PD|YN_PDRV0|YN_PDRV1|YN_PU|YN_SL|YP_CS|YP_IE|YP_PD|YP_PDRV0|YP_PDRV1|YP_PU|YP_SL|ZN_CS|ZN_IE|ZN_PD|ZN_PDRV0|ZN_PDRV1|ZN_PU|ZN_SL|ZP_CS|ZP_IE|ZP_PD|ZP_PDRV0|ZP_PDRV1|ZP_PU|ZP_SL
+ nfet_06v0 L=1U W=5U AS=1.3P AD=2.2P PS=5.52U PD=10.88U
M$1266 \$7281 \$46 \$7279
+ VSS|XN_CS|XN_IE|XN_PD|XN_PDRV0|XN_PDRV1|XN_PU|XN_SL|XP_CS|XP_IE|XP_PD|XP_PDRV0|XP_PDRV1|XP_PU|XP_SL|YN_CS|YN_IE|YN_PD|YN_PDRV0|YN_PDRV1|YN_PU|YN_SL|YP_CS|YP_IE|YP_PD|YP_PDRV0|YP_PDRV1|YP_PU|YP_SL|ZN_CS|ZN_IE|ZN_PD|ZN_PDRV0|ZN_PDRV1|ZN_PU|ZN_SL|ZP_CS|ZP_IE|ZP_PD|ZP_PDRV0|ZP_PDRV1|ZP_PU|ZP_SL
+ nfet_06v0 L=1U W=5U AS=2.2P AD=1.3P PS=10.88U PD=5.52U
M$1267 \$7279 \$46 \$7281
+ VSS|XN_CS|XN_IE|XN_PD|XN_PDRV0|XN_PDRV1|XN_PU|XN_SL|XP_CS|XP_IE|XP_PD|XP_PDRV0|XP_PDRV1|XP_PU|XP_SL|YN_CS|YN_IE|YN_PD|YN_PDRV0|YN_PDRV1|YN_PU|YN_SL|YP_CS|YP_IE|YP_PD|YP_PDRV0|YP_PDRV1|YP_PU|YP_SL|ZN_CS|ZN_IE|ZN_PD|ZN_PDRV0|ZN_PDRV1|ZN_PU|ZN_SL|ZP_CS|ZP_IE|ZP_PD|ZP_PDRV0|ZP_PDRV1|ZP_PU|ZP_SL
+ nfet_06v0 L=1U W=5U AS=1.3P AD=2.2P PS=5.52U PD=10.88U
M$1268 \$7283 \$7278 \$7282
+ VSS|XN_CS|XN_IE|XN_PD|XN_PDRV0|XN_PDRV1|XN_PU|XN_SL|XP_CS|XP_IE|XP_PD|XP_PDRV0|XP_PDRV1|XP_PU|XP_SL|YN_CS|YN_IE|YN_PD|YN_PDRV0|YN_PDRV1|YN_PU|YN_SL|YP_CS|YP_IE|YP_PD|YP_PDRV0|YP_PDRV1|YP_PU|YP_SL|ZN_CS|ZN_IE|ZN_PD|ZN_PDRV0|ZN_PDRV1|ZN_PU|ZN_SL|ZP_CS|ZP_IE|ZP_PD|ZP_PDRV0|ZP_PDRV1|ZP_PU|ZP_SL
+ nfet_06v0 L=1U W=2.5U AS=1.1P AD=0.65P PS=5.88U PD=3.02U
M$1269 \$7282 \$7278 \$7283
+ VSS|XN_CS|XN_IE|XN_PD|XN_PDRV0|XN_PDRV1|XN_PU|XN_SL|XP_CS|XP_IE|XP_PD|XP_PDRV0|XP_PDRV1|XP_PU|XP_SL|YN_CS|YN_IE|YN_PD|YN_PDRV0|YN_PDRV1|YN_PU|YN_SL|YP_CS|YP_IE|YP_PD|YP_PDRV0|YP_PDRV1|YP_PU|YP_SL|ZN_CS|ZN_IE|ZN_PD|ZN_PDRV0|ZN_PDRV1|ZN_PU|ZN_SL|ZP_CS|ZP_IE|ZP_PD|ZP_PDRV0|ZP_PDRV1|ZP_PU|ZP_SL
+ nfet_06v0 L=1U W=2.5U AS=0.65P AD=1.1P PS=3.02U PD=5.88U
M$1270 \$7285 \$7278 \$7284
+ VSS|XN_CS|XN_IE|XN_PD|XN_PDRV0|XN_PDRV1|XN_PU|XN_SL|XP_CS|XP_IE|XP_PD|XP_PDRV0|XP_PDRV1|XP_PU|XP_SL|YN_CS|YN_IE|YN_PD|YN_PDRV0|YN_PDRV1|YN_PU|YN_SL|YP_CS|YP_IE|YP_PD|YP_PDRV0|YP_PDRV1|YP_PU|YP_SL|ZN_CS|ZN_IE|ZN_PD|ZN_PDRV0|ZN_PDRV1|ZN_PU|ZN_SL|ZP_CS|ZP_IE|ZP_PD|ZP_PDRV0|ZP_PDRV1|ZP_PU|ZP_SL
+ nfet_06v0 L=1U W=2.5U AS=1.1P AD=0.65P PS=5.88U PD=3.02U
M$1271 \$7284 \$7278 \$7285
+ VSS|XN_CS|XN_IE|XN_PD|XN_PDRV0|XN_PDRV1|XN_PU|XN_SL|XP_CS|XP_IE|XP_PD|XP_PDRV0|XP_PDRV1|XP_PU|XP_SL|YN_CS|YN_IE|YN_PD|YN_PDRV0|YN_PDRV1|YN_PU|YN_SL|YP_CS|YP_IE|YP_PD|YP_PDRV0|YP_PDRV1|YP_PU|YP_SL|ZN_CS|ZN_IE|ZN_PD|ZN_PDRV0|ZN_PDRV1|ZN_PU|ZN_SL|ZP_CS|ZP_IE|ZP_PD|ZP_PDRV0|ZP_PDRV1|ZP_PU|ZP_SL
+ nfet_06v0 L=1U W=2.5U AS=0.65P AD=1.1P PS=3.02U PD=5.88U
M$1272 \$7282 \$7283
+ VSS|XN_CS|XN_IE|XN_PD|XN_PDRV0|XN_PDRV1|XN_PU|XN_SL|XP_CS|XP_IE|XP_PD|XP_PDRV0|XP_PDRV1|XP_PU|XP_SL|YN_CS|YN_IE|YN_PD|YN_PDRV0|YN_PDRV1|YN_PU|YN_SL|YP_CS|YP_IE|YP_PD|YP_PDRV0|YP_PDRV1|YP_PU|YP_SL|ZN_CS|ZN_IE|ZN_PD|ZN_PDRV0|ZN_PDRV1|ZN_PU|ZN_SL|ZP_CS|ZP_IE|ZP_PD|ZP_PDRV0|ZP_PDRV1|ZP_PU|ZP_SL
+ VSS|XN_CS|XN_IE|XN_PD|XN_PDRV0|XN_PDRV1|XN_PU|XN_SL|XP_CS|XP_IE|XP_PD|XP_PDRV0|XP_PDRV1|XP_PU|XP_SL|YN_CS|YN_IE|YN_PD|YN_PDRV0|YN_PDRV1|YN_PU|YN_SL|YP_CS|YP_IE|YP_PD|YP_PDRV0|YP_PDRV1|YP_PU|YP_SL|ZN_CS|ZN_IE|ZN_PD|ZN_PDRV0|ZN_PDRV1|ZN_PU|ZN_SL|ZP_CS|ZP_IE|ZP_PD|ZP_PDRV0|ZP_PDRV1|ZP_PU|ZP_SL
+ nfet_06v0 L=1U W=2.5U AS=1.1P AD=0.65P PS=5.88U PD=3.02U
M$1273
+ VSS|XN_CS|XN_IE|XN_PD|XN_PDRV0|XN_PDRV1|XN_PU|XN_SL|XP_CS|XP_IE|XP_PD|XP_PDRV0|XP_PDRV1|XP_PU|XP_SL|YN_CS|YN_IE|YN_PD|YN_PDRV0|YN_PDRV1|YN_PU|YN_SL|YP_CS|YP_IE|YP_PD|YP_PDRV0|YP_PDRV1|YP_PU|YP_SL|ZN_CS|ZN_IE|ZN_PD|ZN_PDRV0|ZN_PDRV1|ZN_PU|ZN_SL|ZP_CS|ZP_IE|ZP_PD|ZP_PDRV0|ZP_PDRV1|ZP_PU|ZP_SL
+ \$7283 \$7282
+ VSS|XN_CS|XN_IE|XN_PD|XN_PDRV0|XN_PDRV1|XN_PU|XN_SL|XP_CS|XP_IE|XP_PD|XP_PDRV0|XP_PDRV1|XP_PU|XP_SL|YN_CS|YN_IE|YN_PD|YN_PDRV0|YN_PDRV1|YN_PU|YN_SL|YP_CS|YP_IE|YP_PD|YP_PDRV0|YP_PDRV1|YP_PU|YP_SL|ZN_CS|ZN_IE|ZN_PD|ZN_PDRV0|ZN_PDRV1|ZN_PU|ZN_SL|ZP_CS|ZP_IE|ZP_PD|ZP_PDRV0|ZP_PDRV1|ZP_PU|ZP_SL
+ nfet_06v0 L=1U W=2.5U AS=0.65P AD=0.65P PS=3.02U PD=3.02U
M$1274 \$7282 \$7283
+ VSS|XN_CS|XN_IE|XN_PD|XN_PDRV0|XN_PDRV1|XN_PU|XN_SL|XP_CS|XP_IE|XP_PD|XP_PDRV0|XP_PDRV1|XP_PU|XP_SL|YN_CS|YN_IE|YN_PD|YN_PDRV0|YN_PDRV1|YN_PU|YN_SL|YP_CS|YP_IE|YP_PD|YP_PDRV0|YP_PDRV1|YP_PU|YP_SL|ZN_CS|ZN_IE|ZN_PD|ZN_PDRV0|ZN_PDRV1|ZN_PU|ZN_SL|ZP_CS|ZP_IE|ZP_PD|ZP_PDRV0|ZP_PDRV1|ZP_PU|ZP_SL
+ VSS|XN_CS|XN_IE|XN_PD|XN_PDRV0|XN_PDRV1|XN_PU|XN_SL|XP_CS|XP_IE|XP_PD|XP_PDRV0|XP_PDRV1|XP_PU|XP_SL|YN_CS|YN_IE|YN_PD|YN_PDRV0|YN_PDRV1|YN_PU|YN_SL|YP_CS|YP_IE|YP_PD|YP_PDRV0|YP_PDRV1|YP_PU|YP_SL|ZN_CS|ZN_IE|ZN_PD|ZN_PDRV0|ZN_PDRV1|ZN_PU|ZN_SL|ZP_CS|ZP_IE|ZP_PD|ZP_PDRV0|ZP_PDRV1|ZP_PU|ZP_SL
+ nfet_06v0 L=1U W=2.5U AS=0.65P AD=0.65P PS=3.02U PD=3.02U
M$1275
+ VSS|XN_CS|XN_IE|XN_PD|XN_PDRV0|XN_PDRV1|XN_PU|XN_SL|XP_CS|XP_IE|XP_PD|XP_PDRV0|XP_PDRV1|XP_PU|XP_SL|YN_CS|YN_IE|YN_PD|YN_PDRV0|YN_PDRV1|YN_PU|YN_SL|YP_CS|YP_IE|YP_PD|YP_PDRV0|YP_PDRV1|YP_PU|YP_SL|ZN_CS|ZN_IE|ZN_PD|ZN_PDRV0|ZN_PDRV1|ZN_PU|ZN_SL|ZP_CS|ZP_IE|ZP_PD|ZP_PDRV0|ZP_PDRV1|ZP_PU|ZP_SL
+ \$7283 \$7282
+ VSS|XN_CS|XN_IE|XN_PD|XN_PDRV0|XN_PDRV1|XN_PU|XN_SL|XP_CS|XP_IE|XP_PD|XP_PDRV0|XP_PDRV1|XP_PU|XP_SL|YN_CS|YN_IE|YN_PD|YN_PDRV0|YN_PDRV1|YN_PU|YN_SL|YP_CS|YP_IE|YP_PD|YP_PDRV0|YP_PDRV1|YP_PU|YP_SL|ZN_CS|ZN_IE|ZN_PD|ZN_PDRV0|ZN_PDRV1|ZN_PU|ZN_SL|ZP_CS|ZP_IE|ZP_PD|ZP_PDRV0|ZP_PDRV1|ZP_PU|ZP_SL
+ nfet_06v0 L=1U W=2.5U AS=0.65P AD=1.1P PS=3.02U PD=5.88U
M$1276 \$7284 \$7283
+ VSS|XN_CS|XN_IE|XN_PD|XN_PDRV0|XN_PDRV1|XN_PU|XN_SL|XP_CS|XP_IE|XP_PD|XP_PDRV0|XP_PDRV1|XP_PU|XP_SL|YN_CS|YN_IE|YN_PD|YN_PDRV0|YN_PDRV1|YN_PU|YN_SL|YP_CS|YP_IE|YP_PD|YP_PDRV0|YP_PDRV1|YP_PU|YP_SL|ZN_CS|ZN_IE|ZN_PD|ZN_PDRV0|ZN_PDRV1|ZN_PU|ZN_SL|ZP_CS|ZP_IE|ZP_PD|ZP_PDRV0|ZP_PDRV1|ZP_PU|ZP_SL
+ VSS|XN_CS|XN_IE|XN_PD|XN_PDRV0|XN_PDRV1|XN_PU|XN_SL|XP_CS|XP_IE|XP_PD|XP_PDRV0|XP_PDRV1|XP_PU|XP_SL|YN_CS|YN_IE|YN_PD|YN_PDRV0|YN_PDRV1|YN_PU|YN_SL|YP_CS|YP_IE|YP_PD|YP_PDRV0|YP_PDRV1|YP_PU|YP_SL|ZN_CS|ZN_IE|ZN_PD|ZN_PDRV0|ZN_PDRV1|ZN_PU|ZN_SL|ZP_CS|ZP_IE|ZP_PD|ZP_PDRV0|ZP_PDRV1|ZP_PU|ZP_SL
+ nfet_06v0 L=1U W=2.5U AS=1.1P AD=0.65P PS=5.88U PD=3.02U
M$1277
+ VSS|XN_CS|XN_IE|XN_PD|XN_PDRV0|XN_PDRV1|XN_PU|XN_SL|XP_CS|XP_IE|XP_PD|XP_PDRV0|XP_PDRV1|XP_PU|XP_SL|YN_CS|YN_IE|YN_PD|YN_PDRV0|YN_PDRV1|YN_PU|YN_SL|YP_CS|YP_IE|YP_PD|YP_PDRV0|YP_PDRV1|YP_PU|YP_SL|ZN_CS|ZN_IE|ZN_PD|ZN_PDRV0|ZN_PDRV1|ZN_PU|ZN_SL|ZP_CS|ZP_IE|ZP_PD|ZP_PDRV0|ZP_PDRV1|ZP_PU|ZP_SL
+ \$7283 \$7284
+ VSS|XN_CS|XN_IE|XN_PD|XN_PDRV0|XN_PDRV1|XN_PU|XN_SL|XP_CS|XP_IE|XP_PD|XP_PDRV0|XP_PDRV1|XP_PU|XP_SL|YN_CS|YN_IE|YN_PD|YN_PDRV0|YN_PDRV1|YN_PU|YN_SL|YP_CS|YP_IE|YP_PD|YP_PDRV0|YP_PDRV1|YP_PU|YP_SL|ZN_CS|ZN_IE|ZN_PD|ZN_PDRV0|ZN_PDRV1|ZN_PU|ZN_SL|ZP_CS|ZP_IE|ZP_PD|ZP_PDRV0|ZP_PDRV1|ZP_PU|ZP_SL
+ nfet_06v0 L=1U W=2.5U AS=0.65P AD=0.65P PS=3.02U PD=3.02U
M$1278 \$7284 \$7283
+ VSS|XN_CS|XN_IE|XN_PD|XN_PDRV0|XN_PDRV1|XN_PU|XN_SL|XP_CS|XP_IE|XP_PD|XP_PDRV0|XP_PDRV1|XP_PU|XP_SL|YN_CS|YN_IE|YN_PD|YN_PDRV0|YN_PDRV1|YN_PU|YN_SL|YP_CS|YP_IE|YP_PD|YP_PDRV0|YP_PDRV1|YP_PU|YP_SL|ZN_CS|ZN_IE|ZN_PD|ZN_PDRV0|ZN_PDRV1|ZN_PU|ZN_SL|ZP_CS|ZP_IE|ZP_PD|ZP_PDRV0|ZP_PDRV1|ZP_PU|ZP_SL
+ VSS|XN_CS|XN_IE|XN_PD|XN_PDRV0|XN_PDRV1|XN_PU|XN_SL|XP_CS|XP_IE|XP_PD|XP_PDRV0|XP_PDRV1|XP_PU|XP_SL|YN_CS|YN_IE|YN_PD|YN_PDRV0|YN_PDRV1|YN_PU|YN_SL|YP_CS|YP_IE|YP_PD|YP_PDRV0|YP_PDRV1|YP_PU|YP_SL|ZN_CS|ZN_IE|ZN_PD|ZN_PDRV0|ZN_PDRV1|ZN_PU|ZN_SL|ZP_CS|ZP_IE|ZP_PD|ZP_PDRV0|ZP_PDRV1|ZP_PU|ZP_SL
+ nfet_06v0 L=1U W=2.5U AS=0.65P AD=0.65P PS=3.02U PD=3.02U
M$1279
+ VSS|XN_CS|XN_IE|XN_PD|XN_PDRV0|XN_PDRV1|XN_PU|XN_SL|XP_CS|XP_IE|XP_PD|XP_PDRV0|XP_PDRV1|XP_PU|XP_SL|YN_CS|YN_IE|YN_PD|YN_PDRV0|YN_PDRV1|YN_PU|YN_SL|YP_CS|YP_IE|YP_PD|YP_PDRV0|YP_PDRV1|YP_PU|YP_SL|ZN_CS|ZN_IE|ZN_PD|ZN_PDRV0|ZN_PDRV1|ZN_PU|ZN_SL|ZP_CS|ZP_IE|ZP_PD|ZP_PDRV0|ZP_PDRV1|ZP_PU|ZP_SL
+ \$7283 \$7284
+ VSS|XN_CS|XN_IE|XN_PD|XN_PDRV0|XN_PDRV1|XN_PU|XN_SL|XP_CS|XP_IE|XP_PD|XP_PDRV0|XP_PDRV1|XP_PU|XP_SL|YN_CS|YN_IE|YN_PD|YN_PDRV0|YN_PDRV1|YN_PU|YN_SL|YP_CS|YP_IE|YP_PD|YP_PDRV0|YP_PDRV1|YP_PU|YP_SL|ZN_CS|ZN_IE|ZN_PD|ZN_PDRV0|ZN_PDRV1|ZN_PU|ZN_SL|ZP_CS|ZP_IE|ZP_PD|ZP_PDRV0|ZP_PDRV1|ZP_PU|ZP_SL
+ nfet_06v0 L=1U W=2.5U AS=0.65P AD=1.1P PS=3.02U PD=5.88U
M$1280 \$7364 \$7316 \$7283
+ VSS|XN_CS|XN_IE|XN_PD|XN_PDRV0|XN_PDRV1|XN_PU|XN_SL|XP_CS|XP_IE|XP_PD|XP_PDRV0|XP_PDRV1|XP_PU|XP_SL|YN_CS|YN_IE|YN_PD|YN_PDRV0|YN_PDRV1|YN_PU|YN_SL|YP_CS|YP_IE|YP_PD|YP_PDRV0|YP_PDRV1|YP_PU|YP_SL|ZN_CS|ZN_IE|ZN_PD|ZN_PDRV0|ZN_PDRV1|ZN_PU|ZN_SL|ZP_CS|ZP_IE|ZP_PD|ZP_PDRV0|ZP_PDRV1|ZP_PU|ZP_SL
+ nfet_06v0 L=1U W=2.5U AS=1.1P AD=1.1P PS=5.88U PD=5.88U
M$1281 \$7264 \$7316 \$7285
+ VSS|XN_CS|XN_IE|XN_PD|XN_PDRV0|XN_PDRV1|XN_PU|XN_SL|XP_CS|XP_IE|XP_PD|XP_PDRV0|XP_PDRV1|XP_PU|XP_SL|YN_CS|YN_IE|YN_PD|YN_PDRV0|YN_PDRV1|YN_PU|YN_SL|YP_CS|YP_IE|YP_PD|YP_PDRV0|YP_PDRV1|YP_PU|YP_SL|ZN_CS|ZN_IE|ZN_PD|ZN_PDRV0|ZN_PDRV1|ZN_PU|ZN_SL|ZP_CS|ZP_IE|ZP_PD|ZP_PDRV0|ZP_PDRV1|ZP_PU|ZP_SL
+ nfet_06v0 L=1U W=2.5U AS=1.1P AD=1.1P PS=5.88U PD=5.88U
M$1282 \$7326 \$7263
+ VSS|XN_CS|XN_IE|XN_PD|XN_PDRV0|XN_PDRV1|XN_PU|XN_SL|XP_CS|XP_IE|XP_PD|XP_PDRV0|XP_PDRV1|XP_PU|XP_SL|YN_CS|YN_IE|YN_PD|YN_PDRV0|YN_PDRV1|YN_PU|YN_SL|YP_CS|YP_IE|YP_PD|YP_PDRV0|YP_PDRV1|YP_PU|YP_SL|ZN_CS|ZN_IE|ZN_PD|ZN_PDRV0|ZN_PDRV1|ZN_PU|ZN_SL|ZP_CS|ZP_IE|ZP_PD|ZP_PDRV0|ZP_PDRV1|ZP_PU|ZP_SL
+ VSS|XN_CS|XN_IE|XN_PD|XN_PDRV0|XN_PDRV1|XN_PU|XN_SL|XP_CS|XP_IE|XP_PD|XP_PDRV0|XP_PDRV1|XP_PU|XP_SL|YN_CS|YN_IE|YN_PD|YN_PDRV0|YN_PDRV1|YN_PU|YN_SL|YP_CS|YP_IE|YP_PD|YP_PDRV0|YP_PDRV1|YP_PU|YP_SL|ZN_CS|ZN_IE|ZN_PD|ZN_PDRV0|ZN_PDRV1|ZN_PU|ZN_SL|ZP_CS|ZP_IE|ZP_PD|ZP_PDRV0|ZP_PDRV1|ZP_PU|ZP_SL
+ nfet_06v0 L=1U W=5U AS=2.2P AD=1.25P PS=10.88U PD=5.5U
M$1283 \$7265 \$7278 \$7326
+ VSS|XN_CS|XN_IE|XN_PD|XN_PDRV0|XN_PDRV1|XN_PU|XN_SL|XP_CS|XP_IE|XP_PD|XP_PDRV0|XP_PDRV1|XP_PU|XP_SL|YN_CS|YN_IE|YN_PD|YN_PDRV0|YN_PDRV1|YN_PU|YN_SL|YP_CS|YP_IE|YP_PD|YP_PDRV0|YP_PDRV1|YP_PU|YP_SL|ZN_CS|ZN_IE|ZN_PD|ZN_PDRV0|ZN_PDRV1|ZN_PU|ZN_SL|ZP_CS|ZP_IE|ZP_PD|ZP_PDRV0|ZP_PDRV1|ZP_PU|ZP_SL
+ nfet_06v0 L=1U W=5U AS=1.25P AD=2.2P PS=5.5U PD=10.88U
M$1284 \$7327 \$7266
+ VSS|XN_CS|XN_IE|XN_PD|XN_PDRV0|XN_PDRV1|XN_PU|XN_SL|XP_CS|XP_IE|XP_PD|XP_PDRV0|XP_PDRV1|XP_PU|XP_SL|YN_CS|YN_IE|YN_PD|YN_PDRV0|YN_PDRV1|YN_PU|YN_SL|YP_CS|YP_IE|YP_PD|YP_PDRV0|YP_PDRV1|YP_PU|YP_SL|ZN_CS|ZN_IE|ZN_PD|ZN_PDRV0|ZN_PDRV1|ZN_PU|ZN_SL|ZP_CS|ZP_IE|ZP_PD|ZP_PDRV0|ZP_PDRV1|ZP_PU|ZP_SL
+ VSS|XN_CS|XN_IE|XN_PD|XN_PDRV0|XN_PDRV1|XN_PU|XN_SL|XP_CS|XP_IE|XP_PD|XP_PDRV0|XP_PDRV1|XP_PU|XP_SL|YN_CS|YN_IE|YN_PD|YN_PDRV0|YN_PDRV1|YN_PU|YN_SL|YP_CS|YP_IE|YP_PD|YP_PDRV0|YP_PDRV1|YP_PU|YP_SL|ZN_CS|ZN_IE|ZN_PD|ZN_PDRV0|ZN_PDRV1|ZN_PU|ZN_SL|ZP_CS|ZP_IE|ZP_PD|ZP_PDRV0|ZP_PDRV1|ZP_PU|ZP_SL
+ nfet_06v0 L=1U W=5U AS=2.2P AD=1.25P PS=10.88U PD=5.5U
M$1285 \$7266 \$7278 \$7327
+ VSS|XN_CS|XN_IE|XN_PD|XN_PDRV0|XN_PDRV1|XN_PU|XN_SL|XP_CS|XP_IE|XP_PD|XP_PDRV0|XP_PDRV1|XP_PU|XP_SL|YN_CS|YN_IE|YN_PD|YN_PDRV0|YN_PDRV1|YN_PU|YN_SL|YP_CS|YP_IE|YP_PD|YP_PDRV0|YP_PDRV1|YP_PU|YP_SL|ZN_CS|ZN_IE|ZN_PD|ZN_PDRV0|ZN_PDRV1|ZN_PU|ZN_SL|ZP_CS|ZP_IE|ZP_PD|ZP_PDRV0|ZP_PDRV1|ZP_PU|ZP_SL
+ nfet_06v0 L=1U W=5U AS=1.25P AD=1.65P PS=5.5U PD=5.66U
M$1286 \$7316 \$7316 \$7266
+ VSS|XN_CS|XN_IE|XN_PD|XN_PDRV0|XN_PDRV1|XN_PU|XN_SL|XP_CS|XP_IE|XP_PD|XP_PDRV0|XP_PDRV1|XP_PU|XP_SL|YN_CS|YN_IE|YN_PD|YN_PDRV0|YN_PDRV1|YN_PU|YN_SL|YP_CS|YP_IE|YP_PD|YP_PDRV0|YP_PDRV1|YP_PU|YP_SL|ZN_CS|ZN_IE|ZN_PD|ZN_PDRV0|ZN_PDRV1|ZN_PU|ZN_SL|ZP_CS|ZP_IE|ZP_PD|ZP_PDRV0|ZP_PDRV1|ZP_PU|ZP_SL
+ nfet_06v0 L=1U W=5U AS=1.65P AD=2.2P PS=5.66U PD=10.88U
M$1287 \$7286 \$7285
+ VSS|XN_CS|XN_IE|XN_PD|XN_PDRV0|XN_PDRV1|XN_PU|XN_SL|XP_CS|XP_IE|XP_PD|XP_PDRV0|XP_PDRV1|XP_PU|XP_SL|YN_CS|YN_IE|YN_PD|YN_PDRV0|YN_PDRV1|YN_PU|YN_SL|YP_CS|YP_IE|YP_PD|YP_PDRV0|YP_PDRV1|YP_PU|YP_SL|ZN_CS|ZN_IE|ZN_PD|ZN_PDRV0|ZN_PDRV1|ZN_PU|ZN_SL|ZP_CS|ZP_IE|ZP_PD|ZP_PDRV0|ZP_PDRV1|ZP_PU|ZP_SL
+ VSS|XN_CS|XN_IE|XN_PD|XN_PDRV0|XN_PDRV1|XN_PU|XN_SL|XP_CS|XP_IE|XP_PD|XP_PDRV0|XP_PDRV1|XP_PU|XP_SL|YN_CS|YN_IE|YN_PD|YN_PDRV0|YN_PDRV1|YN_PU|YN_SL|YP_CS|YP_IE|YP_PD|YP_PDRV0|YP_PDRV1|YP_PU|YP_SL|ZN_CS|ZN_IE|ZN_PD|ZN_PDRV0|ZN_PDRV1|ZN_PU|ZN_SL|ZP_CS|ZP_IE|ZP_PD|ZP_PDRV0|ZP_PDRV1|ZP_PU|ZP_SL
+ nfet_06v0 L=1U W=5U AS=2.2P AD=1.3P PS=10.88U PD=5.52U
M$1288
+ VSS|XN_CS|XN_IE|XN_PD|XN_PDRV0|XN_PDRV1|XN_PU|XN_SL|XP_CS|XP_IE|XP_PD|XP_PDRV0|XP_PDRV1|XP_PU|XP_SL|YN_CS|YN_IE|YN_PD|YN_PDRV0|YN_PDRV1|YN_PU|YN_SL|YP_CS|YP_IE|YP_PD|YP_PDRV0|YP_PDRV1|YP_PU|YP_SL|ZN_CS|ZN_IE|ZN_PD|ZN_PDRV0|ZN_PDRV1|ZN_PU|ZN_SL|ZP_CS|ZP_IE|ZP_PD|ZP_PDRV0|ZP_PDRV1|ZP_PU|ZP_SL
+ \$7285 \$7286
+ VSS|XN_CS|XN_IE|XN_PD|XN_PDRV0|XN_PDRV1|XN_PU|XN_SL|XP_CS|XP_IE|XP_PD|XP_PDRV0|XP_PDRV1|XP_PU|XP_SL|YN_CS|YN_IE|YN_PD|YN_PDRV0|YN_PDRV1|YN_PU|YN_SL|YP_CS|YP_IE|YP_PD|YP_PDRV0|YP_PDRV1|YP_PU|YP_SL|ZN_CS|ZN_IE|ZN_PD|ZN_PDRV0|ZN_PDRV1|ZN_PU|ZN_SL|ZP_CS|ZP_IE|ZP_PD|ZP_PDRV0|ZP_PDRV1|ZP_PU|ZP_SL
+ nfet_06v0 L=1U W=5U AS=1.3P AD=1.3P PS=5.52U PD=5.52U
M$1289 \$7286 \$7285
+ VSS|XN_CS|XN_IE|XN_PD|XN_PDRV0|XN_PDRV1|XN_PU|XN_SL|XP_CS|XP_IE|XP_PD|XP_PDRV0|XP_PDRV1|XP_PU|XP_SL|YN_CS|YN_IE|YN_PD|YN_PDRV0|YN_PDRV1|YN_PU|YN_SL|YP_CS|YP_IE|YP_PD|YP_PDRV0|YP_PDRV1|YP_PU|YP_SL|ZN_CS|ZN_IE|ZN_PD|ZN_PDRV0|ZN_PDRV1|ZN_PU|ZN_SL|ZP_CS|ZP_IE|ZP_PD|ZP_PDRV0|ZP_PDRV1|ZP_PU|ZP_SL
+ VSS|XN_CS|XN_IE|XN_PD|XN_PDRV0|XN_PDRV1|XN_PU|XN_SL|XP_CS|XP_IE|XP_PD|XP_PDRV0|XP_PDRV1|XP_PU|XP_SL|YN_CS|YN_IE|YN_PD|YN_PDRV0|YN_PDRV1|YN_PU|YN_SL|YP_CS|YP_IE|YP_PD|YP_PDRV0|YP_PDRV1|YP_PU|YP_SL|ZN_CS|ZN_IE|ZN_PD|ZN_PDRV0|ZN_PDRV1|ZN_PU|ZN_SL|ZP_CS|ZP_IE|ZP_PD|ZP_PDRV0|ZP_PDRV1|ZP_PU|ZP_SL
+ nfet_06v0 L=1U W=5U AS=1.3P AD=2.2P PS=5.52U PD=10.88U
M$1290
+ VSS|XN_CS|XN_IE|XN_PD|XN_PDRV0|XN_PDRV1|XN_PU|XN_SL|XP_CS|XP_IE|XP_PD|XP_PDRV0|XP_PDRV1|XP_PU|XP_SL|YN_CS|YN_IE|YN_PD|YN_PDRV0|YN_PDRV1|YN_PU|YN_SL|YP_CS|YP_IE|YP_PD|YP_PDRV0|YP_PDRV1|YP_PU|YP_SL|ZN_CS|ZN_IE|ZN_PD|ZN_PDRV0|ZN_PDRV1|ZN_PU|ZN_SL|ZP_CS|ZP_IE|ZP_PD|ZP_PDRV0|ZP_PDRV1|ZP_PU|ZP_SL
+ VDD|XN_OE|XP_OE|YN_OE|YP_OE|ZN_OE|ZP_OE
+ VSS|XN_CS|XN_IE|XN_PD|XN_PDRV0|XN_PDRV1|XN_PU|XN_SL|XP_CS|XP_IE|XP_PD|XP_PDRV0|XP_PDRV1|XP_PU|XP_SL|YN_CS|YN_IE|YN_PD|YN_PDRV0|YN_PDRV1|YN_PU|YN_SL|YP_CS|YP_IE|YP_PD|YP_PDRV0|YP_PDRV1|YP_PU|YP_SL|ZN_CS|ZN_IE|ZN_PD|ZN_PDRV0|ZN_PDRV1|ZN_PU|ZN_SL|ZP_CS|ZP_IE|ZP_PD|ZP_PDRV0|ZP_PDRV1|ZP_PU|ZP_SL
+ VSS|XN_CS|XN_IE|XN_PD|XN_PDRV0|XN_PDRV1|XN_PU|XN_SL|XP_CS|XP_IE|XP_PD|XP_PDRV0|XP_PDRV1|XP_PU|XP_SL|YN_CS|YN_IE|YN_PD|YN_PDRV0|YN_PDRV1|YN_PU|YN_SL|YP_CS|YP_IE|YP_PD|YP_PDRV0|YP_PDRV1|YP_PU|YP_SL|ZN_CS|ZN_IE|ZN_PD|ZN_PDRV0|ZN_PDRV1|ZN_PU|ZN_SL|ZP_CS|ZP_IE|ZP_PD|ZP_PDRV0|ZP_PDRV1|ZP_PU|ZP_SL
+ nfet_06v0 L=2U W=18U AS=7.92P AD=7.92P PS=36.88U PD=36.88U
M$1291
+ VSS|XN_CS|XN_IE|XN_PD|XN_PDRV0|XN_PDRV1|XN_PU|XN_SL|XP_CS|XP_IE|XP_PD|XP_PDRV0|XP_PDRV1|XP_PU|XP_SL|YN_CS|YN_IE|YN_PD|YN_PDRV0|YN_PDRV1|YN_PU|YN_SL|YP_CS|YP_IE|YP_PD|YP_PDRV0|YP_PDRV1|YP_PU|YP_SL|ZN_CS|ZN_IE|ZN_PD|ZN_PDRV0|ZN_PDRV1|ZN_PU|ZN_SL|ZP_CS|ZP_IE|ZP_PD|ZP_PDRV0|ZP_PDRV1|ZP_PU|ZP_SL
+ VDD|XN_OE|XP_OE|YN_OE|YP_OE|ZN_OE|ZP_OE
+ VSS|XN_CS|XN_IE|XN_PD|XN_PDRV0|XN_PDRV1|XN_PU|XN_SL|XP_CS|XP_IE|XP_PD|XP_PDRV0|XP_PDRV1|XP_PU|XP_SL|YN_CS|YN_IE|YN_PD|YN_PDRV0|YN_PDRV1|YN_PU|YN_SL|YP_CS|YP_IE|YP_PD|YP_PDRV0|YP_PDRV1|YP_PU|YP_SL|ZN_CS|ZN_IE|ZN_PD|ZN_PDRV0|ZN_PDRV1|ZN_PU|ZN_SL|ZP_CS|ZP_IE|ZP_PD|ZP_PDRV0|ZP_PDRV1|ZP_PU|ZP_SL
+ VSS|XN_CS|XN_IE|XN_PD|XN_PDRV0|XN_PDRV1|XN_PU|XN_SL|XP_CS|XP_IE|XP_PD|XP_PDRV0|XP_PDRV1|XP_PU|XP_SL|YN_CS|YN_IE|YN_PD|YN_PDRV0|YN_PDRV1|YN_PU|YN_SL|YP_CS|YP_IE|YP_PD|YP_PDRV0|YP_PDRV1|YP_PU|YP_SL|ZN_CS|ZN_IE|ZN_PD|ZN_PDRV0|ZN_PDRV1|ZN_PU|ZN_SL|ZP_CS|ZP_IE|ZP_PD|ZP_PDRV0|ZP_PDRV1|ZP_PU|ZP_SL
+ nfet_06v0 L=2U W=18U AS=7.92P AD=7.92P PS=36.88U PD=36.88U
M$1292 \$7287 \$7287
+ VSS|XN_CS|XN_IE|XN_PD|XN_PDRV0|XN_PDRV1|XN_PU|XN_SL|XP_CS|XP_IE|XP_PD|XP_PDRV0|XP_PDRV1|XP_PU|XP_SL|YN_CS|YN_IE|YN_PD|YN_PDRV0|YN_PDRV1|YN_PU|YN_SL|YP_CS|YP_IE|YP_PD|YP_PDRV0|YP_PDRV1|YP_PU|YP_SL|ZN_CS|ZN_IE|ZN_PD|ZN_PDRV0|ZN_PDRV1|ZN_PU|ZN_SL|ZP_CS|ZP_IE|ZP_PD|ZP_PDRV0|ZP_PDRV1|ZP_PU|ZP_SL
+ VSS|XN_CS|XN_IE|XN_PD|XN_PDRV0|XN_PDRV1|XN_PU|XN_SL|XP_CS|XP_IE|XP_PD|XP_PDRV0|XP_PDRV1|XP_PU|XP_SL|YN_CS|YN_IE|YN_PD|YN_PDRV0|YN_PDRV1|YN_PU|YN_SL|YP_CS|YP_IE|YP_PD|YP_PDRV0|YP_PDRV1|YP_PU|YP_SL|ZN_CS|ZN_IE|ZN_PD|ZN_PDRV0|ZN_PDRV1|ZN_PU|ZN_SL|ZP_CS|ZP_IE|ZP_PD|ZP_PDRV0|ZP_PDRV1|ZP_PU|ZP_SL
+ nfet_06v0 L=1U W=1U AS=0.44P AD=0.44P PS=2.88U PD=2.88U
M$1293 \$7328 \$7267
+ VSS|XN_CS|XN_IE|XN_PD|XN_PDRV0|XN_PDRV1|XN_PU|XN_SL|XP_CS|XP_IE|XP_PD|XP_PDRV0|XP_PDRV1|XP_PU|XP_SL|YN_CS|YN_IE|YN_PD|YN_PDRV0|YN_PDRV1|YN_PU|YN_SL|YP_CS|YP_IE|YP_PD|YP_PDRV0|YP_PDRV1|YP_PU|YP_SL|ZN_CS|ZN_IE|ZN_PD|ZN_PDRV0|ZN_PDRV1|ZN_PU|ZN_SL|ZP_CS|ZP_IE|ZP_PD|ZP_PDRV0|ZP_PDRV1|ZP_PU|ZP_SL
+ VSS|XN_CS|XN_IE|XN_PD|XN_PDRV0|XN_PDRV1|XN_PU|XN_SL|XP_CS|XP_IE|XP_PD|XP_PDRV0|XP_PDRV1|XP_PU|XP_SL|YN_CS|YN_IE|YN_PD|YN_PDRV0|YN_PDRV1|YN_PU|YN_SL|YP_CS|YP_IE|YP_PD|YP_PDRV0|YP_PDRV1|YP_PU|YP_SL|ZN_CS|ZN_IE|ZN_PD|ZN_PDRV0|ZN_PDRV1|ZN_PU|ZN_SL|ZP_CS|ZP_IE|ZP_PD|ZP_PDRV0|ZP_PDRV1|ZP_PU|ZP_SL
+ nfet_06v0 L=1U W=5U AS=2.2P AD=1.25P PS=10.88U PD=5.5U
M$1294 \$7267 \$7287 \$7328
+ VSS|XN_CS|XN_IE|XN_PD|XN_PDRV0|XN_PDRV1|XN_PU|XN_SL|XP_CS|XP_IE|XP_PD|XP_PDRV0|XP_PDRV1|XP_PU|XP_SL|YN_CS|YN_IE|YN_PD|YN_PDRV0|YN_PDRV1|YN_PU|YN_SL|YP_CS|YP_IE|YP_PD|YP_PDRV0|YP_PDRV1|YP_PU|YP_SL|ZN_CS|ZN_IE|ZN_PD|ZN_PDRV0|ZN_PDRV1|ZN_PU|ZN_SL|ZP_CS|ZP_IE|ZP_PD|ZP_PDRV0|ZP_PDRV1|ZP_PU|ZP_SL
+ nfet_06v0 L=1U W=5U AS=1.25P AD=2.2P PS=5.5U PD=10.88U
M$1295 \$7312 \$7901
+ VSS|XN_CS|XN_IE|XN_PD|XN_PDRV0|XN_PDRV1|XN_PU|XN_SL|XP_CS|XP_IE|XP_PD|XP_PDRV0|XP_PDRV1|XP_PU|XP_SL|YN_CS|YN_IE|YN_PD|YN_PDRV0|YN_PDRV1|YN_PU|YN_SL|YP_CS|YP_IE|YP_PD|YP_PDRV0|YP_PDRV1|YP_PU|YP_SL|ZN_CS|ZN_IE|ZN_PD|ZN_PDRV0|ZN_PDRV1|ZN_PU|ZN_SL|ZP_CS|ZP_IE|ZP_PD|ZP_PDRV0|ZP_PDRV1|ZP_PU|ZP_SL
+ VSS|XN_CS|XN_IE|XN_PD|XN_PDRV0|XN_PDRV1|XN_PU|XN_SL|XP_CS|XP_IE|XP_PD|XP_PDRV0|XP_PDRV1|XP_PU|XP_SL|YN_CS|YN_IE|YN_PD|YN_PDRV0|YN_PDRV1|YN_PU|YN_SL|YP_CS|YP_IE|YP_PD|YP_PDRV0|YP_PDRV1|YP_PU|YP_SL|ZN_CS|ZN_IE|ZN_PD|ZN_PDRV0|ZN_PDRV1|ZN_PU|ZN_SL|ZP_CS|ZP_IE|ZP_PD|ZP_PDRV0|ZP_PDRV1|ZP_PU|ZP_SL
+ nfet_06v0 L=1U W=1U AS=0.44P AD=0.25P PS=2.88U PD=1.5U
M$1296 \$7900 \$7901 \$7312
+ VSS|XN_CS|XN_IE|XN_PD|XN_PDRV0|XN_PDRV1|XN_PU|XN_SL|XP_CS|XP_IE|XP_PD|XP_PDRV0|XP_PDRV1|XP_PU|XP_SL|YN_CS|YN_IE|YN_PD|YN_PDRV0|YN_PDRV1|YN_PU|YN_SL|YP_CS|YP_IE|YP_PD|YP_PDRV0|YP_PDRV1|YP_PU|YP_SL|ZN_CS|ZN_IE|ZN_PD|ZN_PDRV0|ZN_PDRV1|ZN_PU|ZN_SL|ZP_CS|ZP_IE|ZP_PD|ZP_PDRV0|ZP_PDRV1|ZP_PU|ZP_SL
+ nfet_06v0 L=1U W=1U AS=0.25P AD=0.44P PS=1.5U PD=2.88U
M$1297 \$7313 \$7901
+ VSS|XN_CS|XN_IE|XN_PD|XN_PDRV0|XN_PDRV1|XN_PU|XN_SL|XP_CS|XP_IE|XP_PD|XP_PDRV0|XP_PDRV1|XP_PU|XP_SL|YN_CS|YN_IE|YN_PD|YN_PDRV0|YN_PDRV1|YN_PU|YN_SL|YP_CS|YP_IE|YP_PD|YP_PDRV0|YP_PDRV1|YP_PU|YP_SL|ZN_CS|ZN_IE|ZN_PD|ZN_PDRV0|ZN_PDRV1|ZN_PU|ZN_SL|ZP_CS|ZP_IE|ZP_PD|ZP_PDRV0|ZP_PDRV1|ZP_PU|ZP_SL
+ VSS|XN_CS|XN_IE|XN_PD|XN_PDRV0|XN_PDRV1|XN_PU|XN_SL|XP_CS|XP_IE|XP_PD|XP_PDRV0|XP_PDRV1|XP_PU|XP_SL|YN_CS|YN_IE|YN_PD|YN_PDRV0|YN_PDRV1|YN_PU|YN_SL|YP_CS|YP_IE|YP_PD|YP_PDRV0|YP_PDRV1|YP_PU|YP_SL|ZN_CS|ZN_IE|ZN_PD|ZN_PDRV0|ZN_PDRV1|ZN_PU|ZN_SL|ZP_CS|ZP_IE|ZP_PD|ZP_PDRV0|ZP_PDRV1|ZP_PU|ZP_SL
+ nfet_06v0 L=1U W=1U AS=0.44P AD=0.25P PS=2.88U PD=1.5U
M$1298 \$7901 \$7901 \$7313
+ VSS|XN_CS|XN_IE|XN_PD|XN_PDRV0|XN_PDRV1|XN_PU|XN_SL|XP_CS|XP_IE|XP_PD|XP_PDRV0|XP_PDRV1|XP_PU|XP_SL|YN_CS|YN_IE|YN_PD|YN_PDRV0|YN_PDRV1|YN_PU|YN_SL|YP_CS|YP_IE|YP_PD|YP_PDRV0|YP_PDRV1|YP_PU|YP_SL|ZN_CS|ZN_IE|ZN_PD|ZN_PDRV0|ZN_PDRV1|ZN_PU|ZN_SL|ZP_CS|ZP_IE|ZP_PD|ZP_PDRV0|ZP_PDRV1|ZP_PU|ZP_SL
+ nfet_06v0 L=1U W=1U AS=0.25P AD=0.44P PS=1.5U PD=2.88U
M$1299 \$7329 \$7267
+ VSS|XN_CS|XN_IE|XN_PD|XN_PDRV0|XN_PDRV1|XN_PU|XN_SL|XP_CS|XP_IE|XP_PD|XP_PDRV0|XP_PDRV1|XP_PU|XP_SL|YN_CS|YN_IE|YN_PD|YN_PDRV0|YN_PDRV1|YN_PU|YN_SL|YP_CS|YP_IE|YP_PD|YP_PDRV0|YP_PDRV1|YP_PU|YP_SL|ZN_CS|ZN_IE|ZN_PD|ZN_PDRV0|ZN_PDRV1|ZN_PU|ZN_SL|ZP_CS|ZP_IE|ZP_PD|ZP_PDRV0|ZP_PDRV1|ZP_PU|ZP_SL
+ VSS|XN_CS|XN_IE|XN_PD|XN_PDRV0|XN_PDRV1|XN_PU|XN_SL|XP_CS|XP_IE|XP_PD|XP_PDRV0|XP_PDRV1|XP_PU|XP_SL|YN_CS|YN_IE|YN_PD|YN_PDRV0|YN_PDRV1|YN_PU|YN_SL|YP_CS|YP_IE|YP_PD|YP_PDRV0|YP_PDRV1|YP_PU|YP_SL|ZN_CS|ZN_IE|ZN_PD|ZN_PDRV0|ZN_PDRV1|ZN_PU|ZN_SL|ZP_CS|ZP_IE|ZP_PD|ZP_PDRV0|ZP_PDRV1|ZP_PU|ZP_SL
+ nfet_06v0 L=1U W=5U AS=2.2P AD=1.25P PS=10.88U PD=5.5U
M$1300 \$7288 \$7287 \$7329
+ VSS|XN_CS|XN_IE|XN_PD|XN_PDRV0|XN_PDRV1|XN_PU|XN_SL|XP_CS|XP_IE|XP_PD|XP_PDRV0|XP_PDRV1|XP_PU|XP_SL|YN_CS|YN_IE|YN_PD|YN_PDRV0|YN_PDRV1|YN_PU|YN_SL|YP_CS|YP_IE|YP_PD|YP_PDRV0|YP_PDRV1|YP_PU|YP_SL|ZN_CS|ZN_IE|ZN_PD|ZN_PDRV0|ZN_PDRV1|ZN_PU|ZN_SL|ZP_CS|ZP_IE|ZP_PD|ZP_PDRV0|ZP_PDRV1|ZP_PU|ZP_SL
+ nfet_06v0 L=1U W=5U AS=1.25P AD=1.65P PS=5.5U PD=5.66U
M$1301 \$7330 \$7287 \$7288
+ VSS|XN_CS|XN_IE|XN_PD|XN_PDRV0|XN_PDRV1|XN_PU|XN_SL|XP_CS|XP_IE|XP_PD|XP_PDRV0|XP_PDRV1|XP_PU|XP_SL|YN_CS|YN_IE|YN_PD|YN_PDRV0|YN_PDRV1|YN_PU|YN_SL|YP_CS|YP_IE|YP_PD|YP_PDRV0|YP_PDRV1|YP_PU|YP_SL|ZN_CS|ZN_IE|ZN_PD|ZN_PDRV0|ZN_PDRV1|ZN_PU|ZN_SL|ZP_CS|ZP_IE|ZP_PD|ZP_PDRV0|ZP_PDRV1|ZP_PU|ZP_SL
+ nfet_06v0 L=1U W=5U AS=1.65P AD=1.25P PS=5.66U PD=5.5U
M$1302
+ VSS|XN_CS|XN_IE|XN_PD|XN_PDRV0|XN_PDRV1|XN_PU|XN_SL|XP_CS|XP_IE|XP_PD|XP_PDRV0|XP_PDRV1|XP_PU|XP_SL|YN_CS|YN_IE|YN_PD|YN_PDRV0|YN_PDRV1|YN_PU|YN_SL|YP_CS|YP_IE|YP_PD|YP_PDRV0|YP_PDRV1|YP_PU|YP_SL|ZN_CS|ZN_IE|ZN_PD|ZN_PDRV0|ZN_PDRV1|ZN_PU|ZN_SL|ZP_CS|ZP_IE|ZP_PD|ZP_PDRV0|ZP_PDRV1|ZP_PU|ZP_SL
+ \$7267 \$7330
+ VSS|XN_CS|XN_IE|XN_PD|XN_PDRV0|XN_PDRV1|XN_PU|XN_SL|XP_CS|XP_IE|XP_PD|XP_PDRV0|XP_PDRV1|XP_PU|XP_SL|YN_CS|YN_IE|YN_PD|YN_PDRV0|YN_PDRV1|YN_PU|YN_SL|YP_CS|YP_IE|YP_PD|YP_PDRV0|YP_PDRV1|YP_PU|YP_SL|ZN_CS|ZN_IE|ZN_PD|ZN_PDRV0|ZN_PDRV1|ZN_PU|ZN_SL|ZP_CS|ZP_IE|ZP_PD|ZP_PDRV0|ZP_PDRV1|ZP_PU|ZP_SL
+ nfet_06v0 L=1U W=5U AS=1.25P AD=2.2P PS=5.5U PD=10.88U
M$1303 \$7289 \$38 \$7288
+ VSS|XN_CS|XN_IE|XN_PD|XN_PDRV0|XN_PDRV1|XN_PU|XN_SL|XP_CS|XP_IE|XP_PD|XP_PDRV0|XP_PDRV1|XP_PU|XP_SL|YN_CS|YN_IE|YN_PD|YN_PDRV0|YN_PDRV1|YN_PU|YN_SL|YP_CS|YP_IE|YP_PD|YP_PDRV0|YP_PDRV1|YP_PU|YP_SL|ZN_CS|ZN_IE|ZN_PD|ZN_PDRV0|ZN_PDRV1|ZN_PU|ZN_SL|ZP_CS|ZP_IE|ZP_PD|ZP_PDRV0|ZP_PDRV1|ZP_PU|ZP_SL
+ nfet_06v0 L=1U W=5U AS=2.2P AD=1.3P PS=10.88U PD=5.52U
M$1304 \$7288 \$38 \$7289
+ VSS|XN_CS|XN_IE|XN_PD|XN_PDRV0|XN_PDRV1|XN_PU|XN_SL|XP_CS|XP_IE|XP_PD|XP_PDRV0|XP_PDRV1|XP_PU|XP_SL|YN_CS|YN_IE|YN_PD|YN_PDRV0|YN_PDRV1|YN_PU|YN_SL|YP_CS|YP_IE|YP_PD|YP_PDRV0|YP_PDRV1|YP_PU|YP_SL|ZN_CS|ZN_IE|ZN_PD|ZN_PDRV0|ZN_PDRV1|ZN_PU|ZN_SL|ZP_CS|ZP_IE|ZP_PD|ZP_PDRV0|ZP_PDRV1|ZP_PU|ZP_SL
+ nfet_06v0 L=1U W=5U AS=1.3P AD=2.2P PS=5.52U PD=10.88U
M$1305 \$7290 \$46 \$7288
+ VSS|XN_CS|XN_IE|XN_PD|XN_PDRV0|XN_PDRV1|XN_PU|XN_SL|XP_CS|XP_IE|XP_PD|XP_PDRV0|XP_PDRV1|XP_PU|XP_SL|YN_CS|YN_IE|YN_PD|YN_PDRV0|YN_PDRV1|YN_PU|YN_SL|YP_CS|YP_IE|YP_PD|YP_PDRV0|YP_PDRV1|YP_PU|YP_SL|ZN_CS|ZN_IE|ZN_PD|ZN_PDRV0|ZN_PDRV1|ZN_PU|ZN_SL|ZP_CS|ZP_IE|ZP_PD|ZP_PDRV0|ZP_PDRV1|ZP_PU|ZP_SL
+ nfet_06v0 L=1U W=5U AS=2.2P AD=1.3P PS=10.88U PD=5.52U
M$1306 \$7288 \$46 \$7290
+ VSS|XN_CS|XN_IE|XN_PD|XN_PDRV0|XN_PDRV1|XN_PU|XN_SL|XP_CS|XP_IE|XP_PD|XP_PDRV0|XP_PDRV1|XP_PU|XP_SL|YN_CS|YN_IE|YN_PD|YN_PDRV0|YN_PDRV1|YN_PU|YN_SL|YP_CS|YP_IE|YP_PD|YP_PDRV0|YP_PDRV1|YP_PU|YP_SL|ZN_CS|ZN_IE|ZN_PD|ZN_PDRV0|ZN_PDRV1|ZN_PU|ZN_SL|ZP_CS|ZP_IE|ZP_PD|ZP_PDRV0|ZP_PDRV1|ZP_PU|ZP_SL
+ nfet_06v0 L=1U W=5U AS=1.3P AD=2.2P PS=5.52U PD=10.88U
M$1307 \$7292 \$7287 \$7291
+ VSS|XN_CS|XN_IE|XN_PD|XN_PDRV0|XN_PDRV1|XN_PU|XN_SL|XP_CS|XP_IE|XP_PD|XP_PDRV0|XP_PDRV1|XP_PU|XP_SL|YN_CS|YN_IE|YN_PD|YN_PDRV0|YN_PDRV1|YN_PU|YN_SL|YP_CS|YP_IE|YP_PD|YP_PDRV0|YP_PDRV1|YP_PU|YP_SL|ZN_CS|ZN_IE|ZN_PD|ZN_PDRV0|ZN_PDRV1|ZN_PU|ZN_SL|ZP_CS|ZP_IE|ZP_PD|ZP_PDRV0|ZP_PDRV1|ZP_PU|ZP_SL
+ nfet_06v0 L=1U W=2.5U AS=1.1P AD=0.65P PS=5.88U PD=3.02U
M$1308 \$7291 \$7287 \$7292
+ VSS|XN_CS|XN_IE|XN_PD|XN_PDRV0|XN_PDRV1|XN_PU|XN_SL|XP_CS|XP_IE|XP_PD|XP_PDRV0|XP_PDRV1|XP_PU|XP_SL|YN_CS|YN_IE|YN_PD|YN_PDRV0|YN_PDRV1|YN_PU|YN_SL|YP_CS|YP_IE|YP_PD|YP_PDRV0|YP_PDRV1|YP_PU|YP_SL|ZN_CS|ZN_IE|ZN_PD|ZN_PDRV0|ZN_PDRV1|ZN_PU|ZN_SL|ZP_CS|ZP_IE|ZP_PD|ZP_PDRV0|ZP_PDRV1|ZP_PU|ZP_SL
+ nfet_06v0 L=1U W=2.5U AS=0.65P AD=1.1P PS=3.02U PD=5.88U
M$1309 \$7294 \$7287 \$7293
+ VSS|XN_CS|XN_IE|XN_PD|XN_PDRV0|XN_PDRV1|XN_PU|XN_SL|XP_CS|XP_IE|XP_PD|XP_PDRV0|XP_PDRV1|XP_PU|XP_SL|YN_CS|YN_IE|YN_PD|YN_PDRV0|YN_PDRV1|YN_PU|YN_SL|YP_CS|YP_IE|YP_PD|YP_PDRV0|YP_PDRV1|YP_PU|YP_SL|ZN_CS|ZN_IE|ZN_PD|ZN_PDRV0|ZN_PDRV1|ZN_PU|ZN_SL|ZP_CS|ZP_IE|ZP_PD|ZP_PDRV0|ZP_PDRV1|ZP_PU|ZP_SL
+ nfet_06v0 L=1U W=2.5U AS=1.1P AD=0.65P PS=5.88U PD=3.02U
M$1310 \$7293 \$7287 \$7294
+ VSS|XN_CS|XN_IE|XN_PD|XN_PDRV0|XN_PDRV1|XN_PU|XN_SL|XP_CS|XP_IE|XP_PD|XP_PDRV0|XP_PDRV1|XP_PU|XP_SL|YN_CS|YN_IE|YN_PD|YN_PDRV0|YN_PDRV1|YN_PU|YN_SL|YP_CS|YP_IE|YP_PD|YP_PDRV0|YP_PDRV1|YP_PU|YP_SL|ZN_CS|ZN_IE|ZN_PD|ZN_PDRV0|ZN_PDRV1|ZN_PU|ZN_SL|ZP_CS|ZP_IE|ZP_PD|ZP_PDRV0|ZP_PDRV1|ZP_PU|ZP_SL
+ nfet_06v0 L=1U W=2.5U AS=0.65P AD=1.1P PS=3.02U PD=5.88U
M$1311 \$7291 \$7292
+ VSS|XN_CS|XN_IE|XN_PD|XN_PDRV0|XN_PDRV1|XN_PU|XN_SL|XP_CS|XP_IE|XP_PD|XP_PDRV0|XP_PDRV1|XP_PU|XP_SL|YN_CS|YN_IE|YN_PD|YN_PDRV0|YN_PDRV1|YN_PU|YN_SL|YP_CS|YP_IE|YP_PD|YP_PDRV0|YP_PDRV1|YP_PU|YP_SL|ZN_CS|ZN_IE|ZN_PD|ZN_PDRV0|ZN_PDRV1|ZN_PU|ZN_SL|ZP_CS|ZP_IE|ZP_PD|ZP_PDRV0|ZP_PDRV1|ZP_PU|ZP_SL
+ VSS|XN_CS|XN_IE|XN_PD|XN_PDRV0|XN_PDRV1|XN_PU|XN_SL|XP_CS|XP_IE|XP_PD|XP_PDRV0|XP_PDRV1|XP_PU|XP_SL|YN_CS|YN_IE|YN_PD|YN_PDRV0|YN_PDRV1|YN_PU|YN_SL|YP_CS|YP_IE|YP_PD|YP_PDRV0|YP_PDRV1|YP_PU|YP_SL|ZN_CS|ZN_IE|ZN_PD|ZN_PDRV0|ZN_PDRV1|ZN_PU|ZN_SL|ZP_CS|ZP_IE|ZP_PD|ZP_PDRV0|ZP_PDRV1|ZP_PU|ZP_SL
+ nfet_06v0 L=1U W=2.5U AS=1.1P AD=0.65P PS=5.88U PD=3.02U
M$1312
+ VSS|XN_CS|XN_IE|XN_PD|XN_PDRV0|XN_PDRV1|XN_PU|XN_SL|XP_CS|XP_IE|XP_PD|XP_PDRV0|XP_PDRV1|XP_PU|XP_SL|YN_CS|YN_IE|YN_PD|YN_PDRV0|YN_PDRV1|YN_PU|YN_SL|YP_CS|YP_IE|YP_PD|YP_PDRV0|YP_PDRV1|YP_PU|YP_SL|ZN_CS|ZN_IE|ZN_PD|ZN_PDRV0|ZN_PDRV1|ZN_PU|ZN_SL|ZP_CS|ZP_IE|ZP_PD|ZP_PDRV0|ZP_PDRV1|ZP_PU|ZP_SL
+ \$7292 \$7291
+ VSS|XN_CS|XN_IE|XN_PD|XN_PDRV0|XN_PDRV1|XN_PU|XN_SL|XP_CS|XP_IE|XP_PD|XP_PDRV0|XP_PDRV1|XP_PU|XP_SL|YN_CS|YN_IE|YN_PD|YN_PDRV0|YN_PDRV1|YN_PU|YN_SL|YP_CS|YP_IE|YP_PD|YP_PDRV0|YP_PDRV1|YP_PU|YP_SL|ZN_CS|ZN_IE|ZN_PD|ZN_PDRV0|ZN_PDRV1|ZN_PU|ZN_SL|ZP_CS|ZP_IE|ZP_PD|ZP_PDRV0|ZP_PDRV1|ZP_PU|ZP_SL
+ nfet_06v0 L=1U W=2.5U AS=0.65P AD=0.65P PS=3.02U PD=3.02U
M$1313 \$7291 \$7292
+ VSS|XN_CS|XN_IE|XN_PD|XN_PDRV0|XN_PDRV1|XN_PU|XN_SL|XP_CS|XP_IE|XP_PD|XP_PDRV0|XP_PDRV1|XP_PU|XP_SL|YN_CS|YN_IE|YN_PD|YN_PDRV0|YN_PDRV1|YN_PU|YN_SL|YP_CS|YP_IE|YP_PD|YP_PDRV0|YP_PDRV1|YP_PU|YP_SL|ZN_CS|ZN_IE|ZN_PD|ZN_PDRV0|ZN_PDRV1|ZN_PU|ZN_SL|ZP_CS|ZP_IE|ZP_PD|ZP_PDRV0|ZP_PDRV1|ZP_PU|ZP_SL
+ VSS|XN_CS|XN_IE|XN_PD|XN_PDRV0|XN_PDRV1|XN_PU|XN_SL|XP_CS|XP_IE|XP_PD|XP_PDRV0|XP_PDRV1|XP_PU|XP_SL|YN_CS|YN_IE|YN_PD|YN_PDRV0|YN_PDRV1|YN_PU|YN_SL|YP_CS|YP_IE|YP_PD|YP_PDRV0|YP_PDRV1|YP_PU|YP_SL|ZN_CS|ZN_IE|ZN_PD|ZN_PDRV0|ZN_PDRV1|ZN_PU|ZN_SL|ZP_CS|ZP_IE|ZP_PD|ZP_PDRV0|ZP_PDRV1|ZP_PU|ZP_SL
+ nfet_06v0 L=1U W=2.5U AS=0.65P AD=0.65P PS=3.02U PD=3.02U
M$1314
+ VSS|XN_CS|XN_IE|XN_PD|XN_PDRV0|XN_PDRV1|XN_PU|XN_SL|XP_CS|XP_IE|XP_PD|XP_PDRV0|XP_PDRV1|XP_PU|XP_SL|YN_CS|YN_IE|YN_PD|YN_PDRV0|YN_PDRV1|YN_PU|YN_SL|YP_CS|YP_IE|YP_PD|YP_PDRV0|YP_PDRV1|YP_PU|YP_SL|ZN_CS|ZN_IE|ZN_PD|ZN_PDRV0|ZN_PDRV1|ZN_PU|ZN_SL|ZP_CS|ZP_IE|ZP_PD|ZP_PDRV0|ZP_PDRV1|ZP_PU|ZP_SL
+ \$7292 \$7291
+ VSS|XN_CS|XN_IE|XN_PD|XN_PDRV0|XN_PDRV1|XN_PU|XN_SL|XP_CS|XP_IE|XP_PD|XP_PDRV0|XP_PDRV1|XP_PU|XP_SL|YN_CS|YN_IE|YN_PD|YN_PDRV0|YN_PDRV1|YN_PU|YN_SL|YP_CS|YP_IE|YP_PD|YP_PDRV0|YP_PDRV1|YP_PU|YP_SL|ZN_CS|ZN_IE|ZN_PD|ZN_PDRV0|ZN_PDRV1|ZN_PU|ZN_SL|ZP_CS|ZP_IE|ZP_PD|ZP_PDRV0|ZP_PDRV1|ZP_PU|ZP_SL
+ nfet_06v0 L=1U W=2.5U AS=0.65P AD=1.1P PS=3.02U PD=5.88U
M$1315 \$7293 \$7292
+ VSS|XN_CS|XN_IE|XN_PD|XN_PDRV0|XN_PDRV1|XN_PU|XN_SL|XP_CS|XP_IE|XP_PD|XP_PDRV0|XP_PDRV1|XP_PU|XP_SL|YN_CS|YN_IE|YN_PD|YN_PDRV0|YN_PDRV1|YN_PU|YN_SL|YP_CS|YP_IE|YP_PD|YP_PDRV0|YP_PDRV1|YP_PU|YP_SL|ZN_CS|ZN_IE|ZN_PD|ZN_PDRV0|ZN_PDRV1|ZN_PU|ZN_SL|ZP_CS|ZP_IE|ZP_PD|ZP_PDRV0|ZP_PDRV1|ZP_PU|ZP_SL
+ VSS|XN_CS|XN_IE|XN_PD|XN_PDRV0|XN_PDRV1|XN_PU|XN_SL|XP_CS|XP_IE|XP_PD|XP_PDRV0|XP_PDRV1|XP_PU|XP_SL|YN_CS|YN_IE|YN_PD|YN_PDRV0|YN_PDRV1|YN_PU|YN_SL|YP_CS|YP_IE|YP_PD|YP_PDRV0|YP_PDRV1|YP_PU|YP_SL|ZN_CS|ZN_IE|ZN_PD|ZN_PDRV0|ZN_PDRV1|ZN_PU|ZN_SL|ZP_CS|ZP_IE|ZP_PD|ZP_PDRV0|ZP_PDRV1|ZP_PU|ZP_SL
+ nfet_06v0 L=1U W=2.5U AS=1.1P AD=0.65P PS=5.88U PD=3.02U
M$1316
+ VSS|XN_CS|XN_IE|XN_PD|XN_PDRV0|XN_PDRV1|XN_PU|XN_SL|XP_CS|XP_IE|XP_PD|XP_PDRV0|XP_PDRV1|XP_PU|XP_SL|YN_CS|YN_IE|YN_PD|YN_PDRV0|YN_PDRV1|YN_PU|YN_SL|YP_CS|YP_IE|YP_PD|YP_PDRV0|YP_PDRV1|YP_PU|YP_SL|ZN_CS|ZN_IE|ZN_PD|ZN_PDRV0|ZN_PDRV1|ZN_PU|ZN_SL|ZP_CS|ZP_IE|ZP_PD|ZP_PDRV0|ZP_PDRV1|ZP_PU|ZP_SL
+ \$7292 \$7293
+ VSS|XN_CS|XN_IE|XN_PD|XN_PDRV0|XN_PDRV1|XN_PU|XN_SL|XP_CS|XP_IE|XP_PD|XP_PDRV0|XP_PDRV1|XP_PU|XP_SL|YN_CS|YN_IE|YN_PD|YN_PDRV0|YN_PDRV1|YN_PU|YN_SL|YP_CS|YP_IE|YP_PD|YP_PDRV0|YP_PDRV1|YP_PU|YP_SL|ZN_CS|ZN_IE|ZN_PD|ZN_PDRV0|ZN_PDRV1|ZN_PU|ZN_SL|ZP_CS|ZP_IE|ZP_PD|ZP_PDRV0|ZP_PDRV1|ZP_PU|ZP_SL
+ nfet_06v0 L=1U W=2.5U AS=0.65P AD=0.65P PS=3.02U PD=3.02U
M$1317 \$7293 \$7292
+ VSS|XN_CS|XN_IE|XN_PD|XN_PDRV0|XN_PDRV1|XN_PU|XN_SL|XP_CS|XP_IE|XP_PD|XP_PDRV0|XP_PDRV1|XP_PU|XP_SL|YN_CS|YN_IE|YN_PD|YN_PDRV0|YN_PDRV1|YN_PU|YN_SL|YP_CS|YP_IE|YP_PD|YP_PDRV0|YP_PDRV1|YP_PU|YP_SL|ZN_CS|ZN_IE|ZN_PD|ZN_PDRV0|ZN_PDRV1|ZN_PU|ZN_SL|ZP_CS|ZP_IE|ZP_PD|ZP_PDRV0|ZP_PDRV1|ZP_PU|ZP_SL
+ VSS|XN_CS|XN_IE|XN_PD|XN_PDRV0|XN_PDRV1|XN_PU|XN_SL|XP_CS|XP_IE|XP_PD|XP_PDRV0|XP_PDRV1|XP_PU|XP_SL|YN_CS|YN_IE|YN_PD|YN_PDRV0|YN_PDRV1|YN_PU|YN_SL|YP_CS|YP_IE|YP_PD|YP_PDRV0|YP_PDRV1|YP_PU|YP_SL|ZN_CS|ZN_IE|ZN_PD|ZN_PDRV0|ZN_PDRV1|ZN_PU|ZN_SL|ZP_CS|ZP_IE|ZP_PD|ZP_PDRV0|ZP_PDRV1|ZP_PU|ZP_SL
+ nfet_06v0 L=1U W=2.5U AS=0.65P AD=0.65P PS=3.02U PD=3.02U
M$1318
+ VSS|XN_CS|XN_IE|XN_PD|XN_PDRV0|XN_PDRV1|XN_PU|XN_SL|XP_CS|XP_IE|XP_PD|XP_PDRV0|XP_PDRV1|XP_PU|XP_SL|YN_CS|YN_IE|YN_PD|YN_PDRV0|YN_PDRV1|YN_PU|YN_SL|YP_CS|YP_IE|YP_PD|YP_PDRV0|YP_PDRV1|YP_PU|YP_SL|ZN_CS|ZN_IE|ZN_PD|ZN_PDRV0|ZN_PDRV1|ZN_PU|ZN_SL|ZP_CS|ZP_IE|ZP_PD|ZP_PDRV0|ZP_PDRV1|ZP_PU|ZP_SL
+ \$7292 \$7293
+ VSS|XN_CS|XN_IE|XN_PD|XN_PDRV0|XN_PDRV1|XN_PU|XN_SL|XP_CS|XP_IE|XP_PD|XP_PDRV0|XP_PDRV1|XP_PU|XP_SL|YN_CS|YN_IE|YN_PD|YN_PDRV0|YN_PDRV1|YN_PU|YN_SL|YP_CS|YP_IE|YP_PD|YP_PDRV0|YP_PDRV1|YP_PU|YP_SL|ZN_CS|ZN_IE|ZN_PD|ZN_PDRV0|ZN_PDRV1|ZN_PU|ZN_SL|ZP_CS|ZP_IE|ZP_PD|ZP_PDRV0|ZP_PDRV1|ZP_PU|ZP_SL
+ nfet_06v0 L=1U W=2.5U AS=0.65P AD=1.1P PS=3.02U PD=5.88U
M$1319 \$7366 \$7317 \$7292
+ VSS|XN_CS|XN_IE|XN_PD|XN_PDRV0|XN_PDRV1|XN_PU|XN_SL|XP_CS|XP_IE|XP_PD|XP_PDRV0|XP_PDRV1|XP_PU|XP_SL|YN_CS|YN_IE|YN_PD|YN_PDRV0|YN_PDRV1|YN_PU|YN_SL|YP_CS|YP_IE|YP_PD|YP_PDRV0|YP_PDRV1|YP_PU|YP_SL|ZN_CS|ZN_IE|ZN_PD|ZN_PDRV0|ZN_PDRV1|ZN_PU|ZN_SL|ZP_CS|ZP_IE|ZP_PD|ZP_PDRV0|ZP_PDRV1|ZP_PU|ZP_SL
+ nfet_06v0 L=1U W=2.5U AS=1.1P AD=1.1P PS=5.88U PD=5.88U
M$1320 \$7268 \$7317 \$7294
+ VSS|XN_CS|XN_IE|XN_PD|XN_PDRV0|XN_PDRV1|XN_PU|XN_SL|XP_CS|XP_IE|XP_PD|XP_PDRV0|XP_PDRV1|XP_PU|XP_SL|YN_CS|YN_IE|YN_PD|YN_PDRV0|YN_PDRV1|YN_PU|YN_SL|YP_CS|YP_IE|YP_PD|YP_PDRV0|YP_PDRV1|YP_PU|YP_SL|ZN_CS|ZN_IE|ZN_PD|ZN_PDRV0|ZN_PDRV1|ZN_PU|ZN_SL|ZP_CS|ZP_IE|ZP_PD|ZP_PDRV0|ZP_PDRV1|ZP_PU|ZP_SL
+ nfet_06v0 L=1U W=2.5U AS=1.1P AD=1.1P PS=5.88U PD=5.88U
M$1321 \$7333 \$7267
+ VSS|XN_CS|XN_IE|XN_PD|XN_PDRV0|XN_PDRV1|XN_PU|XN_SL|XP_CS|XP_IE|XP_PD|XP_PDRV0|XP_PDRV1|XP_PU|XP_SL|YN_CS|YN_IE|YN_PD|YN_PDRV0|YN_PDRV1|YN_PU|YN_SL|YP_CS|YP_IE|YP_PD|YP_PDRV0|YP_PDRV1|YP_PU|YP_SL|ZN_CS|ZN_IE|ZN_PD|ZN_PDRV0|ZN_PDRV1|ZN_PU|ZN_SL|ZP_CS|ZP_IE|ZP_PD|ZP_PDRV0|ZP_PDRV1|ZP_PU|ZP_SL
+ VSS|XN_CS|XN_IE|XN_PD|XN_PDRV0|XN_PDRV1|XN_PU|XN_SL|XP_CS|XP_IE|XP_PD|XP_PDRV0|XP_PDRV1|XP_PU|XP_SL|YN_CS|YN_IE|YN_PD|YN_PDRV0|YN_PDRV1|YN_PU|YN_SL|YP_CS|YP_IE|YP_PD|YP_PDRV0|YP_PDRV1|YP_PU|YP_SL|ZN_CS|ZN_IE|ZN_PD|ZN_PDRV0|ZN_PDRV1|ZN_PU|ZN_SL|ZP_CS|ZP_IE|ZP_PD|ZP_PDRV0|ZP_PDRV1|ZP_PU|ZP_SL
+ nfet_06v0 L=1U W=5U AS=2.2P AD=1.25P PS=10.88U PD=5.5U
M$1322 \$7269 \$7287 \$7333
+ VSS|XN_CS|XN_IE|XN_PD|XN_PDRV0|XN_PDRV1|XN_PU|XN_SL|XP_CS|XP_IE|XP_PD|XP_PDRV0|XP_PDRV1|XP_PU|XP_SL|YN_CS|YN_IE|YN_PD|YN_PDRV0|YN_PDRV1|YN_PU|YN_SL|YP_CS|YP_IE|YP_PD|YP_PDRV0|YP_PDRV1|YP_PU|YP_SL|ZN_CS|ZN_IE|ZN_PD|ZN_PDRV0|ZN_PDRV1|ZN_PU|ZN_SL|ZP_CS|ZP_IE|ZP_PD|ZP_PDRV0|ZP_PDRV1|ZP_PU|ZP_SL
+ nfet_06v0 L=1U W=5U AS=1.25P AD=2.2P PS=5.5U PD=10.88U
M$1323 \$7334 \$7270
+ VSS|XN_CS|XN_IE|XN_PD|XN_PDRV0|XN_PDRV1|XN_PU|XN_SL|XP_CS|XP_IE|XP_PD|XP_PDRV0|XP_PDRV1|XP_PU|XP_SL|YN_CS|YN_IE|YN_PD|YN_PDRV0|YN_PDRV1|YN_PU|YN_SL|YP_CS|YP_IE|YP_PD|YP_PDRV0|YP_PDRV1|YP_PU|YP_SL|ZN_CS|ZN_IE|ZN_PD|ZN_PDRV0|ZN_PDRV1|ZN_PU|ZN_SL|ZP_CS|ZP_IE|ZP_PD|ZP_PDRV0|ZP_PDRV1|ZP_PU|ZP_SL
+ VSS|XN_CS|XN_IE|XN_PD|XN_PDRV0|XN_PDRV1|XN_PU|XN_SL|XP_CS|XP_IE|XP_PD|XP_PDRV0|XP_PDRV1|XP_PU|XP_SL|YN_CS|YN_IE|YN_PD|YN_PDRV0|YN_PDRV1|YN_PU|YN_SL|YP_CS|YP_IE|YP_PD|YP_PDRV0|YP_PDRV1|YP_PU|YP_SL|ZN_CS|ZN_IE|ZN_PD|ZN_PDRV0|ZN_PDRV1|ZN_PU|ZN_SL|ZP_CS|ZP_IE|ZP_PD|ZP_PDRV0|ZP_PDRV1|ZP_PU|ZP_SL
+ nfet_06v0 L=1U W=5U AS=2.2P AD=1.25P PS=10.88U PD=5.5U
M$1324 \$7270 \$7287 \$7334
+ VSS|XN_CS|XN_IE|XN_PD|XN_PDRV0|XN_PDRV1|XN_PU|XN_SL|XP_CS|XP_IE|XP_PD|XP_PDRV0|XP_PDRV1|XP_PU|XP_SL|YN_CS|YN_IE|YN_PD|YN_PDRV0|YN_PDRV1|YN_PU|YN_SL|YP_CS|YP_IE|YP_PD|YP_PDRV0|YP_PDRV1|YP_PU|YP_SL|ZN_CS|ZN_IE|ZN_PD|ZN_PDRV0|ZN_PDRV1|ZN_PU|ZN_SL|ZP_CS|ZP_IE|ZP_PD|ZP_PDRV0|ZP_PDRV1|ZP_PU|ZP_SL
+ nfet_06v0 L=1U W=5U AS=1.25P AD=1.65P PS=5.5U PD=5.66U
M$1325 \$7317 \$7317 \$7270
+ VSS|XN_CS|XN_IE|XN_PD|XN_PDRV0|XN_PDRV1|XN_PU|XN_SL|XP_CS|XP_IE|XP_PD|XP_PDRV0|XP_PDRV1|XP_PU|XP_SL|YN_CS|YN_IE|YN_PD|YN_PDRV0|YN_PDRV1|YN_PU|YN_SL|YP_CS|YP_IE|YP_PD|YP_PDRV0|YP_PDRV1|YP_PU|YP_SL|ZN_CS|ZN_IE|ZN_PD|ZN_PDRV0|ZN_PDRV1|ZN_PU|ZN_SL|ZP_CS|ZP_IE|ZP_PD|ZP_PDRV0|ZP_PDRV1|ZP_PU|ZP_SL
+ nfet_06v0 L=1U W=5U AS=1.65P AD=2.2P PS=5.66U PD=10.88U
M$1326 \$7295 \$7294
+ VSS|XN_CS|XN_IE|XN_PD|XN_PDRV0|XN_PDRV1|XN_PU|XN_SL|XP_CS|XP_IE|XP_PD|XP_PDRV0|XP_PDRV1|XP_PU|XP_SL|YN_CS|YN_IE|YN_PD|YN_PDRV0|YN_PDRV1|YN_PU|YN_SL|YP_CS|YP_IE|YP_PD|YP_PDRV0|YP_PDRV1|YP_PU|YP_SL|ZN_CS|ZN_IE|ZN_PD|ZN_PDRV0|ZN_PDRV1|ZN_PU|ZN_SL|ZP_CS|ZP_IE|ZP_PD|ZP_PDRV0|ZP_PDRV1|ZP_PU|ZP_SL
+ VSS|XN_CS|XN_IE|XN_PD|XN_PDRV0|XN_PDRV1|XN_PU|XN_SL|XP_CS|XP_IE|XP_PD|XP_PDRV0|XP_PDRV1|XP_PU|XP_SL|YN_CS|YN_IE|YN_PD|YN_PDRV0|YN_PDRV1|YN_PU|YN_SL|YP_CS|YP_IE|YP_PD|YP_PDRV0|YP_PDRV1|YP_PU|YP_SL|ZN_CS|ZN_IE|ZN_PD|ZN_PDRV0|ZN_PDRV1|ZN_PU|ZN_SL|ZP_CS|ZP_IE|ZP_PD|ZP_PDRV0|ZP_PDRV1|ZP_PU|ZP_SL
+ nfet_06v0 L=1U W=5U AS=2.2P AD=1.3P PS=10.88U PD=5.52U
M$1327
+ VSS|XN_CS|XN_IE|XN_PD|XN_PDRV0|XN_PDRV1|XN_PU|XN_SL|XP_CS|XP_IE|XP_PD|XP_PDRV0|XP_PDRV1|XP_PU|XP_SL|YN_CS|YN_IE|YN_PD|YN_PDRV0|YN_PDRV1|YN_PU|YN_SL|YP_CS|YP_IE|YP_PD|YP_PDRV0|YP_PDRV1|YP_PU|YP_SL|ZN_CS|ZN_IE|ZN_PD|ZN_PDRV0|ZN_PDRV1|ZN_PU|ZN_SL|ZP_CS|ZP_IE|ZP_PD|ZP_PDRV0|ZP_PDRV1|ZP_PU|ZP_SL
+ \$7294 \$7295
+ VSS|XN_CS|XN_IE|XN_PD|XN_PDRV0|XN_PDRV1|XN_PU|XN_SL|XP_CS|XP_IE|XP_PD|XP_PDRV0|XP_PDRV1|XP_PU|XP_SL|YN_CS|YN_IE|YN_PD|YN_PDRV0|YN_PDRV1|YN_PU|YN_SL|YP_CS|YP_IE|YP_PD|YP_PDRV0|YP_PDRV1|YP_PU|YP_SL|ZN_CS|ZN_IE|ZN_PD|ZN_PDRV0|ZN_PDRV1|ZN_PU|ZN_SL|ZP_CS|ZP_IE|ZP_PD|ZP_PDRV0|ZP_PDRV1|ZP_PU|ZP_SL
+ nfet_06v0 L=1U W=5U AS=1.3P AD=1.3P PS=5.52U PD=5.52U
M$1328 \$7295 \$7294
+ VSS|XN_CS|XN_IE|XN_PD|XN_PDRV0|XN_PDRV1|XN_PU|XN_SL|XP_CS|XP_IE|XP_PD|XP_PDRV0|XP_PDRV1|XP_PU|XP_SL|YN_CS|YN_IE|YN_PD|YN_PDRV0|YN_PDRV1|YN_PU|YN_SL|YP_CS|YP_IE|YP_PD|YP_PDRV0|YP_PDRV1|YP_PU|YP_SL|ZN_CS|ZN_IE|ZN_PD|ZN_PDRV0|ZN_PDRV1|ZN_PU|ZN_SL|ZP_CS|ZP_IE|ZP_PD|ZP_PDRV0|ZP_PDRV1|ZP_PU|ZP_SL
+ VSS|XN_CS|XN_IE|XN_PD|XN_PDRV0|XN_PDRV1|XN_PU|XN_SL|XP_CS|XP_IE|XP_PD|XP_PDRV0|XP_PDRV1|XP_PU|XP_SL|YN_CS|YN_IE|YN_PD|YN_PDRV0|YN_PDRV1|YN_PU|YN_SL|YP_CS|YP_IE|YP_PD|YP_PDRV0|YP_PDRV1|YP_PU|YP_SL|ZN_CS|ZN_IE|ZN_PD|ZN_PDRV0|ZN_PDRV1|ZN_PU|ZN_SL|ZP_CS|ZP_IE|ZP_PD|ZP_PDRV0|ZP_PDRV1|ZP_PU|ZP_SL
+ nfet_06v0 L=1U W=5U AS=1.3P AD=2.2P PS=5.52U PD=10.88U
M$1329
+ VSS|XN_CS|XN_IE|XN_PD|XN_PDRV0|XN_PDRV1|XN_PU|XN_SL|XP_CS|XP_IE|XP_PD|XP_PDRV0|XP_PDRV1|XP_PU|XP_SL|YN_CS|YN_IE|YN_PD|YN_PDRV0|YN_PDRV1|YN_PU|YN_SL|YP_CS|YP_IE|YP_PD|YP_PDRV0|YP_PDRV1|YP_PU|YP_SL|ZN_CS|ZN_IE|ZN_PD|ZN_PDRV0|ZN_PDRV1|ZN_PU|ZN_SL|ZP_CS|ZP_IE|ZP_PD|ZP_PDRV0|ZP_PDRV1|ZP_PU|ZP_SL
+ VDD|XN_OE|XP_OE|YN_OE|YP_OE|ZN_OE|ZP_OE
+ VSS|XN_CS|XN_IE|XN_PD|XN_PDRV0|XN_PDRV1|XN_PU|XN_SL|XP_CS|XP_IE|XP_PD|XP_PDRV0|XP_PDRV1|XP_PU|XP_SL|YN_CS|YN_IE|YN_PD|YN_PDRV0|YN_PDRV1|YN_PU|YN_SL|YP_CS|YP_IE|YP_PD|YP_PDRV0|YP_PDRV1|YP_PU|YP_SL|ZN_CS|ZN_IE|ZN_PD|ZN_PDRV0|ZN_PDRV1|ZN_PU|ZN_SL|ZP_CS|ZP_IE|ZP_PD|ZP_PDRV0|ZP_PDRV1|ZP_PU|ZP_SL
+ VSS|XN_CS|XN_IE|XN_PD|XN_PDRV0|XN_PDRV1|XN_PU|XN_SL|XP_CS|XP_IE|XP_PD|XP_PDRV0|XP_PDRV1|XP_PU|XP_SL|YN_CS|YN_IE|YN_PD|YN_PDRV0|YN_PDRV1|YN_PU|YN_SL|YP_CS|YP_IE|YP_PD|YP_PDRV0|YP_PDRV1|YP_PU|YP_SL|ZN_CS|ZN_IE|ZN_PD|ZN_PDRV0|ZN_PDRV1|ZN_PU|ZN_SL|ZP_CS|ZP_IE|ZP_PD|ZP_PDRV0|ZP_PDRV1|ZP_PU|ZP_SL
+ nfet_06v0 L=2U W=18U AS=7.92P AD=7.92P PS=36.88U PD=36.88U
M$1330
+ VSS|XN_CS|XN_IE|XN_PD|XN_PDRV0|XN_PDRV1|XN_PU|XN_SL|XP_CS|XP_IE|XP_PD|XP_PDRV0|XP_PDRV1|XP_PU|XP_SL|YN_CS|YN_IE|YN_PD|YN_PDRV0|YN_PDRV1|YN_PU|YN_SL|YP_CS|YP_IE|YP_PD|YP_PDRV0|YP_PDRV1|YP_PU|YP_SL|ZN_CS|ZN_IE|ZN_PD|ZN_PDRV0|ZN_PDRV1|ZN_PU|ZN_SL|ZP_CS|ZP_IE|ZP_PD|ZP_PDRV0|ZP_PDRV1|ZP_PU|ZP_SL
+ VDD|XN_OE|XP_OE|YN_OE|YP_OE|ZN_OE|ZP_OE
+ VSS|XN_CS|XN_IE|XN_PD|XN_PDRV0|XN_PDRV1|XN_PU|XN_SL|XP_CS|XP_IE|XP_PD|XP_PDRV0|XP_PDRV1|XP_PU|XP_SL|YN_CS|YN_IE|YN_PD|YN_PDRV0|YN_PDRV1|YN_PU|YN_SL|YP_CS|YP_IE|YP_PD|YP_PDRV0|YP_PDRV1|YP_PU|YP_SL|ZN_CS|ZN_IE|ZN_PD|ZN_PDRV0|ZN_PDRV1|ZN_PU|ZN_SL|ZP_CS|ZP_IE|ZP_PD|ZP_PDRV0|ZP_PDRV1|ZP_PU|ZP_SL
+ VSS|XN_CS|XN_IE|XN_PD|XN_PDRV0|XN_PDRV1|XN_PU|XN_SL|XP_CS|XP_IE|XP_PD|XP_PDRV0|XP_PDRV1|XP_PU|XP_SL|YN_CS|YN_IE|YN_PD|YN_PDRV0|YN_PDRV1|YN_PU|YN_SL|YP_CS|YP_IE|YP_PD|YP_PDRV0|YP_PDRV1|YP_PU|YP_SL|ZN_CS|ZN_IE|ZN_PD|ZN_PDRV0|ZN_PDRV1|ZN_PU|ZN_SL|ZP_CS|ZP_IE|ZP_PD|ZP_PDRV0|ZP_PDRV1|ZP_PU|ZP_SL
+ nfet_06v0 L=2U W=18U AS=7.92P AD=7.92P PS=36.88U PD=36.88U
M$1331 \$7296 \$7296
+ VSS|XN_CS|XN_IE|XN_PD|XN_PDRV0|XN_PDRV1|XN_PU|XN_SL|XP_CS|XP_IE|XP_PD|XP_PDRV0|XP_PDRV1|XP_PU|XP_SL|YN_CS|YN_IE|YN_PD|YN_PDRV0|YN_PDRV1|YN_PU|YN_SL|YP_CS|YP_IE|YP_PD|YP_PDRV0|YP_PDRV1|YP_PU|YP_SL|ZN_CS|ZN_IE|ZN_PD|ZN_PDRV0|ZN_PDRV1|ZN_PU|ZN_SL|ZP_CS|ZP_IE|ZP_PD|ZP_PDRV0|ZP_PDRV1|ZP_PU|ZP_SL
+ VSS|XN_CS|XN_IE|XN_PD|XN_PDRV0|XN_PDRV1|XN_PU|XN_SL|XP_CS|XP_IE|XP_PD|XP_PDRV0|XP_PDRV1|XP_PU|XP_SL|YN_CS|YN_IE|YN_PD|YN_PDRV0|YN_PDRV1|YN_PU|YN_SL|YP_CS|YP_IE|YP_PD|YP_PDRV0|YP_PDRV1|YP_PU|YP_SL|ZN_CS|ZN_IE|ZN_PD|ZN_PDRV0|ZN_PDRV1|ZN_PU|ZN_SL|ZP_CS|ZP_IE|ZP_PD|ZP_PDRV0|ZP_PDRV1|ZP_PU|ZP_SL
+ nfet_06v0 L=1U W=1U AS=0.44P AD=0.44P PS=2.88U PD=2.88U
M$1332 \$7337 \$7271
+ VSS|XN_CS|XN_IE|XN_PD|XN_PDRV0|XN_PDRV1|XN_PU|XN_SL|XP_CS|XP_IE|XP_PD|XP_PDRV0|XP_PDRV1|XP_PU|XP_SL|YN_CS|YN_IE|YN_PD|YN_PDRV0|YN_PDRV1|YN_PU|YN_SL|YP_CS|YP_IE|YP_PD|YP_PDRV0|YP_PDRV1|YP_PU|YP_SL|ZN_CS|ZN_IE|ZN_PD|ZN_PDRV0|ZN_PDRV1|ZN_PU|ZN_SL|ZP_CS|ZP_IE|ZP_PD|ZP_PDRV0|ZP_PDRV1|ZP_PU|ZP_SL
+ VSS|XN_CS|XN_IE|XN_PD|XN_PDRV0|XN_PDRV1|XN_PU|XN_SL|XP_CS|XP_IE|XP_PD|XP_PDRV0|XP_PDRV1|XP_PU|XP_SL|YN_CS|YN_IE|YN_PD|YN_PDRV0|YN_PDRV1|YN_PU|YN_SL|YP_CS|YP_IE|YP_PD|YP_PDRV0|YP_PDRV1|YP_PU|YP_SL|ZN_CS|ZN_IE|ZN_PD|ZN_PDRV0|ZN_PDRV1|ZN_PU|ZN_SL|ZP_CS|ZP_IE|ZP_PD|ZP_PDRV0|ZP_PDRV1|ZP_PU|ZP_SL
+ nfet_06v0 L=1U W=5U AS=2.2P AD=1.25P PS=10.88U PD=5.5U
M$1333 \$7271 \$7296 \$7337
+ VSS|XN_CS|XN_IE|XN_PD|XN_PDRV0|XN_PDRV1|XN_PU|XN_SL|XP_CS|XP_IE|XP_PD|XP_PDRV0|XP_PDRV1|XP_PU|XP_SL|YN_CS|YN_IE|YN_PD|YN_PDRV0|YN_PDRV1|YN_PU|YN_SL|YP_CS|YP_IE|YP_PD|YP_PDRV0|YP_PDRV1|YP_PU|YP_SL|ZN_CS|ZN_IE|ZN_PD|ZN_PDRV0|ZN_PDRV1|ZN_PU|ZN_SL|ZP_CS|ZP_IE|ZP_PD|ZP_PDRV0|ZP_PDRV1|ZP_PU|ZP_SL
+ nfet_06v0 L=1U W=5U AS=1.25P AD=2.2P PS=5.5U PD=10.88U
M$1334 \$7315 \$7904
+ VSS|XN_CS|XN_IE|XN_PD|XN_PDRV0|XN_PDRV1|XN_PU|XN_SL|XP_CS|XP_IE|XP_PD|XP_PDRV0|XP_PDRV1|XP_PU|XP_SL|YN_CS|YN_IE|YN_PD|YN_PDRV0|YN_PDRV1|YN_PU|YN_SL|YP_CS|YP_IE|YP_PD|YP_PDRV0|YP_PDRV1|YP_PU|YP_SL|ZN_CS|ZN_IE|ZN_PD|ZN_PDRV0|ZN_PDRV1|ZN_PU|ZN_SL|ZP_CS|ZP_IE|ZP_PD|ZP_PDRV0|ZP_PDRV1|ZP_PU|ZP_SL
+ VSS|XN_CS|XN_IE|XN_PD|XN_PDRV0|XN_PDRV1|XN_PU|XN_SL|XP_CS|XP_IE|XP_PD|XP_PDRV0|XP_PDRV1|XP_PU|XP_SL|YN_CS|YN_IE|YN_PD|YN_PDRV0|YN_PDRV1|YN_PU|YN_SL|YP_CS|YP_IE|YP_PD|YP_PDRV0|YP_PDRV1|YP_PU|YP_SL|ZN_CS|ZN_IE|ZN_PD|ZN_PDRV0|ZN_PDRV1|ZN_PU|ZN_SL|ZP_CS|ZP_IE|ZP_PD|ZP_PDRV0|ZP_PDRV1|ZP_PU|ZP_SL
+ nfet_06v0 L=1U W=1U AS=0.44P AD=0.25P PS=2.88U PD=1.5U
M$1335 \$7903 \$7904 \$7315
+ VSS|XN_CS|XN_IE|XN_PD|XN_PDRV0|XN_PDRV1|XN_PU|XN_SL|XP_CS|XP_IE|XP_PD|XP_PDRV0|XP_PDRV1|XP_PU|XP_SL|YN_CS|YN_IE|YN_PD|YN_PDRV0|YN_PDRV1|YN_PU|YN_SL|YP_CS|YP_IE|YP_PD|YP_PDRV0|YP_PDRV1|YP_PU|YP_SL|ZN_CS|ZN_IE|ZN_PD|ZN_PDRV0|ZN_PDRV1|ZN_PU|ZN_SL|ZP_CS|ZP_IE|ZP_PD|ZP_PDRV0|ZP_PDRV1|ZP_PU|ZP_SL
+ nfet_06v0 L=1U W=1U AS=0.25P AD=0.44P PS=1.5U PD=2.88U
M$1336 \$7314 \$7904
+ VSS|XN_CS|XN_IE|XN_PD|XN_PDRV0|XN_PDRV1|XN_PU|XN_SL|XP_CS|XP_IE|XP_PD|XP_PDRV0|XP_PDRV1|XP_PU|XP_SL|YN_CS|YN_IE|YN_PD|YN_PDRV0|YN_PDRV1|YN_PU|YN_SL|YP_CS|YP_IE|YP_PD|YP_PDRV0|YP_PDRV1|YP_PU|YP_SL|ZN_CS|ZN_IE|ZN_PD|ZN_PDRV0|ZN_PDRV1|ZN_PU|ZN_SL|ZP_CS|ZP_IE|ZP_PD|ZP_PDRV0|ZP_PDRV1|ZP_PU|ZP_SL
+ VSS|XN_CS|XN_IE|XN_PD|XN_PDRV0|XN_PDRV1|XN_PU|XN_SL|XP_CS|XP_IE|XP_PD|XP_PDRV0|XP_PDRV1|XP_PU|XP_SL|YN_CS|YN_IE|YN_PD|YN_PDRV0|YN_PDRV1|YN_PU|YN_SL|YP_CS|YP_IE|YP_PD|YP_PDRV0|YP_PDRV1|YP_PU|YP_SL|ZN_CS|ZN_IE|ZN_PD|ZN_PDRV0|ZN_PDRV1|ZN_PU|ZN_SL|ZP_CS|ZP_IE|ZP_PD|ZP_PDRV0|ZP_PDRV1|ZP_PU|ZP_SL
+ nfet_06v0 L=1U W=1U AS=0.44P AD=0.25P PS=2.88U PD=1.5U
M$1337 \$7904 \$7904 \$7314
+ VSS|XN_CS|XN_IE|XN_PD|XN_PDRV0|XN_PDRV1|XN_PU|XN_SL|XP_CS|XP_IE|XP_PD|XP_PDRV0|XP_PDRV1|XP_PU|XP_SL|YN_CS|YN_IE|YN_PD|YN_PDRV0|YN_PDRV1|YN_PU|YN_SL|YP_CS|YP_IE|YP_PD|YP_PDRV0|YP_PDRV1|YP_PU|YP_SL|ZN_CS|ZN_IE|ZN_PD|ZN_PDRV0|ZN_PDRV1|ZN_PU|ZN_SL|ZP_CS|ZP_IE|ZP_PD|ZP_PDRV0|ZP_PDRV1|ZP_PU|ZP_SL
+ nfet_06v0 L=1U W=1U AS=0.25P AD=0.44P PS=1.5U PD=2.88U
M$1338 \$7336 \$7271
+ VSS|XN_CS|XN_IE|XN_PD|XN_PDRV0|XN_PDRV1|XN_PU|XN_SL|XP_CS|XP_IE|XP_PD|XP_PDRV0|XP_PDRV1|XP_PU|XP_SL|YN_CS|YN_IE|YN_PD|YN_PDRV0|YN_PDRV1|YN_PU|YN_SL|YP_CS|YP_IE|YP_PD|YP_PDRV0|YP_PDRV1|YP_PU|YP_SL|ZN_CS|ZN_IE|ZN_PD|ZN_PDRV0|ZN_PDRV1|ZN_PU|ZN_SL|ZP_CS|ZP_IE|ZP_PD|ZP_PDRV0|ZP_PDRV1|ZP_PU|ZP_SL
+ VSS|XN_CS|XN_IE|XN_PD|XN_PDRV0|XN_PDRV1|XN_PU|XN_SL|XP_CS|XP_IE|XP_PD|XP_PDRV0|XP_PDRV1|XP_PU|XP_SL|YN_CS|YN_IE|YN_PD|YN_PDRV0|YN_PDRV1|YN_PU|YN_SL|YP_CS|YP_IE|YP_PD|YP_PDRV0|YP_PDRV1|YP_PU|YP_SL|ZN_CS|ZN_IE|ZN_PD|ZN_PDRV0|ZN_PDRV1|ZN_PU|ZN_SL|ZP_CS|ZP_IE|ZP_PD|ZP_PDRV0|ZP_PDRV1|ZP_PU|ZP_SL
+ nfet_06v0 L=1U W=5U AS=2.2P AD=1.25P PS=10.88U PD=5.5U
M$1339 \$7297 \$7296 \$7336
+ VSS|XN_CS|XN_IE|XN_PD|XN_PDRV0|XN_PDRV1|XN_PU|XN_SL|XP_CS|XP_IE|XP_PD|XP_PDRV0|XP_PDRV1|XP_PU|XP_SL|YN_CS|YN_IE|YN_PD|YN_PDRV0|YN_PDRV1|YN_PU|YN_SL|YP_CS|YP_IE|YP_PD|YP_PDRV0|YP_PDRV1|YP_PU|YP_SL|ZN_CS|ZN_IE|ZN_PD|ZN_PDRV0|ZN_PDRV1|ZN_PU|ZN_SL|ZP_CS|ZP_IE|ZP_PD|ZP_PDRV0|ZP_PDRV1|ZP_PU|ZP_SL
+ nfet_06v0 L=1U W=5U AS=1.25P AD=1.65P PS=5.5U PD=5.66U
M$1340 \$7335 \$7296 \$7297
+ VSS|XN_CS|XN_IE|XN_PD|XN_PDRV0|XN_PDRV1|XN_PU|XN_SL|XP_CS|XP_IE|XP_PD|XP_PDRV0|XP_PDRV1|XP_PU|XP_SL|YN_CS|YN_IE|YN_PD|YN_PDRV0|YN_PDRV1|YN_PU|YN_SL|YP_CS|YP_IE|YP_PD|YP_PDRV0|YP_PDRV1|YP_PU|YP_SL|ZN_CS|ZN_IE|ZN_PD|ZN_PDRV0|ZN_PDRV1|ZN_PU|ZN_SL|ZP_CS|ZP_IE|ZP_PD|ZP_PDRV0|ZP_PDRV1|ZP_PU|ZP_SL
+ nfet_06v0 L=1U W=5U AS=1.65P AD=1.25P PS=5.66U PD=5.5U
M$1341
+ VSS|XN_CS|XN_IE|XN_PD|XN_PDRV0|XN_PDRV1|XN_PU|XN_SL|XP_CS|XP_IE|XP_PD|XP_PDRV0|XP_PDRV1|XP_PU|XP_SL|YN_CS|YN_IE|YN_PD|YN_PDRV0|YN_PDRV1|YN_PU|YN_SL|YP_CS|YP_IE|YP_PD|YP_PDRV0|YP_PDRV1|YP_PU|YP_SL|ZN_CS|ZN_IE|ZN_PD|ZN_PDRV0|ZN_PDRV1|ZN_PU|ZN_SL|ZP_CS|ZP_IE|ZP_PD|ZP_PDRV0|ZP_PDRV1|ZP_PU|ZP_SL
+ \$7271 \$7335
+ VSS|XN_CS|XN_IE|XN_PD|XN_PDRV0|XN_PDRV1|XN_PU|XN_SL|XP_CS|XP_IE|XP_PD|XP_PDRV0|XP_PDRV1|XP_PU|XP_SL|YN_CS|YN_IE|YN_PD|YN_PDRV0|YN_PDRV1|YN_PU|YN_SL|YP_CS|YP_IE|YP_PD|YP_PDRV0|YP_PDRV1|YP_PU|YP_SL|ZN_CS|ZN_IE|ZN_PD|ZN_PDRV0|ZN_PDRV1|ZN_PU|ZN_SL|ZP_CS|ZP_IE|ZP_PD|ZP_PDRV0|ZP_PDRV1|ZP_PU|ZP_SL
+ nfet_06v0 L=1U W=5U AS=1.25P AD=2.2P PS=5.5U PD=10.88U
M$1342 \$7298 \$38 \$7297
+ VSS|XN_CS|XN_IE|XN_PD|XN_PDRV0|XN_PDRV1|XN_PU|XN_SL|XP_CS|XP_IE|XP_PD|XP_PDRV0|XP_PDRV1|XP_PU|XP_SL|YN_CS|YN_IE|YN_PD|YN_PDRV0|YN_PDRV1|YN_PU|YN_SL|YP_CS|YP_IE|YP_PD|YP_PDRV0|YP_PDRV1|YP_PU|YP_SL|ZN_CS|ZN_IE|ZN_PD|ZN_PDRV0|ZN_PDRV1|ZN_PU|ZN_SL|ZP_CS|ZP_IE|ZP_PD|ZP_PDRV0|ZP_PDRV1|ZP_PU|ZP_SL
+ nfet_06v0 L=1U W=5U AS=2.2P AD=1.3P PS=10.88U PD=5.52U
M$1343 \$7297 \$38 \$7298
+ VSS|XN_CS|XN_IE|XN_PD|XN_PDRV0|XN_PDRV1|XN_PU|XN_SL|XP_CS|XP_IE|XP_PD|XP_PDRV0|XP_PDRV1|XP_PU|XP_SL|YN_CS|YN_IE|YN_PD|YN_PDRV0|YN_PDRV1|YN_PU|YN_SL|YP_CS|YP_IE|YP_PD|YP_PDRV0|YP_PDRV1|YP_PU|YP_SL|ZN_CS|ZN_IE|ZN_PD|ZN_PDRV0|ZN_PDRV1|ZN_PU|ZN_SL|ZP_CS|ZP_IE|ZP_PD|ZP_PDRV0|ZP_PDRV1|ZP_PU|ZP_SL
+ nfet_06v0 L=1U W=5U AS=1.3P AD=2.2P PS=5.52U PD=10.88U
M$1344 \$7299 \$30 \$7297
+ VSS|XN_CS|XN_IE|XN_PD|XN_PDRV0|XN_PDRV1|XN_PU|XN_SL|XP_CS|XP_IE|XP_PD|XP_PDRV0|XP_PDRV1|XP_PU|XP_SL|YN_CS|YN_IE|YN_PD|YN_PDRV0|YN_PDRV1|YN_PU|YN_SL|YP_CS|YP_IE|YP_PD|YP_PDRV0|YP_PDRV1|YP_PU|YP_SL|ZN_CS|ZN_IE|ZN_PD|ZN_PDRV0|ZN_PDRV1|ZN_PU|ZN_SL|ZP_CS|ZP_IE|ZP_PD|ZP_PDRV0|ZP_PDRV1|ZP_PU|ZP_SL
+ nfet_06v0 L=1U W=5U AS=2.2P AD=1.3P PS=10.88U PD=5.52U
M$1345 \$7297 \$30 \$7299
+ VSS|XN_CS|XN_IE|XN_PD|XN_PDRV0|XN_PDRV1|XN_PU|XN_SL|XP_CS|XP_IE|XP_PD|XP_PDRV0|XP_PDRV1|XP_PU|XP_SL|YN_CS|YN_IE|YN_PD|YN_PDRV0|YN_PDRV1|YN_PU|YN_SL|YP_CS|YP_IE|YP_PD|YP_PDRV0|YP_PDRV1|YP_PU|YP_SL|ZN_CS|ZN_IE|ZN_PD|ZN_PDRV0|ZN_PDRV1|ZN_PU|ZN_SL|ZP_CS|ZP_IE|ZP_PD|ZP_PDRV0|ZP_PDRV1|ZP_PU|ZP_SL
+ nfet_06v0 L=1U W=5U AS=1.3P AD=2.2P PS=5.52U PD=10.88U
M$1346 \$7301 \$7296 \$7300
+ VSS|XN_CS|XN_IE|XN_PD|XN_PDRV0|XN_PDRV1|XN_PU|XN_SL|XP_CS|XP_IE|XP_PD|XP_PDRV0|XP_PDRV1|XP_PU|XP_SL|YN_CS|YN_IE|YN_PD|YN_PDRV0|YN_PDRV1|YN_PU|YN_SL|YP_CS|YP_IE|YP_PD|YP_PDRV0|YP_PDRV1|YP_PU|YP_SL|ZN_CS|ZN_IE|ZN_PD|ZN_PDRV0|ZN_PDRV1|ZN_PU|ZN_SL|ZP_CS|ZP_IE|ZP_PD|ZP_PDRV0|ZP_PDRV1|ZP_PU|ZP_SL
+ nfet_06v0 L=1U W=2.5U AS=1.1P AD=0.65P PS=5.88U PD=3.02U
M$1347 \$7300 \$7296 \$7301
+ VSS|XN_CS|XN_IE|XN_PD|XN_PDRV0|XN_PDRV1|XN_PU|XN_SL|XP_CS|XP_IE|XP_PD|XP_PDRV0|XP_PDRV1|XP_PU|XP_SL|YN_CS|YN_IE|YN_PD|YN_PDRV0|YN_PDRV1|YN_PU|YN_SL|YP_CS|YP_IE|YP_PD|YP_PDRV0|YP_PDRV1|YP_PU|YP_SL|ZN_CS|ZN_IE|ZN_PD|ZN_PDRV0|ZN_PDRV1|ZN_PU|ZN_SL|ZP_CS|ZP_IE|ZP_PD|ZP_PDRV0|ZP_PDRV1|ZP_PU|ZP_SL
+ nfet_06v0 L=1U W=2.5U AS=0.65P AD=1.1P PS=3.02U PD=5.88U
M$1348 \$7303 \$7296 \$7302
+ VSS|XN_CS|XN_IE|XN_PD|XN_PDRV0|XN_PDRV1|XN_PU|XN_SL|XP_CS|XP_IE|XP_PD|XP_PDRV0|XP_PDRV1|XP_PU|XP_SL|YN_CS|YN_IE|YN_PD|YN_PDRV0|YN_PDRV1|YN_PU|YN_SL|YP_CS|YP_IE|YP_PD|YP_PDRV0|YP_PDRV1|YP_PU|YP_SL|ZN_CS|ZN_IE|ZN_PD|ZN_PDRV0|ZN_PDRV1|ZN_PU|ZN_SL|ZP_CS|ZP_IE|ZP_PD|ZP_PDRV0|ZP_PDRV1|ZP_PU|ZP_SL
+ nfet_06v0 L=1U W=2.5U AS=1.1P AD=0.65P PS=5.88U PD=3.02U
M$1349 \$7302 \$7296 \$7303
+ VSS|XN_CS|XN_IE|XN_PD|XN_PDRV0|XN_PDRV1|XN_PU|XN_SL|XP_CS|XP_IE|XP_PD|XP_PDRV0|XP_PDRV1|XP_PU|XP_SL|YN_CS|YN_IE|YN_PD|YN_PDRV0|YN_PDRV1|YN_PU|YN_SL|YP_CS|YP_IE|YP_PD|YP_PDRV0|YP_PDRV1|YP_PU|YP_SL|ZN_CS|ZN_IE|ZN_PD|ZN_PDRV0|ZN_PDRV1|ZN_PU|ZN_SL|ZP_CS|ZP_IE|ZP_PD|ZP_PDRV0|ZP_PDRV1|ZP_PU|ZP_SL
+ nfet_06v0 L=1U W=2.5U AS=0.65P AD=1.1P PS=3.02U PD=5.88U
M$1350 \$7300 \$7301
+ VSS|XN_CS|XN_IE|XN_PD|XN_PDRV0|XN_PDRV1|XN_PU|XN_SL|XP_CS|XP_IE|XP_PD|XP_PDRV0|XP_PDRV1|XP_PU|XP_SL|YN_CS|YN_IE|YN_PD|YN_PDRV0|YN_PDRV1|YN_PU|YN_SL|YP_CS|YP_IE|YP_PD|YP_PDRV0|YP_PDRV1|YP_PU|YP_SL|ZN_CS|ZN_IE|ZN_PD|ZN_PDRV0|ZN_PDRV1|ZN_PU|ZN_SL|ZP_CS|ZP_IE|ZP_PD|ZP_PDRV0|ZP_PDRV1|ZP_PU|ZP_SL
+ VSS|XN_CS|XN_IE|XN_PD|XN_PDRV0|XN_PDRV1|XN_PU|XN_SL|XP_CS|XP_IE|XP_PD|XP_PDRV0|XP_PDRV1|XP_PU|XP_SL|YN_CS|YN_IE|YN_PD|YN_PDRV0|YN_PDRV1|YN_PU|YN_SL|YP_CS|YP_IE|YP_PD|YP_PDRV0|YP_PDRV1|YP_PU|YP_SL|ZN_CS|ZN_IE|ZN_PD|ZN_PDRV0|ZN_PDRV1|ZN_PU|ZN_SL|ZP_CS|ZP_IE|ZP_PD|ZP_PDRV0|ZP_PDRV1|ZP_PU|ZP_SL
+ nfet_06v0 L=1U W=2.5U AS=1.1P AD=0.65P PS=5.88U PD=3.02U
M$1351
+ VSS|XN_CS|XN_IE|XN_PD|XN_PDRV0|XN_PDRV1|XN_PU|XN_SL|XP_CS|XP_IE|XP_PD|XP_PDRV0|XP_PDRV1|XP_PU|XP_SL|YN_CS|YN_IE|YN_PD|YN_PDRV0|YN_PDRV1|YN_PU|YN_SL|YP_CS|YP_IE|YP_PD|YP_PDRV0|YP_PDRV1|YP_PU|YP_SL|ZN_CS|ZN_IE|ZN_PD|ZN_PDRV0|ZN_PDRV1|ZN_PU|ZN_SL|ZP_CS|ZP_IE|ZP_PD|ZP_PDRV0|ZP_PDRV1|ZP_PU|ZP_SL
+ \$7301 \$7300
+ VSS|XN_CS|XN_IE|XN_PD|XN_PDRV0|XN_PDRV1|XN_PU|XN_SL|XP_CS|XP_IE|XP_PD|XP_PDRV0|XP_PDRV1|XP_PU|XP_SL|YN_CS|YN_IE|YN_PD|YN_PDRV0|YN_PDRV1|YN_PU|YN_SL|YP_CS|YP_IE|YP_PD|YP_PDRV0|YP_PDRV1|YP_PU|YP_SL|ZN_CS|ZN_IE|ZN_PD|ZN_PDRV0|ZN_PDRV1|ZN_PU|ZN_SL|ZP_CS|ZP_IE|ZP_PD|ZP_PDRV0|ZP_PDRV1|ZP_PU|ZP_SL
+ nfet_06v0 L=1U W=2.5U AS=0.65P AD=0.65P PS=3.02U PD=3.02U
M$1352 \$7300 \$7301
+ VSS|XN_CS|XN_IE|XN_PD|XN_PDRV0|XN_PDRV1|XN_PU|XN_SL|XP_CS|XP_IE|XP_PD|XP_PDRV0|XP_PDRV1|XP_PU|XP_SL|YN_CS|YN_IE|YN_PD|YN_PDRV0|YN_PDRV1|YN_PU|YN_SL|YP_CS|YP_IE|YP_PD|YP_PDRV0|YP_PDRV1|YP_PU|YP_SL|ZN_CS|ZN_IE|ZN_PD|ZN_PDRV0|ZN_PDRV1|ZN_PU|ZN_SL|ZP_CS|ZP_IE|ZP_PD|ZP_PDRV0|ZP_PDRV1|ZP_PU|ZP_SL
+ VSS|XN_CS|XN_IE|XN_PD|XN_PDRV0|XN_PDRV1|XN_PU|XN_SL|XP_CS|XP_IE|XP_PD|XP_PDRV0|XP_PDRV1|XP_PU|XP_SL|YN_CS|YN_IE|YN_PD|YN_PDRV0|YN_PDRV1|YN_PU|YN_SL|YP_CS|YP_IE|YP_PD|YP_PDRV0|YP_PDRV1|YP_PU|YP_SL|ZN_CS|ZN_IE|ZN_PD|ZN_PDRV0|ZN_PDRV1|ZN_PU|ZN_SL|ZP_CS|ZP_IE|ZP_PD|ZP_PDRV0|ZP_PDRV1|ZP_PU|ZP_SL
+ nfet_06v0 L=1U W=2.5U AS=0.65P AD=0.65P PS=3.02U PD=3.02U
M$1353
+ VSS|XN_CS|XN_IE|XN_PD|XN_PDRV0|XN_PDRV1|XN_PU|XN_SL|XP_CS|XP_IE|XP_PD|XP_PDRV0|XP_PDRV1|XP_PU|XP_SL|YN_CS|YN_IE|YN_PD|YN_PDRV0|YN_PDRV1|YN_PU|YN_SL|YP_CS|YP_IE|YP_PD|YP_PDRV0|YP_PDRV1|YP_PU|YP_SL|ZN_CS|ZN_IE|ZN_PD|ZN_PDRV0|ZN_PDRV1|ZN_PU|ZN_SL|ZP_CS|ZP_IE|ZP_PD|ZP_PDRV0|ZP_PDRV1|ZP_PU|ZP_SL
+ \$7301 \$7300
+ VSS|XN_CS|XN_IE|XN_PD|XN_PDRV0|XN_PDRV1|XN_PU|XN_SL|XP_CS|XP_IE|XP_PD|XP_PDRV0|XP_PDRV1|XP_PU|XP_SL|YN_CS|YN_IE|YN_PD|YN_PDRV0|YN_PDRV1|YN_PU|YN_SL|YP_CS|YP_IE|YP_PD|YP_PDRV0|YP_PDRV1|YP_PU|YP_SL|ZN_CS|ZN_IE|ZN_PD|ZN_PDRV0|ZN_PDRV1|ZN_PU|ZN_SL|ZP_CS|ZP_IE|ZP_PD|ZP_PDRV0|ZP_PDRV1|ZP_PU|ZP_SL
+ nfet_06v0 L=1U W=2.5U AS=0.65P AD=1.1P PS=3.02U PD=5.88U
M$1354 \$7302 \$7301
+ VSS|XN_CS|XN_IE|XN_PD|XN_PDRV0|XN_PDRV1|XN_PU|XN_SL|XP_CS|XP_IE|XP_PD|XP_PDRV0|XP_PDRV1|XP_PU|XP_SL|YN_CS|YN_IE|YN_PD|YN_PDRV0|YN_PDRV1|YN_PU|YN_SL|YP_CS|YP_IE|YP_PD|YP_PDRV0|YP_PDRV1|YP_PU|YP_SL|ZN_CS|ZN_IE|ZN_PD|ZN_PDRV0|ZN_PDRV1|ZN_PU|ZN_SL|ZP_CS|ZP_IE|ZP_PD|ZP_PDRV0|ZP_PDRV1|ZP_PU|ZP_SL
+ VSS|XN_CS|XN_IE|XN_PD|XN_PDRV0|XN_PDRV1|XN_PU|XN_SL|XP_CS|XP_IE|XP_PD|XP_PDRV0|XP_PDRV1|XP_PU|XP_SL|YN_CS|YN_IE|YN_PD|YN_PDRV0|YN_PDRV1|YN_PU|YN_SL|YP_CS|YP_IE|YP_PD|YP_PDRV0|YP_PDRV1|YP_PU|YP_SL|ZN_CS|ZN_IE|ZN_PD|ZN_PDRV0|ZN_PDRV1|ZN_PU|ZN_SL|ZP_CS|ZP_IE|ZP_PD|ZP_PDRV0|ZP_PDRV1|ZP_PU|ZP_SL
+ nfet_06v0 L=1U W=2.5U AS=1.1P AD=0.65P PS=5.88U PD=3.02U
M$1355
+ VSS|XN_CS|XN_IE|XN_PD|XN_PDRV0|XN_PDRV1|XN_PU|XN_SL|XP_CS|XP_IE|XP_PD|XP_PDRV0|XP_PDRV1|XP_PU|XP_SL|YN_CS|YN_IE|YN_PD|YN_PDRV0|YN_PDRV1|YN_PU|YN_SL|YP_CS|YP_IE|YP_PD|YP_PDRV0|YP_PDRV1|YP_PU|YP_SL|ZN_CS|ZN_IE|ZN_PD|ZN_PDRV0|ZN_PDRV1|ZN_PU|ZN_SL|ZP_CS|ZP_IE|ZP_PD|ZP_PDRV0|ZP_PDRV1|ZP_PU|ZP_SL
+ \$7301 \$7302
+ VSS|XN_CS|XN_IE|XN_PD|XN_PDRV0|XN_PDRV1|XN_PU|XN_SL|XP_CS|XP_IE|XP_PD|XP_PDRV0|XP_PDRV1|XP_PU|XP_SL|YN_CS|YN_IE|YN_PD|YN_PDRV0|YN_PDRV1|YN_PU|YN_SL|YP_CS|YP_IE|YP_PD|YP_PDRV0|YP_PDRV1|YP_PU|YP_SL|ZN_CS|ZN_IE|ZN_PD|ZN_PDRV0|ZN_PDRV1|ZN_PU|ZN_SL|ZP_CS|ZP_IE|ZP_PD|ZP_PDRV0|ZP_PDRV1|ZP_PU|ZP_SL
+ nfet_06v0 L=1U W=2.5U AS=0.65P AD=0.65P PS=3.02U PD=3.02U
M$1356 \$7302 \$7301
+ VSS|XN_CS|XN_IE|XN_PD|XN_PDRV0|XN_PDRV1|XN_PU|XN_SL|XP_CS|XP_IE|XP_PD|XP_PDRV0|XP_PDRV1|XP_PU|XP_SL|YN_CS|YN_IE|YN_PD|YN_PDRV0|YN_PDRV1|YN_PU|YN_SL|YP_CS|YP_IE|YP_PD|YP_PDRV0|YP_PDRV1|YP_PU|YP_SL|ZN_CS|ZN_IE|ZN_PD|ZN_PDRV0|ZN_PDRV1|ZN_PU|ZN_SL|ZP_CS|ZP_IE|ZP_PD|ZP_PDRV0|ZP_PDRV1|ZP_PU|ZP_SL
+ VSS|XN_CS|XN_IE|XN_PD|XN_PDRV0|XN_PDRV1|XN_PU|XN_SL|XP_CS|XP_IE|XP_PD|XP_PDRV0|XP_PDRV1|XP_PU|XP_SL|YN_CS|YN_IE|YN_PD|YN_PDRV0|YN_PDRV1|YN_PU|YN_SL|YP_CS|YP_IE|YP_PD|YP_PDRV0|YP_PDRV1|YP_PU|YP_SL|ZN_CS|ZN_IE|ZN_PD|ZN_PDRV0|ZN_PDRV1|ZN_PU|ZN_SL|ZP_CS|ZP_IE|ZP_PD|ZP_PDRV0|ZP_PDRV1|ZP_PU|ZP_SL
+ nfet_06v0 L=1U W=2.5U AS=0.65P AD=0.65P PS=3.02U PD=3.02U
M$1357
+ VSS|XN_CS|XN_IE|XN_PD|XN_PDRV0|XN_PDRV1|XN_PU|XN_SL|XP_CS|XP_IE|XP_PD|XP_PDRV0|XP_PDRV1|XP_PU|XP_SL|YN_CS|YN_IE|YN_PD|YN_PDRV0|YN_PDRV1|YN_PU|YN_SL|YP_CS|YP_IE|YP_PD|YP_PDRV0|YP_PDRV1|YP_PU|YP_SL|ZN_CS|ZN_IE|ZN_PD|ZN_PDRV0|ZN_PDRV1|ZN_PU|ZN_SL|ZP_CS|ZP_IE|ZP_PD|ZP_PDRV0|ZP_PDRV1|ZP_PU|ZP_SL
+ \$7301 \$7302
+ VSS|XN_CS|XN_IE|XN_PD|XN_PDRV0|XN_PDRV1|XN_PU|XN_SL|XP_CS|XP_IE|XP_PD|XP_PDRV0|XP_PDRV1|XP_PU|XP_SL|YN_CS|YN_IE|YN_PD|YN_PDRV0|YN_PDRV1|YN_PU|YN_SL|YP_CS|YP_IE|YP_PD|YP_PDRV0|YP_PDRV1|YP_PU|YP_SL|ZN_CS|ZN_IE|ZN_PD|ZN_PDRV0|ZN_PDRV1|ZN_PU|ZN_SL|ZP_CS|ZP_IE|ZP_PD|ZP_PDRV0|ZP_PDRV1|ZP_PU|ZP_SL
+ nfet_06v0 L=1U W=2.5U AS=0.65P AD=1.1P PS=3.02U PD=5.88U
M$1358 \$7368 \$7318 \$7301
+ VSS|XN_CS|XN_IE|XN_PD|XN_PDRV0|XN_PDRV1|XN_PU|XN_SL|XP_CS|XP_IE|XP_PD|XP_PDRV0|XP_PDRV1|XP_PU|XP_SL|YN_CS|YN_IE|YN_PD|YN_PDRV0|YN_PDRV1|YN_PU|YN_SL|YP_CS|YP_IE|YP_PD|YP_PDRV0|YP_PDRV1|YP_PU|YP_SL|ZN_CS|ZN_IE|ZN_PD|ZN_PDRV0|ZN_PDRV1|ZN_PU|ZN_SL|ZP_CS|ZP_IE|ZP_PD|ZP_PDRV0|ZP_PDRV1|ZP_PU|ZP_SL
+ nfet_06v0 L=1U W=2.5U AS=1.1P AD=1.1P PS=5.88U PD=5.88U
M$1359 \$7272 \$7318 \$7303
+ VSS|XN_CS|XN_IE|XN_PD|XN_PDRV0|XN_PDRV1|XN_PU|XN_SL|XP_CS|XP_IE|XP_PD|XP_PDRV0|XP_PDRV1|XP_PU|XP_SL|YN_CS|YN_IE|YN_PD|YN_PDRV0|YN_PDRV1|YN_PU|YN_SL|YP_CS|YP_IE|YP_PD|YP_PDRV0|YP_PDRV1|YP_PU|YP_SL|ZN_CS|ZN_IE|ZN_PD|ZN_PDRV0|ZN_PDRV1|ZN_PU|ZN_SL|ZP_CS|ZP_IE|ZP_PD|ZP_PDRV0|ZP_PDRV1|ZP_PU|ZP_SL
+ nfet_06v0 L=1U W=2.5U AS=1.1P AD=1.1P PS=5.88U PD=5.88U
M$1360 \$7332 \$7271
+ VSS|XN_CS|XN_IE|XN_PD|XN_PDRV0|XN_PDRV1|XN_PU|XN_SL|XP_CS|XP_IE|XP_PD|XP_PDRV0|XP_PDRV1|XP_PU|XP_SL|YN_CS|YN_IE|YN_PD|YN_PDRV0|YN_PDRV1|YN_PU|YN_SL|YP_CS|YP_IE|YP_PD|YP_PDRV0|YP_PDRV1|YP_PU|YP_SL|ZN_CS|ZN_IE|ZN_PD|ZN_PDRV0|ZN_PDRV1|ZN_PU|ZN_SL|ZP_CS|ZP_IE|ZP_PD|ZP_PDRV0|ZP_PDRV1|ZP_PU|ZP_SL
+ VSS|XN_CS|XN_IE|XN_PD|XN_PDRV0|XN_PDRV1|XN_PU|XN_SL|XP_CS|XP_IE|XP_PD|XP_PDRV0|XP_PDRV1|XP_PU|XP_SL|YN_CS|YN_IE|YN_PD|YN_PDRV0|YN_PDRV1|YN_PU|YN_SL|YP_CS|YP_IE|YP_PD|YP_PDRV0|YP_PDRV1|YP_PU|YP_SL|ZN_CS|ZN_IE|ZN_PD|ZN_PDRV0|ZN_PDRV1|ZN_PU|ZN_SL|ZP_CS|ZP_IE|ZP_PD|ZP_PDRV0|ZP_PDRV1|ZP_PU|ZP_SL
+ nfet_06v0 L=1U W=5U AS=2.2P AD=1.25P PS=10.88U PD=5.5U
M$1361 \$7273 \$7296 \$7332
+ VSS|XN_CS|XN_IE|XN_PD|XN_PDRV0|XN_PDRV1|XN_PU|XN_SL|XP_CS|XP_IE|XP_PD|XP_PDRV0|XP_PDRV1|XP_PU|XP_SL|YN_CS|YN_IE|YN_PD|YN_PDRV0|YN_PDRV1|YN_PU|YN_SL|YP_CS|YP_IE|YP_PD|YP_PDRV0|YP_PDRV1|YP_PU|YP_SL|ZN_CS|ZN_IE|ZN_PD|ZN_PDRV0|ZN_PDRV1|ZN_PU|ZN_SL|ZP_CS|ZP_IE|ZP_PD|ZP_PDRV0|ZP_PDRV1|ZP_PU|ZP_SL
+ nfet_06v0 L=1U W=5U AS=1.25P AD=2.2P PS=5.5U PD=10.88U
M$1362 \$7331 \$7274
+ VSS|XN_CS|XN_IE|XN_PD|XN_PDRV0|XN_PDRV1|XN_PU|XN_SL|XP_CS|XP_IE|XP_PD|XP_PDRV0|XP_PDRV1|XP_PU|XP_SL|YN_CS|YN_IE|YN_PD|YN_PDRV0|YN_PDRV1|YN_PU|YN_SL|YP_CS|YP_IE|YP_PD|YP_PDRV0|YP_PDRV1|YP_PU|YP_SL|ZN_CS|ZN_IE|ZN_PD|ZN_PDRV0|ZN_PDRV1|ZN_PU|ZN_SL|ZP_CS|ZP_IE|ZP_PD|ZP_PDRV0|ZP_PDRV1|ZP_PU|ZP_SL
+ VSS|XN_CS|XN_IE|XN_PD|XN_PDRV0|XN_PDRV1|XN_PU|XN_SL|XP_CS|XP_IE|XP_PD|XP_PDRV0|XP_PDRV1|XP_PU|XP_SL|YN_CS|YN_IE|YN_PD|YN_PDRV0|YN_PDRV1|YN_PU|YN_SL|YP_CS|YP_IE|YP_PD|YP_PDRV0|YP_PDRV1|YP_PU|YP_SL|ZN_CS|ZN_IE|ZN_PD|ZN_PDRV0|ZN_PDRV1|ZN_PU|ZN_SL|ZP_CS|ZP_IE|ZP_PD|ZP_PDRV0|ZP_PDRV1|ZP_PU|ZP_SL
+ nfet_06v0 L=1U W=5U AS=2.2P AD=1.25P PS=10.88U PD=5.5U
M$1363 \$7274 \$7296 \$7331
+ VSS|XN_CS|XN_IE|XN_PD|XN_PDRV0|XN_PDRV1|XN_PU|XN_SL|XP_CS|XP_IE|XP_PD|XP_PDRV0|XP_PDRV1|XP_PU|XP_SL|YN_CS|YN_IE|YN_PD|YN_PDRV0|YN_PDRV1|YN_PU|YN_SL|YP_CS|YP_IE|YP_PD|YP_PDRV0|YP_PDRV1|YP_PU|YP_SL|ZN_CS|ZN_IE|ZN_PD|ZN_PDRV0|ZN_PDRV1|ZN_PU|ZN_SL|ZP_CS|ZP_IE|ZP_PD|ZP_PDRV0|ZP_PDRV1|ZP_PU|ZP_SL
+ nfet_06v0 L=1U W=5U AS=1.25P AD=1.65P PS=5.5U PD=5.66U
M$1364 \$7318 \$7318 \$7274
+ VSS|XN_CS|XN_IE|XN_PD|XN_PDRV0|XN_PDRV1|XN_PU|XN_SL|XP_CS|XP_IE|XP_PD|XP_PDRV0|XP_PDRV1|XP_PU|XP_SL|YN_CS|YN_IE|YN_PD|YN_PDRV0|YN_PDRV1|YN_PU|YN_SL|YP_CS|YP_IE|YP_PD|YP_PDRV0|YP_PDRV1|YP_PU|YP_SL|ZN_CS|ZN_IE|ZN_PD|ZN_PDRV0|ZN_PDRV1|ZN_PU|ZN_SL|ZP_CS|ZP_IE|ZP_PD|ZP_PDRV0|ZP_PDRV1|ZP_PU|ZP_SL
+ nfet_06v0 L=1U W=5U AS=1.65P AD=2.2P PS=5.66U PD=10.88U
M$1365 \$7304 \$7303
+ VSS|XN_CS|XN_IE|XN_PD|XN_PDRV0|XN_PDRV1|XN_PU|XN_SL|XP_CS|XP_IE|XP_PD|XP_PDRV0|XP_PDRV1|XP_PU|XP_SL|YN_CS|YN_IE|YN_PD|YN_PDRV0|YN_PDRV1|YN_PU|YN_SL|YP_CS|YP_IE|YP_PD|YP_PDRV0|YP_PDRV1|YP_PU|YP_SL|ZN_CS|ZN_IE|ZN_PD|ZN_PDRV0|ZN_PDRV1|ZN_PU|ZN_SL|ZP_CS|ZP_IE|ZP_PD|ZP_PDRV0|ZP_PDRV1|ZP_PU|ZP_SL
+ VSS|XN_CS|XN_IE|XN_PD|XN_PDRV0|XN_PDRV1|XN_PU|XN_SL|XP_CS|XP_IE|XP_PD|XP_PDRV0|XP_PDRV1|XP_PU|XP_SL|YN_CS|YN_IE|YN_PD|YN_PDRV0|YN_PDRV1|YN_PU|YN_SL|YP_CS|YP_IE|YP_PD|YP_PDRV0|YP_PDRV1|YP_PU|YP_SL|ZN_CS|ZN_IE|ZN_PD|ZN_PDRV0|ZN_PDRV1|ZN_PU|ZN_SL|ZP_CS|ZP_IE|ZP_PD|ZP_PDRV0|ZP_PDRV1|ZP_PU|ZP_SL
+ nfet_06v0 L=1U W=5U AS=2.2P AD=1.3P PS=10.88U PD=5.52U
M$1366
+ VSS|XN_CS|XN_IE|XN_PD|XN_PDRV0|XN_PDRV1|XN_PU|XN_SL|XP_CS|XP_IE|XP_PD|XP_PDRV0|XP_PDRV1|XP_PU|XP_SL|YN_CS|YN_IE|YN_PD|YN_PDRV0|YN_PDRV1|YN_PU|YN_SL|YP_CS|YP_IE|YP_PD|YP_PDRV0|YP_PDRV1|YP_PU|YP_SL|ZN_CS|ZN_IE|ZN_PD|ZN_PDRV0|ZN_PDRV1|ZN_PU|ZN_SL|ZP_CS|ZP_IE|ZP_PD|ZP_PDRV0|ZP_PDRV1|ZP_PU|ZP_SL
+ \$7303 \$7304
+ VSS|XN_CS|XN_IE|XN_PD|XN_PDRV0|XN_PDRV1|XN_PU|XN_SL|XP_CS|XP_IE|XP_PD|XP_PDRV0|XP_PDRV1|XP_PU|XP_SL|YN_CS|YN_IE|YN_PD|YN_PDRV0|YN_PDRV1|YN_PU|YN_SL|YP_CS|YP_IE|YP_PD|YP_PDRV0|YP_PDRV1|YP_PU|YP_SL|ZN_CS|ZN_IE|ZN_PD|ZN_PDRV0|ZN_PDRV1|ZN_PU|ZN_SL|ZP_CS|ZP_IE|ZP_PD|ZP_PDRV0|ZP_PDRV1|ZP_PU|ZP_SL
+ nfet_06v0 L=1U W=5U AS=1.3P AD=1.3P PS=5.52U PD=5.52U
M$1367 \$7304 \$7303
+ VSS|XN_CS|XN_IE|XN_PD|XN_PDRV0|XN_PDRV1|XN_PU|XN_SL|XP_CS|XP_IE|XP_PD|XP_PDRV0|XP_PDRV1|XP_PU|XP_SL|YN_CS|YN_IE|YN_PD|YN_PDRV0|YN_PDRV1|YN_PU|YN_SL|YP_CS|YP_IE|YP_PD|YP_PDRV0|YP_PDRV1|YP_PU|YP_SL|ZN_CS|ZN_IE|ZN_PD|ZN_PDRV0|ZN_PDRV1|ZN_PU|ZN_SL|ZP_CS|ZP_IE|ZP_PD|ZP_PDRV0|ZP_PDRV1|ZP_PU|ZP_SL
+ VSS|XN_CS|XN_IE|XN_PD|XN_PDRV0|XN_PDRV1|XN_PU|XN_SL|XP_CS|XP_IE|XP_PD|XP_PDRV0|XP_PDRV1|XP_PU|XP_SL|YN_CS|YN_IE|YN_PD|YN_PDRV0|YN_PDRV1|YN_PU|YN_SL|YP_CS|YP_IE|YP_PD|YP_PDRV0|YP_PDRV1|YP_PU|YP_SL|ZN_CS|ZN_IE|ZN_PD|ZN_PDRV0|ZN_PDRV1|ZN_PU|ZN_SL|ZP_CS|ZP_IE|ZP_PD|ZP_PDRV0|ZP_PDRV1|ZP_PU|ZP_SL
+ nfet_06v0 L=1U W=5U AS=1.3P AD=2.2P PS=5.52U PD=10.88U
M$1368
+ VSS|XN_CS|XN_IE|XN_PD|XN_PDRV0|XN_PDRV1|XN_PU|XN_SL|XP_CS|XP_IE|XP_PD|XP_PDRV0|XP_PDRV1|XP_PU|XP_SL|YN_CS|YN_IE|YN_PD|YN_PDRV0|YN_PDRV1|YN_PU|YN_SL|YP_CS|YP_IE|YP_PD|YP_PDRV0|YP_PDRV1|YP_PU|YP_SL|ZN_CS|ZN_IE|ZN_PD|ZN_PDRV0|ZN_PDRV1|ZN_PU|ZN_SL|ZP_CS|ZP_IE|ZP_PD|ZP_PDRV0|ZP_PDRV1|ZP_PU|ZP_SL
+ VDD|XN_OE|XP_OE|YN_OE|YP_OE|ZN_OE|ZP_OE
+ VSS|XN_CS|XN_IE|XN_PD|XN_PDRV0|XN_PDRV1|XN_PU|XN_SL|XP_CS|XP_IE|XP_PD|XP_PDRV0|XP_PDRV1|XP_PU|XP_SL|YN_CS|YN_IE|YN_PD|YN_PDRV0|YN_PDRV1|YN_PU|YN_SL|YP_CS|YP_IE|YP_PD|YP_PDRV0|YP_PDRV1|YP_PU|YP_SL|ZN_CS|ZN_IE|ZN_PD|ZN_PDRV0|ZN_PDRV1|ZN_PU|ZN_SL|ZP_CS|ZP_IE|ZP_PD|ZP_PDRV0|ZP_PDRV1|ZP_PU|ZP_SL
+ VSS|XN_CS|XN_IE|XN_PD|XN_PDRV0|XN_PDRV1|XN_PU|XN_SL|XP_CS|XP_IE|XP_PD|XP_PDRV0|XP_PDRV1|XP_PU|XP_SL|YN_CS|YN_IE|YN_PD|YN_PDRV0|YN_PDRV1|YN_PU|YN_SL|YP_CS|YP_IE|YP_PD|YP_PDRV0|YP_PDRV1|YP_PU|YP_SL|ZN_CS|ZN_IE|ZN_PD|ZN_PDRV0|ZN_PDRV1|ZN_PU|ZN_SL|ZP_CS|ZP_IE|ZP_PD|ZP_PDRV0|ZP_PDRV1|ZP_PU|ZP_SL
+ nfet_06v0 L=2U W=18U AS=7.92P AD=7.92P PS=36.88U PD=36.88U
M$1369
+ VSS|XN_CS|XN_IE|XN_PD|XN_PDRV0|XN_PDRV1|XN_PU|XN_SL|XP_CS|XP_IE|XP_PD|XP_PDRV0|XP_PDRV1|XP_PU|XP_SL|YN_CS|YN_IE|YN_PD|YN_PDRV0|YN_PDRV1|YN_PU|YN_SL|YP_CS|YP_IE|YP_PD|YP_PDRV0|YP_PDRV1|YP_PU|YP_SL|ZN_CS|ZN_IE|ZN_PD|ZN_PDRV0|ZN_PDRV1|ZN_PU|ZN_SL|ZP_CS|ZP_IE|ZP_PD|ZP_PDRV0|ZP_PDRV1|ZP_PU|ZP_SL
+ VDD|XN_OE|XP_OE|YN_OE|YP_OE|ZN_OE|ZP_OE
+ VSS|XN_CS|XN_IE|XN_PD|XN_PDRV0|XN_PDRV1|XN_PU|XN_SL|XP_CS|XP_IE|XP_PD|XP_PDRV0|XP_PDRV1|XP_PU|XP_SL|YN_CS|YN_IE|YN_PD|YN_PDRV0|YN_PDRV1|YN_PU|YN_SL|YP_CS|YP_IE|YP_PD|YP_PDRV0|YP_PDRV1|YP_PU|YP_SL|ZN_CS|ZN_IE|ZN_PD|ZN_PDRV0|ZN_PDRV1|ZN_PU|ZN_SL|ZP_CS|ZP_IE|ZP_PD|ZP_PDRV0|ZP_PDRV1|ZP_PU|ZP_SL
+ VSS|XN_CS|XN_IE|XN_PD|XN_PDRV0|XN_PDRV1|XN_PU|XN_SL|XP_CS|XP_IE|XP_PD|XP_PDRV0|XP_PDRV1|XP_PU|XP_SL|YN_CS|YN_IE|YN_PD|YN_PDRV0|YN_PDRV1|YN_PU|YN_SL|YP_CS|YP_IE|YP_PD|YP_PDRV0|YP_PDRV1|YP_PU|YP_SL|ZN_CS|ZN_IE|ZN_PD|ZN_PDRV0|ZN_PDRV1|ZN_PU|ZN_SL|ZP_CS|ZP_IE|ZP_PD|ZP_PDRV0|ZP_PDRV1|ZP_PU|ZP_SL
+ nfet_06v0 L=2U W=18U AS=7.92P AD=7.92P PS=36.88U PD=36.88U
M$1370
+ VSS|XN_CS|XN_IE|XN_PD|XN_PDRV0|XN_PDRV1|XN_PU|XN_SL|XP_CS|XP_IE|XP_PD|XP_PDRV0|XP_PDRV1|XP_PU|XP_SL|YN_CS|YN_IE|YN_PD|YN_PDRV0|YN_PDRV1|YN_PU|YN_SL|YP_CS|YP_IE|YP_PD|YP_PDRV0|YP_PDRV1|YP_PU|YP_SL|ZN_CS|ZN_IE|ZN_PD|ZN_PDRV0|ZN_PDRV1|ZN_PU|ZN_SL|ZP_CS|ZP_IE|ZP_PD|ZP_PDRV0|ZP_PDRV1|ZP_PU|ZP_SL
+ \$7286 \$7276
+ VSS|XN_CS|XN_IE|XN_PD|XN_PDRV0|XN_PDRV1|XN_PU|XN_SL|XP_CS|XP_IE|XP_PD|XP_PDRV0|XP_PDRV1|XP_PU|XP_SL|YN_CS|YN_IE|YN_PD|YN_PDRV0|YN_PDRV1|YN_PU|YN_SL|YP_CS|YP_IE|YP_PD|YP_PDRV0|YP_PDRV1|YP_PU|YP_SL|ZN_CS|ZN_IE|ZN_PD|ZN_PDRV0|ZN_PDRV1|ZN_PU|ZN_SL|ZP_CS|ZP_IE|ZP_PD|ZP_PDRV0|ZP_PDRV1|ZP_PU|ZP_SL
+ nfet_06v0 L=1U W=1U AS=0.44P AD=0.44P PS=2.88U PD=2.88U
M$1371
+ VSS|XN_CS|XN_IE|XN_PD|XN_PDRV0|XN_PDRV1|XN_PU|XN_SL|XP_CS|XP_IE|XP_PD|XP_PDRV0|XP_PDRV1|XP_PU|XP_SL|YN_CS|YN_IE|YN_PD|YN_PDRV0|YN_PDRV1|YN_PU|YN_SL|YP_CS|YP_IE|YP_PD|YP_PDRV0|YP_PDRV1|YP_PU|YP_SL|ZN_CS|ZN_IE|ZN_PD|ZN_PDRV0|ZN_PDRV1|ZN_PU|ZN_SL|ZP_CS|ZP_IE|ZP_PD|ZP_PDRV0|ZP_PDRV1|ZP_PU|ZP_SL
+ \$7306 \$7322
+ VSS|XN_CS|XN_IE|XN_PD|XN_PDRV0|XN_PDRV1|XN_PU|XN_SL|XP_CS|XP_IE|XP_PD|XP_PDRV0|XP_PDRV1|XP_PU|XP_SL|YN_CS|YN_IE|YN_PD|YN_PDRV0|YN_PDRV1|YN_PU|YN_SL|YP_CS|YP_IE|YP_PD|YP_PDRV0|YP_PDRV1|YP_PU|YP_SL|ZN_CS|ZN_IE|ZN_PD|ZN_PDRV0|ZN_PDRV1|ZN_PU|ZN_SL|ZP_CS|ZP_IE|ZP_PD|ZP_PDRV0|ZP_PDRV1|ZP_PU|ZP_SL
+ nfet_06v0 L=1U W=1U AS=0.44P AD=0.44P PS=2.88U PD=2.88U
M$1372 \$7311 \$7276 \$7306
+ VSS|XN_CS|XN_IE|XN_PD|XN_PDRV0|XN_PDRV1|XN_PU|XN_SL|XP_CS|XP_IE|XP_PD|XP_PDRV0|XP_PDRV1|XP_PU|XP_SL|YN_CS|YN_IE|YN_PD|YN_PDRV0|YN_PDRV1|YN_PU|YN_SL|YP_CS|YP_IE|YP_PD|YP_PDRV0|YP_PDRV1|YP_PU|YP_SL|ZN_CS|ZN_IE|ZN_PD|ZN_PDRV0|ZN_PDRV1|ZN_PU|ZN_SL|ZP_CS|ZP_IE|ZP_PD|ZP_PDRV0|ZP_PDRV1|ZP_PU|ZP_SL
+ nfet_06v0 L=1U W=1U AS=0.44P AD=0.25P PS=2.88U PD=1.5U
M$1373
+ VSS|XN_CS|XN_IE|XN_PD|XN_PDRV0|XN_PDRV1|XN_PU|XN_SL|XP_CS|XP_IE|XP_PD|XP_PDRV0|XP_PDRV1|XP_PU|XP_SL|YN_CS|YN_IE|YN_PD|YN_PDRV0|YN_PDRV1|YN_PU|YN_SL|YP_CS|YP_IE|YP_PD|YP_PDRV0|YP_PDRV1|YP_PU|YP_SL|ZN_CS|ZN_IE|ZN_PD|ZN_PDRV0|ZN_PDRV1|ZN_PU|ZN_SL|ZP_CS|ZP_IE|ZP_PD|ZP_PDRV0|ZP_PDRV1|ZP_PU|ZP_SL
+ \$7304 \$7311
+ VSS|XN_CS|XN_IE|XN_PD|XN_PDRV0|XN_PDRV1|XN_PU|XN_SL|XP_CS|XP_IE|XP_PD|XP_PDRV0|XP_PDRV1|XP_PU|XP_SL|YN_CS|YN_IE|YN_PD|YN_PDRV0|YN_PDRV1|YN_PU|YN_SL|YP_CS|YP_IE|YP_PD|YP_PDRV0|YP_PDRV1|YP_PU|YP_SL|ZN_CS|ZN_IE|ZN_PD|ZN_PDRV0|ZN_PDRV1|ZN_PU|ZN_SL|ZP_CS|ZP_IE|ZP_PD|ZP_PDRV0|ZP_PDRV1|ZP_PU|ZP_SL
+ nfet_06v0 L=1U W=1U AS=0.25P AD=0.44P PS=1.5U PD=2.88U
M$1374 \$7305 \$7304
+ VSS|XN_CS|XN_IE|XN_PD|XN_PDRV0|XN_PDRV1|XN_PU|XN_SL|XP_CS|XP_IE|XP_PD|XP_PDRV0|XP_PDRV1|XP_PU|XP_SL|YN_CS|YN_IE|YN_PD|YN_PDRV0|YN_PDRV1|YN_PU|YN_SL|YP_CS|YP_IE|YP_PD|YP_PDRV0|YP_PDRV1|YP_PU|YP_SL|ZN_CS|ZN_IE|ZN_PD|ZN_PDRV0|ZN_PDRV1|ZN_PU|ZN_SL|ZP_CS|ZP_IE|ZP_PD|ZP_PDRV0|ZP_PDRV1|ZP_PU|ZP_SL
+ VSS|XN_CS|XN_IE|XN_PD|XN_PDRV0|XN_PDRV1|XN_PU|XN_SL|XP_CS|XP_IE|XP_PD|XP_PDRV0|XP_PDRV1|XP_PU|XP_SL|YN_CS|YN_IE|YN_PD|YN_PDRV0|YN_PDRV1|YN_PU|YN_SL|YP_CS|YP_IE|YP_PD|YP_PDRV0|YP_PDRV1|YP_PU|YP_SL|ZN_CS|ZN_IE|ZN_PD|ZN_PDRV0|ZN_PDRV1|ZN_PU|ZN_SL|ZP_CS|ZP_IE|ZP_PD|ZP_PDRV0|ZP_PDRV1|ZP_PU|ZP_SL
+ nfet_06v0 L=1U W=1U AS=0.44P AD=0.33P PS=2.88U PD=1.66U
M$1375
+ VSS|XN_CS|XN_IE|XN_PD|XN_PDRV0|XN_PDRV1|XN_PU|XN_SL|XP_CS|XP_IE|XP_PD|XP_PDRV0|XP_PDRV1|XP_PU|XP_SL|YN_CS|YN_IE|YN_PD|YN_PDRV0|YN_PDRV1|YN_PU|YN_SL|YP_CS|YP_IE|YP_PD|YP_PDRV0|YP_PDRV1|YP_PU|YP_SL|ZN_CS|ZN_IE|ZN_PD|ZN_PDRV0|ZN_PDRV1|ZN_PU|ZN_SL|ZP_CS|ZP_IE|ZP_PD|ZP_PDRV0|ZP_PDRV1|ZP_PU|ZP_SL
+ \$7295 \$7305
+ VSS|XN_CS|XN_IE|XN_PD|XN_PDRV0|XN_PDRV1|XN_PU|XN_SL|XP_CS|XP_IE|XP_PD|XP_PDRV0|XP_PDRV1|XP_PU|XP_SL|YN_CS|YN_IE|YN_PD|YN_PDRV0|YN_PDRV1|YN_PU|YN_SL|YP_CS|YP_IE|YP_PD|YP_PDRV0|YP_PDRV1|YP_PU|YP_SL|ZN_CS|ZN_IE|ZN_PD|ZN_PDRV0|ZN_PDRV1|ZN_PU|ZN_SL|ZP_CS|ZP_IE|ZP_PD|ZP_PDRV0|ZP_PDRV1|ZP_PU|ZP_SL
+ nfet_06v0 L=1U W=1U AS=0.33P AD=0.44P PS=1.66U PD=2.88U
M$1376
+ VSS|XN_CS|XN_IE|XN_PD|XN_PDRV0|XN_PDRV1|XN_PU|XN_SL|XP_CS|XP_IE|XP_PD|XP_PDRV0|XP_PDRV1|XP_PU|XP_SL|YN_CS|YN_IE|YN_PD|YN_PDRV0|YN_PDRV1|YN_PU|YN_SL|YP_CS|YP_IE|YP_PD|YP_PDRV0|YP_PDRV1|YP_PU|YP_SL|ZN_CS|ZN_IE|ZN_PD|ZN_PDRV0|ZN_PDRV1|ZN_PU|ZN_SL|ZP_CS|ZP_IE|ZP_PD|ZP_PDRV0|ZP_PDRV1|ZP_PU|ZP_SL
+ \$7307 \$7277
+ VSS|XN_CS|XN_IE|XN_PD|XN_PDRV0|XN_PDRV1|XN_PU|XN_SL|XP_CS|XP_IE|XP_PD|XP_PDRV0|XP_PDRV1|XP_PU|XP_SL|YN_CS|YN_IE|YN_PD|YN_PDRV0|YN_PDRV1|YN_PU|YN_SL|YP_CS|YP_IE|YP_PD|YP_PDRV0|YP_PDRV1|YP_PU|YP_SL|ZN_CS|ZN_IE|ZN_PD|ZN_PDRV0|ZN_PDRV1|ZN_PU|ZN_SL|ZP_CS|ZP_IE|ZP_PD|ZP_PDRV0|ZP_PDRV1|ZP_PU|ZP_SL
+ nfet_06v0 L=1U W=1U AS=0.44P AD=0.44P PS=2.88U PD=2.88U
M$1377 \$7308 \$7295 \$7307
+ VSS|XN_CS|XN_IE|XN_PD|XN_PDRV0|XN_PDRV1|XN_PU|XN_SL|XP_CS|XP_IE|XP_PD|XP_PDRV0|XP_PDRV1|XP_PU|XP_SL|YN_CS|YN_IE|YN_PD|YN_PDRV0|YN_PDRV1|YN_PU|YN_SL|YP_CS|YP_IE|YP_PD|YP_PDRV0|YP_PDRV1|YP_PU|YP_SL|ZN_CS|ZN_IE|ZN_PD|ZN_PDRV0|ZN_PDRV1|ZN_PU|ZN_SL|ZP_CS|ZP_IE|ZP_PD|ZP_PDRV0|ZP_PDRV1|ZP_PU|ZP_SL
+ nfet_06v0 L=1U W=1U AS=0.44P AD=0.25P PS=2.88U PD=1.5U
M$1378
+ VSS|XN_CS|XN_IE|XN_PD|XN_PDRV0|XN_PDRV1|XN_PU|XN_SL|XP_CS|XP_IE|XP_PD|XP_PDRV0|XP_PDRV1|XP_PU|XP_SL|YN_CS|YN_IE|YN_PD|YN_PDRV0|YN_PDRV1|YN_PU|YN_SL|YP_CS|YP_IE|YP_PD|YP_PDRV0|YP_PDRV1|YP_PU|YP_SL|ZN_CS|ZN_IE|ZN_PD|ZN_PDRV0|ZN_PDRV1|ZN_PU|ZN_SL|ZP_CS|ZP_IE|ZP_PD|ZP_PDRV0|ZP_PDRV1|ZP_PU|ZP_SL
+ \$7286 \$7308
+ VSS|XN_CS|XN_IE|XN_PD|XN_PDRV0|XN_PDRV1|XN_PU|XN_SL|XP_CS|XP_IE|XP_PD|XP_PDRV0|XP_PDRV1|XP_PU|XP_SL|YN_CS|YN_IE|YN_PD|YN_PDRV0|YN_PDRV1|YN_PU|YN_SL|YP_CS|YP_IE|YP_PD|YP_PDRV0|YP_PDRV1|YP_PU|YP_SL|ZN_CS|ZN_IE|ZN_PD|ZN_PDRV0|ZN_PDRV1|ZN_PU|ZN_SL|ZP_CS|ZP_IE|ZP_PD|ZP_PDRV0|ZP_PDRV1|ZP_PU|ZP_SL
+ nfet_06v0 L=1U W=1U AS=0.25P AD=0.44P PS=1.5U PD=2.88U
M$1379
+ VSS|XN_CS|XN_IE|XN_PD|XN_PDRV0|XN_PDRV1|XN_PU|XN_SL|XP_CS|XP_IE|XP_PD|XP_PDRV0|XP_PDRV1|XP_PU|XP_SL|YN_CS|YN_IE|YN_PD|YN_PDRV0|YN_PDRV1|YN_PU|YN_SL|YP_CS|YP_IE|YP_PD|YP_PDRV0|YP_PDRV1|YP_PU|YP_SL|ZN_CS|ZN_IE|ZN_PD|ZN_PDRV0|ZN_PDRV1|ZN_PU|ZN_SL|ZP_CS|ZP_IE|ZP_PD|ZP_PDRV0|ZP_PDRV1|ZP_PU|ZP_SL
+ VDD|XN_OE|XP_OE|YN_OE|YP_OE|ZN_OE|ZP_OE
+ VSS|XN_CS|XN_IE|XN_PD|XN_PDRV0|XN_PDRV1|XN_PU|XN_SL|XP_CS|XP_IE|XP_PD|XP_PDRV0|XP_PDRV1|XP_PU|XP_SL|YN_CS|YN_IE|YN_PD|YN_PDRV0|YN_PDRV1|YN_PU|YN_SL|YP_CS|YP_IE|YP_PD|YP_PDRV0|YP_PDRV1|YP_PU|YP_SL|ZN_CS|ZN_IE|ZN_PD|ZN_PDRV0|ZN_PDRV1|ZN_PU|ZN_SL|ZP_CS|ZP_IE|ZP_PD|ZP_PDRV0|ZP_PDRV1|ZP_PU|ZP_SL
+ VSS|XN_CS|XN_IE|XN_PD|XN_PDRV0|XN_PDRV1|XN_PU|XN_SL|XP_CS|XP_IE|XP_PD|XP_PDRV0|XP_PDRV1|XP_PU|XP_SL|YN_CS|YN_IE|YN_PD|YN_PDRV0|YN_PDRV1|YN_PU|YN_SL|YP_CS|YP_IE|YP_PD|YP_PDRV0|YP_PDRV1|YP_PU|YP_SL|ZN_CS|ZN_IE|ZN_PD|ZN_PDRV0|ZN_PDRV1|ZN_PU|ZN_SL|ZP_CS|ZP_IE|ZP_PD|ZP_PDRV0|ZP_PDRV1|ZP_PU|ZP_SL
+ nfet_06v0 L=2U W=18U AS=7.92P AD=7.92P PS=36.88U PD=36.88U
M$1380
+ VSS|XN_CS|XN_IE|XN_PD|XN_PDRV0|XN_PDRV1|XN_PU|XN_SL|XP_CS|XP_IE|XP_PD|XP_PDRV0|XP_PDRV1|XP_PU|XP_SL|YN_CS|YN_IE|YN_PD|YN_PDRV0|YN_PDRV1|YN_PU|YN_SL|YP_CS|YP_IE|YP_PD|YP_PDRV0|YP_PDRV1|YP_PU|YP_SL|ZN_CS|ZN_IE|ZN_PD|ZN_PDRV0|ZN_PDRV1|ZN_PU|ZN_SL|ZP_CS|ZP_IE|ZP_PD|ZP_PDRV0|ZP_PDRV1|ZP_PU|ZP_SL
+ VDD|XN_OE|XP_OE|YN_OE|YP_OE|ZN_OE|ZP_OE
+ VSS|XN_CS|XN_IE|XN_PD|XN_PDRV0|XN_PDRV1|XN_PU|XN_SL|XP_CS|XP_IE|XP_PD|XP_PDRV0|XP_PDRV1|XP_PU|XP_SL|YN_CS|YN_IE|YN_PD|YN_PDRV0|YN_PDRV1|YN_PU|YN_SL|YP_CS|YP_IE|YP_PD|YP_PDRV0|YP_PDRV1|YP_PU|YP_SL|ZN_CS|ZN_IE|ZN_PD|ZN_PDRV0|ZN_PDRV1|ZN_PU|ZN_SL|ZP_CS|ZP_IE|ZP_PD|ZP_PDRV0|ZP_PDRV1|ZP_PU|ZP_SL
+ VSS|XN_CS|XN_IE|XN_PD|XN_PDRV0|XN_PDRV1|XN_PU|XN_SL|XP_CS|XP_IE|XP_PD|XP_PDRV0|XP_PDRV1|XP_PU|XP_SL|YN_CS|YN_IE|YN_PD|YN_PDRV0|YN_PDRV1|YN_PU|YN_SL|YP_CS|YP_IE|YP_PD|YP_PDRV0|YP_PDRV1|YP_PU|YP_SL|ZN_CS|ZN_IE|ZN_PD|ZN_PDRV0|ZN_PDRV1|ZN_PU|ZN_SL|ZP_CS|ZP_IE|ZP_PD|ZP_PDRV0|ZP_PDRV1|ZP_PU|ZP_SL
+ nfet_06v0 L=2U W=18U AS=7.92P AD=7.92P PS=36.88U PD=36.88U
M$1381
+ VSS|XN_CS|XN_IE|XN_PD|XN_PDRV0|XN_PDRV1|XN_PU|XN_SL|XP_CS|XP_IE|XP_PD|XP_PDRV0|XP_PDRV1|XP_PU|XP_SL|YN_CS|YN_IE|YN_PD|YN_PDRV0|YN_PDRV1|YN_PU|YN_SL|YP_CS|YP_IE|YP_PD|YP_PDRV0|YP_PDRV1|YP_PU|YP_SL|ZN_CS|ZN_IE|ZN_PD|ZN_PDRV0|ZN_PDRV1|ZN_PU|ZN_SL|ZP_CS|ZP_IE|ZP_PD|ZP_PDRV0|ZP_PDRV1|ZP_PU|ZP_SL
+ VDD|XN_OE|XP_OE|YN_OE|YP_OE|ZN_OE|ZP_OE
+ VSS|XN_CS|XN_IE|XN_PD|XN_PDRV0|XN_PDRV1|XN_PU|XN_SL|XP_CS|XP_IE|XP_PD|XP_PDRV0|XP_PDRV1|XP_PU|XP_SL|YN_CS|YN_IE|YN_PD|YN_PDRV0|YN_PDRV1|YN_PU|YN_SL|YP_CS|YP_IE|YP_PD|YP_PDRV0|YP_PDRV1|YP_PU|YP_SL|ZN_CS|ZN_IE|ZN_PD|ZN_PDRV0|ZN_PDRV1|ZN_PU|ZN_SL|ZP_CS|ZP_IE|ZP_PD|ZP_PDRV0|ZP_PDRV1|ZP_PU|ZP_SL
+ VSS|XN_CS|XN_IE|XN_PD|XN_PDRV0|XN_PDRV1|XN_PU|XN_SL|XP_CS|XP_IE|XP_PD|XP_PDRV0|XP_PDRV1|XP_PU|XP_SL|YN_CS|YN_IE|YN_PD|YN_PDRV0|YN_PDRV1|YN_PU|YN_SL|YP_CS|YP_IE|YP_PD|YP_PDRV0|YP_PDRV1|YP_PU|YP_SL|ZN_CS|ZN_IE|ZN_PD|ZN_PDRV0|ZN_PDRV1|ZN_PU|ZN_SL|ZP_CS|ZP_IE|ZP_PD|ZP_PDRV0|ZP_PDRV1|ZP_PU|ZP_SL
+ nfet_06v0 L=2U W=18U AS=7.92P AD=7.92P PS=36.88U PD=36.88U
M$1382
+ VSS|XN_CS|XN_IE|XN_PD|XN_PDRV0|XN_PDRV1|XN_PU|XN_SL|XP_CS|XP_IE|XP_PD|XP_PDRV0|XP_PDRV1|XP_PU|XP_SL|YN_CS|YN_IE|YN_PD|YN_PDRV0|YN_PDRV1|YN_PU|YN_SL|YP_CS|YP_IE|YP_PD|YP_PDRV0|YP_PDRV1|YP_PU|YP_SL|ZN_CS|ZN_IE|ZN_PD|ZN_PDRV0|ZN_PDRV1|ZN_PU|ZN_SL|ZP_CS|ZP_IE|ZP_PD|ZP_PDRV0|ZP_PDRV1|ZP_PU|ZP_SL
+ VDD|XN_OE|XP_OE|YN_OE|YP_OE|ZN_OE|ZP_OE
+ VSS|XN_CS|XN_IE|XN_PD|XN_PDRV0|XN_PDRV1|XN_PU|XN_SL|XP_CS|XP_IE|XP_PD|XP_PDRV0|XP_PDRV1|XP_PU|XP_SL|YN_CS|YN_IE|YN_PD|YN_PDRV0|YN_PDRV1|YN_PU|YN_SL|YP_CS|YP_IE|YP_PD|YP_PDRV0|YP_PDRV1|YP_PU|YP_SL|ZN_CS|ZN_IE|ZN_PD|ZN_PDRV0|ZN_PDRV1|ZN_PU|ZN_SL|ZP_CS|ZP_IE|ZP_PD|ZP_PDRV0|ZP_PDRV1|ZP_PU|ZP_SL
+ VSS|XN_CS|XN_IE|XN_PD|XN_PDRV0|XN_PDRV1|XN_PU|XN_SL|XP_CS|XP_IE|XP_PD|XP_PDRV0|XP_PDRV1|XP_PU|XP_SL|YN_CS|YN_IE|YN_PD|YN_PDRV0|YN_PDRV1|YN_PU|YN_SL|YP_CS|YP_IE|YP_PD|YP_PDRV0|YP_PDRV1|YP_PU|YP_SL|ZN_CS|ZN_IE|ZN_PD|ZN_PDRV0|ZN_PDRV1|ZN_PU|ZN_SL|ZP_CS|ZP_IE|ZP_PD|ZP_PDRV0|ZP_PDRV1|ZP_PU|ZP_SL
+ nfet_06v0 L=2U W=9.75U AS=4.29P AD=4.29P PS=20.38U PD=20.38U
M$1383 \$9081 \$9081
+ VSS|XN_CS|XN_IE|XN_PD|XN_PDRV0|XN_PDRV1|XN_PU|XN_SL|XP_CS|XP_IE|XP_PD|XP_PDRV0|XP_PDRV1|XP_PU|XP_SL|YN_CS|YN_IE|YN_PD|YN_PDRV0|YN_PDRV1|YN_PU|YN_SL|YP_CS|YP_IE|YP_PD|YP_PDRV0|YP_PDRV1|YP_PU|YP_SL|ZN_CS|ZN_IE|ZN_PD|ZN_PDRV0|ZN_PDRV1|ZN_PU|ZN_SL|ZP_CS|ZP_IE|ZP_PD|ZP_PDRV0|ZP_PDRV1|ZP_PU|ZP_SL
+ VSS|XN_CS|XN_IE|XN_PD|XN_PDRV0|XN_PDRV1|XN_PU|XN_SL|XP_CS|XP_IE|XP_PD|XP_PDRV0|XP_PDRV1|XP_PU|XP_SL|YN_CS|YN_IE|YN_PD|YN_PDRV0|YN_PDRV1|YN_PU|YN_SL|YP_CS|YP_IE|YP_PD|YP_PDRV0|YP_PDRV1|YP_PU|YP_SL|ZN_CS|ZN_IE|ZN_PD|ZN_PDRV0|ZN_PDRV1|ZN_PU|ZN_SL|ZP_CS|ZP_IE|ZP_PD|ZP_PDRV0|ZP_PDRV1|ZP_PU|ZP_SL
+ nfet_06v0 L=1U W=1U AS=0.44P AD=0.44P PS=2.88U PD=2.88U
M$1384 \$9132 \$9064
+ VSS|XN_CS|XN_IE|XN_PD|XN_PDRV0|XN_PDRV1|XN_PU|XN_SL|XP_CS|XP_IE|XP_PD|XP_PDRV0|XP_PDRV1|XP_PU|XP_SL|YN_CS|YN_IE|YN_PD|YN_PDRV0|YN_PDRV1|YN_PU|YN_SL|YP_CS|YP_IE|YP_PD|YP_PDRV0|YP_PDRV1|YP_PU|YP_SL|ZN_CS|ZN_IE|ZN_PD|ZN_PDRV0|ZN_PDRV1|ZN_PU|ZN_SL|ZP_CS|ZP_IE|ZP_PD|ZP_PDRV0|ZP_PDRV1|ZP_PU|ZP_SL
+ VSS|XN_CS|XN_IE|XN_PD|XN_PDRV0|XN_PDRV1|XN_PU|XN_SL|XP_CS|XP_IE|XP_PD|XP_PDRV0|XP_PDRV1|XP_PU|XP_SL|YN_CS|YN_IE|YN_PD|YN_PDRV0|YN_PDRV1|YN_PU|YN_SL|YP_CS|YP_IE|YP_PD|YP_PDRV0|YP_PDRV1|YP_PU|YP_SL|ZN_CS|ZN_IE|ZN_PD|ZN_PDRV0|ZN_PDRV1|ZN_PU|ZN_SL|ZP_CS|ZP_IE|ZP_PD|ZP_PDRV0|ZP_PDRV1|ZP_PU|ZP_SL
+ nfet_06v0 L=1U W=5U AS=2.2P AD=1.25P PS=10.88U PD=5.5U
M$1385 \$9064 \$9081 \$9132
+ VSS|XN_CS|XN_IE|XN_PD|XN_PDRV0|XN_PDRV1|XN_PU|XN_SL|XP_CS|XP_IE|XP_PD|XP_PDRV0|XP_PDRV1|XP_PU|XP_SL|YN_CS|YN_IE|YN_PD|YN_PDRV0|YN_PDRV1|YN_PU|YN_SL|YP_CS|YP_IE|YP_PD|YP_PDRV0|YP_PDRV1|YP_PU|YP_SL|ZN_CS|ZN_IE|ZN_PD|ZN_PDRV0|ZN_PDRV1|ZN_PU|ZN_SL|ZP_CS|ZP_IE|ZP_PD|ZP_PDRV0|ZP_PDRV1|ZP_PU|ZP_SL
+ nfet_06v0 L=1U W=5U AS=1.25P AD=2.2P PS=5.5U PD=10.88U
M$1386 \$9112 \$9701
+ VSS|XN_CS|XN_IE|XN_PD|XN_PDRV0|XN_PDRV1|XN_PU|XN_SL|XP_CS|XP_IE|XP_PD|XP_PDRV0|XP_PDRV1|XP_PU|XP_SL|YN_CS|YN_IE|YN_PD|YN_PDRV0|YN_PDRV1|YN_PU|YN_SL|YP_CS|YP_IE|YP_PD|YP_PDRV0|YP_PDRV1|YP_PU|YP_SL|ZN_CS|ZN_IE|ZN_PD|ZN_PDRV0|ZN_PDRV1|ZN_PU|ZN_SL|ZP_CS|ZP_IE|ZP_PD|ZP_PDRV0|ZP_PDRV1|ZP_PU|ZP_SL
+ VSS|XN_CS|XN_IE|XN_PD|XN_PDRV0|XN_PDRV1|XN_PU|XN_SL|XP_CS|XP_IE|XP_PD|XP_PDRV0|XP_PDRV1|XP_PU|XP_SL|YN_CS|YN_IE|YN_PD|YN_PDRV0|YN_PDRV1|YN_PU|YN_SL|YP_CS|YP_IE|YP_PD|YP_PDRV0|YP_PDRV1|YP_PU|YP_SL|ZN_CS|ZN_IE|ZN_PD|ZN_PDRV0|ZN_PDRV1|ZN_PU|ZN_SL|ZP_CS|ZP_IE|ZP_PD|ZP_PDRV0|ZP_PDRV1|ZP_PU|ZP_SL
+ nfet_06v0 L=1U W=1U AS=0.44P AD=0.25P PS=2.88U PD=1.5U
M$1387 \$9622 \$9701 \$9112
+ VSS|XN_CS|XN_IE|XN_PD|XN_PDRV0|XN_PDRV1|XN_PU|XN_SL|XP_CS|XP_IE|XP_PD|XP_PDRV0|XP_PDRV1|XP_PU|XP_SL|YN_CS|YN_IE|YN_PD|YN_PDRV0|YN_PDRV1|YN_PU|YN_SL|YP_CS|YP_IE|YP_PD|YP_PDRV0|YP_PDRV1|YP_PU|YP_SL|ZN_CS|ZN_IE|ZN_PD|ZN_PDRV0|ZN_PDRV1|ZN_PU|ZN_SL|ZP_CS|ZP_IE|ZP_PD|ZP_PDRV0|ZP_PDRV1|ZP_PU|ZP_SL
+ nfet_06v0 L=1U W=1U AS=0.25P AD=0.44P PS=1.5U PD=2.88U
M$1388 \$9113 \$9701
+ VSS|XN_CS|XN_IE|XN_PD|XN_PDRV0|XN_PDRV1|XN_PU|XN_SL|XP_CS|XP_IE|XP_PD|XP_PDRV0|XP_PDRV1|XP_PU|XP_SL|YN_CS|YN_IE|YN_PD|YN_PDRV0|YN_PDRV1|YN_PU|YN_SL|YP_CS|YP_IE|YP_PD|YP_PDRV0|YP_PDRV1|YP_PU|YP_SL|ZN_CS|ZN_IE|ZN_PD|ZN_PDRV0|ZN_PDRV1|ZN_PU|ZN_SL|ZP_CS|ZP_IE|ZP_PD|ZP_PDRV0|ZP_PDRV1|ZP_PU|ZP_SL
+ VSS|XN_CS|XN_IE|XN_PD|XN_PDRV0|XN_PDRV1|XN_PU|XN_SL|XP_CS|XP_IE|XP_PD|XP_PDRV0|XP_PDRV1|XP_PU|XP_SL|YN_CS|YN_IE|YN_PD|YN_PDRV0|YN_PDRV1|YN_PU|YN_SL|YP_CS|YP_IE|YP_PD|YP_PDRV0|YP_PDRV1|YP_PU|YP_SL|ZN_CS|ZN_IE|ZN_PD|ZN_PDRV0|ZN_PDRV1|ZN_PU|ZN_SL|ZP_CS|ZP_IE|ZP_PD|ZP_PDRV0|ZP_PDRV1|ZP_PU|ZP_SL
+ nfet_06v0 L=1U W=1U AS=0.44P AD=0.25P PS=2.88U PD=1.5U
M$1389 \$9701 \$9701 \$9113
+ VSS|XN_CS|XN_IE|XN_PD|XN_PDRV0|XN_PDRV1|XN_PU|XN_SL|XP_CS|XP_IE|XP_PD|XP_PDRV0|XP_PDRV1|XP_PU|XP_SL|YN_CS|YN_IE|YN_PD|YN_PDRV0|YN_PDRV1|YN_PU|YN_SL|YP_CS|YP_IE|YP_PD|YP_PDRV0|YP_PDRV1|YP_PU|YP_SL|ZN_CS|ZN_IE|ZN_PD|ZN_PDRV0|ZN_PDRV1|ZN_PU|ZN_SL|ZP_CS|ZP_IE|ZP_PD|ZP_PDRV0|ZP_PDRV1|ZP_PU|ZP_SL
+ nfet_06v0 L=1U W=1U AS=0.25P AD=0.44P PS=1.5U PD=2.88U
M$1390 \$9133 \$9064
+ VSS|XN_CS|XN_IE|XN_PD|XN_PDRV0|XN_PDRV1|XN_PU|XN_SL|XP_CS|XP_IE|XP_PD|XP_PDRV0|XP_PDRV1|XP_PU|XP_SL|YN_CS|YN_IE|YN_PD|YN_PDRV0|YN_PDRV1|YN_PU|YN_SL|YP_CS|YP_IE|YP_PD|YP_PDRV0|YP_PDRV1|YP_PU|YP_SL|ZN_CS|ZN_IE|ZN_PD|ZN_PDRV0|ZN_PDRV1|ZN_PU|ZN_SL|ZP_CS|ZP_IE|ZP_PD|ZP_PDRV0|ZP_PDRV1|ZP_PU|ZP_SL
+ VSS|XN_CS|XN_IE|XN_PD|XN_PDRV0|XN_PDRV1|XN_PU|XN_SL|XP_CS|XP_IE|XP_PD|XP_PDRV0|XP_PDRV1|XP_PU|XP_SL|YN_CS|YN_IE|YN_PD|YN_PDRV0|YN_PDRV1|YN_PU|YN_SL|YP_CS|YP_IE|YP_PD|YP_PDRV0|YP_PDRV1|YP_PU|YP_SL|ZN_CS|ZN_IE|ZN_PD|ZN_PDRV0|ZN_PDRV1|ZN_PU|ZN_SL|ZP_CS|ZP_IE|ZP_PD|ZP_PDRV0|ZP_PDRV1|ZP_PU|ZP_SL
+ nfet_06v0 L=1U W=5U AS=2.2P AD=1.25P PS=10.88U PD=5.5U
M$1391 \$9082 \$9081 \$9133
+ VSS|XN_CS|XN_IE|XN_PD|XN_PDRV0|XN_PDRV1|XN_PU|XN_SL|XP_CS|XP_IE|XP_PD|XP_PDRV0|XP_PDRV1|XP_PU|XP_SL|YN_CS|YN_IE|YN_PD|YN_PDRV0|YN_PDRV1|YN_PU|YN_SL|YP_CS|YP_IE|YP_PD|YP_PDRV0|YP_PDRV1|YP_PU|YP_SL|ZN_CS|ZN_IE|ZN_PD|ZN_PDRV0|ZN_PDRV1|ZN_PU|ZN_SL|ZP_CS|ZP_IE|ZP_PD|ZP_PDRV0|ZP_PDRV1|ZP_PU|ZP_SL
+ nfet_06v0 L=1U W=5U AS=1.25P AD=1.65P PS=5.5U PD=5.66U
M$1392 \$9134 \$9081 \$9082
+ VSS|XN_CS|XN_IE|XN_PD|XN_PDRV0|XN_PDRV1|XN_PU|XN_SL|XP_CS|XP_IE|XP_PD|XP_PDRV0|XP_PDRV1|XP_PU|XP_SL|YN_CS|YN_IE|YN_PD|YN_PDRV0|YN_PDRV1|YN_PU|YN_SL|YP_CS|YP_IE|YP_PD|YP_PDRV0|YP_PDRV1|YP_PU|YP_SL|ZN_CS|ZN_IE|ZN_PD|ZN_PDRV0|ZN_PDRV1|ZN_PU|ZN_SL|ZP_CS|ZP_IE|ZP_PD|ZP_PDRV0|ZP_PDRV1|ZP_PU|ZP_SL
+ nfet_06v0 L=1U W=5U AS=1.65P AD=1.25P PS=5.66U PD=5.5U
M$1393
+ VSS|XN_CS|XN_IE|XN_PD|XN_PDRV0|XN_PDRV1|XN_PU|XN_SL|XP_CS|XP_IE|XP_PD|XP_PDRV0|XP_PDRV1|XP_PU|XP_SL|YN_CS|YN_IE|YN_PD|YN_PDRV0|YN_PDRV1|YN_PU|YN_SL|YP_CS|YP_IE|YP_PD|YP_PDRV0|YP_PDRV1|YP_PU|YP_SL|ZN_CS|ZN_IE|ZN_PD|ZN_PDRV0|ZN_PDRV1|ZN_PU|ZN_SL|ZP_CS|ZP_IE|ZP_PD|ZP_PDRV0|ZP_PDRV1|ZP_PU|ZP_SL
+ \$9064 \$9134
+ VSS|XN_CS|XN_IE|XN_PD|XN_PDRV0|XN_PDRV1|XN_PU|XN_SL|XP_CS|XP_IE|XP_PD|XP_PDRV0|XP_PDRV1|XP_PU|XP_SL|YN_CS|YN_IE|YN_PD|YN_PDRV0|YN_PDRV1|YN_PU|YN_SL|YP_CS|YP_IE|YP_PD|YP_PDRV0|YP_PDRV1|YP_PU|YP_SL|ZN_CS|ZN_IE|ZN_PD|ZN_PDRV0|ZN_PDRV1|ZN_PU|ZN_SL|ZP_CS|ZP_IE|ZP_PD|ZP_PDRV0|ZP_PDRV1|ZP_PU|ZP_SL
+ nfet_06v0 L=1U W=5U AS=1.25P AD=2.2P PS=5.5U PD=10.88U
M$1394 \$9083 \$54 \$9082
+ VSS|XN_CS|XN_IE|XN_PD|XN_PDRV0|XN_PDRV1|XN_PU|XN_SL|XP_CS|XP_IE|XP_PD|XP_PDRV0|XP_PDRV1|XP_PU|XP_SL|YN_CS|YN_IE|YN_PD|YN_PDRV0|YN_PDRV1|YN_PU|YN_SL|YP_CS|YP_IE|YP_PD|YP_PDRV0|YP_PDRV1|YP_PU|YP_SL|ZN_CS|ZN_IE|ZN_PD|ZN_PDRV0|ZN_PDRV1|ZN_PU|ZN_SL|ZP_CS|ZP_IE|ZP_PD|ZP_PDRV0|ZP_PDRV1|ZP_PU|ZP_SL
+ nfet_06v0 L=1U W=5U AS=2.2P AD=1.3P PS=10.88U PD=5.52U
M$1395 \$9082 \$54 \$9083
+ VSS|XN_CS|XN_IE|XN_PD|XN_PDRV0|XN_PDRV1|XN_PU|XN_SL|XP_CS|XP_IE|XP_PD|XP_PDRV0|XP_PDRV1|XP_PU|XP_SL|YN_CS|YN_IE|YN_PD|YN_PDRV0|YN_PDRV1|YN_PU|YN_SL|YP_CS|YP_IE|YP_PD|YP_PDRV0|YP_PDRV1|YP_PU|YP_SL|ZN_CS|ZN_IE|ZN_PD|ZN_PDRV0|ZN_PDRV1|ZN_PU|ZN_SL|ZP_CS|ZP_IE|ZP_PD|ZP_PDRV0|ZP_PDRV1|ZP_PU|ZP_SL
+ nfet_06v0 L=1U W=5U AS=1.3P AD=2.2P PS=5.52U PD=10.88U
M$1396 \$9084 \$2449 \$9082
+ VSS|XN_CS|XN_IE|XN_PD|XN_PDRV0|XN_PDRV1|XN_PU|XN_SL|XP_CS|XP_IE|XP_PD|XP_PDRV0|XP_PDRV1|XP_PU|XP_SL|YN_CS|YN_IE|YN_PD|YN_PDRV0|YN_PDRV1|YN_PU|YN_SL|YP_CS|YP_IE|YP_PD|YP_PDRV0|YP_PDRV1|YP_PU|YP_SL|ZN_CS|ZN_IE|ZN_PD|ZN_PDRV0|ZN_PDRV1|ZN_PU|ZN_SL|ZP_CS|ZP_IE|ZP_PD|ZP_PDRV0|ZP_PDRV1|ZP_PU|ZP_SL
+ nfet_06v0 L=1U W=5U AS=2.2P AD=1.3P PS=10.88U PD=5.52U
M$1397 \$9082 \$2449 \$9084
+ VSS|XN_CS|XN_IE|XN_PD|XN_PDRV0|XN_PDRV1|XN_PU|XN_SL|XP_CS|XP_IE|XP_PD|XP_PDRV0|XP_PDRV1|XP_PU|XP_SL|YN_CS|YN_IE|YN_PD|YN_PDRV0|YN_PDRV1|YN_PU|YN_SL|YP_CS|YP_IE|YP_PD|YP_PDRV0|YP_PDRV1|YP_PU|YP_SL|ZN_CS|ZN_IE|ZN_PD|ZN_PDRV0|ZN_PDRV1|ZN_PU|ZN_SL|ZP_CS|ZP_IE|ZP_PD|ZP_PDRV0|ZP_PDRV1|ZP_PU|ZP_SL
+ nfet_06v0 L=1U W=5U AS=1.3P AD=2.2P PS=5.52U PD=10.88U
M$1398 \$9086 \$9081 \$9085
+ VSS|XN_CS|XN_IE|XN_PD|XN_PDRV0|XN_PDRV1|XN_PU|XN_SL|XP_CS|XP_IE|XP_PD|XP_PDRV0|XP_PDRV1|XP_PU|XP_SL|YN_CS|YN_IE|YN_PD|YN_PDRV0|YN_PDRV1|YN_PU|YN_SL|YP_CS|YP_IE|YP_PD|YP_PDRV0|YP_PDRV1|YP_PU|YP_SL|ZN_CS|ZN_IE|ZN_PD|ZN_PDRV0|ZN_PDRV1|ZN_PU|ZN_SL|ZP_CS|ZP_IE|ZP_PD|ZP_PDRV0|ZP_PDRV1|ZP_PU|ZP_SL
+ nfet_06v0 L=1U W=2.5U AS=1.1P AD=0.65P PS=5.88U PD=3.02U
M$1399 \$9085 \$9081 \$9086
+ VSS|XN_CS|XN_IE|XN_PD|XN_PDRV0|XN_PDRV1|XN_PU|XN_SL|XP_CS|XP_IE|XP_PD|XP_PDRV0|XP_PDRV1|XP_PU|XP_SL|YN_CS|YN_IE|YN_PD|YN_PDRV0|YN_PDRV1|YN_PU|YN_SL|YP_CS|YP_IE|YP_PD|YP_PDRV0|YP_PDRV1|YP_PU|YP_SL|ZN_CS|ZN_IE|ZN_PD|ZN_PDRV0|ZN_PDRV1|ZN_PU|ZN_SL|ZP_CS|ZP_IE|ZP_PD|ZP_PDRV0|ZP_PDRV1|ZP_PU|ZP_SL
+ nfet_06v0 L=1U W=2.5U AS=0.65P AD=1.1P PS=3.02U PD=5.88U
M$1400 \$9088 \$9081 \$9087
+ VSS|XN_CS|XN_IE|XN_PD|XN_PDRV0|XN_PDRV1|XN_PU|XN_SL|XP_CS|XP_IE|XP_PD|XP_PDRV0|XP_PDRV1|XP_PU|XP_SL|YN_CS|YN_IE|YN_PD|YN_PDRV0|YN_PDRV1|YN_PU|YN_SL|YP_CS|YP_IE|YP_PD|YP_PDRV0|YP_PDRV1|YP_PU|YP_SL|ZN_CS|ZN_IE|ZN_PD|ZN_PDRV0|ZN_PDRV1|ZN_PU|ZN_SL|ZP_CS|ZP_IE|ZP_PD|ZP_PDRV0|ZP_PDRV1|ZP_PU|ZP_SL
+ nfet_06v0 L=1U W=2.5U AS=1.1P AD=0.65P PS=5.88U PD=3.02U
M$1401 \$9087 \$9081 \$9088
+ VSS|XN_CS|XN_IE|XN_PD|XN_PDRV0|XN_PDRV1|XN_PU|XN_SL|XP_CS|XP_IE|XP_PD|XP_PDRV0|XP_PDRV1|XP_PU|XP_SL|YN_CS|YN_IE|YN_PD|YN_PDRV0|YN_PDRV1|YN_PU|YN_SL|YP_CS|YP_IE|YP_PD|YP_PDRV0|YP_PDRV1|YP_PU|YP_SL|ZN_CS|ZN_IE|ZN_PD|ZN_PDRV0|ZN_PDRV1|ZN_PU|ZN_SL|ZP_CS|ZP_IE|ZP_PD|ZP_PDRV0|ZP_PDRV1|ZP_PU|ZP_SL
+ nfet_06v0 L=1U W=2.5U AS=0.65P AD=1.1P PS=3.02U PD=5.88U
M$1402 \$9085 \$9086
+ VSS|XN_CS|XN_IE|XN_PD|XN_PDRV0|XN_PDRV1|XN_PU|XN_SL|XP_CS|XP_IE|XP_PD|XP_PDRV0|XP_PDRV1|XP_PU|XP_SL|YN_CS|YN_IE|YN_PD|YN_PDRV0|YN_PDRV1|YN_PU|YN_SL|YP_CS|YP_IE|YP_PD|YP_PDRV0|YP_PDRV1|YP_PU|YP_SL|ZN_CS|ZN_IE|ZN_PD|ZN_PDRV0|ZN_PDRV1|ZN_PU|ZN_SL|ZP_CS|ZP_IE|ZP_PD|ZP_PDRV0|ZP_PDRV1|ZP_PU|ZP_SL
+ VSS|XN_CS|XN_IE|XN_PD|XN_PDRV0|XN_PDRV1|XN_PU|XN_SL|XP_CS|XP_IE|XP_PD|XP_PDRV0|XP_PDRV1|XP_PU|XP_SL|YN_CS|YN_IE|YN_PD|YN_PDRV0|YN_PDRV1|YN_PU|YN_SL|YP_CS|YP_IE|YP_PD|YP_PDRV0|YP_PDRV1|YP_PU|YP_SL|ZN_CS|ZN_IE|ZN_PD|ZN_PDRV0|ZN_PDRV1|ZN_PU|ZN_SL|ZP_CS|ZP_IE|ZP_PD|ZP_PDRV0|ZP_PDRV1|ZP_PU|ZP_SL
+ nfet_06v0 L=1U W=2.5U AS=1.1P AD=0.65P PS=5.88U PD=3.02U
M$1403
+ VSS|XN_CS|XN_IE|XN_PD|XN_PDRV0|XN_PDRV1|XN_PU|XN_SL|XP_CS|XP_IE|XP_PD|XP_PDRV0|XP_PDRV1|XP_PU|XP_SL|YN_CS|YN_IE|YN_PD|YN_PDRV0|YN_PDRV1|YN_PU|YN_SL|YP_CS|YP_IE|YP_PD|YP_PDRV0|YP_PDRV1|YP_PU|YP_SL|ZN_CS|ZN_IE|ZN_PD|ZN_PDRV0|ZN_PDRV1|ZN_PU|ZN_SL|ZP_CS|ZP_IE|ZP_PD|ZP_PDRV0|ZP_PDRV1|ZP_PU|ZP_SL
+ \$9086 \$9085
+ VSS|XN_CS|XN_IE|XN_PD|XN_PDRV0|XN_PDRV1|XN_PU|XN_SL|XP_CS|XP_IE|XP_PD|XP_PDRV0|XP_PDRV1|XP_PU|XP_SL|YN_CS|YN_IE|YN_PD|YN_PDRV0|YN_PDRV1|YN_PU|YN_SL|YP_CS|YP_IE|YP_PD|YP_PDRV0|YP_PDRV1|YP_PU|YP_SL|ZN_CS|ZN_IE|ZN_PD|ZN_PDRV0|ZN_PDRV1|ZN_PU|ZN_SL|ZP_CS|ZP_IE|ZP_PD|ZP_PDRV0|ZP_PDRV1|ZP_PU|ZP_SL
+ nfet_06v0 L=1U W=2.5U AS=0.65P AD=0.65P PS=3.02U PD=3.02U
M$1404 \$9085 \$9086
+ VSS|XN_CS|XN_IE|XN_PD|XN_PDRV0|XN_PDRV1|XN_PU|XN_SL|XP_CS|XP_IE|XP_PD|XP_PDRV0|XP_PDRV1|XP_PU|XP_SL|YN_CS|YN_IE|YN_PD|YN_PDRV0|YN_PDRV1|YN_PU|YN_SL|YP_CS|YP_IE|YP_PD|YP_PDRV0|YP_PDRV1|YP_PU|YP_SL|ZN_CS|ZN_IE|ZN_PD|ZN_PDRV0|ZN_PDRV1|ZN_PU|ZN_SL|ZP_CS|ZP_IE|ZP_PD|ZP_PDRV0|ZP_PDRV1|ZP_PU|ZP_SL
+ VSS|XN_CS|XN_IE|XN_PD|XN_PDRV0|XN_PDRV1|XN_PU|XN_SL|XP_CS|XP_IE|XP_PD|XP_PDRV0|XP_PDRV1|XP_PU|XP_SL|YN_CS|YN_IE|YN_PD|YN_PDRV0|YN_PDRV1|YN_PU|YN_SL|YP_CS|YP_IE|YP_PD|YP_PDRV0|YP_PDRV1|YP_PU|YP_SL|ZN_CS|ZN_IE|ZN_PD|ZN_PDRV0|ZN_PDRV1|ZN_PU|ZN_SL|ZP_CS|ZP_IE|ZP_PD|ZP_PDRV0|ZP_PDRV1|ZP_PU|ZP_SL
+ nfet_06v0 L=1U W=2.5U AS=0.65P AD=0.65P PS=3.02U PD=3.02U
M$1405
+ VSS|XN_CS|XN_IE|XN_PD|XN_PDRV0|XN_PDRV1|XN_PU|XN_SL|XP_CS|XP_IE|XP_PD|XP_PDRV0|XP_PDRV1|XP_PU|XP_SL|YN_CS|YN_IE|YN_PD|YN_PDRV0|YN_PDRV1|YN_PU|YN_SL|YP_CS|YP_IE|YP_PD|YP_PDRV0|YP_PDRV1|YP_PU|YP_SL|ZN_CS|ZN_IE|ZN_PD|ZN_PDRV0|ZN_PDRV1|ZN_PU|ZN_SL|ZP_CS|ZP_IE|ZP_PD|ZP_PDRV0|ZP_PDRV1|ZP_PU|ZP_SL
+ \$9086 \$9085
+ VSS|XN_CS|XN_IE|XN_PD|XN_PDRV0|XN_PDRV1|XN_PU|XN_SL|XP_CS|XP_IE|XP_PD|XP_PDRV0|XP_PDRV1|XP_PU|XP_SL|YN_CS|YN_IE|YN_PD|YN_PDRV0|YN_PDRV1|YN_PU|YN_SL|YP_CS|YP_IE|YP_PD|YP_PDRV0|YP_PDRV1|YP_PU|YP_SL|ZN_CS|ZN_IE|ZN_PD|ZN_PDRV0|ZN_PDRV1|ZN_PU|ZN_SL|ZP_CS|ZP_IE|ZP_PD|ZP_PDRV0|ZP_PDRV1|ZP_PU|ZP_SL
+ nfet_06v0 L=1U W=2.5U AS=0.65P AD=1.1P PS=3.02U PD=5.88U
M$1406 \$9087 \$9086
+ VSS|XN_CS|XN_IE|XN_PD|XN_PDRV0|XN_PDRV1|XN_PU|XN_SL|XP_CS|XP_IE|XP_PD|XP_PDRV0|XP_PDRV1|XP_PU|XP_SL|YN_CS|YN_IE|YN_PD|YN_PDRV0|YN_PDRV1|YN_PU|YN_SL|YP_CS|YP_IE|YP_PD|YP_PDRV0|YP_PDRV1|YP_PU|YP_SL|ZN_CS|ZN_IE|ZN_PD|ZN_PDRV0|ZN_PDRV1|ZN_PU|ZN_SL|ZP_CS|ZP_IE|ZP_PD|ZP_PDRV0|ZP_PDRV1|ZP_PU|ZP_SL
+ VSS|XN_CS|XN_IE|XN_PD|XN_PDRV0|XN_PDRV1|XN_PU|XN_SL|XP_CS|XP_IE|XP_PD|XP_PDRV0|XP_PDRV1|XP_PU|XP_SL|YN_CS|YN_IE|YN_PD|YN_PDRV0|YN_PDRV1|YN_PU|YN_SL|YP_CS|YP_IE|YP_PD|YP_PDRV0|YP_PDRV1|YP_PU|YP_SL|ZN_CS|ZN_IE|ZN_PD|ZN_PDRV0|ZN_PDRV1|ZN_PU|ZN_SL|ZP_CS|ZP_IE|ZP_PD|ZP_PDRV0|ZP_PDRV1|ZP_PU|ZP_SL
+ nfet_06v0 L=1U W=2.5U AS=1.1P AD=0.65P PS=5.88U PD=3.02U
M$1407
+ VSS|XN_CS|XN_IE|XN_PD|XN_PDRV0|XN_PDRV1|XN_PU|XN_SL|XP_CS|XP_IE|XP_PD|XP_PDRV0|XP_PDRV1|XP_PU|XP_SL|YN_CS|YN_IE|YN_PD|YN_PDRV0|YN_PDRV1|YN_PU|YN_SL|YP_CS|YP_IE|YP_PD|YP_PDRV0|YP_PDRV1|YP_PU|YP_SL|ZN_CS|ZN_IE|ZN_PD|ZN_PDRV0|ZN_PDRV1|ZN_PU|ZN_SL|ZP_CS|ZP_IE|ZP_PD|ZP_PDRV0|ZP_PDRV1|ZP_PU|ZP_SL
+ \$9086 \$9087
+ VSS|XN_CS|XN_IE|XN_PD|XN_PDRV0|XN_PDRV1|XN_PU|XN_SL|XP_CS|XP_IE|XP_PD|XP_PDRV0|XP_PDRV1|XP_PU|XP_SL|YN_CS|YN_IE|YN_PD|YN_PDRV0|YN_PDRV1|YN_PU|YN_SL|YP_CS|YP_IE|YP_PD|YP_PDRV0|YP_PDRV1|YP_PU|YP_SL|ZN_CS|ZN_IE|ZN_PD|ZN_PDRV0|ZN_PDRV1|ZN_PU|ZN_SL|ZP_CS|ZP_IE|ZP_PD|ZP_PDRV0|ZP_PDRV1|ZP_PU|ZP_SL
+ nfet_06v0 L=1U W=2.5U AS=0.65P AD=0.65P PS=3.02U PD=3.02U
M$1408 \$9087 \$9086
+ VSS|XN_CS|XN_IE|XN_PD|XN_PDRV0|XN_PDRV1|XN_PU|XN_SL|XP_CS|XP_IE|XP_PD|XP_PDRV0|XP_PDRV1|XP_PU|XP_SL|YN_CS|YN_IE|YN_PD|YN_PDRV0|YN_PDRV1|YN_PU|YN_SL|YP_CS|YP_IE|YP_PD|YP_PDRV0|YP_PDRV1|YP_PU|YP_SL|ZN_CS|ZN_IE|ZN_PD|ZN_PDRV0|ZN_PDRV1|ZN_PU|ZN_SL|ZP_CS|ZP_IE|ZP_PD|ZP_PDRV0|ZP_PDRV1|ZP_PU|ZP_SL
+ VSS|XN_CS|XN_IE|XN_PD|XN_PDRV0|XN_PDRV1|XN_PU|XN_SL|XP_CS|XP_IE|XP_PD|XP_PDRV0|XP_PDRV1|XP_PU|XP_SL|YN_CS|YN_IE|YN_PD|YN_PDRV0|YN_PDRV1|YN_PU|YN_SL|YP_CS|YP_IE|YP_PD|YP_PDRV0|YP_PDRV1|YP_PU|YP_SL|ZN_CS|ZN_IE|ZN_PD|ZN_PDRV0|ZN_PDRV1|ZN_PU|ZN_SL|ZP_CS|ZP_IE|ZP_PD|ZP_PDRV0|ZP_PDRV1|ZP_PU|ZP_SL
+ nfet_06v0 L=1U W=2.5U AS=0.65P AD=0.65P PS=3.02U PD=3.02U
M$1409
+ VSS|XN_CS|XN_IE|XN_PD|XN_PDRV0|XN_PDRV1|XN_PU|XN_SL|XP_CS|XP_IE|XP_PD|XP_PDRV0|XP_PDRV1|XP_PU|XP_SL|YN_CS|YN_IE|YN_PD|YN_PDRV0|YN_PDRV1|YN_PU|YN_SL|YP_CS|YP_IE|YP_PD|YP_PDRV0|YP_PDRV1|YP_PU|YP_SL|ZN_CS|ZN_IE|ZN_PD|ZN_PDRV0|ZN_PDRV1|ZN_PU|ZN_SL|ZP_CS|ZP_IE|ZP_PD|ZP_PDRV0|ZP_PDRV1|ZP_PU|ZP_SL
+ \$9086 \$9087
+ VSS|XN_CS|XN_IE|XN_PD|XN_PDRV0|XN_PDRV1|XN_PU|XN_SL|XP_CS|XP_IE|XP_PD|XP_PDRV0|XP_PDRV1|XP_PU|XP_SL|YN_CS|YN_IE|YN_PD|YN_PDRV0|YN_PDRV1|YN_PU|YN_SL|YP_CS|YP_IE|YP_PD|YP_PDRV0|YP_PDRV1|YP_PU|YP_SL|ZN_CS|ZN_IE|ZN_PD|ZN_PDRV0|ZN_PDRV1|ZN_PU|ZN_SL|ZP_CS|ZP_IE|ZP_PD|ZP_PDRV0|ZP_PDRV1|ZP_PU|ZP_SL
+ nfet_06v0 L=1U W=2.5U AS=0.65P AD=1.1P PS=3.02U PD=5.88U
M$1410 \$9165 \$9119 \$9086
+ VSS|XN_CS|XN_IE|XN_PD|XN_PDRV0|XN_PDRV1|XN_PU|XN_SL|XP_CS|XP_IE|XP_PD|XP_PDRV0|XP_PDRV1|XP_PU|XP_SL|YN_CS|YN_IE|YN_PD|YN_PDRV0|YN_PDRV1|YN_PU|YN_SL|YP_CS|YP_IE|YP_PD|YP_PDRV0|YP_PDRV1|YP_PU|YP_SL|ZN_CS|ZN_IE|ZN_PD|ZN_PDRV0|ZN_PDRV1|ZN_PU|ZN_SL|ZP_CS|ZP_IE|ZP_PD|ZP_PDRV0|ZP_PDRV1|ZP_PU|ZP_SL
+ nfet_06v0 L=1U W=2.5U AS=1.1P AD=1.1P PS=5.88U PD=5.88U
M$1411 \$9065 \$9119 \$9088
+ VSS|XN_CS|XN_IE|XN_PD|XN_PDRV0|XN_PDRV1|XN_PU|XN_SL|XP_CS|XP_IE|XP_PD|XP_PDRV0|XP_PDRV1|XP_PU|XP_SL|YN_CS|YN_IE|YN_PD|YN_PDRV0|YN_PDRV1|YN_PU|YN_SL|YP_CS|YP_IE|YP_PD|YP_PDRV0|YP_PDRV1|YP_PU|YP_SL|ZN_CS|ZN_IE|ZN_PD|ZN_PDRV0|ZN_PDRV1|ZN_PU|ZN_SL|ZP_CS|ZP_IE|ZP_PD|ZP_PDRV0|ZP_PDRV1|ZP_PU|ZP_SL
+ nfet_06v0 L=1U W=2.5U AS=1.1P AD=1.1P PS=5.88U PD=5.88U
M$1412 \$9135 \$9064
+ VSS|XN_CS|XN_IE|XN_PD|XN_PDRV0|XN_PDRV1|XN_PU|XN_SL|XP_CS|XP_IE|XP_PD|XP_PDRV0|XP_PDRV1|XP_PU|XP_SL|YN_CS|YN_IE|YN_PD|YN_PDRV0|YN_PDRV1|YN_PU|YN_SL|YP_CS|YP_IE|YP_PD|YP_PDRV0|YP_PDRV1|YP_PU|YP_SL|ZN_CS|ZN_IE|ZN_PD|ZN_PDRV0|ZN_PDRV1|ZN_PU|ZN_SL|ZP_CS|ZP_IE|ZP_PD|ZP_PDRV0|ZP_PDRV1|ZP_PU|ZP_SL
+ VSS|XN_CS|XN_IE|XN_PD|XN_PDRV0|XN_PDRV1|XN_PU|XN_SL|XP_CS|XP_IE|XP_PD|XP_PDRV0|XP_PDRV1|XP_PU|XP_SL|YN_CS|YN_IE|YN_PD|YN_PDRV0|YN_PDRV1|YN_PU|YN_SL|YP_CS|YP_IE|YP_PD|YP_PDRV0|YP_PDRV1|YP_PU|YP_SL|ZN_CS|ZN_IE|ZN_PD|ZN_PDRV0|ZN_PDRV1|ZN_PU|ZN_SL|ZP_CS|ZP_IE|ZP_PD|ZP_PDRV0|ZP_PDRV1|ZP_PU|ZP_SL
+ nfet_06v0 L=1U W=5U AS=2.2P AD=1.25P PS=10.88U PD=5.5U
M$1413 \$9066 \$9081 \$9135
+ VSS|XN_CS|XN_IE|XN_PD|XN_PDRV0|XN_PDRV1|XN_PU|XN_SL|XP_CS|XP_IE|XP_PD|XP_PDRV0|XP_PDRV1|XP_PU|XP_SL|YN_CS|YN_IE|YN_PD|YN_PDRV0|YN_PDRV1|YN_PU|YN_SL|YP_CS|YP_IE|YP_PD|YP_PDRV0|YP_PDRV1|YP_PU|YP_SL|ZN_CS|ZN_IE|ZN_PD|ZN_PDRV0|ZN_PDRV1|ZN_PU|ZN_SL|ZP_CS|ZP_IE|ZP_PD|ZP_PDRV0|ZP_PDRV1|ZP_PU|ZP_SL
+ nfet_06v0 L=1U W=5U AS=1.25P AD=2.2P PS=5.5U PD=10.88U
M$1414 \$9136 \$9067
+ VSS|XN_CS|XN_IE|XN_PD|XN_PDRV0|XN_PDRV1|XN_PU|XN_SL|XP_CS|XP_IE|XP_PD|XP_PDRV0|XP_PDRV1|XP_PU|XP_SL|YN_CS|YN_IE|YN_PD|YN_PDRV0|YN_PDRV1|YN_PU|YN_SL|YP_CS|YP_IE|YP_PD|YP_PDRV0|YP_PDRV1|YP_PU|YP_SL|ZN_CS|ZN_IE|ZN_PD|ZN_PDRV0|ZN_PDRV1|ZN_PU|ZN_SL|ZP_CS|ZP_IE|ZP_PD|ZP_PDRV0|ZP_PDRV1|ZP_PU|ZP_SL
+ VSS|XN_CS|XN_IE|XN_PD|XN_PDRV0|XN_PDRV1|XN_PU|XN_SL|XP_CS|XP_IE|XP_PD|XP_PDRV0|XP_PDRV1|XP_PU|XP_SL|YN_CS|YN_IE|YN_PD|YN_PDRV0|YN_PDRV1|YN_PU|YN_SL|YP_CS|YP_IE|YP_PD|YP_PDRV0|YP_PDRV1|YP_PU|YP_SL|ZN_CS|ZN_IE|ZN_PD|ZN_PDRV0|ZN_PDRV1|ZN_PU|ZN_SL|ZP_CS|ZP_IE|ZP_PD|ZP_PDRV0|ZP_PDRV1|ZP_PU|ZP_SL
+ nfet_06v0 L=1U W=5U AS=2.2P AD=1.25P PS=10.88U PD=5.5U
M$1415 \$9067 \$9081 \$9136
+ VSS|XN_CS|XN_IE|XN_PD|XN_PDRV0|XN_PDRV1|XN_PU|XN_SL|XP_CS|XP_IE|XP_PD|XP_PDRV0|XP_PDRV1|XP_PU|XP_SL|YN_CS|YN_IE|YN_PD|YN_PDRV0|YN_PDRV1|YN_PU|YN_SL|YP_CS|YP_IE|YP_PD|YP_PDRV0|YP_PDRV1|YP_PU|YP_SL|ZN_CS|ZN_IE|ZN_PD|ZN_PDRV0|ZN_PDRV1|ZN_PU|ZN_SL|ZP_CS|ZP_IE|ZP_PD|ZP_PDRV0|ZP_PDRV1|ZP_PU|ZP_SL
+ nfet_06v0 L=1U W=5U AS=1.25P AD=1.65P PS=5.5U PD=5.66U
M$1416 \$9119 \$9119 \$9067
+ VSS|XN_CS|XN_IE|XN_PD|XN_PDRV0|XN_PDRV1|XN_PU|XN_SL|XP_CS|XP_IE|XP_PD|XP_PDRV0|XP_PDRV1|XP_PU|XP_SL|YN_CS|YN_IE|YN_PD|YN_PDRV0|YN_PDRV1|YN_PU|YN_SL|YP_CS|YP_IE|YP_PD|YP_PDRV0|YP_PDRV1|YP_PU|YP_SL|ZN_CS|ZN_IE|ZN_PD|ZN_PDRV0|ZN_PDRV1|ZN_PU|ZN_SL|ZP_CS|ZP_IE|ZP_PD|ZP_PDRV0|ZP_PDRV1|ZP_PU|ZP_SL
+ nfet_06v0 L=1U W=5U AS=1.65P AD=2.2P PS=5.66U PD=10.88U
M$1417 \$9089 \$9088
+ VSS|XN_CS|XN_IE|XN_PD|XN_PDRV0|XN_PDRV1|XN_PU|XN_SL|XP_CS|XP_IE|XP_PD|XP_PDRV0|XP_PDRV1|XP_PU|XP_SL|YN_CS|YN_IE|YN_PD|YN_PDRV0|YN_PDRV1|YN_PU|YN_SL|YP_CS|YP_IE|YP_PD|YP_PDRV0|YP_PDRV1|YP_PU|YP_SL|ZN_CS|ZN_IE|ZN_PD|ZN_PDRV0|ZN_PDRV1|ZN_PU|ZN_SL|ZP_CS|ZP_IE|ZP_PD|ZP_PDRV0|ZP_PDRV1|ZP_PU|ZP_SL
+ VSS|XN_CS|XN_IE|XN_PD|XN_PDRV0|XN_PDRV1|XN_PU|XN_SL|XP_CS|XP_IE|XP_PD|XP_PDRV0|XP_PDRV1|XP_PU|XP_SL|YN_CS|YN_IE|YN_PD|YN_PDRV0|YN_PDRV1|YN_PU|YN_SL|YP_CS|YP_IE|YP_PD|YP_PDRV0|YP_PDRV1|YP_PU|YP_SL|ZN_CS|ZN_IE|ZN_PD|ZN_PDRV0|ZN_PDRV1|ZN_PU|ZN_SL|ZP_CS|ZP_IE|ZP_PD|ZP_PDRV0|ZP_PDRV1|ZP_PU|ZP_SL
+ nfet_06v0 L=1U W=5U AS=2.2P AD=1.3P PS=10.88U PD=5.52U
M$1418
+ VSS|XN_CS|XN_IE|XN_PD|XN_PDRV0|XN_PDRV1|XN_PU|XN_SL|XP_CS|XP_IE|XP_PD|XP_PDRV0|XP_PDRV1|XP_PU|XP_SL|YN_CS|YN_IE|YN_PD|YN_PDRV0|YN_PDRV1|YN_PU|YN_SL|YP_CS|YP_IE|YP_PD|YP_PDRV0|YP_PDRV1|YP_PU|YP_SL|ZN_CS|ZN_IE|ZN_PD|ZN_PDRV0|ZN_PDRV1|ZN_PU|ZN_SL|ZP_CS|ZP_IE|ZP_PD|ZP_PDRV0|ZP_PDRV1|ZP_PU|ZP_SL
+ \$9088 \$9089
+ VSS|XN_CS|XN_IE|XN_PD|XN_PDRV0|XN_PDRV1|XN_PU|XN_SL|XP_CS|XP_IE|XP_PD|XP_PDRV0|XP_PDRV1|XP_PU|XP_SL|YN_CS|YN_IE|YN_PD|YN_PDRV0|YN_PDRV1|YN_PU|YN_SL|YP_CS|YP_IE|YP_PD|YP_PDRV0|YP_PDRV1|YP_PU|YP_SL|ZN_CS|ZN_IE|ZN_PD|ZN_PDRV0|ZN_PDRV1|ZN_PU|ZN_SL|ZP_CS|ZP_IE|ZP_PD|ZP_PDRV0|ZP_PDRV1|ZP_PU|ZP_SL
+ nfet_06v0 L=1U W=5U AS=1.3P AD=1.3P PS=5.52U PD=5.52U
M$1419 \$9089 \$9088
+ VSS|XN_CS|XN_IE|XN_PD|XN_PDRV0|XN_PDRV1|XN_PU|XN_SL|XP_CS|XP_IE|XP_PD|XP_PDRV0|XP_PDRV1|XP_PU|XP_SL|YN_CS|YN_IE|YN_PD|YN_PDRV0|YN_PDRV1|YN_PU|YN_SL|YP_CS|YP_IE|YP_PD|YP_PDRV0|YP_PDRV1|YP_PU|YP_SL|ZN_CS|ZN_IE|ZN_PD|ZN_PDRV0|ZN_PDRV1|ZN_PU|ZN_SL|ZP_CS|ZP_IE|ZP_PD|ZP_PDRV0|ZP_PDRV1|ZP_PU|ZP_SL
+ VSS|XN_CS|XN_IE|XN_PD|XN_PDRV0|XN_PDRV1|XN_PU|XN_SL|XP_CS|XP_IE|XP_PD|XP_PDRV0|XP_PDRV1|XP_PU|XP_SL|YN_CS|YN_IE|YN_PD|YN_PDRV0|YN_PDRV1|YN_PU|YN_SL|YP_CS|YP_IE|YP_PD|YP_PDRV0|YP_PDRV1|YP_PU|YP_SL|ZN_CS|ZN_IE|ZN_PD|ZN_PDRV0|ZN_PDRV1|ZN_PU|ZN_SL|ZP_CS|ZP_IE|ZP_PD|ZP_PDRV0|ZP_PDRV1|ZP_PU|ZP_SL
+ nfet_06v0 L=1U W=5U AS=1.3P AD=2.2P PS=5.52U PD=10.88U
M$1420
+ VSS|XN_CS|XN_IE|XN_PD|XN_PDRV0|XN_PDRV1|XN_PU|XN_SL|XP_CS|XP_IE|XP_PD|XP_PDRV0|XP_PDRV1|XP_PU|XP_SL|YN_CS|YN_IE|YN_PD|YN_PDRV0|YN_PDRV1|YN_PU|YN_SL|YP_CS|YP_IE|YP_PD|YP_PDRV0|YP_PDRV1|YP_PU|YP_SL|ZN_CS|ZN_IE|ZN_PD|ZN_PDRV0|ZN_PDRV1|ZN_PU|ZN_SL|ZP_CS|ZP_IE|ZP_PD|ZP_PDRV0|ZP_PDRV1|ZP_PU|ZP_SL
+ VDD|XN_OE|XP_OE|YN_OE|YP_OE|ZN_OE|ZP_OE
+ VSS|XN_CS|XN_IE|XN_PD|XN_PDRV0|XN_PDRV1|XN_PU|XN_SL|XP_CS|XP_IE|XP_PD|XP_PDRV0|XP_PDRV1|XP_PU|XP_SL|YN_CS|YN_IE|YN_PD|YN_PDRV0|YN_PDRV1|YN_PU|YN_SL|YP_CS|YP_IE|YP_PD|YP_PDRV0|YP_PDRV1|YP_PU|YP_SL|ZN_CS|ZN_IE|ZN_PD|ZN_PDRV0|ZN_PDRV1|ZN_PU|ZN_SL|ZP_CS|ZP_IE|ZP_PD|ZP_PDRV0|ZP_PDRV1|ZP_PU|ZP_SL
+ VSS|XN_CS|XN_IE|XN_PD|XN_PDRV0|XN_PDRV1|XN_PU|XN_SL|XP_CS|XP_IE|XP_PD|XP_PDRV0|XP_PDRV1|XP_PU|XP_SL|YN_CS|YN_IE|YN_PD|YN_PDRV0|YN_PDRV1|YN_PU|YN_SL|YP_CS|YP_IE|YP_PD|YP_PDRV0|YP_PDRV1|YP_PU|YP_SL|ZN_CS|ZN_IE|ZN_PD|ZN_PDRV0|ZN_PDRV1|ZN_PU|ZN_SL|ZP_CS|ZP_IE|ZP_PD|ZP_PDRV0|ZP_PDRV1|ZP_PU|ZP_SL
+ nfet_06v0 L=2U W=9.75U AS=4.29P AD=4.29P PS=20.38U PD=20.38U
M$1421
+ VSS|XN_CS|XN_IE|XN_PD|XN_PDRV0|XN_PDRV1|XN_PU|XN_SL|XP_CS|XP_IE|XP_PD|XP_PDRV0|XP_PDRV1|XP_PU|XP_SL|YN_CS|YN_IE|YN_PD|YN_PDRV0|YN_PDRV1|YN_PU|YN_SL|YP_CS|YP_IE|YP_PD|YP_PDRV0|YP_PDRV1|YP_PU|YP_SL|ZN_CS|ZN_IE|ZN_PD|ZN_PDRV0|ZN_PDRV1|ZN_PU|ZN_SL|ZP_CS|ZP_IE|ZP_PD|ZP_PDRV0|ZP_PDRV1|ZP_PU|ZP_SL
+ VDD|XN_OE|XP_OE|YN_OE|YP_OE|ZN_OE|ZP_OE
+ VSS|XN_CS|XN_IE|XN_PD|XN_PDRV0|XN_PDRV1|XN_PU|XN_SL|XP_CS|XP_IE|XP_PD|XP_PDRV0|XP_PDRV1|XP_PU|XP_SL|YN_CS|YN_IE|YN_PD|YN_PDRV0|YN_PDRV1|YN_PU|YN_SL|YP_CS|YP_IE|YP_PD|YP_PDRV0|YP_PDRV1|YP_PU|YP_SL|ZN_CS|ZN_IE|ZN_PD|ZN_PDRV0|ZN_PDRV1|ZN_PU|ZN_SL|ZP_CS|ZP_IE|ZP_PD|ZP_PDRV0|ZP_PDRV1|ZP_PU|ZP_SL
+ VSS|XN_CS|XN_IE|XN_PD|XN_PDRV0|XN_PDRV1|XN_PU|XN_SL|XP_CS|XP_IE|XP_PD|XP_PDRV0|XP_PDRV1|XP_PU|XP_SL|YN_CS|YN_IE|YN_PD|YN_PDRV0|YN_PDRV1|YN_PU|YN_SL|YP_CS|YP_IE|YP_PD|YP_PDRV0|YP_PDRV1|YP_PU|YP_SL|ZN_CS|ZN_IE|ZN_PD|ZN_PDRV0|ZN_PDRV1|ZN_PU|ZN_SL|ZP_CS|ZP_IE|ZP_PD|ZP_PDRV0|ZP_PDRV1|ZP_PU|ZP_SL
+ nfet_06v0 L=2U W=9.75U AS=4.29P AD=4.29P PS=20.38U PD=20.38U
M$1422 \$9090 \$9090
+ VSS|XN_CS|XN_IE|XN_PD|XN_PDRV0|XN_PDRV1|XN_PU|XN_SL|XP_CS|XP_IE|XP_PD|XP_PDRV0|XP_PDRV1|XP_PU|XP_SL|YN_CS|YN_IE|YN_PD|YN_PDRV0|YN_PDRV1|YN_PU|YN_SL|YP_CS|YP_IE|YP_PD|YP_PDRV0|YP_PDRV1|YP_PU|YP_SL|ZN_CS|ZN_IE|ZN_PD|ZN_PDRV0|ZN_PDRV1|ZN_PU|ZN_SL|ZP_CS|ZP_IE|ZP_PD|ZP_PDRV0|ZP_PDRV1|ZP_PU|ZP_SL
+ VSS|XN_CS|XN_IE|XN_PD|XN_PDRV0|XN_PDRV1|XN_PU|XN_SL|XP_CS|XP_IE|XP_PD|XP_PDRV0|XP_PDRV1|XP_PU|XP_SL|YN_CS|YN_IE|YN_PD|YN_PDRV0|YN_PDRV1|YN_PU|YN_SL|YP_CS|YP_IE|YP_PD|YP_PDRV0|YP_PDRV1|YP_PU|YP_SL|ZN_CS|ZN_IE|ZN_PD|ZN_PDRV0|ZN_PDRV1|ZN_PU|ZN_SL|ZP_CS|ZP_IE|ZP_PD|ZP_PDRV0|ZP_PDRV1|ZP_PU|ZP_SL
+ nfet_06v0 L=1U W=1U AS=0.44P AD=0.44P PS=2.88U PD=2.88U
M$1423 \$9137 \$9068
+ VSS|XN_CS|XN_IE|XN_PD|XN_PDRV0|XN_PDRV1|XN_PU|XN_SL|XP_CS|XP_IE|XP_PD|XP_PDRV0|XP_PDRV1|XP_PU|XP_SL|YN_CS|YN_IE|YN_PD|YN_PDRV0|YN_PDRV1|YN_PU|YN_SL|YP_CS|YP_IE|YP_PD|YP_PDRV0|YP_PDRV1|YP_PU|YP_SL|ZN_CS|ZN_IE|ZN_PD|ZN_PDRV0|ZN_PDRV1|ZN_PU|ZN_SL|ZP_CS|ZP_IE|ZP_PD|ZP_PDRV0|ZP_PDRV1|ZP_PU|ZP_SL
+ VSS|XN_CS|XN_IE|XN_PD|XN_PDRV0|XN_PDRV1|XN_PU|XN_SL|XP_CS|XP_IE|XP_PD|XP_PDRV0|XP_PDRV1|XP_PU|XP_SL|YN_CS|YN_IE|YN_PD|YN_PDRV0|YN_PDRV1|YN_PU|YN_SL|YP_CS|YP_IE|YP_PD|YP_PDRV0|YP_PDRV1|YP_PU|YP_SL|ZN_CS|ZN_IE|ZN_PD|ZN_PDRV0|ZN_PDRV1|ZN_PU|ZN_SL|ZP_CS|ZP_IE|ZP_PD|ZP_PDRV0|ZP_PDRV1|ZP_PU|ZP_SL
+ nfet_06v0 L=1U W=5U AS=2.2P AD=1.25P PS=10.88U PD=5.5U
M$1424 \$9068 \$9090 \$9137
+ VSS|XN_CS|XN_IE|XN_PD|XN_PDRV0|XN_PDRV1|XN_PU|XN_SL|XP_CS|XP_IE|XP_PD|XP_PDRV0|XP_PDRV1|XP_PU|XP_SL|YN_CS|YN_IE|YN_PD|YN_PDRV0|YN_PDRV1|YN_PU|YN_SL|YP_CS|YP_IE|YP_PD|YP_PDRV0|YP_PDRV1|YP_PU|YP_SL|ZN_CS|ZN_IE|ZN_PD|ZN_PDRV0|ZN_PDRV1|ZN_PU|ZN_SL|ZP_CS|ZP_IE|ZP_PD|ZP_PDRV0|ZP_PDRV1|ZP_PU|ZP_SL
+ nfet_06v0 L=1U W=5U AS=1.25P AD=2.2P PS=5.5U PD=10.88U
M$1425 \$9115 \$9703
+ VSS|XN_CS|XN_IE|XN_PD|XN_PDRV0|XN_PDRV1|XN_PU|XN_SL|XP_CS|XP_IE|XP_PD|XP_PDRV0|XP_PDRV1|XP_PU|XP_SL|YN_CS|YN_IE|YN_PD|YN_PDRV0|YN_PDRV1|YN_PU|YN_SL|YP_CS|YP_IE|YP_PD|YP_PDRV0|YP_PDRV1|YP_PU|YP_SL|ZN_CS|ZN_IE|ZN_PD|ZN_PDRV0|ZN_PDRV1|ZN_PU|ZN_SL|ZP_CS|ZP_IE|ZP_PD|ZP_PDRV0|ZP_PDRV1|ZP_PU|ZP_SL
+ VSS|XN_CS|XN_IE|XN_PD|XN_PDRV0|XN_PDRV1|XN_PU|XN_SL|XP_CS|XP_IE|XP_PD|XP_PDRV0|XP_PDRV1|XP_PU|XP_SL|YN_CS|YN_IE|YN_PD|YN_PDRV0|YN_PDRV1|YN_PU|YN_SL|YP_CS|YP_IE|YP_PD|YP_PDRV0|YP_PDRV1|YP_PU|YP_SL|ZN_CS|ZN_IE|ZN_PD|ZN_PDRV0|ZN_PDRV1|ZN_PU|ZN_SL|ZP_CS|ZP_IE|ZP_PD|ZP_PDRV0|ZP_PDRV1|ZP_PU|ZP_SL
+ nfet_06v0 L=1U W=1U AS=0.44P AD=0.25P PS=2.88U PD=1.5U
M$1426 \$9623 \$9703 \$9115
+ VSS|XN_CS|XN_IE|XN_PD|XN_PDRV0|XN_PDRV1|XN_PU|XN_SL|XP_CS|XP_IE|XP_PD|XP_PDRV0|XP_PDRV1|XP_PU|XP_SL|YN_CS|YN_IE|YN_PD|YN_PDRV0|YN_PDRV1|YN_PU|YN_SL|YP_CS|YP_IE|YP_PD|YP_PDRV0|YP_PDRV1|YP_PU|YP_SL|ZN_CS|ZN_IE|ZN_PD|ZN_PDRV0|ZN_PDRV1|ZN_PU|ZN_SL|ZP_CS|ZP_IE|ZP_PD|ZP_PDRV0|ZP_PDRV1|ZP_PU|ZP_SL
+ nfet_06v0 L=1U W=1U AS=0.25P AD=0.44P PS=1.5U PD=2.88U
M$1427 \$9116 \$9703
+ VSS|XN_CS|XN_IE|XN_PD|XN_PDRV0|XN_PDRV1|XN_PU|XN_SL|XP_CS|XP_IE|XP_PD|XP_PDRV0|XP_PDRV1|XP_PU|XP_SL|YN_CS|YN_IE|YN_PD|YN_PDRV0|YN_PDRV1|YN_PU|YN_SL|YP_CS|YP_IE|YP_PD|YP_PDRV0|YP_PDRV1|YP_PU|YP_SL|ZN_CS|ZN_IE|ZN_PD|ZN_PDRV0|ZN_PDRV1|ZN_PU|ZN_SL|ZP_CS|ZP_IE|ZP_PD|ZP_PDRV0|ZP_PDRV1|ZP_PU|ZP_SL
+ VSS|XN_CS|XN_IE|XN_PD|XN_PDRV0|XN_PDRV1|XN_PU|XN_SL|XP_CS|XP_IE|XP_PD|XP_PDRV0|XP_PDRV1|XP_PU|XP_SL|YN_CS|YN_IE|YN_PD|YN_PDRV0|YN_PDRV1|YN_PU|YN_SL|YP_CS|YP_IE|YP_PD|YP_PDRV0|YP_PDRV1|YP_PU|YP_SL|ZN_CS|ZN_IE|ZN_PD|ZN_PDRV0|ZN_PDRV1|ZN_PU|ZN_SL|ZP_CS|ZP_IE|ZP_PD|ZP_PDRV0|ZP_PDRV1|ZP_PU|ZP_SL
+ nfet_06v0 L=1U W=1U AS=0.44P AD=0.25P PS=2.88U PD=1.5U
M$1428 \$9703 \$9703 \$9116
+ VSS|XN_CS|XN_IE|XN_PD|XN_PDRV0|XN_PDRV1|XN_PU|XN_SL|XP_CS|XP_IE|XP_PD|XP_PDRV0|XP_PDRV1|XP_PU|XP_SL|YN_CS|YN_IE|YN_PD|YN_PDRV0|YN_PDRV1|YN_PU|YN_SL|YP_CS|YP_IE|YP_PD|YP_PDRV0|YP_PDRV1|YP_PU|YP_SL|ZN_CS|ZN_IE|ZN_PD|ZN_PDRV0|ZN_PDRV1|ZN_PU|ZN_SL|ZP_CS|ZP_IE|ZP_PD|ZP_PDRV0|ZP_PDRV1|ZP_PU|ZP_SL
+ nfet_06v0 L=1U W=1U AS=0.25P AD=0.44P PS=1.5U PD=2.88U
M$1429 \$9138 \$9068
+ VSS|XN_CS|XN_IE|XN_PD|XN_PDRV0|XN_PDRV1|XN_PU|XN_SL|XP_CS|XP_IE|XP_PD|XP_PDRV0|XP_PDRV1|XP_PU|XP_SL|YN_CS|YN_IE|YN_PD|YN_PDRV0|YN_PDRV1|YN_PU|YN_SL|YP_CS|YP_IE|YP_PD|YP_PDRV0|YP_PDRV1|YP_PU|YP_SL|ZN_CS|ZN_IE|ZN_PD|ZN_PDRV0|ZN_PDRV1|ZN_PU|ZN_SL|ZP_CS|ZP_IE|ZP_PD|ZP_PDRV0|ZP_PDRV1|ZP_PU|ZP_SL
+ VSS|XN_CS|XN_IE|XN_PD|XN_PDRV0|XN_PDRV1|XN_PU|XN_SL|XP_CS|XP_IE|XP_PD|XP_PDRV0|XP_PDRV1|XP_PU|XP_SL|YN_CS|YN_IE|YN_PD|YN_PDRV0|YN_PDRV1|YN_PU|YN_SL|YP_CS|YP_IE|YP_PD|YP_PDRV0|YP_PDRV1|YP_PU|YP_SL|ZN_CS|ZN_IE|ZN_PD|ZN_PDRV0|ZN_PDRV1|ZN_PU|ZN_SL|ZP_CS|ZP_IE|ZP_PD|ZP_PDRV0|ZP_PDRV1|ZP_PU|ZP_SL
+ nfet_06v0 L=1U W=5U AS=2.2P AD=1.25P PS=10.88U PD=5.5U
M$1430 \$9091 \$9090 \$9138
+ VSS|XN_CS|XN_IE|XN_PD|XN_PDRV0|XN_PDRV1|XN_PU|XN_SL|XP_CS|XP_IE|XP_PD|XP_PDRV0|XP_PDRV1|XP_PU|XP_SL|YN_CS|YN_IE|YN_PD|YN_PDRV0|YN_PDRV1|YN_PU|YN_SL|YP_CS|YP_IE|YP_PD|YP_PDRV0|YP_PDRV1|YP_PU|YP_SL|ZN_CS|ZN_IE|ZN_PD|ZN_PDRV0|ZN_PDRV1|ZN_PU|ZN_SL|ZP_CS|ZP_IE|ZP_PD|ZP_PDRV0|ZP_PDRV1|ZP_PU|ZP_SL
+ nfet_06v0 L=1U W=5U AS=1.25P AD=1.65P PS=5.5U PD=5.66U
M$1431 \$9139 \$9090 \$9091
+ VSS|XN_CS|XN_IE|XN_PD|XN_PDRV0|XN_PDRV1|XN_PU|XN_SL|XP_CS|XP_IE|XP_PD|XP_PDRV0|XP_PDRV1|XP_PU|XP_SL|YN_CS|YN_IE|YN_PD|YN_PDRV0|YN_PDRV1|YN_PU|YN_SL|YP_CS|YP_IE|YP_PD|YP_PDRV0|YP_PDRV1|YP_PU|YP_SL|ZN_CS|ZN_IE|ZN_PD|ZN_PDRV0|ZN_PDRV1|ZN_PU|ZN_SL|ZP_CS|ZP_IE|ZP_PD|ZP_PDRV0|ZP_PDRV1|ZP_PU|ZP_SL
+ nfet_06v0 L=1U W=5U AS=1.65P AD=1.25P PS=5.66U PD=5.5U
M$1432
+ VSS|XN_CS|XN_IE|XN_PD|XN_PDRV0|XN_PDRV1|XN_PU|XN_SL|XP_CS|XP_IE|XP_PD|XP_PDRV0|XP_PDRV1|XP_PU|XP_SL|YN_CS|YN_IE|YN_PD|YN_PDRV0|YN_PDRV1|YN_PU|YN_SL|YP_CS|YP_IE|YP_PD|YP_PDRV0|YP_PDRV1|YP_PU|YP_SL|ZN_CS|ZN_IE|ZN_PD|ZN_PDRV0|ZN_PDRV1|ZN_PU|ZN_SL|ZP_CS|ZP_IE|ZP_PD|ZP_PDRV0|ZP_PDRV1|ZP_PU|ZP_SL
+ \$9068 \$9139
+ VSS|XN_CS|XN_IE|XN_PD|XN_PDRV0|XN_PDRV1|XN_PU|XN_SL|XP_CS|XP_IE|XP_PD|XP_PDRV0|XP_PDRV1|XP_PU|XP_SL|YN_CS|YN_IE|YN_PD|YN_PDRV0|YN_PDRV1|YN_PU|YN_SL|YP_CS|YP_IE|YP_PD|YP_PDRV0|YP_PDRV1|YP_PU|YP_SL|ZN_CS|ZN_IE|ZN_PD|ZN_PDRV0|ZN_PDRV1|ZN_PU|ZN_SL|ZP_CS|ZP_IE|ZP_PD|ZP_PDRV0|ZP_PDRV1|ZP_PU|ZP_SL
+ nfet_06v0 L=1U W=5U AS=1.25P AD=2.2P PS=5.5U PD=10.88U
M$1433 \$9092 \$2441 \$9091
+ VSS|XN_CS|XN_IE|XN_PD|XN_PDRV0|XN_PDRV1|XN_PU|XN_SL|XP_CS|XP_IE|XP_PD|XP_PDRV0|XP_PDRV1|XP_PU|XP_SL|YN_CS|YN_IE|YN_PD|YN_PDRV0|YN_PDRV1|YN_PU|YN_SL|YP_CS|YP_IE|YP_PD|YP_PDRV0|YP_PDRV1|YP_PU|YP_SL|ZN_CS|ZN_IE|ZN_PD|ZN_PDRV0|ZN_PDRV1|ZN_PU|ZN_SL|ZP_CS|ZP_IE|ZP_PD|ZP_PDRV0|ZP_PDRV1|ZP_PU|ZP_SL
+ nfet_06v0 L=1U W=5U AS=2.2P AD=1.3P PS=10.88U PD=5.52U
M$1434 \$9091 \$2441 \$9092
+ VSS|XN_CS|XN_IE|XN_PD|XN_PDRV0|XN_PDRV1|XN_PU|XN_SL|XP_CS|XP_IE|XP_PD|XP_PDRV0|XP_PDRV1|XP_PU|XP_SL|YN_CS|YN_IE|YN_PD|YN_PDRV0|YN_PDRV1|YN_PU|YN_SL|YP_CS|YP_IE|YP_PD|YP_PDRV0|YP_PDRV1|YP_PU|YP_SL|ZN_CS|ZN_IE|ZN_PD|ZN_PDRV0|ZN_PDRV1|ZN_PU|ZN_SL|ZP_CS|ZP_IE|ZP_PD|ZP_PDRV0|ZP_PDRV1|ZP_PU|ZP_SL
+ nfet_06v0 L=1U W=5U AS=1.3P AD=2.2P PS=5.52U PD=10.88U
M$1435 \$9093 \$2449 \$9091
+ VSS|XN_CS|XN_IE|XN_PD|XN_PDRV0|XN_PDRV1|XN_PU|XN_SL|XP_CS|XP_IE|XP_PD|XP_PDRV0|XP_PDRV1|XP_PU|XP_SL|YN_CS|YN_IE|YN_PD|YN_PDRV0|YN_PDRV1|YN_PU|YN_SL|YP_CS|YP_IE|YP_PD|YP_PDRV0|YP_PDRV1|YP_PU|YP_SL|ZN_CS|ZN_IE|ZN_PD|ZN_PDRV0|ZN_PDRV1|ZN_PU|ZN_SL|ZP_CS|ZP_IE|ZP_PD|ZP_PDRV0|ZP_PDRV1|ZP_PU|ZP_SL
+ nfet_06v0 L=1U W=5U AS=2.2P AD=1.3P PS=10.88U PD=5.52U
M$1436 \$9091 \$2449 \$9093
+ VSS|XN_CS|XN_IE|XN_PD|XN_PDRV0|XN_PDRV1|XN_PU|XN_SL|XP_CS|XP_IE|XP_PD|XP_PDRV0|XP_PDRV1|XP_PU|XP_SL|YN_CS|YN_IE|YN_PD|YN_PDRV0|YN_PDRV1|YN_PU|YN_SL|YP_CS|YP_IE|YP_PD|YP_PDRV0|YP_PDRV1|YP_PU|YP_SL|ZN_CS|ZN_IE|ZN_PD|ZN_PDRV0|ZN_PDRV1|ZN_PU|ZN_SL|ZP_CS|ZP_IE|ZP_PD|ZP_PDRV0|ZP_PDRV1|ZP_PU|ZP_SL
+ nfet_06v0 L=1U W=5U AS=1.3P AD=2.2P PS=5.52U PD=10.88U
M$1437 \$9095 \$9090 \$9094
+ VSS|XN_CS|XN_IE|XN_PD|XN_PDRV0|XN_PDRV1|XN_PU|XN_SL|XP_CS|XP_IE|XP_PD|XP_PDRV0|XP_PDRV1|XP_PU|XP_SL|YN_CS|YN_IE|YN_PD|YN_PDRV0|YN_PDRV1|YN_PU|YN_SL|YP_CS|YP_IE|YP_PD|YP_PDRV0|YP_PDRV1|YP_PU|YP_SL|ZN_CS|ZN_IE|ZN_PD|ZN_PDRV0|ZN_PDRV1|ZN_PU|ZN_SL|ZP_CS|ZP_IE|ZP_PD|ZP_PDRV0|ZP_PDRV1|ZP_PU|ZP_SL
+ nfet_06v0 L=1U W=2.5U AS=1.1P AD=0.65P PS=5.88U PD=3.02U
M$1438 \$9094 \$9090 \$9095
+ VSS|XN_CS|XN_IE|XN_PD|XN_PDRV0|XN_PDRV1|XN_PU|XN_SL|XP_CS|XP_IE|XP_PD|XP_PDRV0|XP_PDRV1|XP_PU|XP_SL|YN_CS|YN_IE|YN_PD|YN_PDRV0|YN_PDRV1|YN_PU|YN_SL|YP_CS|YP_IE|YP_PD|YP_PDRV0|YP_PDRV1|YP_PU|YP_SL|ZN_CS|ZN_IE|ZN_PD|ZN_PDRV0|ZN_PDRV1|ZN_PU|ZN_SL|ZP_CS|ZP_IE|ZP_PD|ZP_PDRV0|ZP_PDRV1|ZP_PU|ZP_SL
+ nfet_06v0 L=1U W=2.5U AS=0.65P AD=1.1P PS=3.02U PD=5.88U
M$1439 \$9097 \$9090 \$9096
+ VSS|XN_CS|XN_IE|XN_PD|XN_PDRV0|XN_PDRV1|XN_PU|XN_SL|XP_CS|XP_IE|XP_PD|XP_PDRV0|XP_PDRV1|XP_PU|XP_SL|YN_CS|YN_IE|YN_PD|YN_PDRV0|YN_PDRV1|YN_PU|YN_SL|YP_CS|YP_IE|YP_PD|YP_PDRV0|YP_PDRV1|YP_PU|YP_SL|ZN_CS|ZN_IE|ZN_PD|ZN_PDRV0|ZN_PDRV1|ZN_PU|ZN_SL|ZP_CS|ZP_IE|ZP_PD|ZP_PDRV0|ZP_PDRV1|ZP_PU|ZP_SL
+ nfet_06v0 L=1U W=2.5U AS=1.1P AD=0.65P PS=5.88U PD=3.02U
M$1440 \$9096 \$9090 \$9097
+ VSS|XN_CS|XN_IE|XN_PD|XN_PDRV0|XN_PDRV1|XN_PU|XN_SL|XP_CS|XP_IE|XP_PD|XP_PDRV0|XP_PDRV1|XP_PU|XP_SL|YN_CS|YN_IE|YN_PD|YN_PDRV0|YN_PDRV1|YN_PU|YN_SL|YP_CS|YP_IE|YP_PD|YP_PDRV0|YP_PDRV1|YP_PU|YP_SL|ZN_CS|ZN_IE|ZN_PD|ZN_PDRV0|ZN_PDRV1|ZN_PU|ZN_SL|ZP_CS|ZP_IE|ZP_PD|ZP_PDRV0|ZP_PDRV1|ZP_PU|ZP_SL
+ nfet_06v0 L=1U W=2.5U AS=0.65P AD=1.1P PS=3.02U PD=5.88U
M$1441 \$9094 \$9095
+ VSS|XN_CS|XN_IE|XN_PD|XN_PDRV0|XN_PDRV1|XN_PU|XN_SL|XP_CS|XP_IE|XP_PD|XP_PDRV0|XP_PDRV1|XP_PU|XP_SL|YN_CS|YN_IE|YN_PD|YN_PDRV0|YN_PDRV1|YN_PU|YN_SL|YP_CS|YP_IE|YP_PD|YP_PDRV0|YP_PDRV1|YP_PU|YP_SL|ZN_CS|ZN_IE|ZN_PD|ZN_PDRV0|ZN_PDRV1|ZN_PU|ZN_SL|ZP_CS|ZP_IE|ZP_PD|ZP_PDRV0|ZP_PDRV1|ZP_PU|ZP_SL
+ VSS|XN_CS|XN_IE|XN_PD|XN_PDRV0|XN_PDRV1|XN_PU|XN_SL|XP_CS|XP_IE|XP_PD|XP_PDRV0|XP_PDRV1|XP_PU|XP_SL|YN_CS|YN_IE|YN_PD|YN_PDRV0|YN_PDRV1|YN_PU|YN_SL|YP_CS|YP_IE|YP_PD|YP_PDRV0|YP_PDRV1|YP_PU|YP_SL|ZN_CS|ZN_IE|ZN_PD|ZN_PDRV0|ZN_PDRV1|ZN_PU|ZN_SL|ZP_CS|ZP_IE|ZP_PD|ZP_PDRV0|ZP_PDRV1|ZP_PU|ZP_SL
+ nfet_06v0 L=1U W=2.5U AS=1.1P AD=0.65P PS=5.88U PD=3.02U
M$1442
+ VSS|XN_CS|XN_IE|XN_PD|XN_PDRV0|XN_PDRV1|XN_PU|XN_SL|XP_CS|XP_IE|XP_PD|XP_PDRV0|XP_PDRV1|XP_PU|XP_SL|YN_CS|YN_IE|YN_PD|YN_PDRV0|YN_PDRV1|YN_PU|YN_SL|YP_CS|YP_IE|YP_PD|YP_PDRV0|YP_PDRV1|YP_PU|YP_SL|ZN_CS|ZN_IE|ZN_PD|ZN_PDRV0|ZN_PDRV1|ZN_PU|ZN_SL|ZP_CS|ZP_IE|ZP_PD|ZP_PDRV0|ZP_PDRV1|ZP_PU|ZP_SL
+ \$9095 \$9094
+ VSS|XN_CS|XN_IE|XN_PD|XN_PDRV0|XN_PDRV1|XN_PU|XN_SL|XP_CS|XP_IE|XP_PD|XP_PDRV0|XP_PDRV1|XP_PU|XP_SL|YN_CS|YN_IE|YN_PD|YN_PDRV0|YN_PDRV1|YN_PU|YN_SL|YP_CS|YP_IE|YP_PD|YP_PDRV0|YP_PDRV1|YP_PU|YP_SL|ZN_CS|ZN_IE|ZN_PD|ZN_PDRV0|ZN_PDRV1|ZN_PU|ZN_SL|ZP_CS|ZP_IE|ZP_PD|ZP_PDRV0|ZP_PDRV1|ZP_PU|ZP_SL
+ nfet_06v0 L=1U W=2.5U AS=0.65P AD=0.65P PS=3.02U PD=3.02U
M$1443 \$9094 \$9095
+ VSS|XN_CS|XN_IE|XN_PD|XN_PDRV0|XN_PDRV1|XN_PU|XN_SL|XP_CS|XP_IE|XP_PD|XP_PDRV0|XP_PDRV1|XP_PU|XP_SL|YN_CS|YN_IE|YN_PD|YN_PDRV0|YN_PDRV1|YN_PU|YN_SL|YP_CS|YP_IE|YP_PD|YP_PDRV0|YP_PDRV1|YP_PU|YP_SL|ZN_CS|ZN_IE|ZN_PD|ZN_PDRV0|ZN_PDRV1|ZN_PU|ZN_SL|ZP_CS|ZP_IE|ZP_PD|ZP_PDRV0|ZP_PDRV1|ZP_PU|ZP_SL
+ VSS|XN_CS|XN_IE|XN_PD|XN_PDRV0|XN_PDRV1|XN_PU|XN_SL|XP_CS|XP_IE|XP_PD|XP_PDRV0|XP_PDRV1|XP_PU|XP_SL|YN_CS|YN_IE|YN_PD|YN_PDRV0|YN_PDRV1|YN_PU|YN_SL|YP_CS|YP_IE|YP_PD|YP_PDRV0|YP_PDRV1|YP_PU|YP_SL|ZN_CS|ZN_IE|ZN_PD|ZN_PDRV0|ZN_PDRV1|ZN_PU|ZN_SL|ZP_CS|ZP_IE|ZP_PD|ZP_PDRV0|ZP_PDRV1|ZP_PU|ZP_SL
+ nfet_06v0 L=1U W=2.5U AS=0.65P AD=0.65P PS=3.02U PD=3.02U
M$1444
+ VSS|XN_CS|XN_IE|XN_PD|XN_PDRV0|XN_PDRV1|XN_PU|XN_SL|XP_CS|XP_IE|XP_PD|XP_PDRV0|XP_PDRV1|XP_PU|XP_SL|YN_CS|YN_IE|YN_PD|YN_PDRV0|YN_PDRV1|YN_PU|YN_SL|YP_CS|YP_IE|YP_PD|YP_PDRV0|YP_PDRV1|YP_PU|YP_SL|ZN_CS|ZN_IE|ZN_PD|ZN_PDRV0|ZN_PDRV1|ZN_PU|ZN_SL|ZP_CS|ZP_IE|ZP_PD|ZP_PDRV0|ZP_PDRV1|ZP_PU|ZP_SL
+ \$9095 \$9094
+ VSS|XN_CS|XN_IE|XN_PD|XN_PDRV0|XN_PDRV1|XN_PU|XN_SL|XP_CS|XP_IE|XP_PD|XP_PDRV0|XP_PDRV1|XP_PU|XP_SL|YN_CS|YN_IE|YN_PD|YN_PDRV0|YN_PDRV1|YN_PU|YN_SL|YP_CS|YP_IE|YP_PD|YP_PDRV0|YP_PDRV1|YP_PU|YP_SL|ZN_CS|ZN_IE|ZN_PD|ZN_PDRV0|ZN_PDRV1|ZN_PU|ZN_SL|ZP_CS|ZP_IE|ZP_PD|ZP_PDRV0|ZP_PDRV1|ZP_PU|ZP_SL
+ nfet_06v0 L=1U W=2.5U AS=0.65P AD=1.1P PS=3.02U PD=5.88U
M$1445 \$9096 \$9095
+ VSS|XN_CS|XN_IE|XN_PD|XN_PDRV0|XN_PDRV1|XN_PU|XN_SL|XP_CS|XP_IE|XP_PD|XP_PDRV0|XP_PDRV1|XP_PU|XP_SL|YN_CS|YN_IE|YN_PD|YN_PDRV0|YN_PDRV1|YN_PU|YN_SL|YP_CS|YP_IE|YP_PD|YP_PDRV0|YP_PDRV1|YP_PU|YP_SL|ZN_CS|ZN_IE|ZN_PD|ZN_PDRV0|ZN_PDRV1|ZN_PU|ZN_SL|ZP_CS|ZP_IE|ZP_PD|ZP_PDRV0|ZP_PDRV1|ZP_PU|ZP_SL
+ VSS|XN_CS|XN_IE|XN_PD|XN_PDRV0|XN_PDRV1|XN_PU|XN_SL|XP_CS|XP_IE|XP_PD|XP_PDRV0|XP_PDRV1|XP_PU|XP_SL|YN_CS|YN_IE|YN_PD|YN_PDRV0|YN_PDRV1|YN_PU|YN_SL|YP_CS|YP_IE|YP_PD|YP_PDRV0|YP_PDRV1|YP_PU|YP_SL|ZN_CS|ZN_IE|ZN_PD|ZN_PDRV0|ZN_PDRV1|ZN_PU|ZN_SL|ZP_CS|ZP_IE|ZP_PD|ZP_PDRV0|ZP_PDRV1|ZP_PU|ZP_SL
+ nfet_06v0 L=1U W=2.5U AS=1.1P AD=0.65P PS=5.88U PD=3.02U
M$1446
+ VSS|XN_CS|XN_IE|XN_PD|XN_PDRV0|XN_PDRV1|XN_PU|XN_SL|XP_CS|XP_IE|XP_PD|XP_PDRV0|XP_PDRV1|XP_PU|XP_SL|YN_CS|YN_IE|YN_PD|YN_PDRV0|YN_PDRV1|YN_PU|YN_SL|YP_CS|YP_IE|YP_PD|YP_PDRV0|YP_PDRV1|YP_PU|YP_SL|ZN_CS|ZN_IE|ZN_PD|ZN_PDRV0|ZN_PDRV1|ZN_PU|ZN_SL|ZP_CS|ZP_IE|ZP_PD|ZP_PDRV0|ZP_PDRV1|ZP_PU|ZP_SL
+ \$9095 \$9096
+ VSS|XN_CS|XN_IE|XN_PD|XN_PDRV0|XN_PDRV1|XN_PU|XN_SL|XP_CS|XP_IE|XP_PD|XP_PDRV0|XP_PDRV1|XP_PU|XP_SL|YN_CS|YN_IE|YN_PD|YN_PDRV0|YN_PDRV1|YN_PU|YN_SL|YP_CS|YP_IE|YP_PD|YP_PDRV0|YP_PDRV1|YP_PU|YP_SL|ZN_CS|ZN_IE|ZN_PD|ZN_PDRV0|ZN_PDRV1|ZN_PU|ZN_SL|ZP_CS|ZP_IE|ZP_PD|ZP_PDRV0|ZP_PDRV1|ZP_PU|ZP_SL
+ nfet_06v0 L=1U W=2.5U AS=0.65P AD=0.65P PS=3.02U PD=3.02U
M$1447 \$9096 \$9095
+ VSS|XN_CS|XN_IE|XN_PD|XN_PDRV0|XN_PDRV1|XN_PU|XN_SL|XP_CS|XP_IE|XP_PD|XP_PDRV0|XP_PDRV1|XP_PU|XP_SL|YN_CS|YN_IE|YN_PD|YN_PDRV0|YN_PDRV1|YN_PU|YN_SL|YP_CS|YP_IE|YP_PD|YP_PDRV0|YP_PDRV1|YP_PU|YP_SL|ZN_CS|ZN_IE|ZN_PD|ZN_PDRV0|ZN_PDRV1|ZN_PU|ZN_SL|ZP_CS|ZP_IE|ZP_PD|ZP_PDRV0|ZP_PDRV1|ZP_PU|ZP_SL
+ VSS|XN_CS|XN_IE|XN_PD|XN_PDRV0|XN_PDRV1|XN_PU|XN_SL|XP_CS|XP_IE|XP_PD|XP_PDRV0|XP_PDRV1|XP_PU|XP_SL|YN_CS|YN_IE|YN_PD|YN_PDRV0|YN_PDRV1|YN_PU|YN_SL|YP_CS|YP_IE|YP_PD|YP_PDRV0|YP_PDRV1|YP_PU|YP_SL|ZN_CS|ZN_IE|ZN_PD|ZN_PDRV0|ZN_PDRV1|ZN_PU|ZN_SL|ZP_CS|ZP_IE|ZP_PD|ZP_PDRV0|ZP_PDRV1|ZP_PU|ZP_SL
+ nfet_06v0 L=1U W=2.5U AS=0.65P AD=0.65P PS=3.02U PD=3.02U
M$1448
+ VSS|XN_CS|XN_IE|XN_PD|XN_PDRV0|XN_PDRV1|XN_PU|XN_SL|XP_CS|XP_IE|XP_PD|XP_PDRV0|XP_PDRV1|XP_PU|XP_SL|YN_CS|YN_IE|YN_PD|YN_PDRV0|YN_PDRV1|YN_PU|YN_SL|YP_CS|YP_IE|YP_PD|YP_PDRV0|YP_PDRV1|YP_PU|YP_SL|ZN_CS|ZN_IE|ZN_PD|ZN_PDRV0|ZN_PDRV1|ZN_PU|ZN_SL|ZP_CS|ZP_IE|ZP_PD|ZP_PDRV0|ZP_PDRV1|ZP_PU|ZP_SL
+ \$9095 \$9096
+ VSS|XN_CS|XN_IE|XN_PD|XN_PDRV0|XN_PDRV1|XN_PU|XN_SL|XP_CS|XP_IE|XP_PD|XP_PDRV0|XP_PDRV1|XP_PU|XP_SL|YN_CS|YN_IE|YN_PD|YN_PDRV0|YN_PDRV1|YN_PU|YN_SL|YP_CS|YP_IE|YP_PD|YP_PDRV0|YP_PDRV1|YP_PU|YP_SL|ZN_CS|ZN_IE|ZN_PD|ZN_PDRV0|ZN_PDRV1|ZN_PU|ZN_SL|ZP_CS|ZP_IE|ZP_PD|ZP_PDRV0|ZP_PDRV1|ZP_PU|ZP_SL
+ nfet_06v0 L=1U W=2.5U AS=0.65P AD=1.1P PS=3.02U PD=5.88U
M$1449 \$9167 \$9120 \$9095
+ VSS|XN_CS|XN_IE|XN_PD|XN_PDRV0|XN_PDRV1|XN_PU|XN_SL|XP_CS|XP_IE|XP_PD|XP_PDRV0|XP_PDRV1|XP_PU|XP_SL|YN_CS|YN_IE|YN_PD|YN_PDRV0|YN_PDRV1|YN_PU|YN_SL|YP_CS|YP_IE|YP_PD|YP_PDRV0|YP_PDRV1|YP_PU|YP_SL|ZN_CS|ZN_IE|ZN_PD|ZN_PDRV0|ZN_PDRV1|ZN_PU|ZN_SL|ZP_CS|ZP_IE|ZP_PD|ZP_PDRV0|ZP_PDRV1|ZP_PU|ZP_SL
+ nfet_06v0 L=1U W=2.5U AS=1.1P AD=1.1P PS=5.88U PD=5.88U
M$1450 \$9069 \$9120 \$9097
+ VSS|XN_CS|XN_IE|XN_PD|XN_PDRV0|XN_PDRV1|XN_PU|XN_SL|XP_CS|XP_IE|XP_PD|XP_PDRV0|XP_PDRV1|XP_PU|XP_SL|YN_CS|YN_IE|YN_PD|YN_PDRV0|YN_PDRV1|YN_PU|YN_SL|YP_CS|YP_IE|YP_PD|YP_PDRV0|YP_PDRV1|YP_PU|YP_SL|ZN_CS|ZN_IE|ZN_PD|ZN_PDRV0|ZN_PDRV1|ZN_PU|ZN_SL|ZP_CS|ZP_IE|ZP_PD|ZP_PDRV0|ZP_PDRV1|ZP_PU|ZP_SL
+ nfet_06v0 L=1U W=2.5U AS=1.1P AD=1.1P PS=5.88U PD=5.88U
M$1451 \$9140 \$9068
+ VSS|XN_CS|XN_IE|XN_PD|XN_PDRV0|XN_PDRV1|XN_PU|XN_SL|XP_CS|XP_IE|XP_PD|XP_PDRV0|XP_PDRV1|XP_PU|XP_SL|YN_CS|YN_IE|YN_PD|YN_PDRV0|YN_PDRV1|YN_PU|YN_SL|YP_CS|YP_IE|YP_PD|YP_PDRV0|YP_PDRV1|YP_PU|YP_SL|ZN_CS|ZN_IE|ZN_PD|ZN_PDRV0|ZN_PDRV1|ZN_PU|ZN_SL|ZP_CS|ZP_IE|ZP_PD|ZP_PDRV0|ZP_PDRV1|ZP_PU|ZP_SL
+ VSS|XN_CS|XN_IE|XN_PD|XN_PDRV0|XN_PDRV1|XN_PU|XN_SL|XP_CS|XP_IE|XP_PD|XP_PDRV0|XP_PDRV1|XP_PU|XP_SL|YN_CS|YN_IE|YN_PD|YN_PDRV0|YN_PDRV1|YN_PU|YN_SL|YP_CS|YP_IE|YP_PD|YP_PDRV0|YP_PDRV1|YP_PU|YP_SL|ZN_CS|ZN_IE|ZN_PD|ZN_PDRV0|ZN_PDRV1|ZN_PU|ZN_SL|ZP_CS|ZP_IE|ZP_PD|ZP_PDRV0|ZP_PDRV1|ZP_PU|ZP_SL
+ nfet_06v0 L=1U W=5U AS=2.2P AD=1.25P PS=10.88U PD=5.5U
M$1452 \$9070 \$9090 \$9140
+ VSS|XN_CS|XN_IE|XN_PD|XN_PDRV0|XN_PDRV1|XN_PU|XN_SL|XP_CS|XP_IE|XP_PD|XP_PDRV0|XP_PDRV1|XP_PU|XP_SL|YN_CS|YN_IE|YN_PD|YN_PDRV0|YN_PDRV1|YN_PU|YN_SL|YP_CS|YP_IE|YP_PD|YP_PDRV0|YP_PDRV1|YP_PU|YP_SL|ZN_CS|ZN_IE|ZN_PD|ZN_PDRV0|ZN_PDRV1|ZN_PU|ZN_SL|ZP_CS|ZP_IE|ZP_PD|ZP_PDRV0|ZP_PDRV1|ZP_PU|ZP_SL
+ nfet_06v0 L=1U W=5U AS=1.25P AD=2.2P PS=5.5U PD=10.88U
M$1453 \$9141 \$9071
+ VSS|XN_CS|XN_IE|XN_PD|XN_PDRV0|XN_PDRV1|XN_PU|XN_SL|XP_CS|XP_IE|XP_PD|XP_PDRV0|XP_PDRV1|XP_PU|XP_SL|YN_CS|YN_IE|YN_PD|YN_PDRV0|YN_PDRV1|YN_PU|YN_SL|YP_CS|YP_IE|YP_PD|YP_PDRV0|YP_PDRV1|YP_PU|YP_SL|ZN_CS|ZN_IE|ZN_PD|ZN_PDRV0|ZN_PDRV1|ZN_PU|ZN_SL|ZP_CS|ZP_IE|ZP_PD|ZP_PDRV0|ZP_PDRV1|ZP_PU|ZP_SL
+ VSS|XN_CS|XN_IE|XN_PD|XN_PDRV0|XN_PDRV1|XN_PU|XN_SL|XP_CS|XP_IE|XP_PD|XP_PDRV0|XP_PDRV1|XP_PU|XP_SL|YN_CS|YN_IE|YN_PD|YN_PDRV0|YN_PDRV1|YN_PU|YN_SL|YP_CS|YP_IE|YP_PD|YP_PDRV0|YP_PDRV1|YP_PU|YP_SL|ZN_CS|ZN_IE|ZN_PD|ZN_PDRV0|ZN_PDRV1|ZN_PU|ZN_SL|ZP_CS|ZP_IE|ZP_PD|ZP_PDRV0|ZP_PDRV1|ZP_PU|ZP_SL
+ nfet_06v0 L=1U W=5U AS=2.2P AD=1.25P PS=10.88U PD=5.5U
M$1454 \$9071 \$9090 \$9141
+ VSS|XN_CS|XN_IE|XN_PD|XN_PDRV0|XN_PDRV1|XN_PU|XN_SL|XP_CS|XP_IE|XP_PD|XP_PDRV0|XP_PDRV1|XP_PU|XP_SL|YN_CS|YN_IE|YN_PD|YN_PDRV0|YN_PDRV1|YN_PU|YN_SL|YP_CS|YP_IE|YP_PD|YP_PDRV0|YP_PDRV1|YP_PU|YP_SL|ZN_CS|ZN_IE|ZN_PD|ZN_PDRV0|ZN_PDRV1|ZN_PU|ZN_SL|ZP_CS|ZP_IE|ZP_PD|ZP_PDRV0|ZP_PDRV1|ZP_PU|ZP_SL
+ nfet_06v0 L=1U W=5U AS=1.25P AD=1.65P PS=5.5U PD=5.66U
M$1455 \$9120 \$9120 \$9071
+ VSS|XN_CS|XN_IE|XN_PD|XN_PDRV0|XN_PDRV1|XN_PU|XN_SL|XP_CS|XP_IE|XP_PD|XP_PDRV0|XP_PDRV1|XP_PU|XP_SL|YN_CS|YN_IE|YN_PD|YN_PDRV0|YN_PDRV1|YN_PU|YN_SL|YP_CS|YP_IE|YP_PD|YP_PDRV0|YP_PDRV1|YP_PU|YP_SL|ZN_CS|ZN_IE|ZN_PD|ZN_PDRV0|ZN_PDRV1|ZN_PU|ZN_SL|ZP_CS|ZP_IE|ZP_PD|ZP_PDRV0|ZP_PDRV1|ZP_PU|ZP_SL
+ nfet_06v0 L=1U W=5U AS=1.65P AD=2.2P PS=5.66U PD=10.88U
M$1456 \$9109 \$9097
+ VSS|XN_CS|XN_IE|XN_PD|XN_PDRV0|XN_PDRV1|XN_PU|XN_SL|XP_CS|XP_IE|XP_PD|XP_PDRV0|XP_PDRV1|XP_PU|XP_SL|YN_CS|YN_IE|YN_PD|YN_PDRV0|YN_PDRV1|YN_PU|YN_SL|YP_CS|YP_IE|YP_PD|YP_PDRV0|YP_PDRV1|YP_PU|YP_SL|ZN_CS|ZN_IE|ZN_PD|ZN_PDRV0|ZN_PDRV1|ZN_PU|ZN_SL|ZP_CS|ZP_IE|ZP_PD|ZP_PDRV0|ZP_PDRV1|ZP_PU|ZP_SL
+ VSS|XN_CS|XN_IE|XN_PD|XN_PDRV0|XN_PDRV1|XN_PU|XN_SL|XP_CS|XP_IE|XP_PD|XP_PDRV0|XP_PDRV1|XP_PU|XP_SL|YN_CS|YN_IE|YN_PD|YN_PDRV0|YN_PDRV1|YN_PU|YN_SL|YP_CS|YP_IE|YP_PD|YP_PDRV0|YP_PDRV1|YP_PU|YP_SL|ZN_CS|ZN_IE|ZN_PD|ZN_PDRV0|ZN_PDRV1|ZN_PU|ZN_SL|ZP_CS|ZP_IE|ZP_PD|ZP_PDRV0|ZP_PDRV1|ZP_PU|ZP_SL
+ nfet_06v0 L=1U W=5U AS=2.2P AD=1.3P PS=10.88U PD=5.52U
M$1457
+ VSS|XN_CS|XN_IE|XN_PD|XN_PDRV0|XN_PDRV1|XN_PU|XN_SL|XP_CS|XP_IE|XP_PD|XP_PDRV0|XP_PDRV1|XP_PU|XP_SL|YN_CS|YN_IE|YN_PD|YN_PDRV0|YN_PDRV1|YN_PU|YN_SL|YP_CS|YP_IE|YP_PD|YP_PDRV0|YP_PDRV1|YP_PU|YP_SL|ZN_CS|ZN_IE|ZN_PD|ZN_PDRV0|ZN_PDRV1|ZN_PU|ZN_SL|ZP_CS|ZP_IE|ZP_PD|ZP_PDRV0|ZP_PDRV1|ZP_PU|ZP_SL
+ \$9097 \$9109
+ VSS|XN_CS|XN_IE|XN_PD|XN_PDRV0|XN_PDRV1|XN_PU|XN_SL|XP_CS|XP_IE|XP_PD|XP_PDRV0|XP_PDRV1|XP_PU|XP_SL|YN_CS|YN_IE|YN_PD|YN_PDRV0|YN_PDRV1|YN_PU|YN_SL|YP_CS|YP_IE|YP_PD|YP_PDRV0|YP_PDRV1|YP_PU|YP_SL|ZN_CS|ZN_IE|ZN_PD|ZN_PDRV0|ZN_PDRV1|ZN_PU|ZN_SL|ZP_CS|ZP_IE|ZP_PD|ZP_PDRV0|ZP_PDRV1|ZP_PU|ZP_SL
+ nfet_06v0 L=1U W=5U AS=1.3P AD=1.3P PS=5.52U PD=5.52U
M$1458 \$9109 \$9097
+ VSS|XN_CS|XN_IE|XN_PD|XN_PDRV0|XN_PDRV1|XN_PU|XN_SL|XP_CS|XP_IE|XP_PD|XP_PDRV0|XP_PDRV1|XP_PU|XP_SL|YN_CS|YN_IE|YN_PD|YN_PDRV0|YN_PDRV1|YN_PU|YN_SL|YP_CS|YP_IE|YP_PD|YP_PDRV0|YP_PDRV1|YP_PU|YP_SL|ZN_CS|ZN_IE|ZN_PD|ZN_PDRV0|ZN_PDRV1|ZN_PU|ZN_SL|ZP_CS|ZP_IE|ZP_PD|ZP_PDRV0|ZP_PDRV1|ZP_PU|ZP_SL
+ VSS|XN_CS|XN_IE|XN_PD|XN_PDRV0|XN_PDRV1|XN_PU|XN_SL|XP_CS|XP_IE|XP_PD|XP_PDRV0|XP_PDRV1|XP_PU|XP_SL|YN_CS|YN_IE|YN_PD|YN_PDRV0|YN_PDRV1|YN_PU|YN_SL|YP_CS|YP_IE|YP_PD|YP_PDRV0|YP_PDRV1|YP_PU|YP_SL|ZN_CS|ZN_IE|ZN_PD|ZN_PDRV0|ZN_PDRV1|ZN_PU|ZN_SL|ZP_CS|ZP_IE|ZP_PD|ZP_PDRV0|ZP_PDRV1|ZP_PU|ZP_SL
+ nfet_06v0 L=1U W=5U AS=1.3P AD=2.2P PS=5.52U PD=10.88U
M$1459
+ VSS|XN_CS|XN_IE|XN_PD|XN_PDRV0|XN_PDRV1|XN_PU|XN_SL|XP_CS|XP_IE|XP_PD|XP_PDRV0|XP_PDRV1|XP_PU|XP_SL|YN_CS|YN_IE|YN_PD|YN_PDRV0|YN_PDRV1|YN_PU|YN_SL|YP_CS|YP_IE|YP_PD|YP_PDRV0|YP_PDRV1|YP_PU|YP_SL|ZN_CS|ZN_IE|ZN_PD|ZN_PDRV0|ZN_PDRV1|ZN_PU|ZN_SL|ZP_CS|ZP_IE|ZP_PD|ZP_PDRV0|ZP_PDRV1|ZP_PU|ZP_SL
+ VDD|XN_OE|XP_OE|YN_OE|YP_OE|ZN_OE|ZP_OE
+ VSS|XN_CS|XN_IE|XN_PD|XN_PDRV0|XN_PDRV1|XN_PU|XN_SL|XP_CS|XP_IE|XP_PD|XP_PDRV0|XP_PDRV1|XP_PU|XP_SL|YN_CS|YN_IE|YN_PD|YN_PDRV0|YN_PDRV1|YN_PU|YN_SL|YP_CS|YP_IE|YP_PD|YP_PDRV0|YP_PDRV1|YP_PU|YP_SL|ZN_CS|ZN_IE|ZN_PD|ZN_PDRV0|ZN_PDRV1|ZN_PU|ZN_SL|ZP_CS|ZP_IE|ZP_PD|ZP_PDRV0|ZP_PDRV1|ZP_PU|ZP_SL
+ VSS|XN_CS|XN_IE|XN_PD|XN_PDRV0|XN_PDRV1|XN_PU|XN_SL|XP_CS|XP_IE|XP_PD|XP_PDRV0|XP_PDRV1|XP_PU|XP_SL|YN_CS|YN_IE|YN_PD|YN_PDRV0|YN_PDRV1|YN_PU|YN_SL|YP_CS|YP_IE|YP_PD|YP_PDRV0|YP_PDRV1|YP_PU|YP_SL|ZN_CS|ZN_IE|ZN_PD|ZN_PDRV0|ZN_PDRV1|ZN_PU|ZN_SL|ZP_CS|ZP_IE|ZP_PD|ZP_PDRV0|ZP_PDRV1|ZP_PU|ZP_SL
+ nfet_06v0 L=2U W=9.75U AS=4.29P AD=4.29P PS=20.38U PD=20.38U
M$1460
+ VSS|XN_CS|XN_IE|XN_PD|XN_PDRV0|XN_PDRV1|XN_PU|XN_SL|XP_CS|XP_IE|XP_PD|XP_PDRV0|XP_PDRV1|XP_PU|XP_SL|YN_CS|YN_IE|YN_PD|YN_PDRV0|YN_PDRV1|YN_PU|YN_SL|YP_CS|YP_IE|YP_PD|YP_PDRV0|YP_PDRV1|YP_PU|YP_SL|ZN_CS|ZN_IE|ZN_PD|ZN_PDRV0|ZN_PDRV1|ZN_PU|ZN_SL|ZP_CS|ZP_IE|ZP_PD|ZP_PDRV0|ZP_PDRV1|ZP_PU|ZP_SL
+ VDD|XN_OE|XP_OE|YN_OE|YP_OE|ZN_OE|ZP_OE
+ VSS|XN_CS|XN_IE|XN_PD|XN_PDRV0|XN_PDRV1|XN_PU|XN_SL|XP_CS|XP_IE|XP_PD|XP_PDRV0|XP_PDRV1|XP_PU|XP_SL|YN_CS|YN_IE|YN_PD|YN_PDRV0|YN_PDRV1|YN_PU|YN_SL|YP_CS|YP_IE|YP_PD|YP_PDRV0|YP_PDRV1|YP_PU|YP_SL|ZN_CS|ZN_IE|ZN_PD|ZN_PDRV0|ZN_PDRV1|ZN_PU|ZN_SL|ZP_CS|ZP_IE|ZP_PD|ZP_PDRV0|ZP_PDRV1|ZP_PU|ZP_SL
+ VSS|XN_CS|XN_IE|XN_PD|XN_PDRV0|XN_PDRV1|XN_PU|XN_SL|XP_CS|XP_IE|XP_PD|XP_PDRV0|XP_PDRV1|XP_PU|XP_SL|YN_CS|YN_IE|YN_PD|YN_PDRV0|YN_PDRV1|YN_PU|YN_SL|YP_CS|YP_IE|YP_PD|YP_PDRV0|YP_PDRV1|YP_PU|YP_SL|ZN_CS|ZN_IE|ZN_PD|ZN_PDRV0|ZN_PDRV1|ZN_PU|ZN_SL|ZP_CS|ZP_IE|ZP_PD|ZP_PDRV0|ZP_PDRV1|ZP_PU|ZP_SL
+ nfet_06v0 L=2U W=9.75U AS=4.29P AD=4.29P PS=20.38U PD=20.38U
M$1461 \$9098 \$9098
+ VSS|XN_CS|XN_IE|XN_PD|XN_PDRV0|XN_PDRV1|XN_PU|XN_SL|XP_CS|XP_IE|XP_PD|XP_PDRV0|XP_PDRV1|XP_PU|XP_SL|YN_CS|YN_IE|YN_PD|YN_PDRV0|YN_PDRV1|YN_PU|YN_SL|YP_CS|YP_IE|YP_PD|YP_PDRV0|YP_PDRV1|YP_PU|YP_SL|ZN_CS|ZN_IE|ZN_PD|ZN_PDRV0|ZN_PDRV1|ZN_PU|ZN_SL|ZP_CS|ZP_IE|ZP_PD|ZP_PDRV0|ZP_PDRV1|ZP_PU|ZP_SL
+ VSS|XN_CS|XN_IE|XN_PD|XN_PDRV0|XN_PDRV1|XN_PU|XN_SL|XP_CS|XP_IE|XP_PD|XP_PDRV0|XP_PDRV1|XP_PU|XP_SL|YN_CS|YN_IE|YN_PD|YN_PDRV0|YN_PDRV1|YN_PU|YN_SL|YP_CS|YP_IE|YP_PD|YP_PDRV0|YP_PDRV1|YP_PU|YP_SL|ZN_CS|ZN_IE|ZN_PD|ZN_PDRV0|ZN_PDRV1|ZN_PU|ZN_SL|ZP_CS|ZP_IE|ZP_PD|ZP_PDRV0|ZP_PDRV1|ZP_PU|ZP_SL
+ nfet_06v0 L=1U W=1U AS=0.44P AD=0.44P PS=2.88U PD=2.88U
M$1462 \$9144 \$9072
+ VSS|XN_CS|XN_IE|XN_PD|XN_PDRV0|XN_PDRV1|XN_PU|XN_SL|XP_CS|XP_IE|XP_PD|XP_PDRV0|XP_PDRV1|XP_PU|XP_SL|YN_CS|YN_IE|YN_PD|YN_PDRV0|YN_PDRV1|YN_PU|YN_SL|YP_CS|YP_IE|YP_PD|YP_PDRV0|YP_PDRV1|YP_PU|YP_SL|ZN_CS|ZN_IE|ZN_PD|ZN_PDRV0|ZN_PDRV1|ZN_PU|ZN_SL|ZP_CS|ZP_IE|ZP_PD|ZP_PDRV0|ZP_PDRV1|ZP_PU|ZP_SL
+ VSS|XN_CS|XN_IE|XN_PD|XN_PDRV0|XN_PDRV1|XN_PU|XN_SL|XP_CS|XP_IE|XP_PD|XP_PDRV0|XP_PDRV1|XP_PU|XP_SL|YN_CS|YN_IE|YN_PD|YN_PDRV0|YN_PDRV1|YN_PU|YN_SL|YP_CS|YP_IE|YP_PD|YP_PDRV0|YP_PDRV1|YP_PU|YP_SL|ZN_CS|ZN_IE|ZN_PD|ZN_PDRV0|ZN_PDRV1|ZN_PU|ZN_SL|ZP_CS|ZP_IE|ZP_PD|ZP_PDRV0|ZP_PDRV1|ZP_PU|ZP_SL
+ nfet_06v0 L=1U W=5U AS=2.2P AD=1.25P PS=10.88U PD=5.5U
M$1463 \$9072 \$9098 \$9144
+ VSS|XN_CS|XN_IE|XN_PD|XN_PDRV0|XN_PDRV1|XN_PU|XN_SL|XP_CS|XP_IE|XP_PD|XP_PDRV0|XP_PDRV1|XP_PU|XP_SL|YN_CS|YN_IE|YN_PD|YN_PDRV0|YN_PDRV1|YN_PU|YN_SL|YP_CS|YP_IE|YP_PD|YP_PDRV0|YP_PDRV1|YP_PU|YP_SL|ZN_CS|ZN_IE|ZN_PD|ZN_PDRV0|ZN_PDRV1|ZN_PU|ZN_SL|ZP_CS|ZP_IE|ZP_PD|ZP_PDRV0|ZP_PDRV1|ZP_PU|ZP_SL
+ nfet_06v0 L=1U W=5U AS=1.25P AD=2.2P PS=5.5U PD=10.88U
M$1464 \$9118 \$9705
+ VSS|XN_CS|XN_IE|XN_PD|XN_PDRV0|XN_PDRV1|XN_PU|XN_SL|XP_CS|XP_IE|XP_PD|XP_PDRV0|XP_PDRV1|XP_PU|XP_SL|YN_CS|YN_IE|YN_PD|YN_PDRV0|YN_PDRV1|YN_PU|YN_SL|YP_CS|YP_IE|YP_PD|YP_PDRV0|YP_PDRV1|YP_PU|YP_SL|ZN_CS|ZN_IE|ZN_PD|ZN_PDRV0|ZN_PDRV1|ZN_PU|ZN_SL|ZP_CS|ZP_IE|ZP_PD|ZP_PDRV0|ZP_PDRV1|ZP_PU|ZP_SL
+ VSS|XN_CS|XN_IE|XN_PD|XN_PDRV0|XN_PDRV1|XN_PU|XN_SL|XP_CS|XP_IE|XP_PD|XP_PDRV0|XP_PDRV1|XP_PU|XP_SL|YN_CS|YN_IE|YN_PD|YN_PDRV0|YN_PDRV1|YN_PU|YN_SL|YP_CS|YP_IE|YP_PD|YP_PDRV0|YP_PDRV1|YP_PU|YP_SL|ZN_CS|ZN_IE|ZN_PD|ZN_PDRV0|ZN_PDRV1|ZN_PU|ZN_SL|ZP_CS|ZP_IE|ZP_PD|ZP_PDRV0|ZP_PDRV1|ZP_PU|ZP_SL
+ nfet_06v0 L=1U W=1U AS=0.44P AD=0.25P PS=2.88U PD=1.5U
M$1465 \$9624 \$9705 \$9118
+ VSS|XN_CS|XN_IE|XN_PD|XN_PDRV0|XN_PDRV1|XN_PU|XN_SL|XP_CS|XP_IE|XP_PD|XP_PDRV0|XP_PDRV1|XP_PU|XP_SL|YN_CS|YN_IE|YN_PD|YN_PDRV0|YN_PDRV1|YN_PU|YN_SL|YP_CS|YP_IE|YP_PD|YP_PDRV0|YP_PDRV1|YP_PU|YP_SL|ZN_CS|ZN_IE|ZN_PD|ZN_PDRV0|ZN_PDRV1|ZN_PU|ZN_SL|ZP_CS|ZP_IE|ZP_PD|ZP_PDRV0|ZP_PDRV1|ZP_PU|ZP_SL
+ nfet_06v0 L=1U W=1U AS=0.25P AD=0.44P PS=1.5U PD=2.88U
M$1466 \$9117 \$9705
+ VSS|XN_CS|XN_IE|XN_PD|XN_PDRV0|XN_PDRV1|XN_PU|XN_SL|XP_CS|XP_IE|XP_PD|XP_PDRV0|XP_PDRV1|XP_PU|XP_SL|YN_CS|YN_IE|YN_PD|YN_PDRV0|YN_PDRV1|YN_PU|YN_SL|YP_CS|YP_IE|YP_PD|YP_PDRV0|YP_PDRV1|YP_PU|YP_SL|ZN_CS|ZN_IE|ZN_PD|ZN_PDRV0|ZN_PDRV1|ZN_PU|ZN_SL|ZP_CS|ZP_IE|ZP_PD|ZP_PDRV0|ZP_PDRV1|ZP_PU|ZP_SL
+ VSS|XN_CS|XN_IE|XN_PD|XN_PDRV0|XN_PDRV1|XN_PU|XN_SL|XP_CS|XP_IE|XP_PD|XP_PDRV0|XP_PDRV1|XP_PU|XP_SL|YN_CS|YN_IE|YN_PD|YN_PDRV0|YN_PDRV1|YN_PU|YN_SL|YP_CS|YP_IE|YP_PD|YP_PDRV0|YP_PDRV1|YP_PU|YP_SL|ZN_CS|ZN_IE|ZN_PD|ZN_PDRV0|ZN_PDRV1|ZN_PU|ZN_SL|ZP_CS|ZP_IE|ZP_PD|ZP_PDRV0|ZP_PDRV1|ZP_PU|ZP_SL
+ nfet_06v0 L=1U W=1U AS=0.44P AD=0.25P PS=2.88U PD=1.5U
M$1467 \$9705 \$9705 \$9117
+ VSS|XN_CS|XN_IE|XN_PD|XN_PDRV0|XN_PDRV1|XN_PU|XN_SL|XP_CS|XP_IE|XP_PD|XP_PDRV0|XP_PDRV1|XP_PU|XP_SL|YN_CS|YN_IE|YN_PD|YN_PDRV0|YN_PDRV1|YN_PU|YN_SL|YP_CS|YP_IE|YP_PD|YP_PDRV0|YP_PDRV1|YP_PU|YP_SL|ZN_CS|ZN_IE|ZN_PD|ZN_PDRV0|ZN_PDRV1|ZN_PU|ZN_SL|ZP_CS|ZP_IE|ZP_PD|ZP_PDRV0|ZP_PDRV1|ZP_PU|ZP_SL
+ nfet_06v0 L=1U W=1U AS=0.25P AD=0.44P PS=1.5U PD=2.88U
M$1468 \$9145 \$9072
+ VSS|XN_CS|XN_IE|XN_PD|XN_PDRV0|XN_PDRV1|XN_PU|XN_SL|XP_CS|XP_IE|XP_PD|XP_PDRV0|XP_PDRV1|XP_PU|XP_SL|YN_CS|YN_IE|YN_PD|YN_PDRV0|YN_PDRV1|YN_PU|YN_SL|YP_CS|YP_IE|YP_PD|YP_PDRV0|YP_PDRV1|YP_PU|YP_SL|ZN_CS|ZN_IE|ZN_PD|ZN_PDRV0|ZN_PDRV1|ZN_PU|ZN_SL|ZP_CS|ZP_IE|ZP_PD|ZP_PDRV0|ZP_PDRV1|ZP_PU|ZP_SL
+ VSS|XN_CS|XN_IE|XN_PD|XN_PDRV0|XN_PDRV1|XN_PU|XN_SL|XP_CS|XP_IE|XP_PD|XP_PDRV0|XP_PDRV1|XP_PU|XP_SL|YN_CS|YN_IE|YN_PD|YN_PDRV0|YN_PDRV1|YN_PU|YN_SL|YP_CS|YP_IE|YP_PD|YP_PDRV0|YP_PDRV1|YP_PU|YP_SL|ZN_CS|ZN_IE|ZN_PD|ZN_PDRV0|ZN_PDRV1|ZN_PU|ZN_SL|ZP_CS|ZP_IE|ZP_PD|ZP_PDRV0|ZP_PDRV1|ZP_PU|ZP_SL
+ nfet_06v0 L=1U W=5U AS=2.2P AD=1.25P PS=10.88U PD=5.5U
M$1469 \$9099 \$9098 \$9145
+ VSS|XN_CS|XN_IE|XN_PD|XN_PDRV0|XN_PDRV1|XN_PU|XN_SL|XP_CS|XP_IE|XP_PD|XP_PDRV0|XP_PDRV1|XP_PU|XP_SL|YN_CS|YN_IE|YN_PD|YN_PDRV0|YN_PDRV1|YN_PU|YN_SL|YP_CS|YP_IE|YP_PD|YP_PDRV0|YP_PDRV1|YP_PU|YP_SL|ZN_CS|ZN_IE|ZN_PD|ZN_PDRV0|ZN_PDRV1|ZN_PU|ZN_SL|ZP_CS|ZP_IE|ZP_PD|ZP_PDRV0|ZP_PDRV1|ZP_PU|ZP_SL
+ nfet_06v0 L=1U W=5U AS=1.25P AD=1.65P PS=5.5U PD=5.66U
M$1470 \$9146 \$9098 \$9099
+ VSS|XN_CS|XN_IE|XN_PD|XN_PDRV0|XN_PDRV1|XN_PU|XN_SL|XP_CS|XP_IE|XP_PD|XP_PDRV0|XP_PDRV1|XP_PU|XP_SL|YN_CS|YN_IE|YN_PD|YN_PDRV0|YN_PDRV1|YN_PU|YN_SL|YP_CS|YP_IE|YP_PD|YP_PDRV0|YP_PDRV1|YP_PU|YP_SL|ZN_CS|ZN_IE|ZN_PD|ZN_PDRV0|ZN_PDRV1|ZN_PU|ZN_SL|ZP_CS|ZP_IE|ZP_PD|ZP_PDRV0|ZP_PDRV1|ZP_PU|ZP_SL
+ nfet_06v0 L=1U W=5U AS=1.65P AD=1.25P PS=5.66U PD=5.5U
M$1471
+ VSS|XN_CS|XN_IE|XN_PD|XN_PDRV0|XN_PDRV1|XN_PU|XN_SL|XP_CS|XP_IE|XP_PD|XP_PDRV0|XP_PDRV1|XP_PU|XP_SL|YN_CS|YN_IE|YN_PD|YN_PDRV0|YN_PDRV1|YN_PU|YN_SL|YP_CS|YP_IE|YP_PD|YP_PDRV0|YP_PDRV1|YP_PU|YP_SL|ZN_CS|ZN_IE|ZN_PD|ZN_PDRV0|ZN_PDRV1|ZN_PU|ZN_SL|ZP_CS|ZP_IE|ZP_PD|ZP_PDRV0|ZP_PDRV1|ZP_PU|ZP_SL
+ \$9072 \$9146
+ VSS|XN_CS|XN_IE|XN_PD|XN_PDRV0|XN_PDRV1|XN_PU|XN_SL|XP_CS|XP_IE|XP_PD|XP_PDRV0|XP_PDRV1|XP_PU|XP_SL|YN_CS|YN_IE|YN_PD|YN_PDRV0|YN_PDRV1|YN_PU|YN_SL|YP_CS|YP_IE|YP_PD|YP_PDRV0|YP_PDRV1|YP_PU|YP_SL|ZN_CS|ZN_IE|ZN_PD|ZN_PDRV0|ZN_PDRV1|ZN_PU|ZN_SL|ZP_CS|ZP_IE|ZP_PD|ZP_PDRV0|ZP_PDRV1|ZP_PU|ZP_SL
+ nfet_06v0 L=1U W=5U AS=1.25P AD=2.2P PS=5.5U PD=10.88U
M$1472 \$9100 \$2441 \$9099
+ VSS|XN_CS|XN_IE|XN_PD|XN_PDRV0|XN_PDRV1|XN_PU|XN_SL|XP_CS|XP_IE|XP_PD|XP_PDRV0|XP_PDRV1|XP_PU|XP_SL|YN_CS|YN_IE|YN_PD|YN_PDRV0|YN_PDRV1|YN_PU|YN_SL|YP_CS|YP_IE|YP_PD|YP_PDRV0|YP_PDRV1|YP_PU|YP_SL|ZN_CS|ZN_IE|ZN_PD|ZN_PDRV0|ZN_PDRV1|ZN_PU|ZN_SL|ZP_CS|ZP_IE|ZP_PD|ZP_PDRV0|ZP_PDRV1|ZP_PU|ZP_SL
+ nfet_06v0 L=1U W=5U AS=2.2P AD=1.3P PS=10.88U PD=5.52U
M$1473 \$9099 \$2441 \$9100
+ VSS|XN_CS|XN_IE|XN_PD|XN_PDRV0|XN_PDRV1|XN_PU|XN_SL|XP_CS|XP_IE|XP_PD|XP_PDRV0|XP_PDRV1|XP_PU|XP_SL|YN_CS|YN_IE|YN_PD|YN_PDRV0|YN_PDRV1|YN_PU|YN_SL|YP_CS|YP_IE|YP_PD|YP_PDRV0|YP_PDRV1|YP_PU|YP_SL|ZN_CS|ZN_IE|ZN_PD|ZN_PDRV0|ZN_PDRV1|ZN_PU|ZN_SL|ZP_CS|ZP_IE|ZP_PD|ZP_PDRV0|ZP_PDRV1|ZP_PU|ZP_SL
+ nfet_06v0 L=1U W=5U AS=1.3P AD=2.2P PS=5.52U PD=10.88U
M$1474 \$9101 \$54 \$9099
+ VSS|XN_CS|XN_IE|XN_PD|XN_PDRV0|XN_PDRV1|XN_PU|XN_SL|XP_CS|XP_IE|XP_PD|XP_PDRV0|XP_PDRV1|XP_PU|XP_SL|YN_CS|YN_IE|YN_PD|YN_PDRV0|YN_PDRV1|YN_PU|YN_SL|YP_CS|YP_IE|YP_PD|YP_PDRV0|YP_PDRV1|YP_PU|YP_SL|ZN_CS|ZN_IE|ZN_PD|ZN_PDRV0|ZN_PDRV1|ZN_PU|ZN_SL|ZP_CS|ZP_IE|ZP_PD|ZP_PDRV0|ZP_PDRV1|ZP_PU|ZP_SL
+ nfet_06v0 L=1U W=5U AS=2.2P AD=1.3P PS=10.88U PD=5.52U
M$1475 \$9099 \$54 \$9101
+ VSS|XN_CS|XN_IE|XN_PD|XN_PDRV0|XN_PDRV1|XN_PU|XN_SL|XP_CS|XP_IE|XP_PD|XP_PDRV0|XP_PDRV1|XP_PU|XP_SL|YN_CS|YN_IE|YN_PD|YN_PDRV0|YN_PDRV1|YN_PU|YN_SL|YP_CS|YP_IE|YP_PD|YP_PDRV0|YP_PDRV1|YP_PU|YP_SL|ZN_CS|ZN_IE|ZN_PD|ZN_PDRV0|ZN_PDRV1|ZN_PU|ZN_SL|ZP_CS|ZP_IE|ZP_PD|ZP_PDRV0|ZP_PDRV1|ZP_PU|ZP_SL
+ nfet_06v0 L=1U W=5U AS=1.3P AD=2.2P PS=5.52U PD=10.88U
M$1476 \$9103 \$9098 \$9102
+ VSS|XN_CS|XN_IE|XN_PD|XN_PDRV0|XN_PDRV1|XN_PU|XN_SL|XP_CS|XP_IE|XP_PD|XP_PDRV0|XP_PDRV1|XP_PU|XP_SL|YN_CS|YN_IE|YN_PD|YN_PDRV0|YN_PDRV1|YN_PU|YN_SL|YP_CS|YP_IE|YP_PD|YP_PDRV0|YP_PDRV1|YP_PU|YP_SL|ZN_CS|ZN_IE|ZN_PD|ZN_PDRV0|ZN_PDRV1|ZN_PU|ZN_SL|ZP_CS|ZP_IE|ZP_PD|ZP_PDRV0|ZP_PDRV1|ZP_PU|ZP_SL
+ nfet_06v0 L=1U W=2.5U AS=1.1P AD=0.65P PS=5.88U PD=3.02U
M$1477 \$9102 \$9098 \$9103
+ VSS|XN_CS|XN_IE|XN_PD|XN_PDRV0|XN_PDRV1|XN_PU|XN_SL|XP_CS|XP_IE|XP_PD|XP_PDRV0|XP_PDRV1|XP_PU|XP_SL|YN_CS|YN_IE|YN_PD|YN_PDRV0|YN_PDRV1|YN_PU|YN_SL|YP_CS|YP_IE|YP_PD|YP_PDRV0|YP_PDRV1|YP_PU|YP_SL|ZN_CS|ZN_IE|ZN_PD|ZN_PDRV0|ZN_PDRV1|ZN_PU|ZN_SL|ZP_CS|ZP_IE|ZP_PD|ZP_PDRV0|ZP_PDRV1|ZP_PU|ZP_SL
+ nfet_06v0 L=1U W=2.5U AS=0.65P AD=1.1P PS=3.02U PD=5.88U
M$1478 \$9105 \$9098 \$9104
+ VSS|XN_CS|XN_IE|XN_PD|XN_PDRV0|XN_PDRV1|XN_PU|XN_SL|XP_CS|XP_IE|XP_PD|XP_PDRV0|XP_PDRV1|XP_PU|XP_SL|YN_CS|YN_IE|YN_PD|YN_PDRV0|YN_PDRV1|YN_PU|YN_SL|YP_CS|YP_IE|YP_PD|YP_PDRV0|YP_PDRV1|YP_PU|YP_SL|ZN_CS|ZN_IE|ZN_PD|ZN_PDRV0|ZN_PDRV1|ZN_PU|ZN_SL|ZP_CS|ZP_IE|ZP_PD|ZP_PDRV0|ZP_PDRV1|ZP_PU|ZP_SL
+ nfet_06v0 L=1U W=2.5U AS=1.1P AD=0.65P PS=5.88U PD=3.02U
M$1479 \$9104 \$9098 \$9105
+ VSS|XN_CS|XN_IE|XN_PD|XN_PDRV0|XN_PDRV1|XN_PU|XN_SL|XP_CS|XP_IE|XP_PD|XP_PDRV0|XP_PDRV1|XP_PU|XP_SL|YN_CS|YN_IE|YN_PD|YN_PDRV0|YN_PDRV1|YN_PU|YN_SL|YP_CS|YP_IE|YP_PD|YP_PDRV0|YP_PDRV1|YP_PU|YP_SL|ZN_CS|ZN_IE|ZN_PD|ZN_PDRV0|ZN_PDRV1|ZN_PU|ZN_SL|ZP_CS|ZP_IE|ZP_PD|ZP_PDRV0|ZP_PDRV1|ZP_PU|ZP_SL
+ nfet_06v0 L=1U W=2.5U AS=0.65P AD=1.1P PS=3.02U PD=5.88U
M$1480 \$9102 \$9103
+ VSS|XN_CS|XN_IE|XN_PD|XN_PDRV0|XN_PDRV1|XN_PU|XN_SL|XP_CS|XP_IE|XP_PD|XP_PDRV0|XP_PDRV1|XP_PU|XP_SL|YN_CS|YN_IE|YN_PD|YN_PDRV0|YN_PDRV1|YN_PU|YN_SL|YP_CS|YP_IE|YP_PD|YP_PDRV0|YP_PDRV1|YP_PU|YP_SL|ZN_CS|ZN_IE|ZN_PD|ZN_PDRV0|ZN_PDRV1|ZN_PU|ZN_SL|ZP_CS|ZP_IE|ZP_PD|ZP_PDRV0|ZP_PDRV1|ZP_PU|ZP_SL
+ VSS|XN_CS|XN_IE|XN_PD|XN_PDRV0|XN_PDRV1|XN_PU|XN_SL|XP_CS|XP_IE|XP_PD|XP_PDRV0|XP_PDRV1|XP_PU|XP_SL|YN_CS|YN_IE|YN_PD|YN_PDRV0|YN_PDRV1|YN_PU|YN_SL|YP_CS|YP_IE|YP_PD|YP_PDRV0|YP_PDRV1|YP_PU|YP_SL|ZN_CS|ZN_IE|ZN_PD|ZN_PDRV0|ZN_PDRV1|ZN_PU|ZN_SL|ZP_CS|ZP_IE|ZP_PD|ZP_PDRV0|ZP_PDRV1|ZP_PU|ZP_SL
+ nfet_06v0 L=1U W=2.5U AS=1.1P AD=0.65P PS=5.88U PD=3.02U
M$1481
+ VSS|XN_CS|XN_IE|XN_PD|XN_PDRV0|XN_PDRV1|XN_PU|XN_SL|XP_CS|XP_IE|XP_PD|XP_PDRV0|XP_PDRV1|XP_PU|XP_SL|YN_CS|YN_IE|YN_PD|YN_PDRV0|YN_PDRV1|YN_PU|YN_SL|YP_CS|YP_IE|YP_PD|YP_PDRV0|YP_PDRV1|YP_PU|YP_SL|ZN_CS|ZN_IE|ZN_PD|ZN_PDRV0|ZN_PDRV1|ZN_PU|ZN_SL|ZP_CS|ZP_IE|ZP_PD|ZP_PDRV0|ZP_PDRV1|ZP_PU|ZP_SL
+ \$9103 \$9102
+ VSS|XN_CS|XN_IE|XN_PD|XN_PDRV0|XN_PDRV1|XN_PU|XN_SL|XP_CS|XP_IE|XP_PD|XP_PDRV0|XP_PDRV1|XP_PU|XP_SL|YN_CS|YN_IE|YN_PD|YN_PDRV0|YN_PDRV1|YN_PU|YN_SL|YP_CS|YP_IE|YP_PD|YP_PDRV0|YP_PDRV1|YP_PU|YP_SL|ZN_CS|ZN_IE|ZN_PD|ZN_PDRV0|ZN_PDRV1|ZN_PU|ZN_SL|ZP_CS|ZP_IE|ZP_PD|ZP_PDRV0|ZP_PDRV1|ZP_PU|ZP_SL
+ nfet_06v0 L=1U W=2.5U AS=0.65P AD=0.65P PS=3.02U PD=3.02U
M$1482 \$9102 \$9103
+ VSS|XN_CS|XN_IE|XN_PD|XN_PDRV0|XN_PDRV1|XN_PU|XN_SL|XP_CS|XP_IE|XP_PD|XP_PDRV0|XP_PDRV1|XP_PU|XP_SL|YN_CS|YN_IE|YN_PD|YN_PDRV0|YN_PDRV1|YN_PU|YN_SL|YP_CS|YP_IE|YP_PD|YP_PDRV0|YP_PDRV1|YP_PU|YP_SL|ZN_CS|ZN_IE|ZN_PD|ZN_PDRV0|ZN_PDRV1|ZN_PU|ZN_SL|ZP_CS|ZP_IE|ZP_PD|ZP_PDRV0|ZP_PDRV1|ZP_PU|ZP_SL
+ VSS|XN_CS|XN_IE|XN_PD|XN_PDRV0|XN_PDRV1|XN_PU|XN_SL|XP_CS|XP_IE|XP_PD|XP_PDRV0|XP_PDRV1|XP_PU|XP_SL|YN_CS|YN_IE|YN_PD|YN_PDRV0|YN_PDRV1|YN_PU|YN_SL|YP_CS|YP_IE|YP_PD|YP_PDRV0|YP_PDRV1|YP_PU|YP_SL|ZN_CS|ZN_IE|ZN_PD|ZN_PDRV0|ZN_PDRV1|ZN_PU|ZN_SL|ZP_CS|ZP_IE|ZP_PD|ZP_PDRV0|ZP_PDRV1|ZP_PU|ZP_SL
+ nfet_06v0 L=1U W=2.5U AS=0.65P AD=0.65P PS=3.02U PD=3.02U
M$1483
+ VSS|XN_CS|XN_IE|XN_PD|XN_PDRV0|XN_PDRV1|XN_PU|XN_SL|XP_CS|XP_IE|XP_PD|XP_PDRV0|XP_PDRV1|XP_PU|XP_SL|YN_CS|YN_IE|YN_PD|YN_PDRV0|YN_PDRV1|YN_PU|YN_SL|YP_CS|YP_IE|YP_PD|YP_PDRV0|YP_PDRV1|YP_PU|YP_SL|ZN_CS|ZN_IE|ZN_PD|ZN_PDRV0|ZN_PDRV1|ZN_PU|ZN_SL|ZP_CS|ZP_IE|ZP_PD|ZP_PDRV0|ZP_PDRV1|ZP_PU|ZP_SL
+ \$9103 \$9102
+ VSS|XN_CS|XN_IE|XN_PD|XN_PDRV0|XN_PDRV1|XN_PU|XN_SL|XP_CS|XP_IE|XP_PD|XP_PDRV0|XP_PDRV1|XP_PU|XP_SL|YN_CS|YN_IE|YN_PD|YN_PDRV0|YN_PDRV1|YN_PU|YN_SL|YP_CS|YP_IE|YP_PD|YP_PDRV0|YP_PDRV1|YP_PU|YP_SL|ZN_CS|ZN_IE|ZN_PD|ZN_PDRV0|ZN_PDRV1|ZN_PU|ZN_SL|ZP_CS|ZP_IE|ZP_PD|ZP_PDRV0|ZP_PDRV1|ZP_PU|ZP_SL
+ nfet_06v0 L=1U W=2.5U AS=0.65P AD=1.1P PS=3.02U PD=5.88U
M$1484 \$9104 \$9103
+ VSS|XN_CS|XN_IE|XN_PD|XN_PDRV0|XN_PDRV1|XN_PU|XN_SL|XP_CS|XP_IE|XP_PD|XP_PDRV0|XP_PDRV1|XP_PU|XP_SL|YN_CS|YN_IE|YN_PD|YN_PDRV0|YN_PDRV1|YN_PU|YN_SL|YP_CS|YP_IE|YP_PD|YP_PDRV0|YP_PDRV1|YP_PU|YP_SL|ZN_CS|ZN_IE|ZN_PD|ZN_PDRV0|ZN_PDRV1|ZN_PU|ZN_SL|ZP_CS|ZP_IE|ZP_PD|ZP_PDRV0|ZP_PDRV1|ZP_PU|ZP_SL
+ VSS|XN_CS|XN_IE|XN_PD|XN_PDRV0|XN_PDRV1|XN_PU|XN_SL|XP_CS|XP_IE|XP_PD|XP_PDRV0|XP_PDRV1|XP_PU|XP_SL|YN_CS|YN_IE|YN_PD|YN_PDRV0|YN_PDRV1|YN_PU|YN_SL|YP_CS|YP_IE|YP_PD|YP_PDRV0|YP_PDRV1|YP_PU|YP_SL|ZN_CS|ZN_IE|ZN_PD|ZN_PDRV0|ZN_PDRV1|ZN_PU|ZN_SL|ZP_CS|ZP_IE|ZP_PD|ZP_PDRV0|ZP_PDRV1|ZP_PU|ZP_SL
+ nfet_06v0 L=1U W=2.5U AS=1.1P AD=0.65P PS=5.88U PD=3.02U
M$1485
+ VSS|XN_CS|XN_IE|XN_PD|XN_PDRV0|XN_PDRV1|XN_PU|XN_SL|XP_CS|XP_IE|XP_PD|XP_PDRV0|XP_PDRV1|XP_PU|XP_SL|YN_CS|YN_IE|YN_PD|YN_PDRV0|YN_PDRV1|YN_PU|YN_SL|YP_CS|YP_IE|YP_PD|YP_PDRV0|YP_PDRV1|YP_PU|YP_SL|ZN_CS|ZN_IE|ZN_PD|ZN_PDRV0|ZN_PDRV1|ZN_PU|ZN_SL|ZP_CS|ZP_IE|ZP_PD|ZP_PDRV0|ZP_PDRV1|ZP_PU|ZP_SL
+ \$9103 \$9104
+ VSS|XN_CS|XN_IE|XN_PD|XN_PDRV0|XN_PDRV1|XN_PU|XN_SL|XP_CS|XP_IE|XP_PD|XP_PDRV0|XP_PDRV1|XP_PU|XP_SL|YN_CS|YN_IE|YN_PD|YN_PDRV0|YN_PDRV1|YN_PU|YN_SL|YP_CS|YP_IE|YP_PD|YP_PDRV0|YP_PDRV1|YP_PU|YP_SL|ZN_CS|ZN_IE|ZN_PD|ZN_PDRV0|ZN_PDRV1|ZN_PU|ZN_SL|ZP_CS|ZP_IE|ZP_PD|ZP_PDRV0|ZP_PDRV1|ZP_PU|ZP_SL
+ nfet_06v0 L=1U W=2.5U AS=0.65P AD=0.65P PS=3.02U PD=3.02U
M$1486 \$9104 \$9103
+ VSS|XN_CS|XN_IE|XN_PD|XN_PDRV0|XN_PDRV1|XN_PU|XN_SL|XP_CS|XP_IE|XP_PD|XP_PDRV0|XP_PDRV1|XP_PU|XP_SL|YN_CS|YN_IE|YN_PD|YN_PDRV0|YN_PDRV1|YN_PU|YN_SL|YP_CS|YP_IE|YP_PD|YP_PDRV0|YP_PDRV1|YP_PU|YP_SL|ZN_CS|ZN_IE|ZN_PD|ZN_PDRV0|ZN_PDRV1|ZN_PU|ZN_SL|ZP_CS|ZP_IE|ZP_PD|ZP_PDRV0|ZP_PDRV1|ZP_PU|ZP_SL
+ VSS|XN_CS|XN_IE|XN_PD|XN_PDRV0|XN_PDRV1|XN_PU|XN_SL|XP_CS|XP_IE|XP_PD|XP_PDRV0|XP_PDRV1|XP_PU|XP_SL|YN_CS|YN_IE|YN_PD|YN_PDRV0|YN_PDRV1|YN_PU|YN_SL|YP_CS|YP_IE|YP_PD|YP_PDRV0|YP_PDRV1|YP_PU|YP_SL|ZN_CS|ZN_IE|ZN_PD|ZN_PDRV0|ZN_PDRV1|ZN_PU|ZN_SL|ZP_CS|ZP_IE|ZP_PD|ZP_PDRV0|ZP_PDRV1|ZP_PU|ZP_SL
+ nfet_06v0 L=1U W=2.5U AS=0.65P AD=0.65P PS=3.02U PD=3.02U
M$1487
+ VSS|XN_CS|XN_IE|XN_PD|XN_PDRV0|XN_PDRV1|XN_PU|XN_SL|XP_CS|XP_IE|XP_PD|XP_PDRV0|XP_PDRV1|XP_PU|XP_SL|YN_CS|YN_IE|YN_PD|YN_PDRV0|YN_PDRV1|YN_PU|YN_SL|YP_CS|YP_IE|YP_PD|YP_PDRV0|YP_PDRV1|YP_PU|YP_SL|ZN_CS|ZN_IE|ZN_PD|ZN_PDRV0|ZN_PDRV1|ZN_PU|ZN_SL|ZP_CS|ZP_IE|ZP_PD|ZP_PDRV0|ZP_PDRV1|ZP_PU|ZP_SL
+ \$9103 \$9104
+ VSS|XN_CS|XN_IE|XN_PD|XN_PDRV0|XN_PDRV1|XN_PU|XN_SL|XP_CS|XP_IE|XP_PD|XP_PDRV0|XP_PDRV1|XP_PU|XP_SL|YN_CS|YN_IE|YN_PD|YN_PDRV0|YN_PDRV1|YN_PU|YN_SL|YP_CS|YP_IE|YP_PD|YP_PDRV0|YP_PDRV1|YP_PU|YP_SL|ZN_CS|ZN_IE|ZN_PD|ZN_PDRV0|ZN_PDRV1|ZN_PU|ZN_SL|ZP_CS|ZP_IE|ZP_PD|ZP_PDRV0|ZP_PDRV1|ZP_PU|ZP_SL
+ nfet_06v0 L=1U W=2.5U AS=0.65P AD=1.1P PS=3.02U PD=5.88U
M$1488 \$9169 \$9121 \$9103
+ VSS|XN_CS|XN_IE|XN_PD|XN_PDRV0|XN_PDRV1|XN_PU|XN_SL|XP_CS|XP_IE|XP_PD|XP_PDRV0|XP_PDRV1|XP_PU|XP_SL|YN_CS|YN_IE|YN_PD|YN_PDRV0|YN_PDRV1|YN_PU|YN_SL|YP_CS|YP_IE|YP_PD|YP_PDRV0|YP_PDRV1|YP_PU|YP_SL|ZN_CS|ZN_IE|ZN_PD|ZN_PDRV0|ZN_PDRV1|ZN_PU|ZN_SL|ZP_CS|ZP_IE|ZP_PD|ZP_PDRV0|ZP_PDRV1|ZP_PU|ZP_SL
+ nfet_06v0 L=1U W=2.5U AS=1.1P AD=1.1P PS=5.88U PD=5.88U
M$1489 \$9073 \$9121 \$9105
+ VSS|XN_CS|XN_IE|XN_PD|XN_PDRV0|XN_PDRV1|XN_PU|XN_SL|XP_CS|XP_IE|XP_PD|XP_PDRV0|XP_PDRV1|XP_PU|XP_SL|YN_CS|YN_IE|YN_PD|YN_PDRV0|YN_PDRV1|YN_PU|YN_SL|YP_CS|YP_IE|YP_PD|YP_PDRV0|YP_PDRV1|YP_PU|YP_SL|ZN_CS|ZN_IE|ZN_PD|ZN_PDRV0|ZN_PDRV1|ZN_PU|ZN_SL|ZP_CS|ZP_IE|ZP_PD|ZP_PDRV0|ZP_PDRV1|ZP_PU|ZP_SL
+ nfet_06v0 L=1U W=2.5U AS=1.1P AD=1.1P PS=5.88U PD=5.88U
M$1490 \$9143 \$9072
+ VSS|XN_CS|XN_IE|XN_PD|XN_PDRV0|XN_PDRV1|XN_PU|XN_SL|XP_CS|XP_IE|XP_PD|XP_PDRV0|XP_PDRV1|XP_PU|XP_SL|YN_CS|YN_IE|YN_PD|YN_PDRV0|YN_PDRV1|YN_PU|YN_SL|YP_CS|YP_IE|YP_PD|YP_PDRV0|YP_PDRV1|YP_PU|YP_SL|ZN_CS|ZN_IE|ZN_PD|ZN_PDRV0|ZN_PDRV1|ZN_PU|ZN_SL|ZP_CS|ZP_IE|ZP_PD|ZP_PDRV0|ZP_PDRV1|ZP_PU|ZP_SL
+ VSS|XN_CS|XN_IE|XN_PD|XN_PDRV0|XN_PDRV1|XN_PU|XN_SL|XP_CS|XP_IE|XP_PD|XP_PDRV0|XP_PDRV1|XP_PU|XP_SL|YN_CS|YN_IE|YN_PD|YN_PDRV0|YN_PDRV1|YN_PU|YN_SL|YP_CS|YP_IE|YP_PD|YP_PDRV0|YP_PDRV1|YP_PU|YP_SL|ZN_CS|ZN_IE|ZN_PD|ZN_PDRV0|ZN_PDRV1|ZN_PU|ZN_SL|ZP_CS|ZP_IE|ZP_PD|ZP_PDRV0|ZP_PDRV1|ZP_PU|ZP_SL
+ nfet_06v0 L=1U W=5U AS=2.2P AD=1.25P PS=10.88U PD=5.5U
M$1491 \$9074 \$9098 \$9143
+ VSS|XN_CS|XN_IE|XN_PD|XN_PDRV0|XN_PDRV1|XN_PU|XN_SL|XP_CS|XP_IE|XP_PD|XP_PDRV0|XP_PDRV1|XP_PU|XP_SL|YN_CS|YN_IE|YN_PD|YN_PDRV0|YN_PDRV1|YN_PU|YN_SL|YP_CS|YP_IE|YP_PD|YP_PDRV0|YP_PDRV1|YP_PU|YP_SL|ZN_CS|ZN_IE|ZN_PD|ZN_PDRV0|ZN_PDRV1|ZN_PU|ZN_SL|ZP_CS|ZP_IE|ZP_PD|ZP_PDRV0|ZP_PDRV1|ZP_PU|ZP_SL
+ nfet_06v0 L=1U W=5U AS=1.25P AD=2.2P PS=5.5U PD=10.88U
M$1492 \$9142 \$9075
+ VSS|XN_CS|XN_IE|XN_PD|XN_PDRV0|XN_PDRV1|XN_PU|XN_SL|XP_CS|XP_IE|XP_PD|XP_PDRV0|XP_PDRV1|XP_PU|XP_SL|YN_CS|YN_IE|YN_PD|YN_PDRV0|YN_PDRV1|YN_PU|YN_SL|YP_CS|YP_IE|YP_PD|YP_PDRV0|YP_PDRV1|YP_PU|YP_SL|ZN_CS|ZN_IE|ZN_PD|ZN_PDRV0|ZN_PDRV1|ZN_PU|ZN_SL|ZP_CS|ZP_IE|ZP_PD|ZP_PDRV0|ZP_PDRV1|ZP_PU|ZP_SL
+ VSS|XN_CS|XN_IE|XN_PD|XN_PDRV0|XN_PDRV1|XN_PU|XN_SL|XP_CS|XP_IE|XP_PD|XP_PDRV0|XP_PDRV1|XP_PU|XP_SL|YN_CS|YN_IE|YN_PD|YN_PDRV0|YN_PDRV1|YN_PU|YN_SL|YP_CS|YP_IE|YP_PD|YP_PDRV0|YP_PDRV1|YP_PU|YP_SL|ZN_CS|ZN_IE|ZN_PD|ZN_PDRV0|ZN_PDRV1|ZN_PU|ZN_SL|ZP_CS|ZP_IE|ZP_PD|ZP_PDRV0|ZP_PDRV1|ZP_PU|ZP_SL
+ nfet_06v0 L=1U W=5U AS=2.2P AD=1.25P PS=10.88U PD=5.5U
M$1493 \$9075 \$9098 \$9142
+ VSS|XN_CS|XN_IE|XN_PD|XN_PDRV0|XN_PDRV1|XN_PU|XN_SL|XP_CS|XP_IE|XP_PD|XP_PDRV0|XP_PDRV1|XP_PU|XP_SL|YN_CS|YN_IE|YN_PD|YN_PDRV0|YN_PDRV1|YN_PU|YN_SL|YP_CS|YP_IE|YP_PD|YP_PDRV0|YP_PDRV1|YP_PU|YP_SL|ZN_CS|ZN_IE|ZN_PD|ZN_PDRV0|ZN_PDRV1|ZN_PU|ZN_SL|ZP_CS|ZP_IE|ZP_PD|ZP_PDRV0|ZP_PDRV1|ZP_PU|ZP_SL
+ nfet_06v0 L=1U W=5U AS=1.25P AD=1.65P PS=5.5U PD=5.66U
M$1494 \$9121 \$9121 \$9075
+ VSS|XN_CS|XN_IE|XN_PD|XN_PDRV0|XN_PDRV1|XN_PU|XN_SL|XP_CS|XP_IE|XP_PD|XP_PDRV0|XP_PDRV1|XP_PU|XP_SL|YN_CS|YN_IE|YN_PD|YN_PDRV0|YN_PDRV1|YN_PU|YN_SL|YP_CS|YP_IE|YP_PD|YP_PDRV0|YP_PDRV1|YP_PU|YP_SL|ZN_CS|ZN_IE|ZN_PD|ZN_PDRV0|ZN_PDRV1|ZN_PU|ZN_SL|ZP_CS|ZP_IE|ZP_PD|ZP_PDRV0|ZP_PDRV1|ZP_PU|ZP_SL
+ nfet_06v0 L=1U W=5U AS=1.65P AD=2.2P PS=5.66U PD=10.88U
M$1495 \$9106 \$9105
+ VSS|XN_CS|XN_IE|XN_PD|XN_PDRV0|XN_PDRV1|XN_PU|XN_SL|XP_CS|XP_IE|XP_PD|XP_PDRV0|XP_PDRV1|XP_PU|XP_SL|YN_CS|YN_IE|YN_PD|YN_PDRV0|YN_PDRV1|YN_PU|YN_SL|YP_CS|YP_IE|YP_PD|YP_PDRV0|YP_PDRV1|YP_PU|YP_SL|ZN_CS|ZN_IE|ZN_PD|ZN_PDRV0|ZN_PDRV1|ZN_PU|ZN_SL|ZP_CS|ZP_IE|ZP_PD|ZP_PDRV0|ZP_PDRV1|ZP_PU|ZP_SL
+ VSS|XN_CS|XN_IE|XN_PD|XN_PDRV0|XN_PDRV1|XN_PU|XN_SL|XP_CS|XP_IE|XP_PD|XP_PDRV0|XP_PDRV1|XP_PU|XP_SL|YN_CS|YN_IE|YN_PD|YN_PDRV0|YN_PDRV1|YN_PU|YN_SL|YP_CS|YP_IE|YP_PD|YP_PDRV0|YP_PDRV1|YP_PU|YP_SL|ZN_CS|ZN_IE|ZN_PD|ZN_PDRV0|ZN_PDRV1|ZN_PU|ZN_SL|ZP_CS|ZP_IE|ZP_PD|ZP_PDRV0|ZP_PDRV1|ZP_PU|ZP_SL
+ nfet_06v0 L=1U W=5U AS=2.2P AD=1.3P PS=10.88U PD=5.52U
M$1496
+ VSS|XN_CS|XN_IE|XN_PD|XN_PDRV0|XN_PDRV1|XN_PU|XN_SL|XP_CS|XP_IE|XP_PD|XP_PDRV0|XP_PDRV1|XP_PU|XP_SL|YN_CS|YN_IE|YN_PD|YN_PDRV0|YN_PDRV1|YN_PU|YN_SL|YP_CS|YP_IE|YP_PD|YP_PDRV0|YP_PDRV1|YP_PU|YP_SL|ZN_CS|ZN_IE|ZN_PD|ZN_PDRV0|ZN_PDRV1|ZN_PU|ZN_SL|ZP_CS|ZP_IE|ZP_PD|ZP_PDRV0|ZP_PDRV1|ZP_PU|ZP_SL
+ \$9105 \$9106
+ VSS|XN_CS|XN_IE|XN_PD|XN_PDRV0|XN_PDRV1|XN_PU|XN_SL|XP_CS|XP_IE|XP_PD|XP_PDRV0|XP_PDRV1|XP_PU|XP_SL|YN_CS|YN_IE|YN_PD|YN_PDRV0|YN_PDRV1|YN_PU|YN_SL|YP_CS|YP_IE|YP_PD|YP_PDRV0|YP_PDRV1|YP_PU|YP_SL|ZN_CS|ZN_IE|ZN_PD|ZN_PDRV0|ZN_PDRV1|ZN_PU|ZN_SL|ZP_CS|ZP_IE|ZP_PD|ZP_PDRV0|ZP_PDRV1|ZP_PU|ZP_SL
+ nfet_06v0 L=1U W=5U AS=1.3P AD=1.3P PS=5.52U PD=5.52U
M$1497 \$9106 \$9105
+ VSS|XN_CS|XN_IE|XN_PD|XN_PDRV0|XN_PDRV1|XN_PU|XN_SL|XP_CS|XP_IE|XP_PD|XP_PDRV0|XP_PDRV1|XP_PU|XP_SL|YN_CS|YN_IE|YN_PD|YN_PDRV0|YN_PDRV1|YN_PU|YN_SL|YP_CS|YP_IE|YP_PD|YP_PDRV0|YP_PDRV1|YP_PU|YP_SL|ZN_CS|ZN_IE|ZN_PD|ZN_PDRV0|ZN_PDRV1|ZN_PU|ZN_SL|ZP_CS|ZP_IE|ZP_PD|ZP_PDRV0|ZP_PDRV1|ZP_PU|ZP_SL
+ VSS|XN_CS|XN_IE|XN_PD|XN_PDRV0|XN_PDRV1|XN_PU|XN_SL|XP_CS|XP_IE|XP_PD|XP_PDRV0|XP_PDRV1|XP_PU|XP_SL|YN_CS|YN_IE|YN_PD|YN_PDRV0|YN_PDRV1|YN_PU|YN_SL|YP_CS|YP_IE|YP_PD|YP_PDRV0|YP_PDRV1|YP_PU|YP_SL|ZN_CS|ZN_IE|ZN_PD|ZN_PDRV0|ZN_PDRV1|ZN_PU|ZN_SL|ZP_CS|ZP_IE|ZP_PD|ZP_PDRV0|ZP_PDRV1|ZP_PU|ZP_SL
+ nfet_06v0 L=1U W=5U AS=1.3P AD=2.2P PS=5.52U PD=10.88U
M$1498
+ VSS|XN_CS|XN_IE|XN_PD|XN_PDRV0|XN_PDRV1|XN_PU|XN_SL|XP_CS|XP_IE|XP_PD|XP_PDRV0|XP_PDRV1|XP_PU|XP_SL|YN_CS|YN_IE|YN_PD|YN_PDRV0|YN_PDRV1|YN_PU|YN_SL|YP_CS|YP_IE|YP_PD|YP_PDRV0|YP_PDRV1|YP_PU|YP_SL|ZN_CS|ZN_IE|ZN_PD|ZN_PDRV0|ZN_PDRV1|ZN_PU|ZN_SL|ZP_CS|ZP_IE|ZP_PD|ZP_PDRV0|ZP_PDRV1|ZP_PU|ZP_SL
+ VDD|XN_OE|XP_OE|YN_OE|YP_OE|ZN_OE|ZP_OE
+ VSS|XN_CS|XN_IE|XN_PD|XN_PDRV0|XN_PDRV1|XN_PU|XN_SL|XP_CS|XP_IE|XP_PD|XP_PDRV0|XP_PDRV1|XP_PU|XP_SL|YN_CS|YN_IE|YN_PD|YN_PDRV0|YN_PDRV1|YN_PU|YN_SL|YP_CS|YP_IE|YP_PD|YP_PDRV0|YP_PDRV1|YP_PU|YP_SL|ZN_CS|ZN_IE|ZN_PD|ZN_PDRV0|ZN_PDRV1|ZN_PU|ZN_SL|ZP_CS|ZP_IE|ZP_PD|ZP_PDRV0|ZP_PDRV1|ZP_PU|ZP_SL
+ VSS|XN_CS|XN_IE|XN_PD|XN_PDRV0|XN_PDRV1|XN_PU|XN_SL|XP_CS|XP_IE|XP_PD|XP_PDRV0|XP_PDRV1|XP_PU|XP_SL|YN_CS|YN_IE|YN_PD|YN_PDRV0|YN_PDRV1|YN_PU|YN_SL|YP_CS|YP_IE|YP_PD|YP_PDRV0|YP_PDRV1|YP_PU|YP_SL|ZN_CS|ZN_IE|ZN_PD|ZN_PDRV0|ZN_PDRV1|ZN_PU|ZN_SL|ZP_CS|ZP_IE|ZP_PD|ZP_PDRV0|ZP_PDRV1|ZP_PU|ZP_SL
+ nfet_06v0 L=2U W=9.75U AS=4.29P AD=4.29P PS=20.38U PD=20.38U
M$1499
+ VSS|XN_CS|XN_IE|XN_PD|XN_PDRV0|XN_PDRV1|XN_PU|XN_SL|XP_CS|XP_IE|XP_PD|XP_PDRV0|XP_PDRV1|XP_PU|XP_SL|YN_CS|YN_IE|YN_PD|YN_PDRV0|YN_PDRV1|YN_PU|YN_SL|YP_CS|YP_IE|YP_PD|YP_PDRV0|YP_PDRV1|YP_PU|YP_SL|ZN_CS|ZN_IE|ZN_PD|ZN_PDRV0|ZN_PDRV1|ZN_PU|ZN_SL|ZP_CS|ZP_IE|ZP_PD|ZP_PDRV0|ZP_PDRV1|ZP_PU|ZP_SL
+ VDD|XN_OE|XP_OE|YN_OE|YP_OE|ZN_OE|ZP_OE
+ VSS|XN_CS|XN_IE|XN_PD|XN_PDRV0|XN_PDRV1|XN_PU|XN_SL|XP_CS|XP_IE|XP_PD|XP_PDRV0|XP_PDRV1|XP_PU|XP_SL|YN_CS|YN_IE|YN_PD|YN_PDRV0|YN_PDRV1|YN_PU|YN_SL|YP_CS|YP_IE|YP_PD|YP_PDRV0|YP_PDRV1|YP_PU|YP_SL|ZN_CS|ZN_IE|ZN_PD|ZN_PDRV0|ZN_PDRV1|ZN_PU|ZN_SL|ZP_CS|ZP_IE|ZP_PD|ZP_PDRV0|ZP_PDRV1|ZP_PU|ZP_SL
+ VSS|XN_CS|XN_IE|XN_PD|XN_PDRV0|XN_PDRV1|XN_PU|XN_SL|XP_CS|XP_IE|XP_PD|XP_PDRV0|XP_PDRV1|XP_PU|XP_SL|YN_CS|YN_IE|YN_PD|YN_PDRV0|YN_PDRV1|YN_PU|YN_SL|YP_CS|YP_IE|YP_PD|YP_PDRV0|YP_PDRV1|YP_PU|YP_SL|ZN_CS|ZN_IE|ZN_PD|ZN_PDRV0|ZN_PDRV1|ZN_PU|ZN_SL|ZP_CS|ZP_IE|ZP_PD|ZP_PDRV0|ZP_PDRV1|ZP_PU|ZP_SL
+ nfet_06v0 L=2U W=9.75U AS=4.29P AD=4.29P PS=20.38U PD=20.38U
M$1500 \$7258 \$7261
+ VSS|XN_CS|XN_IE|XN_PD|XN_PDRV0|XN_PDRV1|XN_PU|XN_SL|XP_CS|XP_IE|XP_PD|XP_PDRV0|XP_PDRV1|XP_PU|XP_SL|YN_CS|YN_IE|YN_PD|YN_PDRV0|YN_PDRV1|YN_PU|YN_SL|YP_CS|YP_IE|YP_PD|YP_PDRV0|YP_PDRV1|YP_PU|YP_SL|ZN_CS|ZN_IE|ZN_PD|ZN_PDRV0|ZN_PDRV1|ZN_PU|ZN_SL|ZP_CS|ZP_IE|ZP_PD|ZP_PDRV0|ZP_PDRV1|ZP_PU|ZP_SL
+ VSS|XN_CS|XN_IE|XN_PD|XN_PDRV0|XN_PDRV1|XN_PU|XN_SL|XP_CS|XP_IE|XP_PD|XP_PDRV0|XP_PDRV1|XP_PU|XP_SL|YN_CS|YN_IE|YN_PD|YN_PDRV0|YN_PDRV1|YN_PU|YN_SL|YP_CS|YP_IE|YP_PD|YP_PDRV0|YP_PDRV1|YP_PU|YP_SL|ZN_CS|ZN_IE|ZN_PD|ZN_PDRV0|ZN_PDRV1|ZN_PU|ZN_SL|ZP_CS|ZP_IE|ZP_PD|ZP_PDRV0|ZP_PDRV1|ZP_PU|ZP_SL
+ nfet_06v0 L=1U W=1.24U AS=0.5456P AD=0.5456P PS=3.36U PD=3.36U
M$1501 X \$7344 \$7275
+ VSS|XN_CS|XN_IE|XN_PD|XN_PDRV0|XN_PDRV1|XN_PU|XN_SL|XP_CS|XP_IE|XP_PD|XP_PDRV0|XP_PDRV1|XP_PU|XP_SL|YN_CS|YN_IE|YN_PD|YN_PDRV0|YN_PDRV1|YN_PU|YN_SL|YP_CS|YP_IE|YP_PD|YP_PDRV0|YP_PDRV1|YP_PU|YP_SL|ZN_CS|ZN_IE|ZN_PD|ZN_PDRV0|ZN_PDRV1|ZN_PU|ZN_SL|ZP_CS|ZP_IE|ZP_PD|ZP_PDRV0|ZP_PDRV1|ZP_PU|ZP_SL
+ nfet_06v0 L=1U W=2.48U AS=1.0912P AD=0.6448P PS=5.84U PD=3U
M$1502 \$7275 \$7344 X
+ VSS|XN_CS|XN_IE|XN_PD|XN_PDRV0|XN_PDRV1|XN_PU|XN_SL|XP_CS|XP_IE|XP_PD|XP_PDRV0|XP_PDRV1|XP_PU|XP_SL|YN_CS|YN_IE|YN_PD|YN_PDRV0|YN_PDRV1|YN_PU|YN_SL|YP_CS|YP_IE|YP_PD|YP_PDRV0|YP_PDRV1|YP_PU|YP_SL|ZN_CS|ZN_IE|ZN_PD|ZN_PDRV0|ZN_PDRV1|ZN_PU|ZN_SL|ZP_CS|ZP_IE|ZP_PD|ZP_PDRV0|ZP_PDRV1|ZP_PU|ZP_SL
+ nfet_06v0 L=1U W=2.48U AS=0.6448P AD=1.0912P PS=3U PD=5.84U
M$1503 \$7275 \$7261
+ VSS|XN_CS|XN_IE|XN_PD|XN_PDRV0|XN_PDRV1|XN_PU|XN_SL|XP_CS|XP_IE|XP_PD|XP_PDRV0|XP_PDRV1|XP_PU|XP_SL|YN_CS|YN_IE|YN_PD|YN_PDRV0|YN_PDRV1|YN_PU|YN_SL|YP_CS|YP_IE|YP_PD|YP_PDRV0|YP_PDRV1|YP_PU|YP_SL|ZN_CS|ZN_IE|ZN_PD|ZN_PDRV0|ZN_PDRV1|ZN_PU|ZN_SL|ZP_CS|ZP_IE|ZP_PD|ZP_PDRV0|ZP_PDRV1|ZP_PU|ZP_SL
+ VSS|XN_CS|XN_IE|XN_PD|XN_PDRV0|XN_PDRV1|XN_PU|XN_SL|XP_CS|XP_IE|XP_PD|XP_PDRV0|XP_PDRV1|XP_PU|XP_SL|YN_CS|YN_IE|YN_PD|YN_PDRV0|YN_PDRV1|YN_PU|YN_SL|YP_CS|YP_IE|YP_PD|YP_PDRV0|YP_PDRV1|YP_PU|YP_SL|ZN_CS|ZN_IE|ZN_PD|ZN_PDRV0|ZN_PDRV1|ZN_PU|ZN_SL|ZP_CS|ZP_IE|ZP_PD|ZP_PDRV0|ZP_PDRV1|ZP_PU|ZP_SL
+ nfet_06v0 L=1U W=1.24U AS=0.5456P AD=0.5456P PS=3.36U PD=3.36U
M$1504 X \$7745 \$7359
+ VSS|XN_CS|XN_IE|XN_PD|XN_PDRV0|XN_PDRV1|XN_PU|XN_SL|XP_CS|XP_IE|XP_PD|XP_PDRV0|XP_PDRV1|XP_PU|XP_SL|YN_CS|YN_IE|YN_PD|YN_PDRV0|YN_PDRV1|YN_PU|YN_SL|YP_CS|YP_IE|YP_PD|YP_PDRV0|YP_PDRV1|YP_PU|YP_SL|ZN_CS|ZN_IE|ZN_PD|ZN_PDRV0|ZN_PDRV1|ZN_PU|ZN_SL|ZP_CS|ZP_IE|ZP_PD|ZP_PDRV0|ZP_PDRV1|ZP_PU|ZP_SL
+ nfet_06v0 L=1U W=2.48U AS=1.0912P AD=0.6448P PS=5.84U PD=3U
M$1505 \$7359 \$7745 X
+ VSS|XN_CS|XN_IE|XN_PD|XN_PDRV0|XN_PDRV1|XN_PU|XN_SL|XP_CS|XP_IE|XP_PD|XP_PDRV0|XP_PDRV1|XP_PU|XP_SL|YN_CS|YN_IE|YN_PD|YN_PDRV0|YN_PDRV1|YN_PU|YN_SL|YP_CS|YP_IE|YP_PD|YP_PDRV0|YP_PDRV1|YP_PU|YP_SL|ZN_CS|ZN_IE|ZN_PD|ZN_PDRV0|ZN_PDRV1|ZN_PU|ZN_SL|ZP_CS|ZP_IE|ZP_PD|ZP_PDRV0|ZP_PDRV1|ZP_PU|ZP_SL
+ nfet_06v0 L=1U W=2.48U AS=0.6448P AD=1.0912P PS=3U PD=5.84U
M$1506 \$7320 \$7261
+ VSS|XN_CS|XN_IE|XN_PD|XN_PDRV0|XN_PDRV1|XN_PU|XN_SL|XP_CS|XP_IE|XP_PD|XP_PDRV0|XP_PDRV1|XP_PU|XP_SL|YN_CS|YN_IE|YN_PD|YN_PDRV0|YN_PDRV1|YN_PU|YN_SL|YP_CS|YP_IE|YP_PD|YP_PDRV0|YP_PDRV1|YP_PU|YP_SL|ZN_CS|ZN_IE|ZN_PD|ZN_PDRV0|ZN_PDRV1|ZN_PU|ZN_SL|ZP_CS|ZP_IE|ZP_PD|ZP_PDRV0|ZP_PDRV1|ZP_PU|ZP_SL
+ VSS|XN_CS|XN_IE|XN_PD|XN_PDRV0|XN_PDRV1|XN_PU|XN_SL|XP_CS|XP_IE|XP_PD|XP_PDRV0|XP_PDRV1|XP_PU|XP_SL|YN_CS|YN_IE|YN_PD|YN_PDRV0|YN_PDRV1|YN_PU|YN_SL|YP_CS|YP_IE|YP_PD|YP_PDRV0|YP_PDRV1|YP_PU|YP_SL|ZN_CS|ZN_IE|ZN_PD|ZN_PDRV0|ZN_PDRV1|ZN_PU|ZN_SL|ZP_CS|ZP_IE|ZP_PD|ZP_PDRV0|ZP_PDRV1|ZP_PU|ZP_SL
+ nfet_06v0 L=1U W=0.7U AS=0.308P AD=0.175P PS=2.28U PD=1.2U
M$1507 \$7321 \$7261 \$7320
+ VSS|XN_CS|XN_IE|XN_PD|XN_PDRV0|XN_PDRV1|XN_PU|XN_SL|XP_CS|XP_IE|XP_PD|XP_PDRV0|XP_PDRV1|XP_PU|XP_SL|YN_CS|YN_IE|YN_PD|YN_PDRV0|YN_PDRV1|YN_PU|YN_SL|YP_CS|YP_IE|YP_PD|YP_PDRV0|YP_PDRV1|YP_PU|YP_SL|ZN_CS|ZN_IE|ZN_PD|ZN_PDRV0|ZN_PDRV1|ZN_PU|ZN_SL|ZP_CS|ZP_IE|ZP_PD|ZP_PDRV0|ZP_PDRV1|ZP_PU|ZP_SL
+ nfet_06v0 L=1U W=0.7U AS=0.175P AD=0.175P PS=1.2U PD=1.2U
M$1508 \$7319 \$7261 \$7321
+ VSS|XN_CS|XN_IE|XN_PD|XN_PDRV0|XN_PDRV1|XN_PU|XN_SL|XP_CS|XP_IE|XP_PD|XP_PDRV0|XP_PDRV1|XP_PU|XP_SL|YN_CS|YN_IE|YN_PD|YN_PDRV0|YN_PDRV1|YN_PU|YN_SL|YP_CS|YP_IE|YP_PD|YP_PDRV0|YP_PDRV1|YP_PU|YP_SL|ZN_CS|ZN_IE|ZN_PD|ZN_PDRV0|ZN_PDRV1|ZN_PU|ZN_SL|ZP_CS|ZP_IE|ZP_PD|ZP_PDRV0|ZP_PDRV1|ZP_PU|ZP_SL
+ nfet_06v0 L=1U W=0.7U AS=0.175P AD=0.175P PS=1.2U PD=1.2U
M$1509 \$7261 \$7261 \$7319
+ VSS|XN_CS|XN_IE|XN_PD|XN_PDRV0|XN_PDRV1|XN_PU|XN_SL|XP_CS|XP_IE|XP_PD|XP_PDRV0|XP_PDRV1|XP_PU|XP_SL|YN_CS|YN_IE|YN_PD|YN_PDRV0|YN_PDRV1|YN_PU|YN_SL|YP_CS|YP_IE|YP_PD|YP_PDRV0|YP_PDRV1|YP_PU|YP_SL|ZN_CS|ZN_IE|ZN_PD|ZN_PDRV0|ZN_PDRV1|ZN_PU|ZN_SL|ZP_CS|ZP_IE|ZP_PD|ZP_PDRV0|ZP_PDRV1|ZP_PU|ZP_SL
+ nfet_06v0 L=1U W=0.7U AS=0.175P AD=0.308P PS=1.2U PD=2.28U
M$1510 \$7359 \$7261
+ VSS|XN_CS|XN_IE|XN_PD|XN_PDRV0|XN_PDRV1|XN_PU|XN_SL|XP_CS|XP_IE|XP_PD|XP_PDRV0|XP_PDRV1|XP_PU|XP_SL|YN_CS|YN_IE|YN_PD|YN_PDRV0|YN_PDRV1|YN_PU|YN_SL|YP_CS|YP_IE|YP_PD|YP_PDRV0|YP_PDRV1|YP_PU|YP_SL|ZN_CS|ZN_IE|ZN_PD|ZN_PDRV0|ZN_PDRV1|ZN_PU|ZN_SL|ZP_CS|ZP_IE|ZP_PD|ZP_PDRV0|ZP_PDRV1|ZP_PU|ZP_SL
+ VSS|XN_CS|XN_IE|XN_PD|XN_PDRV0|XN_PDRV1|XN_PU|XN_SL|XP_CS|XP_IE|XP_PD|XP_PDRV0|XP_PDRV1|XP_PU|XP_SL|YN_CS|YN_IE|YN_PD|YN_PDRV0|YN_PDRV1|YN_PU|YN_SL|YP_CS|YP_IE|YP_PD|YP_PDRV0|YP_PDRV1|YP_PU|YP_SL|ZN_CS|ZN_IE|ZN_PD|ZN_PDRV0|ZN_PDRV1|ZN_PU|ZN_SL|ZP_CS|ZP_IE|ZP_PD|ZP_PDRV0|ZP_PDRV1|ZP_PU|ZP_SL
+ nfet_06v0 L=1U W=1.24U AS=0.5456P AD=0.5456P PS=3.36U PD=3.36U
M$1511 X X \$7360
+ VSS|XN_CS|XN_IE|XN_PD|XN_PDRV0|XN_PDRV1|XN_PU|XN_SL|XP_CS|XP_IE|XP_PD|XP_PDRV0|XP_PDRV1|XP_PU|XP_SL|YN_CS|YN_IE|YN_PD|YN_PDRV0|YN_PDRV1|YN_PU|YN_SL|YP_CS|YP_IE|YP_PD|YP_PDRV0|YP_PDRV1|YP_PU|YP_SL|ZN_CS|ZN_IE|ZN_PD|ZN_PDRV0|ZN_PDRV1|ZN_PU|ZN_SL|ZP_CS|ZP_IE|ZP_PD|ZP_PDRV0|ZP_PDRV1|ZP_PU|ZP_SL
+ nfet_06v0 L=1U W=2U AS=0.88P AD=0.52P PS=4.88U PD=2.52U
M$1512 \$7360 X X
+ VSS|XN_CS|XN_IE|XN_PD|XN_PDRV0|XN_PDRV1|XN_PU|XN_SL|XP_CS|XP_IE|XP_PD|XP_PDRV0|XP_PDRV1|XP_PU|XP_SL|YN_CS|YN_IE|YN_PD|YN_PDRV0|YN_PDRV1|YN_PU|YN_SL|YP_CS|YP_IE|YP_PD|YP_PDRV0|YP_PDRV1|YP_PU|YP_SL|ZN_CS|ZN_IE|ZN_PD|ZN_PDRV0|ZN_PDRV1|ZN_PU|ZN_SL|ZP_CS|ZP_IE|ZP_PD|ZP_PDRV0|ZP_PDRV1|ZP_PU|ZP_SL
+ nfet_06v0 L=1U W=2U AS=0.52P AD=0.88P PS=2.52U PD=4.88U
M$1513 X VDD|XN_OE|XP_OE|YN_OE|YP_OE|ZN_OE|ZP_OE \$7259
+ VSS|XN_CS|XN_IE|XN_PD|XN_PDRV0|XN_PDRV1|XN_PU|XN_SL|XP_CS|XP_IE|XP_PD|XP_PDRV0|XP_PDRV1|XP_PU|XP_SL|YN_CS|YN_IE|YN_PD|YN_PDRV0|YN_PDRV1|YN_PU|YN_SL|YP_CS|YP_IE|YP_PD|YP_PDRV0|YP_PDRV1|YP_PU|YP_SL|ZN_CS|ZN_IE|ZN_PD|ZN_PDRV0|ZN_PDRV1|ZN_PU|ZN_SL|ZP_CS|ZP_IE|ZP_PD|ZP_PDRV0|ZP_PDRV1|ZP_PU|ZP_SL
+ nfet_06v0 L=1U W=2.48U AS=1.0912P AD=0.6448P PS=5.84U PD=3U
M$1514 \$7259 VDD|XN_OE|XP_OE|YN_OE|YP_OE|ZN_OE|ZP_OE X
+ VSS|XN_CS|XN_IE|XN_PD|XN_PDRV0|XN_PDRV1|XN_PU|XN_SL|XP_CS|XP_IE|XP_PD|XP_PDRV0|XP_PDRV1|XP_PU|XP_SL|YN_CS|YN_IE|YN_PD|YN_PDRV0|YN_PDRV1|YN_PU|YN_SL|YP_CS|YP_IE|YP_PD|YP_PDRV0|YP_PDRV1|YP_PU|YP_SL|ZN_CS|ZN_IE|ZN_PD|ZN_PDRV0|ZN_PDRV1|ZN_PU|ZN_SL|ZP_CS|ZP_IE|ZP_PD|ZP_PDRV0|ZP_PDRV1|ZP_PU|ZP_SL
+ nfet_06v0 L=1U W=2.48U AS=0.6448P AD=1.0912P PS=3U PD=5.84U
M$1515 \$7362 X
+ VSS|XN_CS|XN_IE|XN_PD|XN_PDRV0|XN_PDRV1|XN_PU|XN_SL|XP_CS|XP_IE|XP_PD|XP_PDRV0|XP_PDRV1|XP_PU|XP_SL|YN_CS|YN_IE|YN_PD|YN_PDRV0|YN_PDRV1|YN_PU|YN_SL|YP_CS|YP_IE|YP_PD|YP_PDRV0|YP_PDRV1|YP_PU|YP_SL|ZN_CS|ZN_IE|ZN_PD|ZN_PDRV0|ZN_PDRV1|ZN_PU|ZN_SL|ZP_CS|ZP_IE|ZP_PD|ZP_PDRV0|ZP_PDRV1|ZP_PU|ZP_SL
+ VSS|XN_CS|XN_IE|XN_PD|XN_PDRV0|XN_PDRV1|XN_PU|XN_SL|XP_CS|XP_IE|XP_PD|XP_PDRV0|XP_PDRV1|XP_PU|XP_SL|YN_CS|YN_IE|YN_PD|YN_PDRV0|YN_PDRV1|YN_PU|YN_SL|YP_CS|YP_IE|YP_PD|YP_PDRV0|YP_PDRV1|YP_PU|YP_SL|ZN_CS|ZN_IE|ZN_PD|ZN_PDRV0|ZN_PDRV1|ZN_PU|ZN_SL|ZP_CS|ZP_IE|ZP_PD|ZP_PDRV0|ZP_PDRV1|ZP_PU|ZP_SL
+ nfet_06v0 L=1U W=2U AS=0.88P AD=0.5P PS=4.88U PD=2.5U
M$1516 \$7360 X \$7362
+ VSS|XN_CS|XN_IE|XN_PD|XN_PDRV0|XN_PDRV1|XN_PU|XN_SL|XP_CS|XP_IE|XP_PD|XP_PDRV0|XP_PDRV1|XP_PU|XP_SL|YN_CS|YN_IE|YN_PD|YN_PDRV0|YN_PDRV1|YN_PU|YN_SL|YP_CS|YP_IE|YP_PD|YP_PDRV0|YP_PDRV1|YP_PU|YP_SL|ZN_CS|ZN_IE|ZN_PD|ZN_PDRV0|ZN_PDRV1|ZN_PU|ZN_SL|ZP_CS|ZP_IE|ZP_PD|ZP_PDRV0|ZP_PDRV1|ZP_PU|ZP_SL
+ nfet_06v0 L=1U W=2U AS=0.5P AD=0.88P PS=2.5U PD=4.88U
M$1517 \$7259 \$7261
+ VSS|XN_CS|XN_IE|XN_PD|XN_PDRV0|XN_PDRV1|XN_PU|XN_SL|XP_CS|XP_IE|XP_PD|XP_PDRV0|XP_PDRV1|XP_PU|XP_SL|YN_CS|YN_IE|YN_PD|YN_PDRV0|YN_PDRV1|YN_PU|YN_SL|YP_CS|YP_IE|YP_PD|YP_PDRV0|YP_PDRV1|YP_PU|YP_SL|ZN_CS|ZN_IE|ZN_PD|ZN_PDRV0|ZN_PDRV1|ZN_PU|ZN_SL|ZP_CS|ZP_IE|ZP_PD|ZP_PDRV0|ZP_PDRV1|ZP_PU|ZP_SL
+ VSS|XN_CS|XN_IE|XN_PD|XN_PDRV0|XN_PDRV1|XN_PU|XN_SL|XP_CS|XP_IE|XP_PD|XP_PDRV0|XP_PDRV1|XP_PU|XP_SL|YN_CS|YN_IE|YN_PD|YN_PDRV0|YN_PDRV1|YN_PU|YN_SL|YP_CS|YP_IE|YP_PD|YP_PDRV0|YP_PDRV1|YP_PU|YP_SL|ZN_CS|ZN_IE|ZN_PD|ZN_PDRV0|ZN_PDRV1|ZN_PU|ZN_SL|ZP_CS|ZP_IE|ZP_PD|ZP_PDRV0|ZP_PDRV1|ZP_PU|ZP_SL
+ nfet_06v0 L=1U W=1.24U AS=0.5456P AD=0.5456P PS=3.36U PD=3.36U
M$1518 X \$7277 \$7361
+ VSS|XN_CS|XN_IE|XN_PD|XN_PDRV0|XN_PDRV1|XN_PU|XN_SL|XP_CS|XP_IE|XP_PD|XP_PDRV0|XP_PDRV1|XP_PU|XP_SL|YN_CS|YN_IE|YN_PD|YN_PDRV0|YN_PDRV1|YN_PU|YN_SL|YP_CS|YP_IE|YP_PD|YP_PDRV0|YP_PDRV1|YP_PU|YP_SL|ZN_CS|ZN_IE|ZN_PD|ZN_PDRV0|ZN_PDRV1|ZN_PU|ZN_SL|ZP_CS|ZP_IE|ZP_PD|ZP_PDRV0|ZP_PDRV1|ZP_PU|ZP_SL
+ nfet_06v0 L=1U W=2.48U AS=1.0912P AD=0.6448P PS=5.84U PD=3U
M$1519 \$7361 \$7277 X
+ VSS|XN_CS|XN_IE|XN_PD|XN_PDRV0|XN_PDRV1|XN_PU|XN_SL|XP_CS|XP_IE|XP_PD|XP_PDRV0|XP_PDRV1|XP_PU|XP_SL|YN_CS|YN_IE|YN_PD|YN_PDRV0|YN_PDRV1|YN_PU|YN_SL|YP_CS|YP_IE|YP_PD|YP_PDRV0|YP_PDRV1|YP_PU|YP_SL|ZN_CS|ZN_IE|ZN_PD|ZN_PDRV0|ZN_PDRV1|ZN_PU|ZN_SL|ZP_CS|ZP_IE|ZP_PD|ZP_PDRV0|ZP_PDRV1|ZP_PU|ZP_SL
+ nfet_06v0 L=1U W=2.48U AS=0.6448P AD=1.0912P PS=3U PD=5.84U
M$1520 \$7361 \$7261
+ VSS|XN_CS|XN_IE|XN_PD|XN_PDRV0|XN_PDRV1|XN_PU|XN_SL|XP_CS|XP_IE|XP_PD|XP_PDRV0|XP_PDRV1|XP_PU|XP_SL|YN_CS|YN_IE|YN_PD|YN_PDRV0|YN_PDRV1|YN_PU|YN_SL|YP_CS|YP_IE|YP_PD|YP_PDRV0|YP_PDRV1|YP_PU|YP_SL|ZN_CS|ZN_IE|ZN_PD|ZN_PDRV0|ZN_PDRV1|ZN_PU|ZN_SL|ZP_CS|ZP_IE|ZP_PD|ZP_PDRV0|ZP_PDRV1|ZP_PU|ZP_SL
+ VSS|XN_CS|XN_IE|XN_PD|XN_PDRV0|XN_PDRV1|XN_PU|XN_SL|XP_CS|XP_IE|XP_PD|XP_PDRV0|XP_PDRV1|XP_PU|XP_SL|YN_CS|YN_IE|YN_PD|YN_PDRV0|YN_PDRV1|YN_PU|YN_SL|YP_CS|YP_IE|YP_PD|YP_PDRV0|YP_PDRV1|YP_PU|YP_SL|ZN_CS|ZN_IE|ZN_PD|ZN_PDRV0|ZN_PDRV1|ZN_PU|ZN_SL|ZP_CS|ZP_IE|ZP_PD|ZP_PDRV0|ZP_PDRV1|ZP_PU|ZP_SL
+ nfet_06v0 L=1U W=1.24U AS=0.5456P AD=0.5456P PS=3.36U PD=3.36U
M$1521 X \$7345 \$7258
+ VSS|XN_CS|XN_IE|XN_PD|XN_PDRV0|XN_PDRV1|XN_PU|XN_SL|XP_CS|XP_IE|XP_PD|XP_PDRV0|XP_PDRV1|XP_PU|XP_SL|YN_CS|YN_IE|YN_PD|YN_PDRV0|YN_PDRV1|YN_PU|YN_SL|YP_CS|YP_IE|YP_PD|YP_PDRV0|YP_PDRV1|YP_PU|YP_SL|ZN_CS|ZN_IE|ZN_PD|ZN_PDRV0|ZN_PDRV1|ZN_PU|ZN_SL|ZP_CS|ZP_IE|ZP_PD|ZP_PDRV0|ZP_PDRV1|ZP_PU|ZP_SL
+ nfet_06v0 L=1U W=2.48U AS=1.0912P AD=0.6448P PS=5.84U PD=3U
M$1522 \$7258 \$7345 X
+ VSS|XN_CS|XN_IE|XN_PD|XN_PDRV0|XN_PDRV1|XN_PU|XN_SL|XP_CS|XP_IE|XP_PD|XP_PDRV0|XP_PDRV1|XP_PU|XP_SL|YN_CS|YN_IE|YN_PD|YN_PDRV0|YN_PDRV1|YN_PU|YN_SL|YP_CS|YP_IE|YP_PD|YP_PDRV0|YP_PDRV1|YP_PU|YP_SL|ZN_CS|ZN_IE|ZN_PD|ZN_PDRV0|ZN_PDRV1|ZN_PU|ZN_SL|ZP_CS|ZP_IE|ZP_PD|ZP_PDRV0|ZP_PDRV1|ZP_PU|ZP_SL
+ nfet_06v0 L=1U W=2.48U AS=0.6448P AD=1.0912P PS=3U PD=5.84U
M$1523
+ VSS|XN_CS|XN_IE|XN_PD|XN_PDRV0|XN_PDRV1|XN_PU|XN_SL|XP_CS|XP_IE|XP_PD|XP_PDRV0|XP_PDRV1|XP_PU|XP_SL|YN_CS|YN_IE|YN_PD|YN_PDRV0|YN_PDRV1|YN_PU|YN_SL|YP_CS|YP_IE|YP_PD|YP_PDRV0|YP_PDRV1|YP_PU|YP_SL|ZN_CS|ZN_IE|ZN_PD|ZN_PDRV0|ZN_PDRV1|ZN_PU|ZN_SL|ZP_CS|ZP_IE|ZP_PD|ZP_PDRV0|ZP_PDRV1|ZP_PU|ZP_SL
+ VDD|XN_OE|XP_OE|YN_OE|YP_OE|ZN_OE|ZP_OE
+ VSS|XN_CS|XN_IE|XN_PD|XN_PDRV0|XN_PDRV1|XN_PU|XN_SL|XP_CS|XP_IE|XP_PD|XP_PDRV0|XP_PDRV1|XP_PU|XP_SL|YN_CS|YN_IE|YN_PD|YN_PDRV0|YN_PDRV1|YN_PU|YN_SL|YP_CS|YP_IE|YP_PD|YP_PDRV0|YP_PDRV1|YP_PU|YP_SL|ZN_CS|ZN_IE|ZN_PD|ZN_PDRV0|ZN_PDRV1|ZN_PU|ZN_SL|ZP_CS|ZP_IE|ZP_PD|ZP_PDRV0|ZP_PDRV1|ZP_PU|ZP_SL
+ VSS|XN_CS|XN_IE|XN_PD|XN_PDRV0|XN_PDRV1|XN_PU|XN_SL|XP_CS|XP_IE|XP_PD|XP_PDRV0|XP_PDRV1|XP_PU|XP_SL|YN_CS|YN_IE|YN_PD|YN_PDRV0|YN_PDRV1|YN_PU|YN_SL|YP_CS|YP_IE|YP_PD|YP_PDRV0|YP_PDRV1|YP_PU|YP_SL|ZN_CS|ZN_IE|ZN_PD|ZN_PDRV0|ZN_PDRV1|ZN_PU|ZN_SL|ZP_CS|ZP_IE|ZP_PD|ZP_PDRV0|ZP_PDRV1|ZP_PU|ZP_SL
+ nfet_06v0 L=2U W=1U AS=0.44P AD=0.44P PS=2.88U PD=2.88U
M$1524
+ VSS|XN_CS|XN_IE|XN_PD|XN_PDRV0|XN_PDRV1|XN_PU|XN_SL|XP_CS|XP_IE|XP_PD|XP_PDRV0|XP_PDRV1|XP_PU|XP_SL|YN_CS|YN_IE|YN_PD|YN_PDRV0|YN_PDRV1|YN_PU|YN_SL|YP_CS|YP_IE|YP_PD|YP_PDRV0|YP_PDRV1|YP_PU|YP_SL|ZN_CS|ZN_IE|ZN_PD|ZN_PDRV0|ZN_PDRV1|ZN_PU|ZN_SL|ZP_CS|ZP_IE|ZP_PD|ZP_PDRV0|ZP_PDRV1|ZP_PU|ZP_SL
+ VDD|XN_OE|XP_OE|YN_OE|YP_OE|ZN_OE|ZP_OE
+ VSS|XN_CS|XN_IE|XN_PD|XN_PDRV0|XN_PDRV1|XN_PU|XN_SL|XP_CS|XP_IE|XP_PD|XP_PDRV0|XP_PDRV1|XP_PU|XP_SL|YN_CS|YN_IE|YN_PD|YN_PDRV0|YN_PDRV1|YN_PU|YN_SL|YP_CS|YP_IE|YP_PD|YP_PDRV0|YP_PDRV1|YP_PU|YP_SL|ZN_CS|ZN_IE|ZN_PD|ZN_PDRV0|ZN_PDRV1|ZN_PU|ZN_SL|ZP_CS|ZP_IE|ZP_PD|ZP_PDRV0|ZP_PDRV1|ZP_PU|ZP_SL
+ VSS|XN_CS|XN_IE|XN_PD|XN_PDRV0|XN_PDRV1|XN_PU|XN_SL|XP_CS|XP_IE|XP_PD|XP_PDRV0|XP_PDRV1|XP_PU|XP_SL|YN_CS|YN_IE|YN_PD|YN_PDRV0|YN_PDRV1|YN_PU|YN_SL|YP_CS|YP_IE|YP_PD|YP_PDRV0|YP_PDRV1|YP_PU|YP_SL|ZN_CS|ZN_IE|ZN_PD|ZN_PDRV0|ZN_PDRV1|ZN_PU|ZN_SL|ZP_CS|ZP_IE|ZP_PD|ZP_PDRV0|ZP_PDRV1|ZP_PU|ZP_SL
+ nfet_06v0 L=2U W=1U AS=0.44P AD=0.44P PS=2.88U PD=2.88U
M$1525
+ VSS|XN_CS|XN_IE|XN_PD|XN_PDRV0|XN_PDRV1|XN_PU|XN_SL|XP_CS|XP_IE|XP_PD|XP_PDRV0|XP_PDRV1|XP_PU|XP_SL|YN_CS|YN_IE|YN_PD|YN_PDRV0|YN_PDRV1|YN_PU|YN_SL|YP_CS|YP_IE|YP_PD|YP_PDRV0|YP_PDRV1|YP_PU|YP_SL|ZN_CS|ZN_IE|ZN_PD|ZN_PDRV0|ZN_PDRV1|ZN_PU|ZN_SL|ZP_CS|ZP_IE|ZP_PD|ZP_PDRV0|ZP_PDRV1|ZP_PU|ZP_SL
+ \$9089 \$9080
+ VSS|XN_CS|XN_IE|XN_PD|XN_PDRV0|XN_PDRV1|XN_PU|XN_SL|XP_CS|XP_IE|XP_PD|XP_PDRV0|XP_PDRV1|XP_PU|XP_SL|YN_CS|YN_IE|YN_PD|YN_PDRV0|YN_PDRV1|YN_PU|YN_SL|YP_CS|YP_IE|YP_PD|YP_PDRV0|YP_PDRV1|YP_PU|YP_SL|ZN_CS|ZN_IE|ZN_PD|ZN_PDRV0|ZN_PDRV1|ZN_PU|ZN_SL|ZP_CS|ZP_IE|ZP_PD|ZP_PDRV0|ZP_PDRV1|ZP_PU|ZP_SL
+ nfet_06v0 L=1U W=1U AS=0.44P AD=0.44P PS=2.88U PD=2.88U
M$1526
+ VSS|XN_CS|XN_IE|XN_PD|XN_PDRV0|XN_PDRV1|XN_PU|XN_SL|XP_CS|XP_IE|XP_PD|XP_PDRV0|XP_PDRV1|XP_PU|XP_SL|YN_CS|YN_IE|YN_PD|YN_PDRV0|YN_PDRV1|YN_PU|YN_SL|YP_CS|YP_IE|YP_PD|YP_PDRV0|YP_PDRV1|YP_PU|YP_SL|ZN_CS|ZN_IE|ZN_PD|ZN_PDRV0|ZN_PDRV1|ZN_PU|ZN_SL|ZP_CS|ZP_IE|ZP_PD|ZP_PDRV0|ZP_PDRV1|ZP_PU|ZP_SL
+ \$9108 \$9122
+ VSS|XN_CS|XN_IE|XN_PD|XN_PDRV0|XN_PDRV1|XN_PU|XN_SL|XP_CS|XP_IE|XP_PD|XP_PDRV0|XP_PDRV1|XP_PU|XP_SL|YN_CS|YN_IE|YN_PD|YN_PDRV0|YN_PDRV1|YN_PU|YN_SL|YP_CS|YP_IE|YP_PD|YP_PDRV0|YP_PDRV1|YP_PU|YP_SL|ZN_CS|ZN_IE|ZN_PD|ZN_PDRV0|ZN_PDRV1|ZN_PU|ZN_SL|ZP_CS|ZP_IE|ZP_PD|ZP_PDRV0|ZP_PDRV1|ZP_PU|ZP_SL
+ nfet_06v0 L=1U W=1U AS=0.44P AD=0.44P PS=2.88U PD=2.88U
M$1527 \$9114 \$9080 \$9108
+ VSS|XN_CS|XN_IE|XN_PD|XN_PDRV0|XN_PDRV1|XN_PU|XN_SL|XP_CS|XP_IE|XP_PD|XP_PDRV0|XP_PDRV1|XP_PU|XP_SL|YN_CS|YN_IE|YN_PD|YN_PDRV0|YN_PDRV1|YN_PU|YN_SL|YP_CS|YP_IE|YP_PD|YP_PDRV0|YP_PDRV1|YP_PU|YP_SL|ZN_CS|ZN_IE|ZN_PD|ZN_PDRV0|ZN_PDRV1|ZN_PU|ZN_SL|ZP_CS|ZP_IE|ZP_PD|ZP_PDRV0|ZP_PDRV1|ZP_PU|ZP_SL
+ nfet_06v0 L=1U W=1U AS=0.44P AD=0.25P PS=2.88U PD=1.5U
M$1528
+ VSS|XN_CS|XN_IE|XN_PD|XN_PDRV0|XN_PDRV1|XN_PU|XN_SL|XP_CS|XP_IE|XP_PD|XP_PDRV0|XP_PDRV1|XP_PU|XP_SL|YN_CS|YN_IE|YN_PD|YN_PDRV0|YN_PDRV1|YN_PU|YN_SL|YP_CS|YP_IE|YP_PD|YP_PDRV0|YP_PDRV1|YP_PU|YP_SL|ZN_CS|ZN_IE|ZN_PD|ZN_PDRV0|ZN_PDRV1|ZN_PU|ZN_SL|ZP_CS|ZP_IE|ZP_PD|ZP_PDRV0|ZP_PDRV1|ZP_PU|ZP_SL
+ \$9106 \$9114
+ VSS|XN_CS|XN_IE|XN_PD|XN_PDRV0|XN_PDRV1|XN_PU|XN_SL|XP_CS|XP_IE|XP_PD|XP_PDRV0|XP_PDRV1|XP_PU|XP_SL|YN_CS|YN_IE|YN_PD|YN_PDRV0|YN_PDRV1|YN_PU|YN_SL|YP_CS|YP_IE|YP_PD|YP_PDRV0|YP_PDRV1|YP_PU|YP_SL|ZN_CS|ZN_IE|ZN_PD|ZN_PDRV0|ZN_PDRV1|ZN_PU|ZN_SL|ZP_CS|ZP_IE|ZP_PD|ZP_PDRV0|ZP_PDRV1|ZP_PU|ZP_SL
+ nfet_06v0 L=1U W=1U AS=0.25P AD=0.44P PS=1.5U PD=2.88U
M$1529 \$9107 \$9106
+ VSS|XN_CS|XN_IE|XN_PD|XN_PDRV0|XN_PDRV1|XN_PU|XN_SL|XP_CS|XP_IE|XP_PD|XP_PDRV0|XP_PDRV1|XP_PU|XP_SL|YN_CS|YN_IE|YN_PD|YN_PDRV0|YN_PDRV1|YN_PU|YN_SL|YP_CS|YP_IE|YP_PD|YP_PDRV0|YP_PDRV1|YP_PU|YP_SL|ZN_CS|ZN_IE|ZN_PD|ZN_PDRV0|ZN_PDRV1|ZN_PU|ZN_SL|ZP_CS|ZP_IE|ZP_PD|ZP_PDRV0|ZP_PDRV1|ZP_PU|ZP_SL
+ VSS|XN_CS|XN_IE|XN_PD|XN_PDRV0|XN_PDRV1|XN_PU|XN_SL|XP_CS|XP_IE|XP_PD|XP_PDRV0|XP_PDRV1|XP_PU|XP_SL|YN_CS|YN_IE|YN_PD|YN_PDRV0|YN_PDRV1|YN_PU|YN_SL|YP_CS|YP_IE|YP_PD|YP_PDRV0|YP_PDRV1|YP_PU|YP_SL|ZN_CS|ZN_IE|ZN_PD|ZN_PDRV0|ZN_PDRV1|ZN_PU|ZN_SL|ZP_CS|ZP_IE|ZP_PD|ZP_PDRV0|ZP_PDRV1|ZP_PU|ZP_SL
+ nfet_06v0 L=1U W=1U AS=0.44P AD=0.33P PS=2.88U PD=1.66U
M$1530
+ VSS|XN_CS|XN_IE|XN_PD|XN_PDRV0|XN_PDRV1|XN_PU|XN_SL|XP_CS|XP_IE|XP_PD|XP_PDRV0|XP_PDRV1|XP_PU|XP_SL|YN_CS|YN_IE|YN_PD|YN_PDRV0|YN_PDRV1|YN_PU|YN_SL|YP_CS|YP_IE|YP_PD|YP_PDRV0|YP_PDRV1|YP_PU|YP_SL|ZN_CS|ZN_IE|ZN_PD|ZN_PDRV0|ZN_PDRV1|ZN_PU|ZN_SL|ZP_CS|ZP_IE|ZP_PD|ZP_PDRV0|ZP_PDRV1|ZP_PU|ZP_SL
+ \$9109 \$9107
+ VSS|XN_CS|XN_IE|XN_PD|XN_PDRV0|XN_PDRV1|XN_PU|XN_SL|XP_CS|XP_IE|XP_PD|XP_PDRV0|XP_PDRV1|XP_PU|XP_SL|YN_CS|YN_IE|YN_PD|YN_PDRV0|YN_PDRV1|YN_PU|YN_SL|YP_CS|YP_IE|YP_PD|YP_PDRV0|YP_PDRV1|YP_PU|YP_SL|ZN_CS|ZN_IE|ZN_PD|ZN_PDRV0|ZN_PDRV1|ZN_PU|ZN_SL|ZP_CS|ZP_IE|ZP_PD|ZP_PDRV0|ZP_PDRV1|ZP_PU|ZP_SL
+ nfet_06v0 L=1U W=1U AS=0.33P AD=0.44P PS=1.66U PD=2.88U
M$1531
+ VSS|XN_CS|XN_IE|XN_PD|XN_PDRV0|XN_PDRV1|XN_PU|XN_SL|XP_CS|XP_IE|XP_PD|XP_PDRV0|XP_PDRV1|XP_PU|XP_SL|YN_CS|YN_IE|YN_PD|YN_PDRV0|YN_PDRV1|YN_PU|YN_SL|YP_CS|YP_IE|YP_PD|YP_PDRV0|YP_PDRV1|YP_PU|YP_SL|ZN_CS|ZN_IE|ZN_PD|ZN_PDRV0|ZN_PDRV1|ZN_PU|ZN_SL|ZP_CS|ZP_IE|ZP_PD|ZP_PDRV0|ZP_PDRV1|ZP_PU|ZP_SL
+ \$9110 \$7745
+ VSS|XN_CS|XN_IE|XN_PD|XN_PDRV0|XN_PDRV1|XN_PU|XN_SL|XP_CS|XP_IE|XP_PD|XP_PDRV0|XP_PDRV1|XP_PU|XP_SL|YN_CS|YN_IE|YN_PD|YN_PDRV0|YN_PDRV1|YN_PU|YN_SL|YP_CS|YP_IE|YP_PD|YP_PDRV0|YP_PDRV1|YP_PU|YP_SL|ZN_CS|ZN_IE|ZN_PD|ZN_PDRV0|ZN_PDRV1|ZN_PU|ZN_SL|ZP_CS|ZP_IE|ZP_PD|ZP_PDRV0|ZP_PDRV1|ZP_PU|ZP_SL
+ nfet_06v0 L=1U W=1U AS=0.44P AD=0.44P PS=2.88U PD=2.88U
M$1532 \$9111 \$9109 \$9110
+ VSS|XN_CS|XN_IE|XN_PD|XN_PDRV0|XN_PDRV1|XN_PU|XN_SL|XP_CS|XP_IE|XP_PD|XP_PDRV0|XP_PDRV1|XP_PU|XP_SL|YN_CS|YN_IE|YN_PD|YN_PDRV0|YN_PDRV1|YN_PU|YN_SL|YP_CS|YP_IE|YP_PD|YP_PDRV0|YP_PDRV1|YP_PU|YP_SL|ZN_CS|ZN_IE|ZN_PD|ZN_PDRV0|ZN_PDRV1|ZN_PU|ZN_SL|ZP_CS|ZP_IE|ZP_PD|ZP_PDRV0|ZP_PDRV1|ZP_PU|ZP_SL
+ nfet_06v0 L=1U W=1U AS=0.44P AD=0.25P PS=2.88U PD=1.5U
M$1533
+ VSS|XN_CS|XN_IE|XN_PD|XN_PDRV0|XN_PDRV1|XN_PU|XN_SL|XP_CS|XP_IE|XP_PD|XP_PDRV0|XP_PDRV1|XP_PU|XP_SL|YN_CS|YN_IE|YN_PD|YN_PDRV0|YN_PDRV1|YN_PU|YN_SL|YP_CS|YP_IE|YP_PD|YP_PDRV0|YP_PDRV1|YP_PU|YP_SL|ZN_CS|ZN_IE|ZN_PD|ZN_PDRV0|ZN_PDRV1|ZN_PU|ZN_SL|ZP_CS|ZP_IE|ZP_PD|ZP_PDRV0|ZP_PDRV1|ZP_PU|ZP_SL
+ \$9089 \$9111
+ VSS|XN_CS|XN_IE|XN_PD|XN_PDRV0|XN_PDRV1|XN_PU|XN_SL|XP_CS|XP_IE|XP_PD|XP_PDRV0|XP_PDRV1|XP_PU|XP_SL|YN_CS|YN_IE|YN_PD|YN_PDRV0|YN_PDRV1|YN_PU|YN_SL|YP_CS|YP_IE|YP_PD|YP_PDRV0|YP_PDRV1|YP_PU|YP_SL|ZN_CS|ZN_IE|ZN_PD|ZN_PDRV0|ZN_PDRV1|ZN_PU|ZN_SL|ZP_CS|ZP_IE|ZP_PD|ZP_PDRV0|ZP_PDRV1|ZP_PU|ZP_SL
+ nfet_06v0 L=1U W=1U AS=0.25P AD=0.44P PS=1.5U PD=2.88U
M$1534
+ VSS|XN_CS|XN_IE|XN_PD|XN_PDRV0|XN_PDRV1|XN_PU|XN_SL|XP_CS|XP_IE|XP_PD|XP_PDRV0|XP_PDRV1|XP_PU|XP_SL|YN_CS|YN_IE|YN_PD|YN_PDRV0|YN_PDRV1|YN_PU|YN_SL|YP_CS|YP_IE|YP_PD|YP_PDRV0|YP_PDRV1|YP_PU|YP_SL|ZN_CS|ZN_IE|ZN_PD|ZN_PDRV0|ZN_PDRV1|ZN_PU|ZN_SL|ZP_CS|ZP_IE|ZP_PD|ZP_PDRV0|ZP_PDRV1|ZP_PU|ZP_SL
+ VDD|XN_OE|XP_OE|YN_OE|YP_OE|ZN_OE|ZP_OE
+ VSS|XN_CS|XN_IE|XN_PD|XN_PDRV0|XN_PDRV1|XN_PU|XN_SL|XP_CS|XP_IE|XP_PD|XP_PDRV0|XP_PDRV1|XP_PU|XP_SL|YN_CS|YN_IE|YN_PD|YN_PDRV0|YN_PDRV1|YN_PU|YN_SL|YP_CS|YP_IE|YP_PD|YP_PDRV0|YP_PDRV1|YP_PU|YP_SL|ZN_CS|ZN_IE|ZN_PD|ZN_PDRV0|ZN_PDRV1|ZN_PU|ZN_SL|ZP_CS|ZP_IE|ZP_PD|ZP_PDRV0|ZP_PDRV1|ZP_PU|ZP_SL
+ VSS|XN_CS|XN_IE|XN_PD|XN_PDRV0|XN_PDRV1|XN_PU|XN_SL|XP_CS|XP_IE|XP_PD|XP_PDRV0|XP_PDRV1|XP_PU|XP_SL|YN_CS|YN_IE|YN_PD|YN_PDRV0|YN_PDRV1|YN_PU|YN_SL|YP_CS|YP_IE|YP_PD|YP_PDRV0|YP_PDRV1|YP_PU|YP_SL|ZN_CS|ZN_IE|ZN_PD|ZN_PDRV0|ZN_PDRV1|ZN_PU|ZN_SL|ZP_CS|ZP_IE|ZP_PD|ZP_PDRV0|ZP_PDRV1|ZP_PU|ZP_SL
+ nfet_06v0 L=2U W=1U AS=0.44P AD=0.44P PS=2.88U PD=2.88U
M$1535
+ VSS|XN_CS|XN_IE|XN_PD|XN_PDRV0|XN_PDRV1|XN_PU|XN_SL|XP_CS|XP_IE|XP_PD|XP_PDRV0|XP_PDRV1|XP_PU|XP_SL|YN_CS|YN_IE|YN_PD|YN_PDRV0|YN_PDRV1|YN_PU|YN_SL|YP_CS|YP_IE|YP_PD|YP_PDRV0|YP_PDRV1|YP_PU|YP_SL|ZN_CS|ZN_IE|ZN_PD|ZN_PDRV0|ZN_PDRV1|ZN_PU|ZN_SL|ZP_CS|ZP_IE|ZP_PD|ZP_PDRV0|ZP_PDRV1|ZP_PU|ZP_SL
+ VDD|XN_OE|XP_OE|YN_OE|YP_OE|ZN_OE|ZP_OE
+ VSS|XN_CS|XN_IE|XN_PD|XN_PDRV0|XN_PDRV1|XN_PU|XN_SL|XP_CS|XP_IE|XP_PD|XP_PDRV0|XP_PDRV1|XP_PU|XP_SL|YN_CS|YN_IE|YN_PD|YN_PDRV0|YN_PDRV1|YN_PU|YN_SL|YP_CS|YP_IE|YP_PD|YP_PDRV0|YP_PDRV1|YP_PU|YP_SL|ZN_CS|ZN_IE|ZN_PD|ZN_PDRV0|ZN_PDRV1|ZN_PU|ZN_SL|ZP_CS|ZP_IE|ZP_PD|ZP_PDRV0|ZP_PDRV1|ZP_PU|ZP_SL
+ VSS|XN_CS|XN_IE|XN_PD|XN_PDRV0|XN_PDRV1|XN_PU|XN_SL|XP_CS|XP_IE|XP_PD|XP_PDRV0|XP_PDRV1|XP_PU|XP_SL|YN_CS|YN_IE|YN_PD|YN_PDRV0|YN_PDRV1|YN_PU|YN_SL|YP_CS|YP_IE|YP_PD|YP_PDRV0|YP_PDRV1|YP_PU|YP_SL|ZN_CS|ZN_IE|ZN_PD|ZN_PDRV0|ZN_PDRV1|ZN_PU|ZN_SL|ZP_CS|ZP_IE|ZP_PD|ZP_PDRV0|ZP_PDRV1|ZP_PU|ZP_SL
+ nfet_06v0 L=2U W=9.75U AS=4.29P AD=4.29P PS=20.38U PD=20.38U
M$1536 \$10880 \$10880
+ VSS|XN_CS|XN_IE|XN_PD|XN_PDRV0|XN_PDRV1|XN_PU|XN_SL|XP_CS|XP_IE|XP_PD|XP_PDRV0|XP_PDRV1|XP_PU|XP_SL|YN_CS|YN_IE|YN_PD|YN_PDRV0|YN_PDRV1|YN_PU|YN_SL|YP_CS|YP_IE|YP_PD|YP_PDRV0|YP_PDRV1|YP_PU|YP_SL|ZN_CS|ZN_IE|ZN_PD|ZN_PDRV0|ZN_PDRV1|ZN_PU|ZN_SL|ZP_CS|ZP_IE|ZP_PD|ZP_PDRV0|ZP_PDRV1|ZP_PU|ZP_SL
+ VSS|XN_CS|XN_IE|XN_PD|XN_PDRV0|XN_PDRV1|XN_PU|XN_SL|XP_CS|XP_IE|XP_PD|XP_PDRV0|XP_PDRV1|XP_PU|XP_SL|YN_CS|YN_IE|YN_PD|YN_PDRV0|YN_PDRV1|YN_PU|YN_SL|YP_CS|YP_IE|YP_PD|YP_PDRV0|YP_PDRV1|YP_PU|YP_SL|ZN_CS|ZN_IE|ZN_PD|ZN_PDRV0|ZN_PDRV1|ZN_PU|ZN_SL|ZP_CS|ZP_IE|ZP_PD|ZP_PDRV0|ZP_PDRV1|ZP_PU|ZP_SL
+ nfet_06v0 L=1U W=1U AS=0.44P AD=0.44P PS=2.88U PD=2.88U
M$1537 \$10924 \$10866
+ VSS|XN_CS|XN_IE|XN_PD|XN_PDRV0|XN_PDRV1|XN_PU|XN_SL|XP_CS|XP_IE|XP_PD|XP_PDRV0|XP_PDRV1|XP_PU|XP_SL|YN_CS|YN_IE|YN_PD|YN_PDRV0|YN_PDRV1|YN_PU|YN_SL|YP_CS|YP_IE|YP_PD|YP_PDRV0|YP_PDRV1|YP_PU|YP_SL|ZN_CS|ZN_IE|ZN_PD|ZN_PDRV0|ZN_PDRV1|ZN_PU|ZN_SL|ZP_CS|ZP_IE|ZP_PD|ZP_PDRV0|ZP_PDRV1|ZP_PU|ZP_SL
+ VSS|XN_CS|XN_IE|XN_PD|XN_PDRV0|XN_PDRV1|XN_PU|XN_SL|XP_CS|XP_IE|XP_PD|XP_PDRV0|XP_PDRV1|XP_PU|XP_SL|YN_CS|YN_IE|YN_PD|YN_PDRV0|YN_PDRV1|YN_PU|YN_SL|YP_CS|YP_IE|YP_PD|YP_PDRV0|YP_PDRV1|YP_PU|YP_SL|ZN_CS|ZN_IE|ZN_PD|ZN_PDRV0|ZN_PDRV1|ZN_PU|ZN_SL|ZP_CS|ZP_IE|ZP_PD|ZP_PDRV0|ZP_PDRV1|ZP_PU|ZP_SL
+ nfet_06v0 L=1U W=5U AS=2.2P AD=1.25P PS=10.88U PD=5.5U
M$1538 \$10866 \$10880 \$10924
+ VSS|XN_CS|XN_IE|XN_PD|XN_PDRV0|XN_PDRV1|XN_PU|XN_SL|XP_CS|XP_IE|XP_PD|XP_PDRV0|XP_PDRV1|XP_PU|XP_SL|YN_CS|YN_IE|YN_PD|YN_PDRV0|YN_PDRV1|YN_PU|YN_SL|YP_CS|YP_IE|YP_PD|YP_PDRV0|YP_PDRV1|YP_PU|YP_SL|ZN_CS|ZN_IE|ZN_PD|ZN_PDRV0|ZN_PDRV1|ZN_PU|ZN_SL|ZP_CS|ZP_IE|ZP_PD|ZP_PDRV0|ZP_PDRV1|ZP_PU|ZP_SL
+ nfet_06v0 L=1U W=5U AS=1.25P AD=2.2P PS=5.5U PD=10.88U
M$1539 \$10910 \$11421
+ VSS|XN_CS|XN_IE|XN_PD|XN_PDRV0|XN_PDRV1|XN_PU|XN_SL|XP_CS|XP_IE|XP_PD|XP_PDRV0|XP_PDRV1|XP_PU|XP_SL|YN_CS|YN_IE|YN_PD|YN_PDRV0|YN_PDRV1|YN_PU|YN_SL|YP_CS|YP_IE|YP_PD|YP_PDRV0|YP_PDRV1|YP_PU|YP_SL|ZN_CS|ZN_IE|ZN_PD|ZN_PDRV0|ZN_PDRV1|ZN_PU|ZN_SL|ZP_CS|ZP_IE|ZP_PD|ZP_PDRV0|ZP_PDRV1|ZP_PU|ZP_SL
+ VSS|XN_CS|XN_IE|XN_PD|XN_PDRV0|XN_PDRV1|XN_PU|XN_SL|XP_CS|XP_IE|XP_PD|XP_PDRV0|XP_PDRV1|XP_PU|XP_SL|YN_CS|YN_IE|YN_PD|YN_PDRV0|YN_PDRV1|YN_PU|YN_SL|YP_CS|YP_IE|YP_PD|YP_PDRV0|YP_PDRV1|YP_PU|YP_SL|ZN_CS|ZN_IE|ZN_PD|ZN_PDRV0|ZN_PDRV1|ZN_PU|ZN_SL|ZP_CS|ZP_IE|ZP_PD|ZP_PDRV0|ZP_PDRV1|ZP_PU|ZP_SL
+ nfet_06v0 L=1U W=1U AS=0.44P AD=0.25P PS=2.88U PD=1.5U
M$1540 \$11420 \$11421 \$10910
+ VSS|XN_CS|XN_IE|XN_PD|XN_PDRV0|XN_PDRV1|XN_PU|XN_SL|XP_CS|XP_IE|XP_PD|XP_PDRV0|XP_PDRV1|XP_PU|XP_SL|YN_CS|YN_IE|YN_PD|YN_PDRV0|YN_PDRV1|YN_PU|YN_SL|YP_CS|YP_IE|YP_PD|YP_PDRV0|YP_PDRV1|YP_PU|YP_SL|ZN_CS|ZN_IE|ZN_PD|ZN_PDRV0|ZN_PDRV1|ZN_PU|ZN_SL|ZP_CS|ZP_IE|ZP_PD|ZP_PDRV0|ZP_PDRV1|ZP_PU|ZP_SL
+ nfet_06v0 L=1U W=1U AS=0.25P AD=0.44P PS=1.5U PD=2.88U
M$1541 \$10911 \$11421
+ VSS|XN_CS|XN_IE|XN_PD|XN_PDRV0|XN_PDRV1|XN_PU|XN_SL|XP_CS|XP_IE|XP_PD|XP_PDRV0|XP_PDRV1|XP_PU|XP_SL|YN_CS|YN_IE|YN_PD|YN_PDRV0|YN_PDRV1|YN_PU|YN_SL|YP_CS|YP_IE|YP_PD|YP_PDRV0|YP_PDRV1|YP_PU|YP_SL|ZN_CS|ZN_IE|ZN_PD|ZN_PDRV0|ZN_PDRV1|ZN_PU|ZN_SL|ZP_CS|ZP_IE|ZP_PD|ZP_PDRV0|ZP_PDRV1|ZP_PU|ZP_SL
+ VSS|XN_CS|XN_IE|XN_PD|XN_PDRV0|XN_PDRV1|XN_PU|XN_SL|XP_CS|XP_IE|XP_PD|XP_PDRV0|XP_PDRV1|XP_PU|XP_SL|YN_CS|YN_IE|YN_PD|YN_PDRV0|YN_PDRV1|YN_PU|YN_SL|YP_CS|YP_IE|YP_PD|YP_PDRV0|YP_PDRV1|YP_PU|YP_SL|ZN_CS|ZN_IE|ZN_PD|ZN_PDRV0|ZN_PDRV1|ZN_PU|ZN_SL|ZP_CS|ZP_IE|ZP_PD|ZP_PDRV0|ZP_PDRV1|ZP_PU|ZP_SL
+ nfet_06v0 L=1U W=1U AS=0.44P AD=0.25P PS=2.88U PD=1.5U
M$1542 \$11421 \$11421 \$10911
+ VSS|XN_CS|XN_IE|XN_PD|XN_PDRV0|XN_PDRV1|XN_PU|XN_SL|XP_CS|XP_IE|XP_PD|XP_PDRV0|XP_PDRV1|XP_PU|XP_SL|YN_CS|YN_IE|YN_PD|YN_PDRV0|YN_PDRV1|YN_PU|YN_SL|YP_CS|YP_IE|YP_PD|YP_PDRV0|YP_PDRV1|YP_PU|YP_SL|ZN_CS|ZN_IE|ZN_PD|ZN_PDRV0|ZN_PDRV1|ZN_PU|ZN_SL|ZP_CS|ZP_IE|ZP_PD|ZP_PDRV0|ZP_PDRV1|ZP_PU|ZP_SL
+ nfet_06v0 L=1U W=1U AS=0.25P AD=0.44P PS=1.5U PD=2.88U
M$1543 \$10925 \$10866
+ VSS|XN_CS|XN_IE|XN_PD|XN_PDRV0|XN_PDRV1|XN_PU|XN_SL|XP_CS|XP_IE|XP_PD|XP_PDRV0|XP_PDRV1|XP_PU|XP_SL|YN_CS|YN_IE|YN_PD|YN_PDRV0|YN_PDRV1|YN_PU|YN_SL|YP_CS|YP_IE|YP_PD|YP_PDRV0|YP_PDRV1|YP_PU|YP_SL|ZN_CS|ZN_IE|ZN_PD|ZN_PDRV0|ZN_PDRV1|ZN_PU|ZN_SL|ZP_CS|ZP_IE|ZP_PD|ZP_PDRV0|ZP_PDRV1|ZP_PU|ZP_SL
+ VSS|XN_CS|XN_IE|XN_PD|XN_PDRV0|XN_PDRV1|XN_PU|XN_SL|XP_CS|XP_IE|XP_PD|XP_PDRV0|XP_PDRV1|XP_PU|XP_SL|YN_CS|YN_IE|YN_PD|YN_PDRV0|YN_PDRV1|YN_PU|YN_SL|YP_CS|YP_IE|YP_PD|YP_PDRV0|YP_PDRV1|YP_PU|YP_SL|ZN_CS|ZN_IE|ZN_PD|ZN_PDRV0|ZN_PDRV1|ZN_PU|ZN_SL|ZP_CS|ZP_IE|ZP_PD|ZP_PDRV0|ZP_PDRV1|ZP_PU|ZP_SL
+ nfet_06v0 L=1U W=5U AS=2.2P AD=1.25P PS=10.88U PD=5.5U
M$1544 \$10881 \$10880 \$10925
+ VSS|XN_CS|XN_IE|XN_PD|XN_PDRV0|XN_PDRV1|XN_PU|XN_SL|XP_CS|XP_IE|XP_PD|XP_PDRV0|XP_PDRV1|XP_PU|XP_SL|YN_CS|YN_IE|YN_PD|YN_PDRV0|YN_PDRV1|YN_PU|YN_SL|YP_CS|YP_IE|YP_PD|YP_PDRV0|YP_PDRV1|YP_PU|YP_SL|ZN_CS|ZN_IE|ZN_PD|ZN_PDRV0|ZN_PDRV1|ZN_PU|ZN_SL|ZP_CS|ZP_IE|ZP_PD|ZP_PDRV0|ZP_PDRV1|ZP_PU|ZP_SL
+ nfet_06v0 L=1U W=5U AS=1.25P AD=1.65P PS=5.5U PD=5.66U
M$1545 \$10926 \$10880 \$10881
+ VSS|XN_CS|XN_IE|XN_PD|XN_PDRV0|XN_PDRV1|XN_PU|XN_SL|XP_CS|XP_IE|XP_PD|XP_PDRV0|XP_PDRV1|XP_PU|XP_SL|YN_CS|YN_IE|YN_PD|YN_PDRV0|YN_PDRV1|YN_PU|YN_SL|YP_CS|YP_IE|YP_PD|YP_PDRV0|YP_PDRV1|YP_PU|YP_SL|ZN_CS|ZN_IE|ZN_PD|ZN_PDRV0|ZN_PDRV1|ZN_PU|ZN_SL|ZP_CS|ZP_IE|ZP_PD|ZP_PDRV0|ZP_PDRV1|ZP_PU|ZP_SL
+ nfet_06v0 L=1U W=5U AS=1.65P AD=1.25P PS=5.66U PD=5.5U
M$1546
+ VSS|XN_CS|XN_IE|XN_PD|XN_PDRV0|XN_PDRV1|XN_PU|XN_SL|XP_CS|XP_IE|XP_PD|XP_PDRV0|XP_PDRV1|XP_PU|XP_SL|YN_CS|YN_IE|YN_PD|YN_PDRV0|YN_PDRV1|YN_PU|YN_SL|YP_CS|YP_IE|YP_PD|YP_PDRV0|YP_PDRV1|YP_PU|YP_SL|ZN_CS|ZN_IE|ZN_PD|ZN_PDRV0|ZN_PDRV1|ZN_PU|ZN_SL|ZP_CS|ZP_IE|ZP_PD|ZP_PDRV0|ZP_PDRV1|ZP_PU|ZP_SL
+ \$10866 \$10926
+ VSS|XN_CS|XN_IE|XN_PD|XN_PDRV0|XN_PDRV1|XN_PU|XN_SL|XP_CS|XP_IE|XP_PD|XP_PDRV0|XP_PDRV1|XP_PU|XP_SL|YN_CS|YN_IE|YN_PD|YN_PDRV0|YN_PDRV1|YN_PU|YN_SL|YP_CS|YP_IE|YP_PD|YP_PDRV0|YP_PDRV1|YP_PU|YP_SL|ZN_CS|ZN_IE|ZN_PD|ZN_PDRV0|ZN_PDRV1|ZN_PU|ZN_SL|ZP_CS|ZP_IE|ZP_PD|ZP_PDRV0|ZP_PDRV1|ZP_PU|ZP_SL
+ nfet_06v0 L=1U W=5U AS=1.25P AD=2.2P PS=5.5U PD=10.88U
M$1547 \$10882 \$2457 \$10881
+ VSS|XN_CS|XN_IE|XN_PD|XN_PDRV0|XN_PDRV1|XN_PU|XN_SL|XP_CS|XP_IE|XP_PD|XP_PDRV0|XP_PDRV1|XP_PU|XP_SL|YN_CS|YN_IE|YN_PD|YN_PDRV0|YN_PDRV1|YN_PU|YN_SL|YP_CS|YP_IE|YP_PD|YP_PDRV0|YP_PDRV1|YP_PU|YP_SL|ZN_CS|ZN_IE|ZN_PD|ZN_PDRV0|ZN_PDRV1|ZN_PU|ZN_SL|ZP_CS|ZP_IE|ZP_PD|ZP_PDRV0|ZP_PDRV1|ZP_PU|ZP_SL
+ nfet_06v0 L=1U W=5U AS=2.2P AD=1.3P PS=10.88U PD=5.52U
M$1548 \$10881 \$2457 \$10882
+ VSS|XN_CS|XN_IE|XN_PD|XN_PDRV0|XN_PDRV1|XN_PU|XN_SL|XP_CS|XP_IE|XP_PD|XP_PDRV0|XP_PDRV1|XP_PU|XP_SL|YN_CS|YN_IE|YN_PD|YN_PDRV0|YN_PDRV1|YN_PU|YN_SL|YP_CS|YP_IE|YP_PD|YP_PDRV0|YP_PDRV1|YP_PU|YP_SL|ZN_CS|ZN_IE|ZN_PD|ZN_PDRV0|ZN_PDRV1|ZN_PU|ZN_SL|ZP_CS|ZP_IE|ZP_PD|ZP_PDRV0|ZP_PDRV1|ZP_PU|ZP_SL
+ nfet_06v0 L=1U W=5U AS=1.3P AD=2.2P PS=5.52U PD=10.88U
M$1549 \$10883 \$4856 \$10881
+ VSS|XN_CS|XN_IE|XN_PD|XN_PDRV0|XN_PDRV1|XN_PU|XN_SL|XP_CS|XP_IE|XP_PD|XP_PDRV0|XP_PDRV1|XP_PU|XP_SL|YN_CS|YN_IE|YN_PD|YN_PDRV0|YN_PDRV1|YN_PU|YN_SL|YP_CS|YP_IE|YP_PD|YP_PDRV0|YP_PDRV1|YP_PU|YP_SL|ZN_CS|ZN_IE|ZN_PD|ZN_PDRV0|ZN_PDRV1|ZN_PU|ZN_SL|ZP_CS|ZP_IE|ZP_PD|ZP_PDRV0|ZP_PDRV1|ZP_PU|ZP_SL
+ nfet_06v0 L=1U W=5U AS=2.2P AD=1.3P PS=10.88U PD=5.52U
M$1550 \$10881 \$4856 \$10883
+ VSS|XN_CS|XN_IE|XN_PD|XN_PDRV0|XN_PDRV1|XN_PU|XN_SL|XP_CS|XP_IE|XP_PD|XP_PDRV0|XP_PDRV1|XP_PU|XP_SL|YN_CS|YN_IE|YN_PD|YN_PDRV0|YN_PDRV1|YN_PU|YN_SL|YP_CS|YP_IE|YP_PD|YP_PDRV0|YP_PDRV1|YP_PU|YP_SL|ZN_CS|ZN_IE|ZN_PD|ZN_PDRV0|ZN_PDRV1|ZN_PU|ZN_SL|ZP_CS|ZP_IE|ZP_PD|ZP_PDRV0|ZP_PDRV1|ZP_PU|ZP_SL
+ nfet_06v0 L=1U W=5U AS=1.3P AD=2.2P PS=5.52U PD=10.88U
M$1551 \$10885 \$10880 \$10884
+ VSS|XN_CS|XN_IE|XN_PD|XN_PDRV0|XN_PDRV1|XN_PU|XN_SL|XP_CS|XP_IE|XP_PD|XP_PDRV0|XP_PDRV1|XP_PU|XP_SL|YN_CS|YN_IE|YN_PD|YN_PDRV0|YN_PDRV1|YN_PU|YN_SL|YP_CS|YP_IE|YP_PD|YP_PDRV0|YP_PDRV1|YP_PU|YP_SL|ZN_CS|ZN_IE|ZN_PD|ZN_PDRV0|ZN_PDRV1|ZN_PU|ZN_SL|ZP_CS|ZP_IE|ZP_PD|ZP_PDRV0|ZP_PDRV1|ZP_PU|ZP_SL
+ nfet_06v0 L=1U W=2.5U AS=1.1P AD=0.65P PS=5.88U PD=3.02U
M$1552 \$10884 \$10880 \$10885
+ VSS|XN_CS|XN_IE|XN_PD|XN_PDRV0|XN_PDRV1|XN_PU|XN_SL|XP_CS|XP_IE|XP_PD|XP_PDRV0|XP_PDRV1|XP_PU|XP_SL|YN_CS|YN_IE|YN_PD|YN_PDRV0|YN_PDRV1|YN_PU|YN_SL|YP_CS|YP_IE|YP_PD|YP_PDRV0|YP_PDRV1|YP_PU|YP_SL|ZN_CS|ZN_IE|ZN_PD|ZN_PDRV0|ZN_PDRV1|ZN_PU|ZN_SL|ZP_CS|ZP_IE|ZP_PD|ZP_PDRV0|ZP_PDRV1|ZP_PU|ZP_SL
+ nfet_06v0 L=1U W=2.5U AS=0.65P AD=1.1P PS=3.02U PD=5.88U
M$1553 \$10887 \$10880 \$10886
+ VSS|XN_CS|XN_IE|XN_PD|XN_PDRV0|XN_PDRV1|XN_PU|XN_SL|XP_CS|XP_IE|XP_PD|XP_PDRV0|XP_PDRV1|XP_PU|XP_SL|YN_CS|YN_IE|YN_PD|YN_PDRV0|YN_PDRV1|YN_PU|YN_SL|YP_CS|YP_IE|YP_PD|YP_PDRV0|YP_PDRV1|YP_PU|YP_SL|ZN_CS|ZN_IE|ZN_PD|ZN_PDRV0|ZN_PDRV1|ZN_PU|ZN_SL|ZP_CS|ZP_IE|ZP_PD|ZP_PDRV0|ZP_PDRV1|ZP_PU|ZP_SL
+ nfet_06v0 L=1U W=2.5U AS=1.1P AD=0.65P PS=5.88U PD=3.02U
M$1554 \$10886 \$10880 \$10887
+ VSS|XN_CS|XN_IE|XN_PD|XN_PDRV0|XN_PDRV1|XN_PU|XN_SL|XP_CS|XP_IE|XP_PD|XP_PDRV0|XP_PDRV1|XP_PU|XP_SL|YN_CS|YN_IE|YN_PD|YN_PDRV0|YN_PDRV1|YN_PU|YN_SL|YP_CS|YP_IE|YP_PD|YP_PDRV0|YP_PDRV1|YP_PU|YP_SL|ZN_CS|ZN_IE|ZN_PD|ZN_PDRV0|ZN_PDRV1|ZN_PU|ZN_SL|ZP_CS|ZP_IE|ZP_PD|ZP_PDRV0|ZP_PDRV1|ZP_PU|ZP_SL
+ nfet_06v0 L=1U W=2.5U AS=0.65P AD=1.1P PS=3.02U PD=5.88U
M$1555 \$10884 \$10885
+ VSS|XN_CS|XN_IE|XN_PD|XN_PDRV0|XN_PDRV1|XN_PU|XN_SL|XP_CS|XP_IE|XP_PD|XP_PDRV0|XP_PDRV1|XP_PU|XP_SL|YN_CS|YN_IE|YN_PD|YN_PDRV0|YN_PDRV1|YN_PU|YN_SL|YP_CS|YP_IE|YP_PD|YP_PDRV0|YP_PDRV1|YP_PU|YP_SL|ZN_CS|ZN_IE|ZN_PD|ZN_PDRV0|ZN_PDRV1|ZN_PU|ZN_SL|ZP_CS|ZP_IE|ZP_PD|ZP_PDRV0|ZP_PDRV1|ZP_PU|ZP_SL
+ VSS|XN_CS|XN_IE|XN_PD|XN_PDRV0|XN_PDRV1|XN_PU|XN_SL|XP_CS|XP_IE|XP_PD|XP_PDRV0|XP_PDRV1|XP_PU|XP_SL|YN_CS|YN_IE|YN_PD|YN_PDRV0|YN_PDRV1|YN_PU|YN_SL|YP_CS|YP_IE|YP_PD|YP_PDRV0|YP_PDRV1|YP_PU|YP_SL|ZN_CS|ZN_IE|ZN_PD|ZN_PDRV0|ZN_PDRV1|ZN_PU|ZN_SL|ZP_CS|ZP_IE|ZP_PD|ZP_PDRV0|ZP_PDRV1|ZP_PU|ZP_SL
+ nfet_06v0 L=1U W=2.5U AS=1.1P AD=0.65P PS=5.88U PD=3.02U
M$1556
+ VSS|XN_CS|XN_IE|XN_PD|XN_PDRV0|XN_PDRV1|XN_PU|XN_SL|XP_CS|XP_IE|XP_PD|XP_PDRV0|XP_PDRV1|XP_PU|XP_SL|YN_CS|YN_IE|YN_PD|YN_PDRV0|YN_PDRV1|YN_PU|YN_SL|YP_CS|YP_IE|YP_PD|YP_PDRV0|YP_PDRV1|YP_PU|YP_SL|ZN_CS|ZN_IE|ZN_PD|ZN_PDRV0|ZN_PDRV1|ZN_PU|ZN_SL|ZP_CS|ZP_IE|ZP_PD|ZP_PDRV0|ZP_PDRV1|ZP_PU|ZP_SL
+ \$10885 \$10884
+ VSS|XN_CS|XN_IE|XN_PD|XN_PDRV0|XN_PDRV1|XN_PU|XN_SL|XP_CS|XP_IE|XP_PD|XP_PDRV0|XP_PDRV1|XP_PU|XP_SL|YN_CS|YN_IE|YN_PD|YN_PDRV0|YN_PDRV1|YN_PU|YN_SL|YP_CS|YP_IE|YP_PD|YP_PDRV0|YP_PDRV1|YP_PU|YP_SL|ZN_CS|ZN_IE|ZN_PD|ZN_PDRV0|ZN_PDRV1|ZN_PU|ZN_SL|ZP_CS|ZP_IE|ZP_PD|ZP_PDRV0|ZP_PDRV1|ZP_PU|ZP_SL
+ nfet_06v0 L=1U W=2.5U AS=0.65P AD=0.65P PS=3.02U PD=3.02U
M$1557 \$10884 \$10885
+ VSS|XN_CS|XN_IE|XN_PD|XN_PDRV0|XN_PDRV1|XN_PU|XN_SL|XP_CS|XP_IE|XP_PD|XP_PDRV0|XP_PDRV1|XP_PU|XP_SL|YN_CS|YN_IE|YN_PD|YN_PDRV0|YN_PDRV1|YN_PU|YN_SL|YP_CS|YP_IE|YP_PD|YP_PDRV0|YP_PDRV1|YP_PU|YP_SL|ZN_CS|ZN_IE|ZN_PD|ZN_PDRV0|ZN_PDRV1|ZN_PU|ZN_SL|ZP_CS|ZP_IE|ZP_PD|ZP_PDRV0|ZP_PDRV1|ZP_PU|ZP_SL
+ VSS|XN_CS|XN_IE|XN_PD|XN_PDRV0|XN_PDRV1|XN_PU|XN_SL|XP_CS|XP_IE|XP_PD|XP_PDRV0|XP_PDRV1|XP_PU|XP_SL|YN_CS|YN_IE|YN_PD|YN_PDRV0|YN_PDRV1|YN_PU|YN_SL|YP_CS|YP_IE|YP_PD|YP_PDRV0|YP_PDRV1|YP_PU|YP_SL|ZN_CS|ZN_IE|ZN_PD|ZN_PDRV0|ZN_PDRV1|ZN_PU|ZN_SL|ZP_CS|ZP_IE|ZP_PD|ZP_PDRV0|ZP_PDRV1|ZP_PU|ZP_SL
+ nfet_06v0 L=1U W=2.5U AS=0.65P AD=0.65P PS=3.02U PD=3.02U
M$1558
+ VSS|XN_CS|XN_IE|XN_PD|XN_PDRV0|XN_PDRV1|XN_PU|XN_SL|XP_CS|XP_IE|XP_PD|XP_PDRV0|XP_PDRV1|XP_PU|XP_SL|YN_CS|YN_IE|YN_PD|YN_PDRV0|YN_PDRV1|YN_PU|YN_SL|YP_CS|YP_IE|YP_PD|YP_PDRV0|YP_PDRV1|YP_PU|YP_SL|ZN_CS|ZN_IE|ZN_PD|ZN_PDRV0|ZN_PDRV1|ZN_PU|ZN_SL|ZP_CS|ZP_IE|ZP_PD|ZP_PDRV0|ZP_PDRV1|ZP_PU|ZP_SL
+ \$10885 \$10884
+ VSS|XN_CS|XN_IE|XN_PD|XN_PDRV0|XN_PDRV1|XN_PU|XN_SL|XP_CS|XP_IE|XP_PD|XP_PDRV0|XP_PDRV1|XP_PU|XP_SL|YN_CS|YN_IE|YN_PD|YN_PDRV0|YN_PDRV1|YN_PU|YN_SL|YP_CS|YP_IE|YP_PD|YP_PDRV0|YP_PDRV1|YP_PU|YP_SL|ZN_CS|ZN_IE|ZN_PD|ZN_PDRV0|ZN_PDRV1|ZN_PU|ZN_SL|ZP_CS|ZP_IE|ZP_PD|ZP_PDRV0|ZP_PDRV1|ZP_PU|ZP_SL
+ nfet_06v0 L=1U W=2.5U AS=0.65P AD=1.1P PS=3.02U PD=5.88U
M$1559 \$10886 \$10885
+ VSS|XN_CS|XN_IE|XN_PD|XN_PDRV0|XN_PDRV1|XN_PU|XN_SL|XP_CS|XP_IE|XP_PD|XP_PDRV0|XP_PDRV1|XP_PU|XP_SL|YN_CS|YN_IE|YN_PD|YN_PDRV0|YN_PDRV1|YN_PU|YN_SL|YP_CS|YP_IE|YP_PD|YP_PDRV0|YP_PDRV1|YP_PU|YP_SL|ZN_CS|ZN_IE|ZN_PD|ZN_PDRV0|ZN_PDRV1|ZN_PU|ZN_SL|ZP_CS|ZP_IE|ZP_PD|ZP_PDRV0|ZP_PDRV1|ZP_PU|ZP_SL
+ VSS|XN_CS|XN_IE|XN_PD|XN_PDRV0|XN_PDRV1|XN_PU|XN_SL|XP_CS|XP_IE|XP_PD|XP_PDRV0|XP_PDRV1|XP_PU|XP_SL|YN_CS|YN_IE|YN_PD|YN_PDRV0|YN_PDRV1|YN_PU|YN_SL|YP_CS|YP_IE|YP_PD|YP_PDRV0|YP_PDRV1|YP_PU|YP_SL|ZN_CS|ZN_IE|ZN_PD|ZN_PDRV0|ZN_PDRV1|ZN_PU|ZN_SL|ZP_CS|ZP_IE|ZP_PD|ZP_PDRV0|ZP_PDRV1|ZP_PU|ZP_SL
+ nfet_06v0 L=1U W=2.5U AS=1.1P AD=0.65P PS=5.88U PD=3.02U
M$1560
+ VSS|XN_CS|XN_IE|XN_PD|XN_PDRV0|XN_PDRV1|XN_PU|XN_SL|XP_CS|XP_IE|XP_PD|XP_PDRV0|XP_PDRV1|XP_PU|XP_SL|YN_CS|YN_IE|YN_PD|YN_PDRV0|YN_PDRV1|YN_PU|YN_SL|YP_CS|YP_IE|YP_PD|YP_PDRV0|YP_PDRV1|YP_PU|YP_SL|ZN_CS|ZN_IE|ZN_PD|ZN_PDRV0|ZN_PDRV1|ZN_PU|ZN_SL|ZP_CS|ZP_IE|ZP_PD|ZP_PDRV0|ZP_PDRV1|ZP_PU|ZP_SL
+ \$10885 \$10886
+ VSS|XN_CS|XN_IE|XN_PD|XN_PDRV0|XN_PDRV1|XN_PU|XN_SL|XP_CS|XP_IE|XP_PD|XP_PDRV0|XP_PDRV1|XP_PU|XP_SL|YN_CS|YN_IE|YN_PD|YN_PDRV0|YN_PDRV1|YN_PU|YN_SL|YP_CS|YP_IE|YP_PD|YP_PDRV0|YP_PDRV1|YP_PU|YP_SL|ZN_CS|ZN_IE|ZN_PD|ZN_PDRV0|ZN_PDRV1|ZN_PU|ZN_SL|ZP_CS|ZP_IE|ZP_PD|ZP_PDRV0|ZP_PDRV1|ZP_PU|ZP_SL
+ nfet_06v0 L=1U W=2.5U AS=0.65P AD=0.65P PS=3.02U PD=3.02U
M$1561 \$10886 \$10885
+ VSS|XN_CS|XN_IE|XN_PD|XN_PDRV0|XN_PDRV1|XN_PU|XN_SL|XP_CS|XP_IE|XP_PD|XP_PDRV0|XP_PDRV1|XP_PU|XP_SL|YN_CS|YN_IE|YN_PD|YN_PDRV0|YN_PDRV1|YN_PU|YN_SL|YP_CS|YP_IE|YP_PD|YP_PDRV0|YP_PDRV1|YP_PU|YP_SL|ZN_CS|ZN_IE|ZN_PD|ZN_PDRV0|ZN_PDRV1|ZN_PU|ZN_SL|ZP_CS|ZP_IE|ZP_PD|ZP_PDRV0|ZP_PDRV1|ZP_PU|ZP_SL
+ VSS|XN_CS|XN_IE|XN_PD|XN_PDRV0|XN_PDRV1|XN_PU|XN_SL|XP_CS|XP_IE|XP_PD|XP_PDRV0|XP_PDRV1|XP_PU|XP_SL|YN_CS|YN_IE|YN_PD|YN_PDRV0|YN_PDRV1|YN_PU|YN_SL|YP_CS|YP_IE|YP_PD|YP_PDRV0|YP_PDRV1|YP_PU|YP_SL|ZN_CS|ZN_IE|ZN_PD|ZN_PDRV0|ZN_PDRV1|ZN_PU|ZN_SL|ZP_CS|ZP_IE|ZP_PD|ZP_PDRV0|ZP_PDRV1|ZP_PU|ZP_SL
+ nfet_06v0 L=1U W=2.5U AS=0.65P AD=0.65P PS=3.02U PD=3.02U
M$1562
+ VSS|XN_CS|XN_IE|XN_PD|XN_PDRV0|XN_PDRV1|XN_PU|XN_SL|XP_CS|XP_IE|XP_PD|XP_PDRV0|XP_PDRV1|XP_PU|XP_SL|YN_CS|YN_IE|YN_PD|YN_PDRV0|YN_PDRV1|YN_PU|YN_SL|YP_CS|YP_IE|YP_PD|YP_PDRV0|YP_PDRV1|YP_PU|YP_SL|ZN_CS|ZN_IE|ZN_PD|ZN_PDRV0|ZN_PDRV1|ZN_PU|ZN_SL|ZP_CS|ZP_IE|ZP_PD|ZP_PDRV0|ZP_PDRV1|ZP_PU|ZP_SL
+ \$10885 \$10886
+ VSS|XN_CS|XN_IE|XN_PD|XN_PDRV0|XN_PDRV1|XN_PU|XN_SL|XP_CS|XP_IE|XP_PD|XP_PDRV0|XP_PDRV1|XP_PU|XP_SL|YN_CS|YN_IE|YN_PD|YN_PDRV0|YN_PDRV1|YN_PU|YN_SL|YP_CS|YP_IE|YP_PD|YP_PDRV0|YP_PDRV1|YP_PU|YP_SL|ZN_CS|ZN_IE|ZN_PD|ZN_PDRV0|ZN_PDRV1|ZN_PU|ZN_SL|ZP_CS|ZP_IE|ZP_PD|ZP_PDRV0|ZP_PDRV1|ZP_PU|ZP_SL
+ nfet_06v0 L=1U W=2.5U AS=0.65P AD=1.1P PS=3.02U PD=5.88U
M$1563 \$11116 \$10917 \$10885
+ VSS|XN_CS|XN_IE|XN_PD|XN_PDRV0|XN_PDRV1|XN_PU|XN_SL|XP_CS|XP_IE|XP_PD|XP_PDRV0|XP_PDRV1|XP_PU|XP_SL|YN_CS|YN_IE|YN_PD|YN_PDRV0|YN_PDRV1|YN_PU|YN_SL|YP_CS|YP_IE|YP_PD|YP_PDRV0|YP_PDRV1|YP_PU|YP_SL|ZN_CS|ZN_IE|ZN_PD|ZN_PDRV0|ZN_PDRV1|ZN_PU|ZN_SL|ZP_CS|ZP_IE|ZP_PD|ZP_PDRV0|ZP_PDRV1|ZP_PU|ZP_SL
+ nfet_06v0 L=1U W=2.5U AS=1.1P AD=1.1P PS=5.88U PD=5.88U
M$1564 \$10867 \$10917 \$10887
+ VSS|XN_CS|XN_IE|XN_PD|XN_PDRV0|XN_PDRV1|XN_PU|XN_SL|XP_CS|XP_IE|XP_PD|XP_PDRV0|XP_PDRV1|XP_PU|XP_SL|YN_CS|YN_IE|YN_PD|YN_PDRV0|YN_PDRV1|YN_PU|YN_SL|YP_CS|YP_IE|YP_PD|YP_PDRV0|YP_PDRV1|YP_PU|YP_SL|ZN_CS|ZN_IE|ZN_PD|ZN_PDRV0|ZN_PDRV1|ZN_PU|ZN_SL|ZP_CS|ZP_IE|ZP_PD|ZP_PDRV0|ZP_PDRV1|ZP_PU|ZP_SL
+ nfet_06v0 L=1U W=2.5U AS=1.1P AD=1.1P PS=5.88U PD=5.88U
M$1565 \$10927 \$10866
+ VSS|XN_CS|XN_IE|XN_PD|XN_PDRV0|XN_PDRV1|XN_PU|XN_SL|XP_CS|XP_IE|XP_PD|XP_PDRV0|XP_PDRV1|XP_PU|XP_SL|YN_CS|YN_IE|YN_PD|YN_PDRV0|YN_PDRV1|YN_PU|YN_SL|YP_CS|YP_IE|YP_PD|YP_PDRV0|YP_PDRV1|YP_PU|YP_SL|ZN_CS|ZN_IE|ZN_PD|ZN_PDRV0|ZN_PDRV1|ZN_PU|ZN_SL|ZP_CS|ZP_IE|ZP_PD|ZP_PDRV0|ZP_PDRV1|ZP_PU|ZP_SL
+ VSS|XN_CS|XN_IE|XN_PD|XN_PDRV0|XN_PDRV1|XN_PU|XN_SL|XP_CS|XP_IE|XP_PD|XP_PDRV0|XP_PDRV1|XP_PU|XP_SL|YN_CS|YN_IE|YN_PD|YN_PDRV0|YN_PDRV1|YN_PU|YN_SL|YP_CS|YP_IE|YP_PD|YP_PDRV0|YP_PDRV1|YP_PU|YP_SL|ZN_CS|ZN_IE|ZN_PD|ZN_PDRV0|ZN_PDRV1|ZN_PU|ZN_SL|ZP_CS|ZP_IE|ZP_PD|ZP_PDRV0|ZP_PDRV1|ZP_PU|ZP_SL
+ nfet_06v0 L=1U W=5U AS=2.2P AD=1.25P PS=10.88U PD=5.5U
M$1566 \$10868 \$10880 \$10927
+ VSS|XN_CS|XN_IE|XN_PD|XN_PDRV0|XN_PDRV1|XN_PU|XN_SL|XP_CS|XP_IE|XP_PD|XP_PDRV0|XP_PDRV1|XP_PU|XP_SL|YN_CS|YN_IE|YN_PD|YN_PDRV0|YN_PDRV1|YN_PU|YN_SL|YP_CS|YP_IE|YP_PD|YP_PDRV0|YP_PDRV1|YP_PU|YP_SL|ZN_CS|ZN_IE|ZN_PD|ZN_PDRV0|ZN_PDRV1|ZN_PU|ZN_SL|ZP_CS|ZP_IE|ZP_PD|ZP_PDRV0|ZP_PDRV1|ZP_PU|ZP_SL
+ nfet_06v0 L=1U W=5U AS=1.25P AD=2.2P PS=5.5U PD=10.88U
M$1567 \$10928 \$10869
+ VSS|XN_CS|XN_IE|XN_PD|XN_PDRV0|XN_PDRV1|XN_PU|XN_SL|XP_CS|XP_IE|XP_PD|XP_PDRV0|XP_PDRV1|XP_PU|XP_SL|YN_CS|YN_IE|YN_PD|YN_PDRV0|YN_PDRV1|YN_PU|YN_SL|YP_CS|YP_IE|YP_PD|YP_PDRV0|YP_PDRV1|YP_PU|YP_SL|ZN_CS|ZN_IE|ZN_PD|ZN_PDRV0|ZN_PDRV1|ZN_PU|ZN_SL|ZP_CS|ZP_IE|ZP_PD|ZP_PDRV0|ZP_PDRV1|ZP_PU|ZP_SL
+ VSS|XN_CS|XN_IE|XN_PD|XN_PDRV0|XN_PDRV1|XN_PU|XN_SL|XP_CS|XP_IE|XP_PD|XP_PDRV0|XP_PDRV1|XP_PU|XP_SL|YN_CS|YN_IE|YN_PD|YN_PDRV0|YN_PDRV1|YN_PU|YN_SL|YP_CS|YP_IE|YP_PD|YP_PDRV0|YP_PDRV1|YP_PU|YP_SL|ZN_CS|ZN_IE|ZN_PD|ZN_PDRV0|ZN_PDRV1|ZN_PU|ZN_SL|ZP_CS|ZP_IE|ZP_PD|ZP_PDRV0|ZP_PDRV1|ZP_PU|ZP_SL
+ nfet_06v0 L=1U W=5U AS=2.2P AD=1.25P PS=10.88U PD=5.5U
M$1568 \$10869 \$10880 \$10928
+ VSS|XN_CS|XN_IE|XN_PD|XN_PDRV0|XN_PDRV1|XN_PU|XN_SL|XP_CS|XP_IE|XP_PD|XP_PDRV0|XP_PDRV1|XP_PU|XP_SL|YN_CS|YN_IE|YN_PD|YN_PDRV0|YN_PDRV1|YN_PU|YN_SL|YP_CS|YP_IE|YP_PD|YP_PDRV0|YP_PDRV1|YP_PU|YP_SL|ZN_CS|ZN_IE|ZN_PD|ZN_PDRV0|ZN_PDRV1|ZN_PU|ZN_SL|ZP_CS|ZP_IE|ZP_PD|ZP_PDRV0|ZP_PDRV1|ZP_PU|ZP_SL
+ nfet_06v0 L=1U W=5U AS=1.25P AD=1.65P PS=5.5U PD=5.66U
M$1569 \$10917 \$10917 \$10869
+ VSS|XN_CS|XN_IE|XN_PD|XN_PDRV0|XN_PDRV1|XN_PU|XN_SL|XP_CS|XP_IE|XP_PD|XP_PDRV0|XP_PDRV1|XP_PU|XP_SL|YN_CS|YN_IE|YN_PD|YN_PDRV0|YN_PDRV1|YN_PU|YN_SL|YP_CS|YP_IE|YP_PD|YP_PDRV0|YP_PDRV1|YP_PU|YP_SL|ZN_CS|ZN_IE|ZN_PD|ZN_PDRV0|ZN_PDRV1|ZN_PU|ZN_SL|ZP_CS|ZP_IE|ZP_PD|ZP_PDRV0|ZP_PDRV1|ZP_PU|ZP_SL
+ nfet_06v0 L=1U W=5U AS=1.65P AD=2.2P PS=5.66U PD=10.88U
M$1570 \$10888 \$10887
+ VSS|XN_CS|XN_IE|XN_PD|XN_PDRV0|XN_PDRV1|XN_PU|XN_SL|XP_CS|XP_IE|XP_PD|XP_PDRV0|XP_PDRV1|XP_PU|XP_SL|YN_CS|YN_IE|YN_PD|YN_PDRV0|YN_PDRV1|YN_PU|YN_SL|YP_CS|YP_IE|YP_PD|YP_PDRV0|YP_PDRV1|YP_PU|YP_SL|ZN_CS|ZN_IE|ZN_PD|ZN_PDRV0|ZN_PDRV1|ZN_PU|ZN_SL|ZP_CS|ZP_IE|ZP_PD|ZP_PDRV0|ZP_PDRV1|ZP_PU|ZP_SL
+ VSS|XN_CS|XN_IE|XN_PD|XN_PDRV0|XN_PDRV1|XN_PU|XN_SL|XP_CS|XP_IE|XP_PD|XP_PDRV0|XP_PDRV1|XP_PU|XP_SL|YN_CS|YN_IE|YN_PD|YN_PDRV0|YN_PDRV1|YN_PU|YN_SL|YP_CS|YP_IE|YP_PD|YP_PDRV0|YP_PDRV1|YP_PU|YP_SL|ZN_CS|ZN_IE|ZN_PD|ZN_PDRV0|ZN_PDRV1|ZN_PU|ZN_SL|ZP_CS|ZP_IE|ZP_PD|ZP_PDRV0|ZP_PDRV1|ZP_PU|ZP_SL
+ nfet_06v0 L=1U W=5U AS=2.2P AD=1.3P PS=10.88U PD=5.52U
M$1571
+ VSS|XN_CS|XN_IE|XN_PD|XN_PDRV0|XN_PDRV1|XN_PU|XN_SL|XP_CS|XP_IE|XP_PD|XP_PDRV0|XP_PDRV1|XP_PU|XP_SL|YN_CS|YN_IE|YN_PD|YN_PDRV0|YN_PDRV1|YN_PU|YN_SL|YP_CS|YP_IE|YP_PD|YP_PDRV0|YP_PDRV1|YP_PU|YP_SL|ZN_CS|ZN_IE|ZN_PD|ZN_PDRV0|ZN_PDRV1|ZN_PU|ZN_SL|ZP_CS|ZP_IE|ZP_PD|ZP_PDRV0|ZP_PDRV1|ZP_PU|ZP_SL
+ \$10887 \$10888
+ VSS|XN_CS|XN_IE|XN_PD|XN_PDRV0|XN_PDRV1|XN_PU|XN_SL|XP_CS|XP_IE|XP_PD|XP_PDRV0|XP_PDRV1|XP_PU|XP_SL|YN_CS|YN_IE|YN_PD|YN_PDRV0|YN_PDRV1|YN_PU|YN_SL|YP_CS|YP_IE|YP_PD|YP_PDRV0|YP_PDRV1|YP_PU|YP_SL|ZN_CS|ZN_IE|ZN_PD|ZN_PDRV0|ZN_PDRV1|ZN_PU|ZN_SL|ZP_CS|ZP_IE|ZP_PD|ZP_PDRV0|ZP_PDRV1|ZP_PU|ZP_SL
+ nfet_06v0 L=1U W=5U AS=1.3P AD=1.3P PS=5.52U PD=5.52U
M$1572 \$10888 \$10887
+ VSS|XN_CS|XN_IE|XN_PD|XN_PDRV0|XN_PDRV1|XN_PU|XN_SL|XP_CS|XP_IE|XP_PD|XP_PDRV0|XP_PDRV1|XP_PU|XP_SL|YN_CS|YN_IE|YN_PD|YN_PDRV0|YN_PDRV1|YN_PU|YN_SL|YP_CS|YP_IE|YP_PD|YP_PDRV0|YP_PDRV1|YP_PU|YP_SL|ZN_CS|ZN_IE|ZN_PD|ZN_PDRV0|ZN_PDRV1|ZN_PU|ZN_SL|ZP_CS|ZP_IE|ZP_PD|ZP_PDRV0|ZP_PDRV1|ZP_PU|ZP_SL
+ VSS|XN_CS|XN_IE|XN_PD|XN_PDRV0|XN_PDRV1|XN_PU|XN_SL|XP_CS|XP_IE|XP_PD|XP_PDRV0|XP_PDRV1|XP_PU|XP_SL|YN_CS|YN_IE|YN_PD|YN_PDRV0|YN_PDRV1|YN_PU|YN_SL|YP_CS|YP_IE|YP_PD|YP_PDRV0|YP_PDRV1|YP_PU|YP_SL|ZN_CS|ZN_IE|ZN_PD|ZN_PDRV0|ZN_PDRV1|ZN_PU|ZN_SL|ZP_CS|ZP_IE|ZP_PD|ZP_PDRV0|ZP_PDRV1|ZP_PU|ZP_SL
+ nfet_06v0 L=1U W=5U AS=1.3P AD=2.2P PS=5.52U PD=10.88U
M$1573
+ VSS|XN_CS|XN_IE|XN_PD|XN_PDRV0|XN_PDRV1|XN_PU|XN_SL|XP_CS|XP_IE|XP_PD|XP_PDRV0|XP_PDRV1|XP_PU|XP_SL|YN_CS|YN_IE|YN_PD|YN_PDRV0|YN_PDRV1|YN_PU|YN_SL|YP_CS|YP_IE|YP_PD|YP_PDRV0|YP_PDRV1|YP_PU|YP_SL|ZN_CS|ZN_IE|ZN_PD|ZN_PDRV0|ZN_PDRV1|ZN_PU|ZN_SL|ZP_CS|ZP_IE|ZP_PD|ZP_PDRV0|ZP_PDRV1|ZP_PU|ZP_SL
+ VDD|XN_OE|XP_OE|YN_OE|YP_OE|ZN_OE|ZP_OE
+ VSS|XN_CS|XN_IE|XN_PD|XN_PDRV0|XN_PDRV1|XN_PU|XN_SL|XP_CS|XP_IE|XP_PD|XP_PDRV0|XP_PDRV1|XP_PU|XP_SL|YN_CS|YN_IE|YN_PD|YN_PDRV0|YN_PDRV1|YN_PU|YN_SL|YP_CS|YP_IE|YP_PD|YP_PDRV0|YP_PDRV1|YP_PU|YP_SL|ZN_CS|ZN_IE|ZN_PD|ZN_PDRV0|ZN_PDRV1|ZN_PU|ZN_SL|ZP_CS|ZP_IE|ZP_PD|ZP_PDRV0|ZP_PDRV1|ZP_PU|ZP_SL
+ VSS|XN_CS|XN_IE|XN_PD|XN_PDRV0|XN_PDRV1|XN_PU|XN_SL|XP_CS|XP_IE|XP_PD|XP_PDRV0|XP_PDRV1|XP_PU|XP_SL|YN_CS|YN_IE|YN_PD|YN_PDRV0|YN_PDRV1|YN_PU|YN_SL|YP_CS|YP_IE|YP_PD|YP_PDRV0|YP_PDRV1|YP_PU|YP_SL|ZN_CS|ZN_IE|ZN_PD|ZN_PDRV0|ZN_PDRV1|ZN_PU|ZN_SL|ZP_CS|ZP_IE|ZP_PD|ZP_PDRV0|ZP_PDRV1|ZP_PU|ZP_SL
+ nfet_06v0 L=2U W=9.75U AS=4.29P AD=4.29P PS=20.38U PD=20.38U
M$1574
+ VSS|XN_CS|XN_IE|XN_PD|XN_PDRV0|XN_PDRV1|XN_PU|XN_SL|XP_CS|XP_IE|XP_PD|XP_PDRV0|XP_PDRV1|XP_PU|XP_SL|YN_CS|YN_IE|YN_PD|YN_PDRV0|YN_PDRV1|YN_PU|YN_SL|YP_CS|YP_IE|YP_PD|YP_PDRV0|YP_PDRV1|YP_PU|YP_SL|ZN_CS|ZN_IE|ZN_PD|ZN_PDRV0|ZN_PDRV1|ZN_PU|ZN_SL|ZP_CS|ZP_IE|ZP_PD|ZP_PDRV0|ZP_PDRV1|ZP_PU|ZP_SL
+ VDD|XN_OE|XP_OE|YN_OE|YP_OE|ZN_OE|ZP_OE
+ VSS|XN_CS|XN_IE|XN_PD|XN_PDRV0|XN_PDRV1|XN_PU|XN_SL|XP_CS|XP_IE|XP_PD|XP_PDRV0|XP_PDRV1|XP_PU|XP_SL|YN_CS|YN_IE|YN_PD|YN_PDRV0|YN_PDRV1|YN_PU|YN_SL|YP_CS|YP_IE|YP_PD|YP_PDRV0|YP_PDRV1|YP_PU|YP_SL|ZN_CS|ZN_IE|ZN_PD|ZN_PDRV0|ZN_PDRV1|ZN_PU|ZN_SL|ZP_CS|ZP_IE|ZP_PD|ZP_PDRV0|ZP_PDRV1|ZP_PU|ZP_SL
+ VSS|XN_CS|XN_IE|XN_PD|XN_PDRV0|XN_PDRV1|XN_PU|XN_SL|XP_CS|XP_IE|XP_PD|XP_PDRV0|XP_PDRV1|XP_PU|XP_SL|YN_CS|YN_IE|YN_PD|YN_PDRV0|YN_PDRV1|YN_PU|YN_SL|YP_CS|YP_IE|YP_PD|YP_PDRV0|YP_PDRV1|YP_PU|YP_SL|ZN_CS|ZN_IE|ZN_PD|ZN_PDRV0|ZN_PDRV1|ZN_PU|ZN_SL|ZP_CS|ZP_IE|ZP_PD|ZP_PDRV0|ZP_PDRV1|ZP_PU|ZP_SL
+ nfet_06v0 L=2U W=9.75U AS=4.29P AD=4.29P PS=20.38U PD=20.38U
M$1575 \$10889 \$10889
+ VSS|XN_CS|XN_IE|XN_PD|XN_PDRV0|XN_PDRV1|XN_PU|XN_SL|XP_CS|XP_IE|XP_PD|XP_PDRV0|XP_PDRV1|XP_PU|XP_SL|YN_CS|YN_IE|YN_PD|YN_PDRV0|YN_PDRV1|YN_PU|YN_SL|YP_CS|YP_IE|YP_PD|YP_PDRV0|YP_PDRV1|YP_PU|YP_SL|ZN_CS|ZN_IE|ZN_PD|ZN_PDRV0|ZN_PDRV1|ZN_PU|ZN_SL|ZP_CS|ZP_IE|ZP_PD|ZP_PDRV0|ZP_PDRV1|ZP_PU|ZP_SL
+ VSS|XN_CS|XN_IE|XN_PD|XN_PDRV0|XN_PDRV1|XN_PU|XN_SL|XP_CS|XP_IE|XP_PD|XP_PDRV0|XP_PDRV1|XP_PU|XP_SL|YN_CS|YN_IE|YN_PD|YN_PDRV0|YN_PDRV1|YN_PU|YN_SL|YP_CS|YP_IE|YP_PD|YP_PDRV0|YP_PDRV1|YP_PU|YP_SL|ZN_CS|ZN_IE|ZN_PD|ZN_PDRV0|ZN_PDRV1|ZN_PU|ZN_SL|ZP_CS|ZP_IE|ZP_PD|ZP_PDRV0|ZP_PDRV1|ZP_PU|ZP_SL
+ nfet_06v0 L=1U W=1U AS=0.44P AD=0.44P PS=2.88U PD=2.88U
M$1576 \$10929 \$10870
+ VSS|XN_CS|XN_IE|XN_PD|XN_PDRV0|XN_PDRV1|XN_PU|XN_SL|XP_CS|XP_IE|XP_PD|XP_PDRV0|XP_PDRV1|XP_PU|XP_SL|YN_CS|YN_IE|YN_PD|YN_PDRV0|YN_PDRV1|YN_PU|YN_SL|YP_CS|YP_IE|YP_PD|YP_PDRV0|YP_PDRV1|YP_PU|YP_SL|ZN_CS|ZN_IE|ZN_PD|ZN_PDRV0|ZN_PDRV1|ZN_PU|ZN_SL|ZP_CS|ZP_IE|ZP_PD|ZP_PDRV0|ZP_PDRV1|ZP_PU|ZP_SL
+ VSS|XN_CS|XN_IE|XN_PD|XN_PDRV0|XN_PDRV1|XN_PU|XN_SL|XP_CS|XP_IE|XP_PD|XP_PDRV0|XP_PDRV1|XP_PU|XP_SL|YN_CS|YN_IE|YN_PD|YN_PDRV0|YN_PDRV1|YN_PU|YN_SL|YP_CS|YP_IE|YP_PD|YP_PDRV0|YP_PDRV1|YP_PU|YP_SL|ZN_CS|ZN_IE|ZN_PD|ZN_PDRV0|ZN_PDRV1|ZN_PU|ZN_SL|ZP_CS|ZP_IE|ZP_PD|ZP_PDRV0|ZP_PDRV1|ZP_PU|ZP_SL
+ nfet_06v0 L=1U W=5U AS=2.2P AD=1.25P PS=10.88U PD=5.5U
M$1577 \$10870 \$10889 \$10929
+ VSS|XN_CS|XN_IE|XN_PD|XN_PDRV0|XN_PDRV1|XN_PU|XN_SL|XP_CS|XP_IE|XP_PD|XP_PDRV0|XP_PDRV1|XP_PU|XP_SL|YN_CS|YN_IE|YN_PD|YN_PDRV0|YN_PDRV1|YN_PU|YN_SL|YP_CS|YP_IE|YP_PD|YP_PDRV0|YP_PDRV1|YP_PU|YP_SL|ZN_CS|ZN_IE|ZN_PD|ZN_PDRV0|ZN_PDRV1|ZN_PU|ZN_SL|ZP_CS|ZP_IE|ZP_PD|ZP_PDRV0|ZP_PDRV1|ZP_PU|ZP_SL
+ nfet_06v0 L=1U W=5U AS=1.25P AD=2.2P PS=5.5U PD=10.88U
M$1578 \$10913 \$11424
+ VSS|XN_CS|XN_IE|XN_PD|XN_PDRV0|XN_PDRV1|XN_PU|XN_SL|XP_CS|XP_IE|XP_PD|XP_PDRV0|XP_PDRV1|XP_PU|XP_SL|YN_CS|YN_IE|YN_PD|YN_PDRV0|YN_PDRV1|YN_PU|YN_SL|YP_CS|YP_IE|YP_PD|YP_PDRV0|YP_PDRV1|YP_PU|YP_SL|ZN_CS|ZN_IE|ZN_PD|ZN_PDRV0|ZN_PDRV1|ZN_PU|ZN_SL|ZP_CS|ZP_IE|ZP_PD|ZP_PDRV0|ZP_PDRV1|ZP_PU|ZP_SL
+ VSS|XN_CS|XN_IE|XN_PD|XN_PDRV0|XN_PDRV1|XN_PU|XN_SL|XP_CS|XP_IE|XP_PD|XP_PDRV0|XP_PDRV1|XP_PU|XP_SL|YN_CS|YN_IE|YN_PD|YN_PDRV0|YN_PDRV1|YN_PU|YN_SL|YP_CS|YP_IE|YP_PD|YP_PDRV0|YP_PDRV1|YP_PU|YP_SL|ZN_CS|ZN_IE|ZN_PD|ZN_PDRV0|ZN_PDRV1|ZN_PU|ZN_SL|ZP_CS|ZP_IE|ZP_PD|ZP_PDRV0|ZP_PDRV1|ZP_PU|ZP_SL
+ nfet_06v0 L=1U W=1U AS=0.44P AD=0.25P PS=2.88U PD=1.5U
M$1579 \$11423 \$11424 \$10913
+ VSS|XN_CS|XN_IE|XN_PD|XN_PDRV0|XN_PDRV1|XN_PU|XN_SL|XP_CS|XP_IE|XP_PD|XP_PDRV0|XP_PDRV1|XP_PU|XP_SL|YN_CS|YN_IE|YN_PD|YN_PDRV0|YN_PDRV1|YN_PU|YN_SL|YP_CS|YP_IE|YP_PD|YP_PDRV0|YP_PDRV1|YP_PU|YP_SL|ZN_CS|ZN_IE|ZN_PD|ZN_PDRV0|ZN_PDRV1|ZN_PU|ZN_SL|ZP_CS|ZP_IE|ZP_PD|ZP_PDRV0|ZP_PDRV1|ZP_PU|ZP_SL
+ nfet_06v0 L=1U W=1U AS=0.25P AD=0.44P PS=1.5U PD=2.88U
M$1580 \$10914 \$11424
+ VSS|XN_CS|XN_IE|XN_PD|XN_PDRV0|XN_PDRV1|XN_PU|XN_SL|XP_CS|XP_IE|XP_PD|XP_PDRV0|XP_PDRV1|XP_PU|XP_SL|YN_CS|YN_IE|YN_PD|YN_PDRV0|YN_PDRV1|YN_PU|YN_SL|YP_CS|YP_IE|YP_PD|YP_PDRV0|YP_PDRV1|YP_PU|YP_SL|ZN_CS|ZN_IE|ZN_PD|ZN_PDRV0|ZN_PDRV1|ZN_PU|ZN_SL|ZP_CS|ZP_IE|ZP_PD|ZP_PDRV0|ZP_PDRV1|ZP_PU|ZP_SL
+ VSS|XN_CS|XN_IE|XN_PD|XN_PDRV0|XN_PDRV1|XN_PU|XN_SL|XP_CS|XP_IE|XP_PD|XP_PDRV0|XP_PDRV1|XP_PU|XP_SL|YN_CS|YN_IE|YN_PD|YN_PDRV0|YN_PDRV1|YN_PU|YN_SL|YP_CS|YP_IE|YP_PD|YP_PDRV0|YP_PDRV1|YP_PU|YP_SL|ZN_CS|ZN_IE|ZN_PD|ZN_PDRV0|ZN_PDRV1|ZN_PU|ZN_SL|ZP_CS|ZP_IE|ZP_PD|ZP_PDRV0|ZP_PDRV1|ZP_PU|ZP_SL
+ nfet_06v0 L=1U W=1U AS=0.44P AD=0.25P PS=2.88U PD=1.5U
M$1581 \$11424 \$11424 \$10914
+ VSS|XN_CS|XN_IE|XN_PD|XN_PDRV0|XN_PDRV1|XN_PU|XN_SL|XP_CS|XP_IE|XP_PD|XP_PDRV0|XP_PDRV1|XP_PU|XP_SL|YN_CS|YN_IE|YN_PD|YN_PDRV0|YN_PDRV1|YN_PU|YN_SL|YP_CS|YP_IE|YP_PD|YP_PDRV0|YP_PDRV1|YP_PU|YP_SL|ZN_CS|ZN_IE|ZN_PD|ZN_PDRV0|ZN_PDRV1|ZN_PU|ZN_SL|ZP_CS|ZP_IE|ZP_PD|ZP_PDRV0|ZP_PDRV1|ZP_PU|ZP_SL
+ nfet_06v0 L=1U W=1U AS=0.25P AD=0.44P PS=1.5U PD=2.88U
M$1582 \$10930 \$10870
+ VSS|XN_CS|XN_IE|XN_PD|XN_PDRV0|XN_PDRV1|XN_PU|XN_SL|XP_CS|XP_IE|XP_PD|XP_PDRV0|XP_PDRV1|XP_PU|XP_SL|YN_CS|YN_IE|YN_PD|YN_PDRV0|YN_PDRV1|YN_PU|YN_SL|YP_CS|YP_IE|YP_PD|YP_PDRV0|YP_PDRV1|YP_PU|YP_SL|ZN_CS|ZN_IE|ZN_PD|ZN_PDRV0|ZN_PDRV1|ZN_PU|ZN_SL|ZP_CS|ZP_IE|ZP_PD|ZP_PDRV0|ZP_PDRV1|ZP_PU|ZP_SL
+ VSS|XN_CS|XN_IE|XN_PD|XN_PDRV0|XN_PDRV1|XN_PU|XN_SL|XP_CS|XP_IE|XP_PD|XP_PDRV0|XP_PDRV1|XP_PU|XP_SL|YN_CS|YN_IE|YN_PD|YN_PDRV0|YN_PDRV1|YN_PU|YN_SL|YP_CS|YP_IE|YP_PD|YP_PDRV0|YP_PDRV1|YP_PU|YP_SL|ZN_CS|ZN_IE|ZN_PD|ZN_PDRV0|ZN_PDRV1|ZN_PU|ZN_SL|ZP_CS|ZP_IE|ZP_PD|ZP_PDRV0|ZP_PDRV1|ZP_PU|ZP_SL
+ nfet_06v0 L=1U W=5U AS=2.2P AD=1.25P PS=10.88U PD=5.5U
M$1583 \$10890 \$10889 \$10930
+ VSS|XN_CS|XN_IE|XN_PD|XN_PDRV0|XN_PDRV1|XN_PU|XN_SL|XP_CS|XP_IE|XP_PD|XP_PDRV0|XP_PDRV1|XP_PU|XP_SL|YN_CS|YN_IE|YN_PD|YN_PDRV0|YN_PDRV1|YN_PU|YN_SL|YP_CS|YP_IE|YP_PD|YP_PDRV0|YP_PDRV1|YP_PU|YP_SL|ZN_CS|ZN_IE|ZN_PD|ZN_PDRV0|ZN_PDRV1|ZN_PU|ZN_SL|ZP_CS|ZP_IE|ZP_PD|ZP_PDRV0|ZP_PDRV1|ZP_PU|ZP_SL
+ nfet_06v0 L=1U W=5U AS=1.25P AD=1.65P PS=5.5U PD=5.66U
M$1584 \$10931 \$10889 \$10890
+ VSS|XN_CS|XN_IE|XN_PD|XN_PDRV0|XN_PDRV1|XN_PU|XN_SL|XP_CS|XP_IE|XP_PD|XP_PDRV0|XP_PDRV1|XP_PU|XP_SL|YN_CS|YN_IE|YN_PD|YN_PDRV0|YN_PDRV1|YN_PU|YN_SL|YP_CS|YP_IE|YP_PD|YP_PDRV0|YP_PDRV1|YP_PU|YP_SL|ZN_CS|ZN_IE|ZN_PD|ZN_PDRV0|ZN_PDRV1|ZN_PU|ZN_SL|ZP_CS|ZP_IE|ZP_PD|ZP_PDRV0|ZP_PDRV1|ZP_PU|ZP_SL
+ nfet_06v0 L=1U W=5U AS=1.65P AD=1.25P PS=5.66U PD=5.5U
M$1585
+ VSS|XN_CS|XN_IE|XN_PD|XN_PDRV0|XN_PDRV1|XN_PU|XN_SL|XP_CS|XP_IE|XP_PD|XP_PDRV0|XP_PDRV1|XP_PU|XP_SL|YN_CS|YN_IE|YN_PD|YN_PDRV0|YN_PDRV1|YN_PU|YN_SL|YP_CS|YP_IE|YP_PD|YP_PDRV0|YP_PDRV1|YP_PU|YP_SL|ZN_CS|ZN_IE|ZN_PD|ZN_PDRV0|ZN_PDRV1|ZN_PU|ZN_SL|ZP_CS|ZP_IE|ZP_PD|ZP_PDRV0|ZP_PDRV1|ZP_PU|ZP_SL
+ \$10870 \$10931
+ VSS|XN_CS|XN_IE|XN_PD|XN_PDRV0|XN_PDRV1|XN_PU|XN_SL|XP_CS|XP_IE|XP_PD|XP_PDRV0|XP_PDRV1|XP_PU|XP_SL|YN_CS|YN_IE|YN_PD|YN_PDRV0|YN_PDRV1|YN_PU|YN_SL|YP_CS|YP_IE|YP_PD|YP_PDRV0|YP_PDRV1|YP_PU|YP_SL|ZN_CS|ZN_IE|ZN_PD|ZN_PDRV0|ZN_PDRV1|ZN_PU|ZN_SL|ZP_CS|ZP_IE|ZP_PD|ZP_PDRV0|ZP_PDRV1|ZP_PU|ZP_SL
+ nfet_06v0 L=1U W=5U AS=1.25P AD=2.2P PS=5.5U PD=10.88U
M$1586 \$10891 \$2465 \$10890
+ VSS|XN_CS|XN_IE|XN_PD|XN_PDRV0|XN_PDRV1|XN_PU|XN_SL|XP_CS|XP_IE|XP_PD|XP_PDRV0|XP_PDRV1|XP_PU|XP_SL|YN_CS|YN_IE|YN_PD|YN_PDRV0|YN_PDRV1|YN_PU|YN_SL|YP_CS|YP_IE|YP_PD|YP_PDRV0|YP_PDRV1|YP_PU|YP_SL|ZN_CS|ZN_IE|ZN_PD|ZN_PDRV0|ZN_PDRV1|ZN_PU|ZN_SL|ZP_CS|ZP_IE|ZP_PD|ZP_PDRV0|ZP_PDRV1|ZP_PU|ZP_SL
+ nfet_06v0 L=1U W=5U AS=2.2P AD=1.3P PS=10.88U PD=5.52U
M$1587 \$10890 \$2465 \$10891
+ VSS|XN_CS|XN_IE|XN_PD|XN_PDRV0|XN_PDRV1|XN_PU|XN_SL|XP_CS|XP_IE|XP_PD|XP_PDRV0|XP_PDRV1|XP_PU|XP_SL|YN_CS|YN_IE|YN_PD|YN_PDRV0|YN_PDRV1|YN_PU|YN_SL|YP_CS|YP_IE|YP_PD|YP_PDRV0|YP_PDRV1|YP_PU|YP_SL|ZN_CS|ZN_IE|ZN_PD|ZN_PDRV0|ZN_PDRV1|ZN_PU|ZN_SL|ZP_CS|ZP_IE|ZP_PD|ZP_PDRV0|ZP_PDRV1|ZP_PU|ZP_SL
+ nfet_06v0 L=1U W=5U AS=1.3P AD=2.2P PS=5.52U PD=10.88U
M$1588 \$10892 \$4856 \$10890
+ VSS|XN_CS|XN_IE|XN_PD|XN_PDRV0|XN_PDRV1|XN_PU|XN_SL|XP_CS|XP_IE|XP_PD|XP_PDRV0|XP_PDRV1|XP_PU|XP_SL|YN_CS|YN_IE|YN_PD|YN_PDRV0|YN_PDRV1|YN_PU|YN_SL|YP_CS|YP_IE|YP_PD|YP_PDRV0|YP_PDRV1|YP_PU|YP_SL|ZN_CS|ZN_IE|ZN_PD|ZN_PDRV0|ZN_PDRV1|ZN_PU|ZN_SL|ZP_CS|ZP_IE|ZP_PD|ZP_PDRV0|ZP_PDRV1|ZP_PU|ZP_SL
+ nfet_06v0 L=1U W=5U AS=2.2P AD=1.3P PS=10.88U PD=5.52U
M$1589 \$10890 \$4856 \$10892
+ VSS|XN_CS|XN_IE|XN_PD|XN_PDRV0|XN_PDRV1|XN_PU|XN_SL|XP_CS|XP_IE|XP_PD|XP_PDRV0|XP_PDRV1|XP_PU|XP_SL|YN_CS|YN_IE|YN_PD|YN_PDRV0|YN_PDRV1|YN_PU|YN_SL|YP_CS|YP_IE|YP_PD|YP_PDRV0|YP_PDRV1|YP_PU|YP_SL|ZN_CS|ZN_IE|ZN_PD|ZN_PDRV0|ZN_PDRV1|ZN_PU|ZN_SL|ZP_CS|ZP_IE|ZP_PD|ZP_PDRV0|ZP_PDRV1|ZP_PU|ZP_SL
+ nfet_06v0 L=1U W=5U AS=1.3P AD=2.2P PS=5.52U PD=10.88U
M$1590 \$10894 \$10889 \$10893
+ VSS|XN_CS|XN_IE|XN_PD|XN_PDRV0|XN_PDRV1|XN_PU|XN_SL|XP_CS|XP_IE|XP_PD|XP_PDRV0|XP_PDRV1|XP_PU|XP_SL|YN_CS|YN_IE|YN_PD|YN_PDRV0|YN_PDRV1|YN_PU|YN_SL|YP_CS|YP_IE|YP_PD|YP_PDRV0|YP_PDRV1|YP_PU|YP_SL|ZN_CS|ZN_IE|ZN_PD|ZN_PDRV0|ZN_PDRV1|ZN_PU|ZN_SL|ZP_CS|ZP_IE|ZP_PD|ZP_PDRV0|ZP_PDRV1|ZP_PU|ZP_SL
+ nfet_06v0 L=1U W=2.5U AS=1.1P AD=0.65P PS=5.88U PD=3.02U
M$1591 \$10893 \$10889 \$10894
+ VSS|XN_CS|XN_IE|XN_PD|XN_PDRV0|XN_PDRV1|XN_PU|XN_SL|XP_CS|XP_IE|XP_PD|XP_PDRV0|XP_PDRV1|XP_PU|XP_SL|YN_CS|YN_IE|YN_PD|YN_PDRV0|YN_PDRV1|YN_PU|YN_SL|YP_CS|YP_IE|YP_PD|YP_PDRV0|YP_PDRV1|YP_PU|YP_SL|ZN_CS|ZN_IE|ZN_PD|ZN_PDRV0|ZN_PDRV1|ZN_PU|ZN_SL|ZP_CS|ZP_IE|ZP_PD|ZP_PDRV0|ZP_PDRV1|ZP_PU|ZP_SL
+ nfet_06v0 L=1U W=2.5U AS=0.65P AD=1.1P PS=3.02U PD=5.88U
M$1592 \$10896 \$10889 \$10895
+ VSS|XN_CS|XN_IE|XN_PD|XN_PDRV0|XN_PDRV1|XN_PU|XN_SL|XP_CS|XP_IE|XP_PD|XP_PDRV0|XP_PDRV1|XP_PU|XP_SL|YN_CS|YN_IE|YN_PD|YN_PDRV0|YN_PDRV1|YN_PU|YN_SL|YP_CS|YP_IE|YP_PD|YP_PDRV0|YP_PDRV1|YP_PU|YP_SL|ZN_CS|ZN_IE|ZN_PD|ZN_PDRV0|ZN_PDRV1|ZN_PU|ZN_SL|ZP_CS|ZP_IE|ZP_PD|ZP_PDRV0|ZP_PDRV1|ZP_PU|ZP_SL
+ nfet_06v0 L=1U W=2.5U AS=1.1P AD=0.65P PS=5.88U PD=3.02U
M$1593 \$10895 \$10889 \$10896
+ VSS|XN_CS|XN_IE|XN_PD|XN_PDRV0|XN_PDRV1|XN_PU|XN_SL|XP_CS|XP_IE|XP_PD|XP_PDRV0|XP_PDRV1|XP_PU|XP_SL|YN_CS|YN_IE|YN_PD|YN_PDRV0|YN_PDRV1|YN_PU|YN_SL|YP_CS|YP_IE|YP_PD|YP_PDRV0|YP_PDRV1|YP_PU|YP_SL|ZN_CS|ZN_IE|ZN_PD|ZN_PDRV0|ZN_PDRV1|ZN_PU|ZN_SL|ZP_CS|ZP_IE|ZP_PD|ZP_PDRV0|ZP_PDRV1|ZP_PU|ZP_SL
+ nfet_06v0 L=1U W=2.5U AS=0.65P AD=1.1P PS=3.02U PD=5.88U
M$1594 \$10893 \$10894
+ VSS|XN_CS|XN_IE|XN_PD|XN_PDRV0|XN_PDRV1|XN_PU|XN_SL|XP_CS|XP_IE|XP_PD|XP_PDRV0|XP_PDRV1|XP_PU|XP_SL|YN_CS|YN_IE|YN_PD|YN_PDRV0|YN_PDRV1|YN_PU|YN_SL|YP_CS|YP_IE|YP_PD|YP_PDRV0|YP_PDRV1|YP_PU|YP_SL|ZN_CS|ZN_IE|ZN_PD|ZN_PDRV0|ZN_PDRV1|ZN_PU|ZN_SL|ZP_CS|ZP_IE|ZP_PD|ZP_PDRV0|ZP_PDRV1|ZP_PU|ZP_SL
+ VSS|XN_CS|XN_IE|XN_PD|XN_PDRV0|XN_PDRV1|XN_PU|XN_SL|XP_CS|XP_IE|XP_PD|XP_PDRV0|XP_PDRV1|XP_PU|XP_SL|YN_CS|YN_IE|YN_PD|YN_PDRV0|YN_PDRV1|YN_PU|YN_SL|YP_CS|YP_IE|YP_PD|YP_PDRV0|YP_PDRV1|YP_PU|YP_SL|ZN_CS|ZN_IE|ZN_PD|ZN_PDRV0|ZN_PDRV1|ZN_PU|ZN_SL|ZP_CS|ZP_IE|ZP_PD|ZP_PDRV0|ZP_PDRV1|ZP_PU|ZP_SL
+ nfet_06v0 L=1U W=2.5U AS=1.1P AD=0.65P PS=5.88U PD=3.02U
M$1595
+ VSS|XN_CS|XN_IE|XN_PD|XN_PDRV0|XN_PDRV1|XN_PU|XN_SL|XP_CS|XP_IE|XP_PD|XP_PDRV0|XP_PDRV1|XP_PU|XP_SL|YN_CS|YN_IE|YN_PD|YN_PDRV0|YN_PDRV1|YN_PU|YN_SL|YP_CS|YP_IE|YP_PD|YP_PDRV0|YP_PDRV1|YP_PU|YP_SL|ZN_CS|ZN_IE|ZN_PD|ZN_PDRV0|ZN_PDRV1|ZN_PU|ZN_SL|ZP_CS|ZP_IE|ZP_PD|ZP_PDRV0|ZP_PDRV1|ZP_PU|ZP_SL
+ \$10894 \$10893
+ VSS|XN_CS|XN_IE|XN_PD|XN_PDRV0|XN_PDRV1|XN_PU|XN_SL|XP_CS|XP_IE|XP_PD|XP_PDRV0|XP_PDRV1|XP_PU|XP_SL|YN_CS|YN_IE|YN_PD|YN_PDRV0|YN_PDRV1|YN_PU|YN_SL|YP_CS|YP_IE|YP_PD|YP_PDRV0|YP_PDRV1|YP_PU|YP_SL|ZN_CS|ZN_IE|ZN_PD|ZN_PDRV0|ZN_PDRV1|ZN_PU|ZN_SL|ZP_CS|ZP_IE|ZP_PD|ZP_PDRV0|ZP_PDRV1|ZP_PU|ZP_SL
+ nfet_06v0 L=1U W=2.5U AS=0.65P AD=0.65P PS=3.02U PD=3.02U
M$1596 \$10893 \$10894
+ VSS|XN_CS|XN_IE|XN_PD|XN_PDRV0|XN_PDRV1|XN_PU|XN_SL|XP_CS|XP_IE|XP_PD|XP_PDRV0|XP_PDRV1|XP_PU|XP_SL|YN_CS|YN_IE|YN_PD|YN_PDRV0|YN_PDRV1|YN_PU|YN_SL|YP_CS|YP_IE|YP_PD|YP_PDRV0|YP_PDRV1|YP_PU|YP_SL|ZN_CS|ZN_IE|ZN_PD|ZN_PDRV0|ZN_PDRV1|ZN_PU|ZN_SL|ZP_CS|ZP_IE|ZP_PD|ZP_PDRV0|ZP_PDRV1|ZP_PU|ZP_SL
+ VSS|XN_CS|XN_IE|XN_PD|XN_PDRV0|XN_PDRV1|XN_PU|XN_SL|XP_CS|XP_IE|XP_PD|XP_PDRV0|XP_PDRV1|XP_PU|XP_SL|YN_CS|YN_IE|YN_PD|YN_PDRV0|YN_PDRV1|YN_PU|YN_SL|YP_CS|YP_IE|YP_PD|YP_PDRV0|YP_PDRV1|YP_PU|YP_SL|ZN_CS|ZN_IE|ZN_PD|ZN_PDRV0|ZN_PDRV1|ZN_PU|ZN_SL|ZP_CS|ZP_IE|ZP_PD|ZP_PDRV0|ZP_PDRV1|ZP_PU|ZP_SL
+ nfet_06v0 L=1U W=2.5U AS=0.65P AD=0.65P PS=3.02U PD=3.02U
M$1597
+ VSS|XN_CS|XN_IE|XN_PD|XN_PDRV0|XN_PDRV1|XN_PU|XN_SL|XP_CS|XP_IE|XP_PD|XP_PDRV0|XP_PDRV1|XP_PU|XP_SL|YN_CS|YN_IE|YN_PD|YN_PDRV0|YN_PDRV1|YN_PU|YN_SL|YP_CS|YP_IE|YP_PD|YP_PDRV0|YP_PDRV1|YP_PU|YP_SL|ZN_CS|ZN_IE|ZN_PD|ZN_PDRV0|ZN_PDRV1|ZN_PU|ZN_SL|ZP_CS|ZP_IE|ZP_PD|ZP_PDRV0|ZP_PDRV1|ZP_PU|ZP_SL
+ \$10894 \$10893
+ VSS|XN_CS|XN_IE|XN_PD|XN_PDRV0|XN_PDRV1|XN_PU|XN_SL|XP_CS|XP_IE|XP_PD|XP_PDRV0|XP_PDRV1|XP_PU|XP_SL|YN_CS|YN_IE|YN_PD|YN_PDRV0|YN_PDRV1|YN_PU|YN_SL|YP_CS|YP_IE|YP_PD|YP_PDRV0|YP_PDRV1|YP_PU|YP_SL|ZN_CS|ZN_IE|ZN_PD|ZN_PDRV0|ZN_PDRV1|ZN_PU|ZN_SL|ZP_CS|ZP_IE|ZP_PD|ZP_PDRV0|ZP_PDRV1|ZP_PU|ZP_SL
+ nfet_06v0 L=1U W=2.5U AS=0.65P AD=1.1P PS=3.02U PD=5.88U
M$1598 \$10895 \$10894
+ VSS|XN_CS|XN_IE|XN_PD|XN_PDRV0|XN_PDRV1|XN_PU|XN_SL|XP_CS|XP_IE|XP_PD|XP_PDRV0|XP_PDRV1|XP_PU|XP_SL|YN_CS|YN_IE|YN_PD|YN_PDRV0|YN_PDRV1|YN_PU|YN_SL|YP_CS|YP_IE|YP_PD|YP_PDRV0|YP_PDRV1|YP_PU|YP_SL|ZN_CS|ZN_IE|ZN_PD|ZN_PDRV0|ZN_PDRV1|ZN_PU|ZN_SL|ZP_CS|ZP_IE|ZP_PD|ZP_PDRV0|ZP_PDRV1|ZP_PU|ZP_SL
+ VSS|XN_CS|XN_IE|XN_PD|XN_PDRV0|XN_PDRV1|XN_PU|XN_SL|XP_CS|XP_IE|XP_PD|XP_PDRV0|XP_PDRV1|XP_PU|XP_SL|YN_CS|YN_IE|YN_PD|YN_PDRV0|YN_PDRV1|YN_PU|YN_SL|YP_CS|YP_IE|YP_PD|YP_PDRV0|YP_PDRV1|YP_PU|YP_SL|ZN_CS|ZN_IE|ZN_PD|ZN_PDRV0|ZN_PDRV1|ZN_PU|ZN_SL|ZP_CS|ZP_IE|ZP_PD|ZP_PDRV0|ZP_PDRV1|ZP_PU|ZP_SL
+ nfet_06v0 L=1U W=2.5U AS=1.1P AD=0.65P PS=5.88U PD=3.02U
M$1599
+ VSS|XN_CS|XN_IE|XN_PD|XN_PDRV0|XN_PDRV1|XN_PU|XN_SL|XP_CS|XP_IE|XP_PD|XP_PDRV0|XP_PDRV1|XP_PU|XP_SL|YN_CS|YN_IE|YN_PD|YN_PDRV0|YN_PDRV1|YN_PU|YN_SL|YP_CS|YP_IE|YP_PD|YP_PDRV0|YP_PDRV1|YP_PU|YP_SL|ZN_CS|ZN_IE|ZN_PD|ZN_PDRV0|ZN_PDRV1|ZN_PU|ZN_SL|ZP_CS|ZP_IE|ZP_PD|ZP_PDRV0|ZP_PDRV1|ZP_PU|ZP_SL
+ \$10894 \$10895
+ VSS|XN_CS|XN_IE|XN_PD|XN_PDRV0|XN_PDRV1|XN_PU|XN_SL|XP_CS|XP_IE|XP_PD|XP_PDRV0|XP_PDRV1|XP_PU|XP_SL|YN_CS|YN_IE|YN_PD|YN_PDRV0|YN_PDRV1|YN_PU|YN_SL|YP_CS|YP_IE|YP_PD|YP_PDRV0|YP_PDRV1|YP_PU|YP_SL|ZN_CS|ZN_IE|ZN_PD|ZN_PDRV0|ZN_PDRV1|ZN_PU|ZN_SL|ZP_CS|ZP_IE|ZP_PD|ZP_PDRV0|ZP_PDRV1|ZP_PU|ZP_SL
+ nfet_06v0 L=1U W=2.5U AS=0.65P AD=0.65P PS=3.02U PD=3.02U
M$1600 \$10895 \$10894
+ VSS|XN_CS|XN_IE|XN_PD|XN_PDRV0|XN_PDRV1|XN_PU|XN_SL|XP_CS|XP_IE|XP_PD|XP_PDRV0|XP_PDRV1|XP_PU|XP_SL|YN_CS|YN_IE|YN_PD|YN_PDRV0|YN_PDRV1|YN_PU|YN_SL|YP_CS|YP_IE|YP_PD|YP_PDRV0|YP_PDRV1|YP_PU|YP_SL|ZN_CS|ZN_IE|ZN_PD|ZN_PDRV0|ZN_PDRV1|ZN_PU|ZN_SL|ZP_CS|ZP_IE|ZP_PD|ZP_PDRV0|ZP_PDRV1|ZP_PU|ZP_SL
+ VSS|XN_CS|XN_IE|XN_PD|XN_PDRV0|XN_PDRV1|XN_PU|XN_SL|XP_CS|XP_IE|XP_PD|XP_PDRV0|XP_PDRV1|XP_PU|XP_SL|YN_CS|YN_IE|YN_PD|YN_PDRV0|YN_PDRV1|YN_PU|YN_SL|YP_CS|YP_IE|YP_PD|YP_PDRV0|YP_PDRV1|YP_PU|YP_SL|ZN_CS|ZN_IE|ZN_PD|ZN_PDRV0|ZN_PDRV1|ZN_PU|ZN_SL|ZP_CS|ZP_IE|ZP_PD|ZP_PDRV0|ZP_PDRV1|ZP_PU|ZP_SL
+ nfet_06v0 L=1U W=2.5U AS=0.65P AD=0.65P PS=3.02U PD=3.02U
M$1601
+ VSS|XN_CS|XN_IE|XN_PD|XN_PDRV0|XN_PDRV1|XN_PU|XN_SL|XP_CS|XP_IE|XP_PD|XP_PDRV0|XP_PDRV1|XP_PU|XP_SL|YN_CS|YN_IE|YN_PD|YN_PDRV0|YN_PDRV1|YN_PU|YN_SL|YP_CS|YP_IE|YP_PD|YP_PDRV0|YP_PDRV1|YP_PU|YP_SL|ZN_CS|ZN_IE|ZN_PD|ZN_PDRV0|ZN_PDRV1|ZN_PU|ZN_SL|ZP_CS|ZP_IE|ZP_PD|ZP_PDRV0|ZP_PDRV1|ZP_PU|ZP_SL
+ \$10894 \$10895
+ VSS|XN_CS|XN_IE|XN_PD|XN_PDRV0|XN_PDRV1|XN_PU|XN_SL|XP_CS|XP_IE|XP_PD|XP_PDRV0|XP_PDRV1|XP_PU|XP_SL|YN_CS|YN_IE|YN_PD|YN_PDRV0|YN_PDRV1|YN_PU|YN_SL|YP_CS|YP_IE|YP_PD|YP_PDRV0|YP_PDRV1|YP_PU|YP_SL|ZN_CS|ZN_IE|ZN_PD|ZN_PDRV0|ZN_PDRV1|ZN_PU|ZN_SL|ZP_CS|ZP_IE|ZP_PD|ZP_PDRV0|ZP_PDRV1|ZP_PU|ZP_SL
+ nfet_06v0 L=1U W=2.5U AS=0.65P AD=1.1P PS=3.02U PD=5.88U
M$1602 \$11117 \$10918 \$10894
+ VSS|XN_CS|XN_IE|XN_PD|XN_PDRV0|XN_PDRV1|XN_PU|XN_SL|XP_CS|XP_IE|XP_PD|XP_PDRV0|XP_PDRV1|XP_PU|XP_SL|YN_CS|YN_IE|YN_PD|YN_PDRV0|YN_PDRV1|YN_PU|YN_SL|YP_CS|YP_IE|YP_PD|YP_PDRV0|YP_PDRV1|YP_PU|YP_SL|ZN_CS|ZN_IE|ZN_PD|ZN_PDRV0|ZN_PDRV1|ZN_PU|ZN_SL|ZP_CS|ZP_IE|ZP_PD|ZP_PDRV0|ZP_PDRV1|ZP_PU|ZP_SL
+ nfet_06v0 L=1U W=2.5U AS=1.1P AD=1.1P PS=5.88U PD=5.88U
M$1603 \$10871 \$10918 \$10896
+ VSS|XN_CS|XN_IE|XN_PD|XN_PDRV0|XN_PDRV1|XN_PU|XN_SL|XP_CS|XP_IE|XP_PD|XP_PDRV0|XP_PDRV1|XP_PU|XP_SL|YN_CS|YN_IE|YN_PD|YN_PDRV0|YN_PDRV1|YN_PU|YN_SL|YP_CS|YP_IE|YP_PD|YP_PDRV0|YP_PDRV1|YP_PU|YP_SL|ZN_CS|ZN_IE|ZN_PD|ZN_PDRV0|ZN_PDRV1|ZN_PU|ZN_SL|ZP_CS|ZP_IE|ZP_PD|ZP_PDRV0|ZP_PDRV1|ZP_PU|ZP_SL
+ nfet_06v0 L=1U W=2.5U AS=1.1P AD=1.1P PS=5.88U PD=5.88U
M$1604 \$10934 \$10870
+ VSS|XN_CS|XN_IE|XN_PD|XN_PDRV0|XN_PDRV1|XN_PU|XN_SL|XP_CS|XP_IE|XP_PD|XP_PDRV0|XP_PDRV1|XP_PU|XP_SL|YN_CS|YN_IE|YN_PD|YN_PDRV0|YN_PDRV1|YN_PU|YN_SL|YP_CS|YP_IE|YP_PD|YP_PDRV0|YP_PDRV1|YP_PU|YP_SL|ZN_CS|ZN_IE|ZN_PD|ZN_PDRV0|ZN_PDRV1|ZN_PU|ZN_SL|ZP_CS|ZP_IE|ZP_PD|ZP_PDRV0|ZP_PDRV1|ZP_PU|ZP_SL
+ VSS|XN_CS|XN_IE|XN_PD|XN_PDRV0|XN_PDRV1|XN_PU|XN_SL|XP_CS|XP_IE|XP_PD|XP_PDRV0|XP_PDRV1|XP_PU|XP_SL|YN_CS|YN_IE|YN_PD|YN_PDRV0|YN_PDRV1|YN_PU|YN_SL|YP_CS|YP_IE|YP_PD|YP_PDRV0|YP_PDRV1|YP_PU|YP_SL|ZN_CS|ZN_IE|ZN_PD|ZN_PDRV0|ZN_PDRV1|ZN_PU|ZN_SL|ZP_CS|ZP_IE|ZP_PD|ZP_PDRV0|ZP_PDRV1|ZP_PU|ZP_SL
+ nfet_06v0 L=1U W=5U AS=2.2P AD=1.25P PS=10.88U PD=5.5U
M$1605 \$10872 \$10889 \$10934
+ VSS|XN_CS|XN_IE|XN_PD|XN_PDRV0|XN_PDRV1|XN_PU|XN_SL|XP_CS|XP_IE|XP_PD|XP_PDRV0|XP_PDRV1|XP_PU|XP_SL|YN_CS|YN_IE|YN_PD|YN_PDRV0|YN_PDRV1|YN_PU|YN_SL|YP_CS|YP_IE|YP_PD|YP_PDRV0|YP_PDRV1|YP_PU|YP_SL|ZN_CS|ZN_IE|ZN_PD|ZN_PDRV0|ZN_PDRV1|ZN_PU|ZN_SL|ZP_CS|ZP_IE|ZP_PD|ZP_PDRV0|ZP_PDRV1|ZP_PU|ZP_SL
+ nfet_06v0 L=1U W=5U AS=1.25P AD=2.2P PS=5.5U PD=10.88U
M$1606 \$10935 \$10873
+ VSS|XN_CS|XN_IE|XN_PD|XN_PDRV0|XN_PDRV1|XN_PU|XN_SL|XP_CS|XP_IE|XP_PD|XP_PDRV0|XP_PDRV1|XP_PU|XP_SL|YN_CS|YN_IE|YN_PD|YN_PDRV0|YN_PDRV1|YN_PU|YN_SL|YP_CS|YP_IE|YP_PD|YP_PDRV0|YP_PDRV1|YP_PU|YP_SL|ZN_CS|ZN_IE|ZN_PD|ZN_PDRV0|ZN_PDRV1|ZN_PU|ZN_SL|ZP_CS|ZP_IE|ZP_PD|ZP_PDRV0|ZP_PDRV1|ZP_PU|ZP_SL
+ VSS|XN_CS|XN_IE|XN_PD|XN_PDRV0|XN_PDRV1|XN_PU|XN_SL|XP_CS|XP_IE|XP_PD|XP_PDRV0|XP_PDRV1|XP_PU|XP_SL|YN_CS|YN_IE|YN_PD|YN_PDRV0|YN_PDRV1|YN_PU|YN_SL|YP_CS|YP_IE|YP_PD|YP_PDRV0|YP_PDRV1|YP_PU|YP_SL|ZN_CS|ZN_IE|ZN_PD|ZN_PDRV0|ZN_PDRV1|ZN_PU|ZN_SL|ZP_CS|ZP_IE|ZP_PD|ZP_PDRV0|ZP_PDRV1|ZP_PU|ZP_SL
+ nfet_06v0 L=1U W=5U AS=2.2P AD=1.25P PS=10.88U PD=5.5U
M$1607 \$10873 \$10889 \$10935
+ VSS|XN_CS|XN_IE|XN_PD|XN_PDRV0|XN_PDRV1|XN_PU|XN_SL|XP_CS|XP_IE|XP_PD|XP_PDRV0|XP_PDRV1|XP_PU|XP_SL|YN_CS|YN_IE|YN_PD|YN_PDRV0|YN_PDRV1|YN_PU|YN_SL|YP_CS|YP_IE|YP_PD|YP_PDRV0|YP_PDRV1|YP_PU|YP_SL|ZN_CS|ZN_IE|ZN_PD|ZN_PDRV0|ZN_PDRV1|ZN_PU|ZN_SL|ZP_CS|ZP_IE|ZP_PD|ZP_PDRV0|ZP_PDRV1|ZP_PU|ZP_SL
+ nfet_06v0 L=1U W=5U AS=1.25P AD=1.65P PS=5.5U PD=5.66U
M$1608 \$10918 \$10918 \$10873
+ VSS|XN_CS|XN_IE|XN_PD|XN_PDRV0|XN_PDRV1|XN_PU|XN_SL|XP_CS|XP_IE|XP_PD|XP_PDRV0|XP_PDRV1|XP_PU|XP_SL|YN_CS|YN_IE|YN_PD|YN_PDRV0|YN_PDRV1|YN_PU|YN_SL|YP_CS|YP_IE|YP_PD|YP_PDRV0|YP_PDRV1|YP_PU|YP_SL|ZN_CS|ZN_IE|ZN_PD|ZN_PDRV0|ZN_PDRV1|ZN_PU|ZN_SL|ZP_CS|ZP_IE|ZP_PD|ZP_PDRV0|ZP_PDRV1|ZP_PU|ZP_SL
+ nfet_06v0 L=1U W=5U AS=1.65P AD=2.2P PS=5.66U PD=10.88U
M$1609 \$10907 \$10896
+ VSS|XN_CS|XN_IE|XN_PD|XN_PDRV0|XN_PDRV1|XN_PU|XN_SL|XP_CS|XP_IE|XP_PD|XP_PDRV0|XP_PDRV1|XP_PU|XP_SL|YN_CS|YN_IE|YN_PD|YN_PDRV0|YN_PDRV1|YN_PU|YN_SL|YP_CS|YP_IE|YP_PD|YP_PDRV0|YP_PDRV1|YP_PU|YP_SL|ZN_CS|ZN_IE|ZN_PD|ZN_PDRV0|ZN_PDRV1|ZN_PU|ZN_SL|ZP_CS|ZP_IE|ZP_PD|ZP_PDRV0|ZP_PDRV1|ZP_PU|ZP_SL
+ VSS|XN_CS|XN_IE|XN_PD|XN_PDRV0|XN_PDRV1|XN_PU|XN_SL|XP_CS|XP_IE|XP_PD|XP_PDRV0|XP_PDRV1|XP_PU|XP_SL|YN_CS|YN_IE|YN_PD|YN_PDRV0|YN_PDRV1|YN_PU|YN_SL|YP_CS|YP_IE|YP_PD|YP_PDRV0|YP_PDRV1|YP_PU|YP_SL|ZN_CS|ZN_IE|ZN_PD|ZN_PDRV0|ZN_PDRV1|ZN_PU|ZN_SL|ZP_CS|ZP_IE|ZP_PD|ZP_PDRV0|ZP_PDRV1|ZP_PU|ZP_SL
+ nfet_06v0 L=1U W=5U AS=2.2P AD=1.3P PS=10.88U PD=5.52U
M$1610
+ VSS|XN_CS|XN_IE|XN_PD|XN_PDRV0|XN_PDRV1|XN_PU|XN_SL|XP_CS|XP_IE|XP_PD|XP_PDRV0|XP_PDRV1|XP_PU|XP_SL|YN_CS|YN_IE|YN_PD|YN_PDRV0|YN_PDRV1|YN_PU|YN_SL|YP_CS|YP_IE|YP_PD|YP_PDRV0|YP_PDRV1|YP_PU|YP_SL|ZN_CS|ZN_IE|ZN_PD|ZN_PDRV0|ZN_PDRV1|ZN_PU|ZN_SL|ZP_CS|ZP_IE|ZP_PD|ZP_PDRV0|ZP_PDRV1|ZP_PU|ZP_SL
+ \$10896 \$10907
+ VSS|XN_CS|XN_IE|XN_PD|XN_PDRV0|XN_PDRV1|XN_PU|XN_SL|XP_CS|XP_IE|XP_PD|XP_PDRV0|XP_PDRV1|XP_PU|XP_SL|YN_CS|YN_IE|YN_PD|YN_PDRV0|YN_PDRV1|YN_PU|YN_SL|YP_CS|YP_IE|YP_PD|YP_PDRV0|YP_PDRV1|YP_PU|YP_SL|ZN_CS|ZN_IE|ZN_PD|ZN_PDRV0|ZN_PDRV1|ZN_PU|ZN_SL|ZP_CS|ZP_IE|ZP_PD|ZP_PDRV0|ZP_PDRV1|ZP_PU|ZP_SL
+ nfet_06v0 L=1U W=5U AS=1.3P AD=1.3P PS=5.52U PD=5.52U
M$1611 \$10907 \$10896
+ VSS|XN_CS|XN_IE|XN_PD|XN_PDRV0|XN_PDRV1|XN_PU|XN_SL|XP_CS|XP_IE|XP_PD|XP_PDRV0|XP_PDRV1|XP_PU|XP_SL|YN_CS|YN_IE|YN_PD|YN_PDRV0|YN_PDRV1|YN_PU|YN_SL|YP_CS|YP_IE|YP_PD|YP_PDRV0|YP_PDRV1|YP_PU|YP_SL|ZN_CS|ZN_IE|ZN_PD|ZN_PDRV0|ZN_PDRV1|ZN_PU|ZN_SL|ZP_CS|ZP_IE|ZP_PD|ZP_PDRV0|ZP_PDRV1|ZP_PU|ZP_SL
+ VSS|XN_CS|XN_IE|XN_PD|XN_PDRV0|XN_PDRV1|XN_PU|XN_SL|XP_CS|XP_IE|XP_PD|XP_PDRV0|XP_PDRV1|XP_PU|XP_SL|YN_CS|YN_IE|YN_PD|YN_PDRV0|YN_PDRV1|YN_PU|YN_SL|YP_CS|YP_IE|YP_PD|YP_PDRV0|YP_PDRV1|YP_PU|YP_SL|ZN_CS|ZN_IE|ZN_PD|ZN_PDRV0|ZN_PDRV1|ZN_PU|ZN_SL|ZP_CS|ZP_IE|ZP_PD|ZP_PDRV0|ZP_PDRV1|ZP_PU|ZP_SL
+ nfet_06v0 L=1U W=5U AS=1.3P AD=2.2P PS=5.52U PD=10.88U
M$1612
+ VSS|XN_CS|XN_IE|XN_PD|XN_PDRV0|XN_PDRV1|XN_PU|XN_SL|XP_CS|XP_IE|XP_PD|XP_PDRV0|XP_PDRV1|XP_PU|XP_SL|YN_CS|YN_IE|YN_PD|YN_PDRV0|YN_PDRV1|YN_PU|YN_SL|YP_CS|YP_IE|YP_PD|YP_PDRV0|YP_PDRV1|YP_PU|YP_SL|ZN_CS|ZN_IE|ZN_PD|ZN_PDRV0|ZN_PDRV1|ZN_PU|ZN_SL|ZP_CS|ZP_IE|ZP_PD|ZP_PDRV0|ZP_PDRV1|ZP_PU|ZP_SL
+ VDD|XN_OE|XP_OE|YN_OE|YP_OE|ZN_OE|ZP_OE
+ VSS|XN_CS|XN_IE|XN_PD|XN_PDRV0|XN_PDRV1|XN_PU|XN_SL|XP_CS|XP_IE|XP_PD|XP_PDRV0|XP_PDRV1|XP_PU|XP_SL|YN_CS|YN_IE|YN_PD|YN_PDRV0|YN_PDRV1|YN_PU|YN_SL|YP_CS|YP_IE|YP_PD|YP_PDRV0|YP_PDRV1|YP_PU|YP_SL|ZN_CS|ZN_IE|ZN_PD|ZN_PDRV0|ZN_PDRV1|ZN_PU|ZN_SL|ZP_CS|ZP_IE|ZP_PD|ZP_PDRV0|ZP_PDRV1|ZP_PU|ZP_SL
+ VSS|XN_CS|XN_IE|XN_PD|XN_PDRV0|XN_PDRV1|XN_PU|XN_SL|XP_CS|XP_IE|XP_PD|XP_PDRV0|XP_PDRV1|XP_PU|XP_SL|YN_CS|YN_IE|YN_PD|YN_PDRV0|YN_PDRV1|YN_PU|YN_SL|YP_CS|YP_IE|YP_PD|YP_PDRV0|YP_PDRV1|YP_PU|YP_SL|ZN_CS|ZN_IE|ZN_PD|ZN_PDRV0|ZN_PDRV1|ZN_PU|ZN_SL|ZP_CS|ZP_IE|ZP_PD|ZP_PDRV0|ZP_PDRV1|ZP_PU|ZP_SL
+ nfet_06v0 L=2U W=9.75U AS=4.29P AD=4.29P PS=20.38U PD=20.38U
M$1613
+ VSS|XN_CS|XN_IE|XN_PD|XN_PDRV0|XN_PDRV1|XN_PU|XN_SL|XP_CS|XP_IE|XP_PD|XP_PDRV0|XP_PDRV1|XP_PU|XP_SL|YN_CS|YN_IE|YN_PD|YN_PDRV0|YN_PDRV1|YN_PU|YN_SL|YP_CS|YP_IE|YP_PD|YP_PDRV0|YP_PDRV1|YP_PU|YP_SL|ZN_CS|ZN_IE|ZN_PD|ZN_PDRV0|ZN_PDRV1|ZN_PU|ZN_SL|ZP_CS|ZP_IE|ZP_PD|ZP_PDRV0|ZP_PDRV1|ZP_PU|ZP_SL
+ VDD|XN_OE|XP_OE|YN_OE|YP_OE|ZN_OE|ZP_OE
+ VSS|XN_CS|XN_IE|XN_PD|XN_PDRV0|XN_PDRV1|XN_PU|XN_SL|XP_CS|XP_IE|XP_PD|XP_PDRV0|XP_PDRV1|XP_PU|XP_SL|YN_CS|YN_IE|YN_PD|YN_PDRV0|YN_PDRV1|YN_PU|YN_SL|YP_CS|YP_IE|YP_PD|YP_PDRV0|YP_PDRV1|YP_PU|YP_SL|ZN_CS|ZN_IE|ZN_PD|ZN_PDRV0|ZN_PDRV1|ZN_PU|ZN_SL|ZP_CS|ZP_IE|ZP_PD|ZP_PDRV0|ZP_PDRV1|ZP_PU|ZP_SL
+ VSS|XN_CS|XN_IE|XN_PD|XN_PDRV0|XN_PDRV1|XN_PU|XN_SL|XP_CS|XP_IE|XP_PD|XP_PDRV0|XP_PDRV1|XP_PU|XP_SL|YN_CS|YN_IE|YN_PD|YN_PDRV0|YN_PDRV1|YN_PU|YN_SL|YP_CS|YP_IE|YP_PD|YP_PDRV0|YP_PDRV1|YP_PU|YP_SL|ZN_CS|ZN_IE|ZN_PD|ZN_PDRV0|ZN_PDRV1|ZN_PU|ZN_SL|ZP_CS|ZP_IE|ZP_PD|ZP_PDRV0|ZP_PDRV1|ZP_PU|ZP_SL
+ nfet_06v0 L=2U W=9.75U AS=4.29P AD=4.29P PS=20.38U PD=20.38U
M$1614 \$10897 \$10897
+ VSS|XN_CS|XN_IE|XN_PD|XN_PDRV0|XN_PDRV1|XN_PU|XN_SL|XP_CS|XP_IE|XP_PD|XP_PDRV0|XP_PDRV1|XP_PU|XP_SL|YN_CS|YN_IE|YN_PD|YN_PDRV0|YN_PDRV1|YN_PU|YN_SL|YP_CS|YP_IE|YP_PD|YP_PDRV0|YP_PDRV1|YP_PU|YP_SL|ZN_CS|ZN_IE|ZN_PD|ZN_PDRV0|ZN_PDRV1|ZN_PU|ZN_SL|ZP_CS|ZP_IE|ZP_PD|ZP_PDRV0|ZP_PDRV1|ZP_PU|ZP_SL
+ VSS|XN_CS|XN_IE|XN_PD|XN_PDRV0|XN_PDRV1|XN_PU|XN_SL|XP_CS|XP_IE|XP_PD|XP_PDRV0|XP_PDRV1|XP_PU|XP_SL|YN_CS|YN_IE|YN_PD|YN_PDRV0|YN_PDRV1|YN_PU|YN_SL|YP_CS|YP_IE|YP_PD|YP_PDRV0|YP_PDRV1|YP_PU|YP_SL|ZN_CS|ZN_IE|ZN_PD|ZN_PDRV0|ZN_PDRV1|ZN_PU|ZN_SL|ZP_CS|ZP_IE|ZP_PD|ZP_PDRV0|ZP_PDRV1|ZP_PU|ZP_SL
+ nfet_06v0 L=1U W=1U AS=0.44P AD=0.44P PS=2.88U PD=2.88U
M$1615 \$10938 \$10874
+ VSS|XN_CS|XN_IE|XN_PD|XN_PDRV0|XN_PDRV1|XN_PU|XN_SL|XP_CS|XP_IE|XP_PD|XP_PDRV0|XP_PDRV1|XP_PU|XP_SL|YN_CS|YN_IE|YN_PD|YN_PDRV0|YN_PDRV1|YN_PU|YN_SL|YP_CS|YP_IE|YP_PD|YP_PDRV0|YP_PDRV1|YP_PU|YP_SL|ZN_CS|ZN_IE|ZN_PD|ZN_PDRV0|ZN_PDRV1|ZN_PU|ZN_SL|ZP_CS|ZP_IE|ZP_PD|ZP_PDRV0|ZP_PDRV1|ZP_PU|ZP_SL
+ VSS|XN_CS|XN_IE|XN_PD|XN_PDRV0|XN_PDRV1|XN_PU|XN_SL|XP_CS|XP_IE|XP_PD|XP_PDRV0|XP_PDRV1|XP_PU|XP_SL|YN_CS|YN_IE|YN_PD|YN_PDRV0|YN_PDRV1|YN_PU|YN_SL|YP_CS|YP_IE|YP_PD|YP_PDRV0|YP_PDRV1|YP_PU|YP_SL|ZN_CS|ZN_IE|ZN_PD|ZN_PDRV0|ZN_PDRV1|ZN_PU|ZN_SL|ZP_CS|ZP_IE|ZP_PD|ZP_PDRV0|ZP_PDRV1|ZP_PU|ZP_SL
+ nfet_06v0 L=1U W=5U AS=2.2P AD=1.25P PS=10.88U PD=5.5U
M$1616 \$10874 \$10897 \$10938
+ VSS|XN_CS|XN_IE|XN_PD|XN_PDRV0|XN_PDRV1|XN_PU|XN_SL|XP_CS|XP_IE|XP_PD|XP_PDRV0|XP_PDRV1|XP_PU|XP_SL|YN_CS|YN_IE|YN_PD|YN_PDRV0|YN_PDRV1|YN_PU|YN_SL|YP_CS|YP_IE|YP_PD|YP_PDRV0|YP_PDRV1|YP_PU|YP_SL|ZN_CS|ZN_IE|ZN_PD|ZN_PDRV0|ZN_PDRV1|ZN_PU|ZN_SL|ZP_CS|ZP_IE|ZP_PD|ZP_PDRV0|ZP_PDRV1|ZP_PU|ZP_SL
+ nfet_06v0 L=1U W=5U AS=1.25P AD=2.2P PS=5.5U PD=10.88U
M$1617 \$10916 \$11427
+ VSS|XN_CS|XN_IE|XN_PD|XN_PDRV0|XN_PDRV1|XN_PU|XN_SL|XP_CS|XP_IE|XP_PD|XP_PDRV0|XP_PDRV1|XP_PU|XP_SL|YN_CS|YN_IE|YN_PD|YN_PDRV0|YN_PDRV1|YN_PU|YN_SL|YP_CS|YP_IE|YP_PD|YP_PDRV0|YP_PDRV1|YP_PU|YP_SL|ZN_CS|ZN_IE|ZN_PD|ZN_PDRV0|ZN_PDRV1|ZN_PU|ZN_SL|ZP_CS|ZP_IE|ZP_PD|ZP_PDRV0|ZP_PDRV1|ZP_PU|ZP_SL
+ VSS|XN_CS|XN_IE|XN_PD|XN_PDRV0|XN_PDRV1|XN_PU|XN_SL|XP_CS|XP_IE|XP_PD|XP_PDRV0|XP_PDRV1|XP_PU|XP_SL|YN_CS|YN_IE|YN_PD|YN_PDRV0|YN_PDRV1|YN_PU|YN_SL|YP_CS|YP_IE|YP_PD|YP_PDRV0|YP_PDRV1|YP_PU|YP_SL|ZN_CS|ZN_IE|ZN_PD|ZN_PDRV0|ZN_PDRV1|ZN_PU|ZN_SL|ZP_CS|ZP_IE|ZP_PD|ZP_PDRV0|ZP_PDRV1|ZP_PU|ZP_SL
+ nfet_06v0 L=1U W=1U AS=0.44P AD=0.25P PS=2.88U PD=1.5U
M$1618 \$11426 \$11427 \$10916
+ VSS|XN_CS|XN_IE|XN_PD|XN_PDRV0|XN_PDRV1|XN_PU|XN_SL|XP_CS|XP_IE|XP_PD|XP_PDRV0|XP_PDRV1|XP_PU|XP_SL|YN_CS|YN_IE|YN_PD|YN_PDRV0|YN_PDRV1|YN_PU|YN_SL|YP_CS|YP_IE|YP_PD|YP_PDRV0|YP_PDRV1|YP_PU|YP_SL|ZN_CS|ZN_IE|ZN_PD|ZN_PDRV0|ZN_PDRV1|ZN_PU|ZN_SL|ZP_CS|ZP_IE|ZP_PD|ZP_PDRV0|ZP_PDRV1|ZP_PU|ZP_SL
+ nfet_06v0 L=1U W=1U AS=0.25P AD=0.44P PS=1.5U PD=2.88U
M$1619 \$10915 \$11427
+ VSS|XN_CS|XN_IE|XN_PD|XN_PDRV0|XN_PDRV1|XN_PU|XN_SL|XP_CS|XP_IE|XP_PD|XP_PDRV0|XP_PDRV1|XP_PU|XP_SL|YN_CS|YN_IE|YN_PD|YN_PDRV0|YN_PDRV1|YN_PU|YN_SL|YP_CS|YP_IE|YP_PD|YP_PDRV0|YP_PDRV1|YP_PU|YP_SL|ZN_CS|ZN_IE|ZN_PD|ZN_PDRV0|ZN_PDRV1|ZN_PU|ZN_SL|ZP_CS|ZP_IE|ZP_PD|ZP_PDRV0|ZP_PDRV1|ZP_PU|ZP_SL
+ VSS|XN_CS|XN_IE|XN_PD|XN_PDRV0|XN_PDRV1|XN_PU|XN_SL|XP_CS|XP_IE|XP_PD|XP_PDRV0|XP_PDRV1|XP_PU|XP_SL|YN_CS|YN_IE|YN_PD|YN_PDRV0|YN_PDRV1|YN_PU|YN_SL|YP_CS|YP_IE|YP_PD|YP_PDRV0|YP_PDRV1|YP_PU|YP_SL|ZN_CS|ZN_IE|ZN_PD|ZN_PDRV0|ZN_PDRV1|ZN_PU|ZN_SL|ZP_CS|ZP_IE|ZP_PD|ZP_PDRV0|ZP_PDRV1|ZP_PU|ZP_SL
+ nfet_06v0 L=1U W=1U AS=0.44P AD=0.25P PS=2.88U PD=1.5U
M$1620 \$11427 \$11427 \$10915
+ VSS|XN_CS|XN_IE|XN_PD|XN_PDRV0|XN_PDRV1|XN_PU|XN_SL|XP_CS|XP_IE|XP_PD|XP_PDRV0|XP_PDRV1|XP_PU|XP_SL|YN_CS|YN_IE|YN_PD|YN_PDRV0|YN_PDRV1|YN_PU|YN_SL|YP_CS|YP_IE|YP_PD|YP_PDRV0|YP_PDRV1|YP_PU|YP_SL|ZN_CS|ZN_IE|ZN_PD|ZN_PDRV0|ZN_PDRV1|ZN_PU|ZN_SL|ZP_CS|ZP_IE|ZP_PD|ZP_PDRV0|ZP_PDRV1|ZP_PU|ZP_SL
+ nfet_06v0 L=1U W=1U AS=0.25P AD=0.44P PS=1.5U PD=2.88U
M$1621 \$10937 \$10874
+ VSS|XN_CS|XN_IE|XN_PD|XN_PDRV0|XN_PDRV1|XN_PU|XN_SL|XP_CS|XP_IE|XP_PD|XP_PDRV0|XP_PDRV1|XP_PU|XP_SL|YN_CS|YN_IE|YN_PD|YN_PDRV0|YN_PDRV1|YN_PU|YN_SL|YP_CS|YP_IE|YP_PD|YP_PDRV0|YP_PDRV1|YP_PU|YP_SL|ZN_CS|ZN_IE|ZN_PD|ZN_PDRV0|ZN_PDRV1|ZN_PU|ZN_SL|ZP_CS|ZP_IE|ZP_PD|ZP_PDRV0|ZP_PDRV1|ZP_PU|ZP_SL
+ VSS|XN_CS|XN_IE|XN_PD|XN_PDRV0|XN_PDRV1|XN_PU|XN_SL|XP_CS|XP_IE|XP_PD|XP_PDRV0|XP_PDRV1|XP_PU|XP_SL|YN_CS|YN_IE|YN_PD|YN_PDRV0|YN_PDRV1|YN_PU|YN_SL|YP_CS|YP_IE|YP_PD|YP_PDRV0|YP_PDRV1|YP_PU|YP_SL|ZN_CS|ZN_IE|ZN_PD|ZN_PDRV0|ZN_PDRV1|ZN_PU|ZN_SL|ZP_CS|ZP_IE|ZP_PD|ZP_PDRV0|ZP_PDRV1|ZP_PU|ZP_SL
+ nfet_06v0 L=1U W=5U AS=2.2P AD=1.25P PS=10.88U PD=5.5U
M$1622 \$10898 \$10897 \$10937
+ VSS|XN_CS|XN_IE|XN_PD|XN_PDRV0|XN_PDRV1|XN_PU|XN_SL|XP_CS|XP_IE|XP_PD|XP_PDRV0|XP_PDRV1|XP_PU|XP_SL|YN_CS|YN_IE|YN_PD|YN_PDRV0|YN_PDRV1|YN_PU|YN_SL|YP_CS|YP_IE|YP_PD|YP_PDRV0|YP_PDRV1|YP_PU|YP_SL|ZN_CS|ZN_IE|ZN_PD|ZN_PDRV0|ZN_PDRV1|ZN_PU|ZN_SL|ZP_CS|ZP_IE|ZP_PD|ZP_PDRV0|ZP_PDRV1|ZP_PU|ZP_SL
+ nfet_06v0 L=1U W=5U AS=1.25P AD=1.65P PS=5.5U PD=5.66U
M$1623 \$10936 \$10897 \$10898
+ VSS|XN_CS|XN_IE|XN_PD|XN_PDRV0|XN_PDRV1|XN_PU|XN_SL|XP_CS|XP_IE|XP_PD|XP_PDRV0|XP_PDRV1|XP_PU|XP_SL|YN_CS|YN_IE|YN_PD|YN_PDRV0|YN_PDRV1|YN_PU|YN_SL|YP_CS|YP_IE|YP_PD|YP_PDRV0|YP_PDRV1|YP_PU|YP_SL|ZN_CS|ZN_IE|ZN_PD|ZN_PDRV0|ZN_PDRV1|ZN_PU|ZN_SL|ZP_CS|ZP_IE|ZP_PD|ZP_PDRV0|ZP_PDRV1|ZP_PU|ZP_SL
+ nfet_06v0 L=1U W=5U AS=1.65P AD=1.25P PS=5.66U PD=5.5U
M$1624
+ VSS|XN_CS|XN_IE|XN_PD|XN_PDRV0|XN_PDRV1|XN_PU|XN_SL|XP_CS|XP_IE|XP_PD|XP_PDRV0|XP_PDRV1|XP_PU|XP_SL|YN_CS|YN_IE|YN_PD|YN_PDRV0|YN_PDRV1|YN_PU|YN_SL|YP_CS|YP_IE|YP_PD|YP_PDRV0|YP_PDRV1|YP_PU|YP_SL|ZN_CS|ZN_IE|ZN_PD|ZN_PDRV0|ZN_PDRV1|ZN_PU|ZN_SL|ZP_CS|ZP_IE|ZP_PD|ZP_PDRV0|ZP_PDRV1|ZP_PU|ZP_SL
+ \$10874 \$10936
+ VSS|XN_CS|XN_IE|XN_PD|XN_PDRV0|XN_PDRV1|XN_PU|XN_SL|XP_CS|XP_IE|XP_PD|XP_PDRV0|XP_PDRV1|XP_PU|XP_SL|YN_CS|YN_IE|YN_PD|YN_PDRV0|YN_PDRV1|YN_PU|YN_SL|YP_CS|YP_IE|YP_PD|YP_PDRV0|YP_PDRV1|YP_PU|YP_SL|ZN_CS|ZN_IE|ZN_PD|ZN_PDRV0|ZN_PDRV1|ZN_PU|ZN_SL|ZP_CS|ZP_IE|ZP_PD|ZP_PDRV0|ZP_PDRV1|ZP_PU|ZP_SL
+ nfet_06v0 L=1U W=5U AS=1.25P AD=2.2P PS=5.5U PD=10.88U
M$1625 \$10899 \$2465 \$10898
+ VSS|XN_CS|XN_IE|XN_PD|XN_PDRV0|XN_PDRV1|XN_PU|XN_SL|XP_CS|XP_IE|XP_PD|XP_PDRV0|XP_PDRV1|XP_PU|XP_SL|YN_CS|YN_IE|YN_PD|YN_PDRV0|YN_PDRV1|YN_PU|YN_SL|YP_CS|YP_IE|YP_PD|YP_PDRV0|YP_PDRV1|YP_PU|YP_SL|ZN_CS|ZN_IE|ZN_PD|ZN_PDRV0|ZN_PDRV1|ZN_PU|ZN_SL|ZP_CS|ZP_IE|ZP_PD|ZP_PDRV0|ZP_PDRV1|ZP_PU|ZP_SL
+ nfet_06v0 L=1U W=5U AS=2.2P AD=1.3P PS=10.88U PD=5.52U
M$1626 \$10898 \$2465 \$10899
+ VSS|XN_CS|XN_IE|XN_PD|XN_PDRV0|XN_PDRV1|XN_PU|XN_SL|XP_CS|XP_IE|XP_PD|XP_PDRV0|XP_PDRV1|XP_PU|XP_SL|YN_CS|YN_IE|YN_PD|YN_PDRV0|YN_PDRV1|YN_PU|YN_SL|YP_CS|YP_IE|YP_PD|YP_PDRV0|YP_PDRV1|YP_PU|YP_SL|ZN_CS|ZN_IE|ZN_PD|ZN_PDRV0|ZN_PDRV1|ZN_PU|ZN_SL|ZP_CS|ZP_IE|ZP_PD|ZP_PDRV0|ZP_PDRV1|ZP_PU|ZP_SL
+ nfet_06v0 L=1U W=5U AS=1.3P AD=2.2P PS=5.52U PD=10.88U
M$1627 \$10900 \$2457 \$10898
+ VSS|XN_CS|XN_IE|XN_PD|XN_PDRV0|XN_PDRV1|XN_PU|XN_SL|XP_CS|XP_IE|XP_PD|XP_PDRV0|XP_PDRV1|XP_PU|XP_SL|YN_CS|YN_IE|YN_PD|YN_PDRV0|YN_PDRV1|YN_PU|YN_SL|YP_CS|YP_IE|YP_PD|YP_PDRV0|YP_PDRV1|YP_PU|YP_SL|ZN_CS|ZN_IE|ZN_PD|ZN_PDRV0|ZN_PDRV1|ZN_PU|ZN_SL|ZP_CS|ZP_IE|ZP_PD|ZP_PDRV0|ZP_PDRV1|ZP_PU|ZP_SL
+ nfet_06v0 L=1U W=5U AS=2.2P AD=1.3P PS=10.88U PD=5.52U
M$1628 \$10898 \$2457 \$10900
+ VSS|XN_CS|XN_IE|XN_PD|XN_PDRV0|XN_PDRV1|XN_PU|XN_SL|XP_CS|XP_IE|XP_PD|XP_PDRV0|XP_PDRV1|XP_PU|XP_SL|YN_CS|YN_IE|YN_PD|YN_PDRV0|YN_PDRV1|YN_PU|YN_SL|YP_CS|YP_IE|YP_PD|YP_PDRV0|YP_PDRV1|YP_PU|YP_SL|ZN_CS|ZN_IE|ZN_PD|ZN_PDRV0|ZN_PDRV1|ZN_PU|ZN_SL|ZP_CS|ZP_IE|ZP_PD|ZP_PDRV0|ZP_PDRV1|ZP_PU|ZP_SL
+ nfet_06v0 L=1U W=5U AS=1.3P AD=2.2P PS=5.52U PD=10.88U
M$1629 \$10902 \$10897 \$10901
+ VSS|XN_CS|XN_IE|XN_PD|XN_PDRV0|XN_PDRV1|XN_PU|XN_SL|XP_CS|XP_IE|XP_PD|XP_PDRV0|XP_PDRV1|XP_PU|XP_SL|YN_CS|YN_IE|YN_PD|YN_PDRV0|YN_PDRV1|YN_PU|YN_SL|YP_CS|YP_IE|YP_PD|YP_PDRV0|YP_PDRV1|YP_PU|YP_SL|ZN_CS|ZN_IE|ZN_PD|ZN_PDRV0|ZN_PDRV1|ZN_PU|ZN_SL|ZP_CS|ZP_IE|ZP_PD|ZP_PDRV0|ZP_PDRV1|ZP_PU|ZP_SL
+ nfet_06v0 L=1U W=2.5U AS=1.1P AD=0.65P PS=5.88U PD=3.02U
M$1630 \$10901 \$10897 \$10902
+ VSS|XN_CS|XN_IE|XN_PD|XN_PDRV0|XN_PDRV1|XN_PU|XN_SL|XP_CS|XP_IE|XP_PD|XP_PDRV0|XP_PDRV1|XP_PU|XP_SL|YN_CS|YN_IE|YN_PD|YN_PDRV0|YN_PDRV1|YN_PU|YN_SL|YP_CS|YP_IE|YP_PD|YP_PDRV0|YP_PDRV1|YP_PU|YP_SL|ZN_CS|ZN_IE|ZN_PD|ZN_PDRV0|ZN_PDRV1|ZN_PU|ZN_SL|ZP_CS|ZP_IE|ZP_PD|ZP_PDRV0|ZP_PDRV1|ZP_PU|ZP_SL
+ nfet_06v0 L=1U W=2.5U AS=0.65P AD=1.1P PS=3.02U PD=5.88U
M$1631 \$10904 \$10897 \$10903
+ VSS|XN_CS|XN_IE|XN_PD|XN_PDRV0|XN_PDRV1|XN_PU|XN_SL|XP_CS|XP_IE|XP_PD|XP_PDRV0|XP_PDRV1|XP_PU|XP_SL|YN_CS|YN_IE|YN_PD|YN_PDRV0|YN_PDRV1|YN_PU|YN_SL|YP_CS|YP_IE|YP_PD|YP_PDRV0|YP_PDRV1|YP_PU|YP_SL|ZN_CS|ZN_IE|ZN_PD|ZN_PDRV0|ZN_PDRV1|ZN_PU|ZN_SL|ZP_CS|ZP_IE|ZP_PD|ZP_PDRV0|ZP_PDRV1|ZP_PU|ZP_SL
+ nfet_06v0 L=1U W=2.5U AS=1.1P AD=0.65P PS=5.88U PD=3.02U
M$1632 \$10903 \$10897 \$10904
+ VSS|XN_CS|XN_IE|XN_PD|XN_PDRV0|XN_PDRV1|XN_PU|XN_SL|XP_CS|XP_IE|XP_PD|XP_PDRV0|XP_PDRV1|XP_PU|XP_SL|YN_CS|YN_IE|YN_PD|YN_PDRV0|YN_PDRV1|YN_PU|YN_SL|YP_CS|YP_IE|YP_PD|YP_PDRV0|YP_PDRV1|YP_PU|YP_SL|ZN_CS|ZN_IE|ZN_PD|ZN_PDRV0|ZN_PDRV1|ZN_PU|ZN_SL|ZP_CS|ZP_IE|ZP_PD|ZP_PDRV0|ZP_PDRV1|ZP_PU|ZP_SL
+ nfet_06v0 L=1U W=2.5U AS=0.65P AD=1.1P PS=3.02U PD=5.88U
M$1633 \$10901 \$10902
+ VSS|XN_CS|XN_IE|XN_PD|XN_PDRV0|XN_PDRV1|XN_PU|XN_SL|XP_CS|XP_IE|XP_PD|XP_PDRV0|XP_PDRV1|XP_PU|XP_SL|YN_CS|YN_IE|YN_PD|YN_PDRV0|YN_PDRV1|YN_PU|YN_SL|YP_CS|YP_IE|YP_PD|YP_PDRV0|YP_PDRV1|YP_PU|YP_SL|ZN_CS|ZN_IE|ZN_PD|ZN_PDRV0|ZN_PDRV1|ZN_PU|ZN_SL|ZP_CS|ZP_IE|ZP_PD|ZP_PDRV0|ZP_PDRV1|ZP_PU|ZP_SL
+ VSS|XN_CS|XN_IE|XN_PD|XN_PDRV0|XN_PDRV1|XN_PU|XN_SL|XP_CS|XP_IE|XP_PD|XP_PDRV0|XP_PDRV1|XP_PU|XP_SL|YN_CS|YN_IE|YN_PD|YN_PDRV0|YN_PDRV1|YN_PU|YN_SL|YP_CS|YP_IE|YP_PD|YP_PDRV0|YP_PDRV1|YP_PU|YP_SL|ZN_CS|ZN_IE|ZN_PD|ZN_PDRV0|ZN_PDRV1|ZN_PU|ZN_SL|ZP_CS|ZP_IE|ZP_PD|ZP_PDRV0|ZP_PDRV1|ZP_PU|ZP_SL
+ nfet_06v0 L=1U W=2.5U AS=1.1P AD=0.65P PS=5.88U PD=3.02U
M$1634
+ VSS|XN_CS|XN_IE|XN_PD|XN_PDRV0|XN_PDRV1|XN_PU|XN_SL|XP_CS|XP_IE|XP_PD|XP_PDRV0|XP_PDRV1|XP_PU|XP_SL|YN_CS|YN_IE|YN_PD|YN_PDRV0|YN_PDRV1|YN_PU|YN_SL|YP_CS|YP_IE|YP_PD|YP_PDRV0|YP_PDRV1|YP_PU|YP_SL|ZN_CS|ZN_IE|ZN_PD|ZN_PDRV0|ZN_PDRV1|ZN_PU|ZN_SL|ZP_CS|ZP_IE|ZP_PD|ZP_PDRV0|ZP_PDRV1|ZP_PU|ZP_SL
+ \$10902 \$10901
+ VSS|XN_CS|XN_IE|XN_PD|XN_PDRV0|XN_PDRV1|XN_PU|XN_SL|XP_CS|XP_IE|XP_PD|XP_PDRV0|XP_PDRV1|XP_PU|XP_SL|YN_CS|YN_IE|YN_PD|YN_PDRV0|YN_PDRV1|YN_PU|YN_SL|YP_CS|YP_IE|YP_PD|YP_PDRV0|YP_PDRV1|YP_PU|YP_SL|ZN_CS|ZN_IE|ZN_PD|ZN_PDRV0|ZN_PDRV1|ZN_PU|ZN_SL|ZP_CS|ZP_IE|ZP_PD|ZP_PDRV0|ZP_PDRV1|ZP_PU|ZP_SL
+ nfet_06v0 L=1U W=2.5U AS=0.65P AD=0.65P PS=3.02U PD=3.02U
M$1635 \$10901 \$10902
+ VSS|XN_CS|XN_IE|XN_PD|XN_PDRV0|XN_PDRV1|XN_PU|XN_SL|XP_CS|XP_IE|XP_PD|XP_PDRV0|XP_PDRV1|XP_PU|XP_SL|YN_CS|YN_IE|YN_PD|YN_PDRV0|YN_PDRV1|YN_PU|YN_SL|YP_CS|YP_IE|YP_PD|YP_PDRV0|YP_PDRV1|YP_PU|YP_SL|ZN_CS|ZN_IE|ZN_PD|ZN_PDRV0|ZN_PDRV1|ZN_PU|ZN_SL|ZP_CS|ZP_IE|ZP_PD|ZP_PDRV0|ZP_PDRV1|ZP_PU|ZP_SL
+ VSS|XN_CS|XN_IE|XN_PD|XN_PDRV0|XN_PDRV1|XN_PU|XN_SL|XP_CS|XP_IE|XP_PD|XP_PDRV0|XP_PDRV1|XP_PU|XP_SL|YN_CS|YN_IE|YN_PD|YN_PDRV0|YN_PDRV1|YN_PU|YN_SL|YP_CS|YP_IE|YP_PD|YP_PDRV0|YP_PDRV1|YP_PU|YP_SL|ZN_CS|ZN_IE|ZN_PD|ZN_PDRV0|ZN_PDRV1|ZN_PU|ZN_SL|ZP_CS|ZP_IE|ZP_PD|ZP_PDRV0|ZP_PDRV1|ZP_PU|ZP_SL
+ nfet_06v0 L=1U W=2.5U AS=0.65P AD=0.65P PS=3.02U PD=3.02U
M$1636
+ VSS|XN_CS|XN_IE|XN_PD|XN_PDRV0|XN_PDRV1|XN_PU|XN_SL|XP_CS|XP_IE|XP_PD|XP_PDRV0|XP_PDRV1|XP_PU|XP_SL|YN_CS|YN_IE|YN_PD|YN_PDRV0|YN_PDRV1|YN_PU|YN_SL|YP_CS|YP_IE|YP_PD|YP_PDRV0|YP_PDRV1|YP_PU|YP_SL|ZN_CS|ZN_IE|ZN_PD|ZN_PDRV0|ZN_PDRV1|ZN_PU|ZN_SL|ZP_CS|ZP_IE|ZP_PD|ZP_PDRV0|ZP_PDRV1|ZP_PU|ZP_SL
+ \$10902 \$10901
+ VSS|XN_CS|XN_IE|XN_PD|XN_PDRV0|XN_PDRV1|XN_PU|XN_SL|XP_CS|XP_IE|XP_PD|XP_PDRV0|XP_PDRV1|XP_PU|XP_SL|YN_CS|YN_IE|YN_PD|YN_PDRV0|YN_PDRV1|YN_PU|YN_SL|YP_CS|YP_IE|YP_PD|YP_PDRV0|YP_PDRV1|YP_PU|YP_SL|ZN_CS|ZN_IE|ZN_PD|ZN_PDRV0|ZN_PDRV1|ZN_PU|ZN_SL|ZP_CS|ZP_IE|ZP_PD|ZP_PDRV0|ZP_PDRV1|ZP_PU|ZP_SL
+ nfet_06v0 L=1U W=2.5U AS=0.65P AD=1.1P PS=3.02U PD=5.88U
M$1637 \$10903 \$10902
+ VSS|XN_CS|XN_IE|XN_PD|XN_PDRV0|XN_PDRV1|XN_PU|XN_SL|XP_CS|XP_IE|XP_PD|XP_PDRV0|XP_PDRV1|XP_PU|XP_SL|YN_CS|YN_IE|YN_PD|YN_PDRV0|YN_PDRV1|YN_PU|YN_SL|YP_CS|YP_IE|YP_PD|YP_PDRV0|YP_PDRV1|YP_PU|YP_SL|ZN_CS|ZN_IE|ZN_PD|ZN_PDRV0|ZN_PDRV1|ZN_PU|ZN_SL|ZP_CS|ZP_IE|ZP_PD|ZP_PDRV0|ZP_PDRV1|ZP_PU|ZP_SL
+ VSS|XN_CS|XN_IE|XN_PD|XN_PDRV0|XN_PDRV1|XN_PU|XN_SL|XP_CS|XP_IE|XP_PD|XP_PDRV0|XP_PDRV1|XP_PU|XP_SL|YN_CS|YN_IE|YN_PD|YN_PDRV0|YN_PDRV1|YN_PU|YN_SL|YP_CS|YP_IE|YP_PD|YP_PDRV0|YP_PDRV1|YP_PU|YP_SL|ZN_CS|ZN_IE|ZN_PD|ZN_PDRV0|ZN_PDRV1|ZN_PU|ZN_SL|ZP_CS|ZP_IE|ZP_PD|ZP_PDRV0|ZP_PDRV1|ZP_PU|ZP_SL
+ nfet_06v0 L=1U W=2.5U AS=1.1P AD=0.65P PS=5.88U PD=3.02U
M$1638
+ VSS|XN_CS|XN_IE|XN_PD|XN_PDRV0|XN_PDRV1|XN_PU|XN_SL|XP_CS|XP_IE|XP_PD|XP_PDRV0|XP_PDRV1|XP_PU|XP_SL|YN_CS|YN_IE|YN_PD|YN_PDRV0|YN_PDRV1|YN_PU|YN_SL|YP_CS|YP_IE|YP_PD|YP_PDRV0|YP_PDRV1|YP_PU|YP_SL|ZN_CS|ZN_IE|ZN_PD|ZN_PDRV0|ZN_PDRV1|ZN_PU|ZN_SL|ZP_CS|ZP_IE|ZP_PD|ZP_PDRV0|ZP_PDRV1|ZP_PU|ZP_SL
+ \$10902 \$10903
+ VSS|XN_CS|XN_IE|XN_PD|XN_PDRV0|XN_PDRV1|XN_PU|XN_SL|XP_CS|XP_IE|XP_PD|XP_PDRV0|XP_PDRV1|XP_PU|XP_SL|YN_CS|YN_IE|YN_PD|YN_PDRV0|YN_PDRV1|YN_PU|YN_SL|YP_CS|YP_IE|YP_PD|YP_PDRV0|YP_PDRV1|YP_PU|YP_SL|ZN_CS|ZN_IE|ZN_PD|ZN_PDRV0|ZN_PDRV1|ZN_PU|ZN_SL|ZP_CS|ZP_IE|ZP_PD|ZP_PDRV0|ZP_PDRV1|ZP_PU|ZP_SL
+ nfet_06v0 L=1U W=2.5U AS=0.65P AD=0.65P PS=3.02U PD=3.02U
M$1639 \$10903 \$10902
+ VSS|XN_CS|XN_IE|XN_PD|XN_PDRV0|XN_PDRV1|XN_PU|XN_SL|XP_CS|XP_IE|XP_PD|XP_PDRV0|XP_PDRV1|XP_PU|XP_SL|YN_CS|YN_IE|YN_PD|YN_PDRV0|YN_PDRV1|YN_PU|YN_SL|YP_CS|YP_IE|YP_PD|YP_PDRV0|YP_PDRV1|YP_PU|YP_SL|ZN_CS|ZN_IE|ZN_PD|ZN_PDRV0|ZN_PDRV1|ZN_PU|ZN_SL|ZP_CS|ZP_IE|ZP_PD|ZP_PDRV0|ZP_PDRV1|ZP_PU|ZP_SL
+ VSS|XN_CS|XN_IE|XN_PD|XN_PDRV0|XN_PDRV1|XN_PU|XN_SL|XP_CS|XP_IE|XP_PD|XP_PDRV0|XP_PDRV1|XP_PU|XP_SL|YN_CS|YN_IE|YN_PD|YN_PDRV0|YN_PDRV1|YN_PU|YN_SL|YP_CS|YP_IE|YP_PD|YP_PDRV0|YP_PDRV1|YP_PU|YP_SL|ZN_CS|ZN_IE|ZN_PD|ZN_PDRV0|ZN_PDRV1|ZN_PU|ZN_SL|ZP_CS|ZP_IE|ZP_PD|ZP_PDRV0|ZP_PDRV1|ZP_PU|ZP_SL
+ nfet_06v0 L=1U W=2.5U AS=0.65P AD=0.65P PS=3.02U PD=3.02U
M$1640
+ VSS|XN_CS|XN_IE|XN_PD|XN_PDRV0|XN_PDRV1|XN_PU|XN_SL|XP_CS|XP_IE|XP_PD|XP_PDRV0|XP_PDRV1|XP_PU|XP_SL|YN_CS|YN_IE|YN_PD|YN_PDRV0|YN_PDRV1|YN_PU|YN_SL|YP_CS|YP_IE|YP_PD|YP_PDRV0|YP_PDRV1|YP_PU|YP_SL|ZN_CS|ZN_IE|ZN_PD|ZN_PDRV0|ZN_PDRV1|ZN_PU|ZN_SL|ZP_CS|ZP_IE|ZP_PD|ZP_PDRV0|ZP_PDRV1|ZP_PU|ZP_SL
+ \$10902 \$10903
+ VSS|XN_CS|XN_IE|XN_PD|XN_PDRV0|XN_PDRV1|XN_PU|XN_SL|XP_CS|XP_IE|XP_PD|XP_PDRV0|XP_PDRV1|XP_PU|XP_SL|YN_CS|YN_IE|YN_PD|YN_PDRV0|YN_PDRV1|YN_PU|YN_SL|YP_CS|YP_IE|YP_PD|YP_PDRV0|YP_PDRV1|YP_PU|YP_SL|ZN_CS|ZN_IE|ZN_PD|ZN_PDRV0|ZN_PDRV1|ZN_PU|ZN_SL|ZP_CS|ZP_IE|ZP_PD|ZP_PDRV0|ZP_PDRV1|ZP_PU|ZP_SL
+ nfet_06v0 L=1U W=2.5U AS=0.65P AD=1.1P PS=3.02U PD=5.88U
M$1641 \$11118 \$10919 \$10902
+ VSS|XN_CS|XN_IE|XN_PD|XN_PDRV0|XN_PDRV1|XN_PU|XN_SL|XP_CS|XP_IE|XP_PD|XP_PDRV0|XP_PDRV1|XP_PU|XP_SL|YN_CS|YN_IE|YN_PD|YN_PDRV0|YN_PDRV1|YN_PU|YN_SL|YP_CS|YP_IE|YP_PD|YP_PDRV0|YP_PDRV1|YP_PU|YP_SL|ZN_CS|ZN_IE|ZN_PD|ZN_PDRV0|ZN_PDRV1|ZN_PU|ZN_SL|ZP_CS|ZP_IE|ZP_PD|ZP_PDRV0|ZP_PDRV1|ZP_PU|ZP_SL
+ nfet_06v0 L=1U W=2.5U AS=1.1P AD=1.1P PS=5.88U PD=5.88U
M$1642 \$10875 \$10919 \$10904
+ VSS|XN_CS|XN_IE|XN_PD|XN_PDRV0|XN_PDRV1|XN_PU|XN_SL|XP_CS|XP_IE|XP_PD|XP_PDRV0|XP_PDRV1|XP_PU|XP_SL|YN_CS|YN_IE|YN_PD|YN_PDRV0|YN_PDRV1|YN_PU|YN_SL|YP_CS|YP_IE|YP_PD|YP_PDRV0|YP_PDRV1|YP_PU|YP_SL|ZN_CS|ZN_IE|ZN_PD|ZN_PDRV0|ZN_PDRV1|ZN_PU|ZN_SL|ZP_CS|ZP_IE|ZP_PD|ZP_PDRV0|ZP_PDRV1|ZP_PU|ZP_SL
+ nfet_06v0 L=1U W=2.5U AS=1.1P AD=1.1P PS=5.88U PD=5.88U
M$1643 \$10933 \$10874
+ VSS|XN_CS|XN_IE|XN_PD|XN_PDRV0|XN_PDRV1|XN_PU|XN_SL|XP_CS|XP_IE|XP_PD|XP_PDRV0|XP_PDRV1|XP_PU|XP_SL|YN_CS|YN_IE|YN_PD|YN_PDRV0|YN_PDRV1|YN_PU|YN_SL|YP_CS|YP_IE|YP_PD|YP_PDRV0|YP_PDRV1|YP_PU|YP_SL|ZN_CS|ZN_IE|ZN_PD|ZN_PDRV0|ZN_PDRV1|ZN_PU|ZN_SL|ZP_CS|ZP_IE|ZP_PD|ZP_PDRV0|ZP_PDRV1|ZP_PU|ZP_SL
+ VSS|XN_CS|XN_IE|XN_PD|XN_PDRV0|XN_PDRV1|XN_PU|XN_SL|XP_CS|XP_IE|XP_PD|XP_PDRV0|XP_PDRV1|XP_PU|XP_SL|YN_CS|YN_IE|YN_PD|YN_PDRV0|YN_PDRV1|YN_PU|YN_SL|YP_CS|YP_IE|YP_PD|YP_PDRV0|YP_PDRV1|YP_PU|YP_SL|ZN_CS|ZN_IE|ZN_PD|ZN_PDRV0|ZN_PDRV1|ZN_PU|ZN_SL|ZP_CS|ZP_IE|ZP_PD|ZP_PDRV0|ZP_PDRV1|ZP_PU|ZP_SL
+ nfet_06v0 L=1U W=5U AS=2.2P AD=1.25P PS=10.88U PD=5.5U
M$1644 \$10876 \$10897 \$10933
+ VSS|XN_CS|XN_IE|XN_PD|XN_PDRV0|XN_PDRV1|XN_PU|XN_SL|XP_CS|XP_IE|XP_PD|XP_PDRV0|XP_PDRV1|XP_PU|XP_SL|YN_CS|YN_IE|YN_PD|YN_PDRV0|YN_PDRV1|YN_PU|YN_SL|YP_CS|YP_IE|YP_PD|YP_PDRV0|YP_PDRV1|YP_PU|YP_SL|ZN_CS|ZN_IE|ZN_PD|ZN_PDRV0|ZN_PDRV1|ZN_PU|ZN_SL|ZP_CS|ZP_IE|ZP_PD|ZP_PDRV0|ZP_PDRV1|ZP_PU|ZP_SL
+ nfet_06v0 L=1U W=5U AS=1.25P AD=2.2P PS=5.5U PD=10.88U
M$1645 \$10932 \$10877
+ VSS|XN_CS|XN_IE|XN_PD|XN_PDRV0|XN_PDRV1|XN_PU|XN_SL|XP_CS|XP_IE|XP_PD|XP_PDRV0|XP_PDRV1|XP_PU|XP_SL|YN_CS|YN_IE|YN_PD|YN_PDRV0|YN_PDRV1|YN_PU|YN_SL|YP_CS|YP_IE|YP_PD|YP_PDRV0|YP_PDRV1|YP_PU|YP_SL|ZN_CS|ZN_IE|ZN_PD|ZN_PDRV0|ZN_PDRV1|ZN_PU|ZN_SL|ZP_CS|ZP_IE|ZP_PD|ZP_PDRV0|ZP_PDRV1|ZP_PU|ZP_SL
+ VSS|XN_CS|XN_IE|XN_PD|XN_PDRV0|XN_PDRV1|XN_PU|XN_SL|XP_CS|XP_IE|XP_PD|XP_PDRV0|XP_PDRV1|XP_PU|XP_SL|YN_CS|YN_IE|YN_PD|YN_PDRV0|YN_PDRV1|YN_PU|YN_SL|YP_CS|YP_IE|YP_PD|YP_PDRV0|YP_PDRV1|YP_PU|YP_SL|ZN_CS|ZN_IE|ZN_PD|ZN_PDRV0|ZN_PDRV1|ZN_PU|ZN_SL|ZP_CS|ZP_IE|ZP_PD|ZP_PDRV0|ZP_PDRV1|ZP_PU|ZP_SL
+ nfet_06v0 L=1U W=5U AS=2.2P AD=1.25P PS=10.88U PD=5.5U
M$1646 \$10877 \$10897 \$10932
+ VSS|XN_CS|XN_IE|XN_PD|XN_PDRV0|XN_PDRV1|XN_PU|XN_SL|XP_CS|XP_IE|XP_PD|XP_PDRV0|XP_PDRV1|XP_PU|XP_SL|YN_CS|YN_IE|YN_PD|YN_PDRV0|YN_PDRV1|YN_PU|YN_SL|YP_CS|YP_IE|YP_PD|YP_PDRV0|YP_PDRV1|YP_PU|YP_SL|ZN_CS|ZN_IE|ZN_PD|ZN_PDRV0|ZN_PDRV1|ZN_PU|ZN_SL|ZP_CS|ZP_IE|ZP_PD|ZP_PDRV0|ZP_PDRV1|ZP_PU|ZP_SL
+ nfet_06v0 L=1U W=5U AS=1.25P AD=1.65P PS=5.5U PD=5.66U
M$1647 \$10919 \$10919 \$10877
+ VSS|XN_CS|XN_IE|XN_PD|XN_PDRV0|XN_PDRV1|XN_PU|XN_SL|XP_CS|XP_IE|XP_PD|XP_PDRV0|XP_PDRV1|XP_PU|XP_SL|YN_CS|YN_IE|YN_PD|YN_PDRV0|YN_PDRV1|YN_PU|YN_SL|YP_CS|YP_IE|YP_PD|YP_PDRV0|YP_PDRV1|YP_PU|YP_SL|ZN_CS|ZN_IE|ZN_PD|ZN_PDRV0|ZN_PDRV1|ZN_PU|ZN_SL|ZP_CS|ZP_IE|ZP_PD|ZP_PDRV0|ZP_PDRV1|ZP_PU|ZP_SL
+ nfet_06v0 L=1U W=5U AS=1.65P AD=2.2P PS=5.66U PD=10.88U
M$1648 \$10905 \$10904
+ VSS|XN_CS|XN_IE|XN_PD|XN_PDRV0|XN_PDRV1|XN_PU|XN_SL|XP_CS|XP_IE|XP_PD|XP_PDRV0|XP_PDRV1|XP_PU|XP_SL|YN_CS|YN_IE|YN_PD|YN_PDRV0|YN_PDRV1|YN_PU|YN_SL|YP_CS|YP_IE|YP_PD|YP_PDRV0|YP_PDRV1|YP_PU|YP_SL|ZN_CS|ZN_IE|ZN_PD|ZN_PDRV0|ZN_PDRV1|ZN_PU|ZN_SL|ZP_CS|ZP_IE|ZP_PD|ZP_PDRV0|ZP_PDRV1|ZP_PU|ZP_SL
+ VSS|XN_CS|XN_IE|XN_PD|XN_PDRV0|XN_PDRV1|XN_PU|XN_SL|XP_CS|XP_IE|XP_PD|XP_PDRV0|XP_PDRV1|XP_PU|XP_SL|YN_CS|YN_IE|YN_PD|YN_PDRV0|YN_PDRV1|YN_PU|YN_SL|YP_CS|YP_IE|YP_PD|YP_PDRV0|YP_PDRV1|YP_PU|YP_SL|ZN_CS|ZN_IE|ZN_PD|ZN_PDRV0|ZN_PDRV1|ZN_PU|ZN_SL|ZP_CS|ZP_IE|ZP_PD|ZP_PDRV0|ZP_PDRV1|ZP_PU|ZP_SL
+ nfet_06v0 L=1U W=5U AS=2.2P AD=1.3P PS=10.88U PD=5.52U
M$1649
+ VSS|XN_CS|XN_IE|XN_PD|XN_PDRV0|XN_PDRV1|XN_PU|XN_SL|XP_CS|XP_IE|XP_PD|XP_PDRV0|XP_PDRV1|XP_PU|XP_SL|YN_CS|YN_IE|YN_PD|YN_PDRV0|YN_PDRV1|YN_PU|YN_SL|YP_CS|YP_IE|YP_PD|YP_PDRV0|YP_PDRV1|YP_PU|YP_SL|ZN_CS|ZN_IE|ZN_PD|ZN_PDRV0|ZN_PDRV1|ZN_PU|ZN_SL|ZP_CS|ZP_IE|ZP_PD|ZP_PDRV0|ZP_PDRV1|ZP_PU|ZP_SL
+ \$10904 \$10905
+ VSS|XN_CS|XN_IE|XN_PD|XN_PDRV0|XN_PDRV1|XN_PU|XN_SL|XP_CS|XP_IE|XP_PD|XP_PDRV0|XP_PDRV1|XP_PU|XP_SL|YN_CS|YN_IE|YN_PD|YN_PDRV0|YN_PDRV1|YN_PU|YN_SL|YP_CS|YP_IE|YP_PD|YP_PDRV0|YP_PDRV1|YP_PU|YP_SL|ZN_CS|ZN_IE|ZN_PD|ZN_PDRV0|ZN_PDRV1|ZN_PU|ZN_SL|ZP_CS|ZP_IE|ZP_PD|ZP_PDRV0|ZP_PDRV1|ZP_PU|ZP_SL
+ nfet_06v0 L=1U W=5U AS=1.3P AD=1.3P PS=5.52U PD=5.52U
M$1650 \$10905 \$10904
+ VSS|XN_CS|XN_IE|XN_PD|XN_PDRV0|XN_PDRV1|XN_PU|XN_SL|XP_CS|XP_IE|XP_PD|XP_PDRV0|XP_PDRV1|XP_PU|XP_SL|YN_CS|YN_IE|YN_PD|YN_PDRV0|YN_PDRV1|YN_PU|YN_SL|YP_CS|YP_IE|YP_PD|YP_PDRV0|YP_PDRV1|YP_PU|YP_SL|ZN_CS|ZN_IE|ZN_PD|ZN_PDRV0|ZN_PDRV1|ZN_PU|ZN_SL|ZP_CS|ZP_IE|ZP_PD|ZP_PDRV0|ZP_PDRV1|ZP_PU|ZP_SL
+ VSS|XN_CS|XN_IE|XN_PD|XN_PDRV0|XN_PDRV1|XN_PU|XN_SL|XP_CS|XP_IE|XP_PD|XP_PDRV0|XP_PDRV1|XP_PU|XP_SL|YN_CS|YN_IE|YN_PD|YN_PDRV0|YN_PDRV1|YN_PU|YN_SL|YP_CS|YP_IE|YP_PD|YP_PDRV0|YP_PDRV1|YP_PU|YP_SL|ZN_CS|ZN_IE|ZN_PD|ZN_PDRV0|ZN_PDRV1|ZN_PU|ZN_SL|ZP_CS|ZP_IE|ZP_PD|ZP_PDRV0|ZP_PDRV1|ZP_PU|ZP_SL
+ nfet_06v0 L=1U W=5U AS=1.3P AD=2.2P PS=5.52U PD=10.88U
M$1651
+ VSS|XN_CS|XN_IE|XN_PD|XN_PDRV0|XN_PDRV1|XN_PU|XN_SL|XP_CS|XP_IE|XP_PD|XP_PDRV0|XP_PDRV1|XP_PU|XP_SL|YN_CS|YN_IE|YN_PD|YN_PDRV0|YN_PDRV1|YN_PU|YN_SL|YP_CS|YP_IE|YP_PD|YP_PDRV0|YP_PDRV1|YP_PU|YP_SL|ZN_CS|ZN_IE|ZN_PD|ZN_PDRV0|ZN_PDRV1|ZN_PU|ZN_SL|ZP_CS|ZP_IE|ZP_PD|ZP_PDRV0|ZP_PDRV1|ZP_PU|ZP_SL
+ VDD|XN_OE|XP_OE|YN_OE|YP_OE|ZN_OE|ZP_OE
+ VSS|XN_CS|XN_IE|XN_PD|XN_PDRV0|XN_PDRV1|XN_PU|XN_SL|XP_CS|XP_IE|XP_PD|XP_PDRV0|XP_PDRV1|XP_PU|XP_SL|YN_CS|YN_IE|YN_PD|YN_PDRV0|YN_PDRV1|YN_PU|YN_SL|YP_CS|YP_IE|YP_PD|YP_PDRV0|YP_PDRV1|YP_PU|YP_SL|ZN_CS|ZN_IE|ZN_PD|ZN_PDRV0|ZN_PDRV1|ZN_PU|ZN_SL|ZP_CS|ZP_IE|ZP_PD|ZP_PDRV0|ZP_PDRV1|ZP_PU|ZP_SL
+ VSS|XN_CS|XN_IE|XN_PD|XN_PDRV0|XN_PDRV1|XN_PU|XN_SL|XP_CS|XP_IE|XP_PD|XP_PDRV0|XP_PDRV1|XP_PU|XP_SL|YN_CS|YN_IE|YN_PD|YN_PDRV0|YN_PDRV1|YN_PU|YN_SL|YP_CS|YP_IE|YP_PD|YP_PDRV0|YP_PDRV1|YP_PU|YP_SL|ZN_CS|ZN_IE|ZN_PD|ZN_PDRV0|ZN_PDRV1|ZN_PU|ZN_SL|ZP_CS|ZP_IE|ZP_PD|ZP_PDRV0|ZP_PDRV1|ZP_PU|ZP_SL
+ nfet_06v0 L=2U W=9.75U AS=4.29P AD=4.29P PS=20.38U PD=20.38U
M$1652
+ VSS|XN_CS|XN_IE|XN_PD|XN_PDRV0|XN_PDRV1|XN_PU|XN_SL|XP_CS|XP_IE|XP_PD|XP_PDRV0|XP_PDRV1|XP_PU|XP_SL|YN_CS|YN_IE|YN_PD|YN_PDRV0|YN_PDRV1|YN_PU|YN_SL|YP_CS|YP_IE|YP_PD|YP_PDRV0|YP_PDRV1|YP_PU|YP_SL|ZN_CS|ZN_IE|ZN_PD|ZN_PDRV0|ZN_PDRV1|ZN_PU|ZN_SL|ZP_CS|ZP_IE|ZP_PD|ZP_PDRV0|ZP_PDRV1|ZP_PU|ZP_SL
+ VDD|XN_OE|XP_OE|YN_OE|YP_OE|ZN_OE|ZP_OE
+ VSS|XN_CS|XN_IE|XN_PD|XN_PDRV0|XN_PDRV1|XN_PU|XN_SL|XP_CS|XP_IE|XP_PD|XP_PDRV0|XP_PDRV1|XP_PU|XP_SL|YN_CS|YN_IE|YN_PD|YN_PDRV0|YN_PDRV1|YN_PU|YN_SL|YP_CS|YP_IE|YP_PD|YP_PDRV0|YP_PDRV1|YP_PU|YP_SL|ZN_CS|ZN_IE|ZN_PD|ZN_PDRV0|ZN_PDRV1|ZN_PU|ZN_SL|ZP_CS|ZP_IE|ZP_PD|ZP_PDRV0|ZP_PDRV1|ZP_PU|ZP_SL
+ VSS|XN_CS|XN_IE|XN_PD|XN_PDRV0|XN_PDRV1|XN_PU|XN_SL|XP_CS|XP_IE|XP_PD|XP_PDRV0|XP_PDRV1|XP_PU|XP_SL|YN_CS|YN_IE|YN_PD|YN_PDRV0|YN_PDRV1|YN_PU|YN_SL|YP_CS|YP_IE|YP_PD|YP_PDRV0|YP_PDRV1|YP_PU|YP_SL|ZN_CS|ZN_IE|ZN_PD|ZN_PDRV0|ZN_PDRV1|ZN_PU|ZN_SL|ZP_CS|ZP_IE|ZP_PD|ZP_PDRV0|ZP_PDRV1|ZP_PU|ZP_SL
+ nfet_06v0 L=2U W=9.75U AS=4.29P AD=4.29P PS=20.38U PD=20.38U
M$1653 \$9061 \$9076
+ VSS|XN_CS|XN_IE|XN_PD|XN_PDRV0|XN_PDRV1|XN_PU|XN_SL|XP_CS|XP_IE|XP_PD|XP_PDRV0|XP_PDRV1|XP_PU|XP_SL|YN_CS|YN_IE|YN_PD|YN_PDRV0|YN_PDRV1|YN_PU|YN_SL|YP_CS|YP_IE|YP_PD|YP_PDRV0|YP_PDRV1|YP_PU|YP_SL|ZN_CS|ZN_IE|ZN_PD|ZN_PDRV0|ZN_PDRV1|ZN_PU|ZN_SL|ZP_CS|ZP_IE|ZP_PD|ZP_PDRV0|ZP_PDRV1|ZP_PU|ZP_SL
+ VSS|XN_CS|XN_IE|XN_PD|XN_PDRV0|XN_PDRV1|XN_PU|XN_SL|XP_CS|XP_IE|XP_PD|XP_PDRV0|XP_PDRV1|XP_PU|XP_SL|YN_CS|YN_IE|YN_PD|YN_PDRV0|YN_PDRV1|YN_PU|YN_SL|YP_CS|YP_IE|YP_PD|YP_PDRV0|YP_PDRV1|YP_PU|YP_SL|ZN_CS|ZN_IE|ZN_PD|ZN_PDRV0|ZN_PDRV1|ZN_PU|ZN_SL|ZP_CS|ZP_IE|ZP_PD|ZP_PDRV0|ZP_PDRV1|ZP_PU|ZP_SL
+ nfet_06v0 L=1U W=1.24U AS=0.5456P AD=0.5456P PS=3.36U PD=3.36U
M$1654 Y \$9147 \$9077
+ VSS|XN_CS|XN_IE|XN_PD|XN_PDRV0|XN_PDRV1|XN_PU|XN_SL|XP_CS|XP_IE|XP_PD|XP_PDRV0|XP_PDRV1|XP_PU|XP_SL|YN_CS|YN_IE|YN_PD|YN_PDRV0|YN_PDRV1|YN_PU|YN_SL|YP_CS|YP_IE|YP_PD|YP_PDRV0|YP_PDRV1|YP_PU|YP_SL|ZN_CS|ZN_IE|ZN_PD|ZN_PDRV0|ZN_PDRV1|ZN_PU|ZN_SL|ZP_CS|ZP_IE|ZP_PD|ZP_PDRV0|ZP_PDRV1|ZP_PU|ZP_SL
+ nfet_06v0 L=1U W=2.48U AS=1.0912P AD=0.6448P PS=5.84U PD=3U
M$1655 \$9077 \$9147 Y
+ VSS|XN_CS|XN_IE|XN_PD|XN_PDRV0|XN_PDRV1|XN_PU|XN_SL|XP_CS|XP_IE|XP_PD|XP_PDRV0|XP_PDRV1|XP_PU|XP_SL|YN_CS|YN_IE|YN_PD|YN_PDRV0|YN_PDRV1|YN_PU|YN_SL|YP_CS|YP_IE|YP_PD|YP_PDRV0|YP_PDRV1|YP_PU|YP_SL|ZN_CS|ZN_IE|ZN_PD|ZN_PDRV0|ZN_PDRV1|ZN_PU|ZN_SL|ZP_CS|ZP_IE|ZP_PD|ZP_PDRV0|ZP_PDRV1|ZP_PU|ZP_SL
+ nfet_06v0 L=1U W=2.48U AS=0.6448P AD=1.0912P PS=3U PD=5.84U
M$1656 \$9077 \$9076
+ VSS|XN_CS|XN_IE|XN_PD|XN_PDRV0|XN_PDRV1|XN_PU|XN_SL|XP_CS|XP_IE|XP_PD|XP_PDRV0|XP_PDRV1|XP_PU|XP_SL|YN_CS|YN_IE|YN_PD|YN_PDRV0|YN_PDRV1|YN_PU|YN_SL|YP_CS|YP_IE|YP_PD|YP_PDRV0|YP_PDRV1|YP_PU|YP_SL|ZN_CS|ZN_IE|ZN_PD|ZN_PDRV0|ZN_PDRV1|ZN_PU|ZN_SL|ZP_CS|ZP_IE|ZP_PD|ZP_PDRV0|ZP_PDRV1|ZP_PU|ZP_SL
+ VSS|XN_CS|XN_IE|XN_PD|XN_PDRV0|XN_PDRV1|XN_PU|XN_SL|XP_CS|XP_IE|XP_PD|XP_PDRV0|XP_PDRV1|XP_PU|XP_SL|YN_CS|YN_IE|YN_PD|YN_PDRV0|YN_PDRV1|YN_PU|YN_SL|YP_CS|YP_IE|YP_PD|YP_PDRV0|YP_PDRV1|YP_PU|YP_SL|ZN_CS|ZN_IE|ZN_PD|ZN_PDRV0|ZN_PDRV1|ZN_PU|ZN_SL|ZP_CS|ZP_IE|ZP_PD|ZP_PDRV0|ZP_PDRV1|ZP_PU|ZP_SL
+ nfet_06v0 L=1U W=1.24U AS=0.5456P AD=0.5456P PS=3.36U PD=3.36U
M$1657 Y \$9122 \$9161
+ VSS|XN_CS|XN_IE|XN_PD|XN_PDRV0|XN_PDRV1|XN_PU|XN_SL|XP_CS|XP_IE|XP_PD|XP_PDRV0|XP_PDRV1|XP_PU|XP_SL|YN_CS|YN_IE|YN_PD|YN_PDRV0|YN_PDRV1|YN_PU|YN_SL|YP_CS|YP_IE|YP_PD|YP_PDRV0|YP_PDRV1|YP_PU|YP_SL|ZN_CS|ZN_IE|ZN_PD|ZN_PDRV0|ZN_PDRV1|ZN_PU|ZN_SL|ZP_CS|ZP_IE|ZP_PD|ZP_PDRV0|ZP_PDRV1|ZP_PU|ZP_SL
+ nfet_06v0 L=1U W=2.48U AS=1.0912P AD=0.6448P PS=5.84U PD=3U
M$1658 \$9161 \$9122 Y
+ VSS|XN_CS|XN_IE|XN_PD|XN_PDRV0|XN_PDRV1|XN_PU|XN_SL|XP_CS|XP_IE|XP_PD|XP_PDRV0|XP_PDRV1|XP_PU|XP_SL|YN_CS|YN_IE|YN_PD|YN_PDRV0|YN_PDRV1|YN_PU|YN_SL|YP_CS|YP_IE|YP_PD|YP_PDRV0|YP_PDRV1|YP_PU|YP_SL|ZN_CS|ZN_IE|ZN_PD|ZN_PDRV0|ZN_PDRV1|ZN_PU|ZN_SL|ZP_CS|ZP_IE|ZP_PD|ZP_PDRV0|ZP_PDRV1|ZP_PU|ZP_SL
+ nfet_06v0 L=1U W=2.48U AS=0.6448P AD=1.0912P PS=3U PD=5.84U
M$1659 \$9124 \$9076
+ VSS|XN_CS|XN_IE|XN_PD|XN_PDRV0|XN_PDRV1|XN_PU|XN_SL|XP_CS|XP_IE|XP_PD|XP_PDRV0|XP_PDRV1|XP_PU|XP_SL|YN_CS|YN_IE|YN_PD|YN_PDRV0|YN_PDRV1|YN_PU|YN_SL|YP_CS|YP_IE|YP_PD|YP_PDRV0|YP_PDRV1|YP_PU|YP_SL|ZN_CS|ZN_IE|ZN_PD|ZN_PDRV0|ZN_PDRV1|ZN_PU|ZN_SL|ZP_CS|ZP_IE|ZP_PD|ZP_PDRV0|ZP_PDRV1|ZP_PU|ZP_SL
+ VSS|XN_CS|XN_IE|XN_PD|XN_PDRV0|XN_PDRV1|XN_PU|XN_SL|XP_CS|XP_IE|XP_PD|XP_PDRV0|XP_PDRV1|XP_PU|XP_SL|YN_CS|YN_IE|YN_PD|YN_PDRV0|YN_PDRV1|YN_PU|YN_SL|YP_CS|YP_IE|YP_PD|YP_PDRV0|YP_PDRV1|YP_PU|YP_SL|ZN_CS|ZN_IE|ZN_PD|ZN_PDRV0|ZN_PDRV1|ZN_PU|ZN_SL|ZP_CS|ZP_IE|ZP_PD|ZP_PDRV0|ZP_PDRV1|ZP_PU|ZP_SL
+ nfet_06v0 L=1U W=0.7U AS=0.308P AD=0.175P PS=2.28U PD=1.2U
M$1660 \$9123 \$9076 \$9124
+ VSS|XN_CS|XN_IE|XN_PD|XN_PDRV0|XN_PDRV1|XN_PU|XN_SL|XP_CS|XP_IE|XP_PD|XP_PDRV0|XP_PDRV1|XP_PU|XP_SL|YN_CS|YN_IE|YN_PD|YN_PDRV0|YN_PDRV1|YN_PU|YN_SL|YP_CS|YP_IE|YP_PD|YP_PDRV0|YP_PDRV1|YP_PU|YP_SL|ZN_CS|ZN_IE|ZN_PD|ZN_PDRV0|ZN_PDRV1|ZN_PU|ZN_SL|ZP_CS|ZP_IE|ZP_PD|ZP_PDRV0|ZP_PDRV1|ZP_PU|ZP_SL
+ nfet_06v0 L=1U W=0.7U AS=0.175P AD=0.175P PS=1.2U PD=1.2U
M$1661 \$9125 \$9076 \$9123
+ VSS|XN_CS|XN_IE|XN_PD|XN_PDRV0|XN_PDRV1|XN_PU|XN_SL|XP_CS|XP_IE|XP_PD|XP_PDRV0|XP_PDRV1|XP_PU|XP_SL|YN_CS|YN_IE|YN_PD|YN_PDRV0|YN_PDRV1|YN_PU|YN_SL|YP_CS|YP_IE|YP_PD|YP_PDRV0|YP_PDRV1|YP_PU|YP_SL|ZN_CS|ZN_IE|ZN_PD|ZN_PDRV0|ZN_PDRV1|ZN_PU|ZN_SL|ZP_CS|ZP_IE|ZP_PD|ZP_PDRV0|ZP_PDRV1|ZP_PU|ZP_SL
+ nfet_06v0 L=1U W=0.7U AS=0.175P AD=0.175P PS=1.2U PD=1.2U
M$1662 \$9076 \$9076 \$9125
+ VSS|XN_CS|XN_IE|XN_PD|XN_PDRV0|XN_PDRV1|XN_PU|XN_SL|XP_CS|XP_IE|XP_PD|XP_PDRV0|XP_PDRV1|XP_PU|XP_SL|YN_CS|YN_IE|YN_PD|YN_PDRV0|YN_PDRV1|YN_PU|YN_SL|YP_CS|YP_IE|YP_PD|YP_PDRV0|YP_PDRV1|YP_PU|YP_SL|ZN_CS|ZN_IE|ZN_PD|ZN_PDRV0|ZN_PDRV1|ZN_PU|ZN_SL|ZP_CS|ZP_IE|ZP_PD|ZP_PDRV0|ZP_PDRV1|ZP_PU|ZP_SL
+ nfet_06v0 L=1U W=0.7U AS=0.175P AD=0.308P PS=1.2U PD=2.28U
M$1663 \$9161 \$9076
+ VSS|XN_CS|XN_IE|XN_PD|XN_PDRV0|XN_PDRV1|XN_PU|XN_SL|XP_CS|XP_IE|XP_PD|XP_PDRV0|XP_PDRV1|XP_PU|XP_SL|YN_CS|YN_IE|YN_PD|YN_PDRV0|YN_PDRV1|YN_PU|YN_SL|YP_CS|YP_IE|YP_PD|YP_PDRV0|YP_PDRV1|YP_PU|YP_SL|ZN_CS|ZN_IE|ZN_PD|ZN_PDRV0|ZN_PDRV1|ZN_PU|ZN_SL|ZP_CS|ZP_IE|ZP_PD|ZP_PDRV0|ZP_PDRV1|ZP_PU|ZP_SL
+ VSS|XN_CS|XN_IE|XN_PD|XN_PDRV0|XN_PDRV1|XN_PU|XN_SL|XP_CS|XP_IE|XP_PD|XP_PDRV0|XP_PDRV1|XP_PU|XP_SL|YN_CS|YN_IE|YN_PD|YN_PDRV0|YN_PDRV1|YN_PU|YN_SL|YP_CS|YP_IE|YP_PD|YP_PDRV0|YP_PDRV1|YP_PU|YP_SL|ZN_CS|ZN_IE|ZN_PD|ZN_PDRV0|ZN_PDRV1|ZN_PU|ZN_SL|ZP_CS|ZP_IE|ZP_PD|ZP_PDRV0|ZP_PDRV1|ZP_PU|ZP_SL
+ nfet_06v0 L=1U W=1.24U AS=0.5456P AD=0.5456P PS=3.36U PD=3.36U
M$1664 Y Y \$9162
+ VSS|XN_CS|XN_IE|XN_PD|XN_PDRV0|XN_PDRV1|XN_PU|XN_SL|XP_CS|XP_IE|XP_PD|XP_PDRV0|XP_PDRV1|XP_PU|XP_SL|YN_CS|YN_IE|YN_PD|YN_PDRV0|YN_PDRV1|YN_PU|YN_SL|YP_CS|YP_IE|YP_PD|YP_PDRV0|YP_PDRV1|YP_PU|YP_SL|ZN_CS|ZN_IE|ZN_PD|ZN_PDRV0|ZN_PDRV1|ZN_PU|ZN_SL|ZP_CS|ZP_IE|ZP_PD|ZP_PDRV0|ZP_PDRV1|ZP_PU|ZP_SL
+ nfet_06v0 L=1U W=2U AS=0.88P AD=0.52P PS=4.88U PD=2.52U
M$1665 \$9162 Y Y
+ VSS|XN_CS|XN_IE|XN_PD|XN_PDRV0|XN_PDRV1|XN_PU|XN_SL|XP_CS|XP_IE|XP_PD|XP_PDRV0|XP_PDRV1|XP_PU|XP_SL|YN_CS|YN_IE|YN_PD|YN_PDRV0|YN_PDRV1|YN_PU|YN_SL|YP_CS|YP_IE|YP_PD|YP_PDRV0|YP_PDRV1|YP_PU|YP_SL|ZN_CS|ZN_IE|ZN_PD|ZN_PDRV0|ZN_PDRV1|ZN_PU|ZN_SL|ZP_CS|ZP_IE|ZP_PD|ZP_PDRV0|ZP_PDRV1|ZP_PU|ZP_SL
+ nfet_06v0 L=1U W=2U AS=0.52P AD=0.88P PS=2.52U PD=4.88U
M$1666 Y VDD|XN_OE|XP_OE|YN_OE|YP_OE|ZN_OE|ZP_OE \$9062
+ VSS|XN_CS|XN_IE|XN_PD|XN_PDRV0|XN_PDRV1|XN_PU|XN_SL|XP_CS|XP_IE|XP_PD|XP_PDRV0|XP_PDRV1|XP_PU|XP_SL|YN_CS|YN_IE|YN_PD|YN_PDRV0|YN_PDRV1|YN_PU|YN_SL|YP_CS|YP_IE|YP_PD|YP_PDRV0|YP_PDRV1|YP_PU|YP_SL|ZN_CS|ZN_IE|ZN_PD|ZN_PDRV0|ZN_PDRV1|ZN_PU|ZN_SL|ZP_CS|ZP_IE|ZP_PD|ZP_PDRV0|ZP_PDRV1|ZP_PU|ZP_SL
+ nfet_06v0 L=1U W=2.48U AS=1.0912P AD=0.6448P PS=5.84U PD=3U
M$1667 \$9062 VDD|XN_OE|XP_OE|YN_OE|YP_OE|ZN_OE|ZP_OE Y
+ VSS|XN_CS|XN_IE|XN_PD|XN_PDRV0|XN_PDRV1|XN_PU|XN_SL|XP_CS|XP_IE|XP_PD|XP_PDRV0|XP_PDRV1|XP_PU|XP_SL|YN_CS|YN_IE|YN_PD|YN_PDRV0|YN_PDRV1|YN_PU|YN_SL|YP_CS|YP_IE|YP_PD|YP_PDRV0|YP_PDRV1|YP_PU|YP_SL|ZN_CS|ZN_IE|ZN_PD|ZN_PDRV0|ZN_PDRV1|ZN_PU|ZN_SL|ZP_CS|ZP_IE|ZP_PD|ZP_PDRV0|ZP_PDRV1|ZP_PU|ZP_SL
+ nfet_06v0 L=1U W=2.48U AS=0.6448P AD=1.0912P PS=3U PD=5.84U
M$1668 \$9221 Y
+ VSS|XN_CS|XN_IE|XN_PD|XN_PDRV0|XN_PDRV1|XN_PU|XN_SL|XP_CS|XP_IE|XP_PD|XP_PDRV0|XP_PDRV1|XP_PU|XP_SL|YN_CS|YN_IE|YN_PD|YN_PDRV0|YN_PDRV1|YN_PU|YN_SL|YP_CS|YP_IE|YP_PD|YP_PDRV0|YP_PDRV1|YP_PU|YP_SL|ZN_CS|ZN_IE|ZN_PD|ZN_PDRV0|ZN_PDRV1|ZN_PU|ZN_SL|ZP_CS|ZP_IE|ZP_PD|ZP_PDRV0|ZP_PDRV1|ZP_PU|ZP_SL
+ VSS|XN_CS|XN_IE|XN_PD|XN_PDRV0|XN_PDRV1|XN_PU|XN_SL|XP_CS|XP_IE|XP_PD|XP_PDRV0|XP_PDRV1|XP_PU|XP_SL|YN_CS|YN_IE|YN_PD|YN_PDRV0|YN_PDRV1|YN_PU|YN_SL|YP_CS|YP_IE|YP_PD|YP_PDRV0|YP_PDRV1|YP_PU|YP_SL|ZN_CS|ZN_IE|ZN_PD|ZN_PDRV0|ZN_PDRV1|ZN_PU|ZN_SL|ZP_CS|ZP_IE|ZP_PD|ZP_PDRV0|ZP_PDRV1|ZP_PU|ZP_SL
+ nfet_06v0 L=1U W=2U AS=0.88P AD=0.5P PS=4.88U PD=2.5U
M$1669 \$9162 Y \$9221
+ VSS|XN_CS|XN_IE|XN_PD|XN_PDRV0|XN_PDRV1|XN_PU|XN_SL|XP_CS|XP_IE|XP_PD|XP_PDRV0|XP_PDRV1|XP_PU|XP_SL|YN_CS|YN_IE|YN_PD|YN_PDRV0|YN_PDRV1|YN_PU|YN_SL|YP_CS|YP_IE|YP_PD|YP_PDRV0|YP_PDRV1|YP_PU|YP_SL|ZN_CS|ZN_IE|ZN_PD|ZN_PDRV0|ZN_PDRV1|ZN_PU|ZN_SL|ZP_CS|ZP_IE|ZP_PD|ZP_PDRV0|ZP_PDRV1|ZP_PU|ZP_SL
+ nfet_06v0 L=1U W=2U AS=0.5P AD=0.88P PS=2.5U PD=4.88U
M$1670 \$9062 \$9076
+ VSS|XN_CS|XN_IE|XN_PD|XN_PDRV0|XN_PDRV1|XN_PU|XN_SL|XP_CS|XP_IE|XP_PD|XP_PDRV0|XP_PDRV1|XP_PU|XP_SL|YN_CS|YN_IE|YN_PD|YN_PDRV0|YN_PDRV1|YN_PU|YN_SL|YP_CS|YP_IE|YP_PD|YP_PDRV0|YP_PDRV1|YP_PU|YP_SL|ZN_CS|ZN_IE|ZN_PD|ZN_PDRV0|ZN_PDRV1|ZN_PU|ZN_SL|ZP_CS|ZP_IE|ZP_PD|ZP_PDRV0|ZP_PDRV1|ZP_PU|ZP_SL
+ VSS|XN_CS|XN_IE|XN_PD|XN_PDRV0|XN_PDRV1|XN_PU|XN_SL|XP_CS|XP_IE|XP_PD|XP_PDRV0|XP_PDRV1|XP_PU|XP_SL|YN_CS|YN_IE|YN_PD|YN_PDRV0|YN_PDRV1|YN_PU|YN_SL|YP_CS|YP_IE|YP_PD|YP_PDRV0|YP_PDRV1|YP_PU|YP_SL|ZN_CS|ZN_IE|ZN_PD|ZN_PDRV0|ZN_PDRV1|ZN_PU|ZN_SL|ZP_CS|ZP_IE|ZP_PD|ZP_PDRV0|ZP_PDRV1|ZP_PU|ZP_SL
+ nfet_06v0 L=1U W=1.24U AS=0.5456P AD=0.5456P PS=3.36U PD=3.36U
M$1671 Y \$7322 \$9163
+ VSS|XN_CS|XN_IE|XN_PD|XN_PDRV0|XN_PDRV1|XN_PU|XN_SL|XP_CS|XP_IE|XP_PD|XP_PDRV0|XP_PDRV1|XP_PU|XP_SL|YN_CS|YN_IE|YN_PD|YN_PDRV0|YN_PDRV1|YN_PU|YN_SL|YP_CS|YP_IE|YP_PD|YP_PDRV0|YP_PDRV1|YP_PU|YP_SL|ZN_CS|ZN_IE|ZN_PD|ZN_PDRV0|ZN_PDRV1|ZN_PU|ZN_SL|ZP_CS|ZP_IE|ZP_PD|ZP_PDRV0|ZP_PDRV1|ZP_PU|ZP_SL
+ nfet_06v0 L=1U W=2.48U AS=1.0912P AD=0.6448P PS=5.84U PD=3U
M$1672 \$9163 \$7322 Y
+ VSS|XN_CS|XN_IE|XN_PD|XN_PDRV0|XN_PDRV1|XN_PU|XN_SL|XP_CS|XP_IE|XP_PD|XP_PDRV0|XP_PDRV1|XP_PU|XP_SL|YN_CS|YN_IE|YN_PD|YN_PDRV0|YN_PDRV1|YN_PU|YN_SL|YP_CS|YP_IE|YP_PD|YP_PDRV0|YP_PDRV1|YP_PU|YP_SL|ZN_CS|ZN_IE|ZN_PD|ZN_PDRV0|ZN_PDRV1|ZN_PU|ZN_SL|ZP_CS|ZP_IE|ZP_PD|ZP_PDRV0|ZP_PDRV1|ZP_PU|ZP_SL
+ nfet_06v0 L=1U W=2.48U AS=0.6448P AD=1.0912P PS=3U PD=5.84U
M$1673 \$9163 \$9076
+ VSS|XN_CS|XN_IE|XN_PD|XN_PDRV0|XN_PDRV1|XN_PU|XN_SL|XP_CS|XP_IE|XP_PD|XP_PDRV0|XP_PDRV1|XP_PU|XP_SL|YN_CS|YN_IE|YN_PD|YN_PDRV0|YN_PDRV1|YN_PU|YN_SL|YP_CS|YP_IE|YP_PD|YP_PDRV0|YP_PDRV1|YP_PU|YP_SL|ZN_CS|ZN_IE|ZN_PD|ZN_PDRV0|ZN_PDRV1|ZN_PU|ZN_SL|ZP_CS|ZP_IE|ZP_PD|ZP_PDRV0|ZP_PDRV1|ZP_PU|ZP_SL
+ VSS|XN_CS|XN_IE|XN_PD|XN_PDRV0|XN_PDRV1|XN_PU|XN_SL|XP_CS|XP_IE|XP_PD|XP_PDRV0|XP_PDRV1|XP_PU|XP_SL|YN_CS|YN_IE|YN_PD|YN_PDRV0|YN_PDRV1|YN_PU|YN_SL|YP_CS|YP_IE|YP_PD|YP_PDRV0|YP_PDRV1|YP_PU|YP_SL|ZN_CS|ZN_IE|ZN_PD|ZN_PDRV0|ZN_PDRV1|ZN_PU|ZN_SL|ZP_CS|ZP_IE|ZP_PD|ZP_PDRV0|ZP_PDRV1|ZP_PU|ZP_SL
+ nfet_06v0 L=1U W=1.24U AS=0.5456P AD=0.5456P PS=3.36U PD=3.36U
M$1674 Y \$9148 \$9061
+ VSS|XN_CS|XN_IE|XN_PD|XN_PDRV0|XN_PDRV1|XN_PU|XN_SL|XP_CS|XP_IE|XP_PD|XP_PDRV0|XP_PDRV1|XP_PU|XP_SL|YN_CS|YN_IE|YN_PD|YN_PDRV0|YN_PDRV1|YN_PU|YN_SL|YP_CS|YP_IE|YP_PD|YP_PDRV0|YP_PDRV1|YP_PU|YP_SL|ZN_CS|ZN_IE|ZN_PD|ZN_PDRV0|ZN_PDRV1|ZN_PU|ZN_SL|ZP_CS|ZP_IE|ZP_PD|ZP_PDRV0|ZP_PDRV1|ZP_PU|ZP_SL
+ nfet_06v0 L=1U W=2.48U AS=1.0912P AD=0.6448P PS=5.84U PD=3U
M$1675 \$9061 \$9148 Y
+ VSS|XN_CS|XN_IE|XN_PD|XN_PDRV0|XN_PDRV1|XN_PU|XN_SL|XP_CS|XP_IE|XP_PD|XP_PDRV0|XP_PDRV1|XP_PU|XP_SL|YN_CS|YN_IE|YN_PD|YN_PDRV0|YN_PDRV1|YN_PU|YN_SL|YP_CS|YP_IE|YP_PD|YP_PDRV0|YP_PDRV1|YP_PU|YP_SL|ZN_CS|ZN_IE|ZN_PD|ZN_PDRV0|ZN_PDRV1|ZN_PU|ZN_SL|ZP_CS|ZP_IE|ZP_PD|ZP_PDRV0|ZP_PDRV1|ZP_PU|ZP_SL
+ nfet_06v0 L=1U W=2.48U AS=0.6448P AD=1.0912P PS=3U PD=5.84U
M$1676
+ VSS|XN_CS|XN_IE|XN_PD|XN_PDRV0|XN_PDRV1|XN_PU|XN_SL|XP_CS|XP_IE|XP_PD|XP_PDRV0|XP_PDRV1|XP_PU|XP_SL|YN_CS|YN_IE|YN_PD|YN_PDRV0|YN_PDRV1|YN_PU|YN_SL|YP_CS|YP_IE|YP_PD|YP_PDRV0|YP_PDRV1|YP_PU|YP_SL|ZN_CS|ZN_IE|ZN_PD|ZN_PDRV0|ZN_PDRV1|ZN_PU|ZN_SL|ZP_CS|ZP_IE|ZP_PD|ZP_PDRV0|ZP_PDRV1|ZP_PU|ZP_SL
+ VDD|XN_OE|XP_OE|YN_OE|YP_OE|ZN_OE|ZP_OE
+ VSS|XN_CS|XN_IE|XN_PD|XN_PDRV0|XN_PDRV1|XN_PU|XN_SL|XP_CS|XP_IE|XP_PD|XP_PDRV0|XP_PDRV1|XP_PU|XP_SL|YN_CS|YN_IE|YN_PD|YN_PDRV0|YN_PDRV1|YN_PU|YN_SL|YP_CS|YP_IE|YP_PD|YP_PDRV0|YP_PDRV1|YP_PU|YP_SL|ZN_CS|ZN_IE|ZN_PD|ZN_PDRV0|ZN_PDRV1|ZN_PU|ZN_SL|ZP_CS|ZP_IE|ZP_PD|ZP_PDRV0|ZP_PDRV1|ZP_PU|ZP_SL
+ VSS|XN_CS|XN_IE|XN_PD|XN_PDRV0|XN_PDRV1|XN_PU|XN_SL|XP_CS|XP_IE|XP_PD|XP_PDRV0|XP_PDRV1|XP_PU|XP_SL|YN_CS|YN_IE|YN_PD|YN_PDRV0|YN_PDRV1|YN_PU|YN_SL|YP_CS|YP_IE|YP_PD|YP_PDRV0|YP_PDRV1|YP_PU|YP_SL|ZN_CS|ZN_IE|ZN_PD|ZN_PDRV0|ZN_PDRV1|ZN_PU|ZN_SL|ZP_CS|ZP_IE|ZP_PD|ZP_PDRV0|ZP_PDRV1|ZP_PU|ZP_SL
+ nfet_06v0 L=2U W=1U AS=0.44P AD=0.44P PS=2.88U PD=2.88U
M$1677
+ VSS|XN_CS|XN_IE|XN_PD|XN_PDRV0|XN_PDRV1|XN_PU|XN_SL|XP_CS|XP_IE|XP_PD|XP_PDRV0|XP_PDRV1|XP_PU|XP_SL|YN_CS|YN_IE|YN_PD|YN_PDRV0|YN_PDRV1|YN_PU|YN_SL|YP_CS|YP_IE|YP_PD|YP_PDRV0|YP_PDRV1|YP_PU|YP_SL|ZN_CS|ZN_IE|ZN_PD|ZN_PDRV0|ZN_PDRV1|ZN_PU|ZN_SL|ZP_CS|ZP_IE|ZP_PD|ZP_PDRV0|ZP_PDRV1|ZP_PU|ZP_SL
+ VDD|XN_OE|XP_OE|YN_OE|YP_OE|ZN_OE|ZP_OE
+ VSS|XN_CS|XN_IE|XN_PD|XN_PDRV0|XN_PDRV1|XN_PU|XN_SL|XP_CS|XP_IE|XP_PD|XP_PDRV0|XP_PDRV1|XP_PU|XP_SL|YN_CS|YN_IE|YN_PD|YN_PDRV0|YN_PDRV1|YN_PU|YN_SL|YP_CS|YP_IE|YP_PD|YP_PDRV0|YP_PDRV1|YP_PU|YP_SL|ZN_CS|ZN_IE|ZN_PD|ZN_PDRV0|ZN_PDRV1|ZN_PU|ZN_SL|ZP_CS|ZP_IE|ZP_PD|ZP_PDRV0|ZP_PDRV1|ZP_PU|ZP_SL
+ VSS|XN_CS|XN_IE|XN_PD|XN_PDRV0|XN_PDRV1|XN_PU|XN_SL|XP_CS|XP_IE|XP_PD|XP_PDRV0|XP_PDRV1|XP_PU|XP_SL|YN_CS|YN_IE|YN_PD|YN_PDRV0|YN_PDRV1|YN_PU|YN_SL|YP_CS|YP_IE|YP_PD|YP_PDRV0|YP_PDRV1|YP_PU|YP_SL|ZN_CS|ZN_IE|ZN_PD|ZN_PDRV0|ZN_PDRV1|ZN_PU|ZN_SL|ZP_CS|ZP_IE|ZP_PD|ZP_PDRV0|ZP_PDRV1|ZP_PU|ZP_SL
+ nfet_06v0 L=2U W=1U AS=0.44P AD=0.44P PS=2.88U PD=2.88U
M$1678
+ VSS|XN_CS|XN_IE|XN_PD|XN_PDRV0|XN_PDRV1|XN_PU|XN_SL|XP_CS|XP_IE|XP_PD|XP_PDRV0|XP_PDRV1|XP_PU|XP_SL|YN_CS|YN_IE|YN_PD|YN_PDRV0|YN_PDRV1|YN_PU|YN_SL|YP_CS|YP_IE|YP_PD|YP_PDRV0|YP_PDRV1|YP_PU|YP_SL|ZN_CS|ZN_IE|ZN_PD|ZN_PDRV0|ZN_PDRV1|ZN_PU|ZN_SL|ZP_CS|ZP_IE|ZP_PD|ZP_PDRV0|ZP_PDRV1|ZP_PU|ZP_SL
+ \$10888 \$10879
+ VSS|XN_CS|XN_IE|XN_PD|XN_PDRV0|XN_PDRV1|XN_PU|XN_SL|XP_CS|XP_IE|XP_PD|XP_PDRV0|XP_PDRV1|XP_PU|XP_SL|YN_CS|YN_IE|YN_PD|YN_PDRV0|YN_PDRV1|YN_PU|YN_SL|YP_CS|YP_IE|YP_PD|YP_PDRV0|YP_PDRV1|YP_PU|YP_SL|ZN_CS|ZN_IE|ZN_PD|ZN_PDRV0|ZN_PDRV1|ZN_PU|ZN_SL|ZP_CS|ZP_IE|ZP_PD|ZP_PDRV0|ZP_PDRV1|ZP_PU|ZP_SL
+ nfet_06v0 L=1U W=1U AS=0.44P AD=0.44P PS=2.88U PD=2.88U
M$1679
+ VSS|XN_CS|XN_IE|XN_PD|XN_PDRV0|XN_PDRV1|XN_PU|XN_SL|XP_CS|XP_IE|XP_PD|XP_PDRV0|XP_PDRV1|XP_PU|XP_SL|YN_CS|YN_IE|YN_PD|YN_PDRV0|YN_PDRV1|YN_PU|YN_SL|YP_CS|YP_IE|YP_PD|YP_PDRV0|YP_PDRV1|YP_PU|YP_SL|ZN_CS|ZN_IE|ZN_PD|ZN_PDRV0|ZN_PDRV1|ZN_PU|ZN_SL|ZP_CS|ZP_IE|ZP_PD|ZP_PDRV0|ZP_PDRV1|ZP_PU|ZP_SL
+ \$10906 \$9148
+ VSS|XN_CS|XN_IE|XN_PD|XN_PDRV0|XN_PDRV1|XN_PU|XN_SL|XP_CS|XP_IE|XP_PD|XP_PDRV0|XP_PDRV1|XP_PU|XP_SL|YN_CS|YN_IE|YN_PD|YN_PDRV0|YN_PDRV1|YN_PU|YN_SL|YP_CS|YP_IE|YP_PD|YP_PDRV0|YP_PDRV1|YP_PU|YP_SL|ZN_CS|ZN_IE|ZN_PD|ZN_PDRV0|ZN_PDRV1|ZN_PU|ZN_SL|ZP_CS|ZP_IE|ZP_PD|ZP_PDRV0|ZP_PDRV1|ZP_PU|ZP_SL
+ nfet_06v0 L=1U W=1U AS=0.44P AD=0.44P PS=2.88U PD=2.88U
M$1680 \$10912 \$10879 \$10906
+ VSS|XN_CS|XN_IE|XN_PD|XN_PDRV0|XN_PDRV1|XN_PU|XN_SL|XP_CS|XP_IE|XP_PD|XP_PDRV0|XP_PDRV1|XP_PU|XP_SL|YN_CS|YN_IE|YN_PD|YN_PDRV0|YN_PDRV1|YN_PU|YN_SL|YP_CS|YP_IE|YP_PD|YP_PDRV0|YP_PDRV1|YP_PU|YP_SL|ZN_CS|ZN_IE|ZN_PD|ZN_PDRV0|ZN_PDRV1|ZN_PU|ZN_SL|ZP_CS|ZP_IE|ZP_PD|ZP_PDRV0|ZP_PDRV1|ZP_PU|ZP_SL
+ nfet_06v0 L=1U W=1U AS=0.44P AD=0.25P PS=2.88U PD=1.5U
M$1681
+ VSS|XN_CS|XN_IE|XN_PD|XN_PDRV0|XN_PDRV1|XN_PU|XN_SL|XP_CS|XP_IE|XP_PD|XP_PDRV0|XP_PDRV1|XP_PU|XP_SL|YN_CS|YN_IE|YN_PD|YN_PDRV0|YN_PDRV1|YN_PU|YN_SL|YP_CS|YP_IE|YP_PD|YP_PDRV0|YP_PDRV1|YP_PU|YP_SL|ZN_CS|ZN_IE|ZN_PD|ZN_PDRV0|ZN_PDRV1|ZN_PU|ZN_SL|ZP_CS|ZP_IE|ZP_PD|ZP_PDRV0|ZP_PDRV1|ZP_PU|ZP_SL
+ \$10905 \$10912
+ VSS|XN_CS|XN_IE|XN_PD|XN_PDRV0|XN_PDRV1|XN_PU|XN_SL|XP_CS|XP_IE|XP_PD|XP_PDRV0|XP_PDRV1|XP_PU|XP_SL|YN_CS|YN_IE|YN_PD|YN_PDRV0|YN_PDRV1|YN_PU|YN_SL|YP_CS|YP_IE|YP_PD|YP_PDRV0|YP_PDRV1|YP_PU|YP_SL|ZN_CS|ZN_IE|ZN_PD|ZN_PDRV0|ZN_PDRV1|ZN_PU|ZN_SL|ZP_CS|ZP_IE|ZP_PD|ZP_PDRV0|ZP_PDRV1|ZP_PU|ZP_SL
+ nfet_06v0 L=1U W=1U AS=0.25P AD=0.44P PS=1.5U PD=2.88U
M$1682 \$10920 \$10905
+ VSS|XN_CS|XN_IE|XN_PD|XN_PDRV0|XN_PDRV1|XN_PU|XN_SL|XP_CS|XP_IE|XP_PD|XP_PDRV0|XP_PDRV1|XP_PU|XP_SL|YN_CS|YN_IE|YN_PD|YN_PDRV0|YN_PDRV1|YN_PU|YN_SL|YP_CS|YP_IE|YP_PD|YP_PDRV0|YP_PDRV1|YP_PU|YP_SL|ZN_CS|ZN_IE|ZN_PD|ZN_PDRV0|ZN_PDRV1|ZN_PU|ZN_SL|ZP_CS|ZP_IE|ZP_PD|ZP_PDRV0|ZP_PDRV1|ZP_PU|ZP_SL
+ VSS|XN_CS|XN_IE|XN_PD|XN_PDRV0|XN_PDRV1|XN_PU|XN_SL|XP_CS|XP_IE|XP_PD|XP_PDRV0|XP_PDRV1|XP_PU|XP_SL|YN_CS|YN_IE|YN_PD|YN_PDRV0|YN_PDRV1|YN_PU|YN_SL|YP_CS|YP_IE|YP_PD|YP_PDRV0|YP_PDRV1|YP_PU|YP_SL|ZN_CS|ZN_IE|ZN_PD|ZN_PDRV0|ZN_PDRV1|ZN_PU|ZN_SL|ZP_CS|ZP_IE|ZP_PD|ZP_PDRV0|ZP_PDRV1|ZP_PU|ZP_SL
+ nfet_06v0 L=1U W=1U AS=0.44P AD=0.33P PS=2.88U PD=1.66U
M$1683
+ VSS|XN_CS|XN_IE|XN_PD|XN_PDRV0|XN_PDRV1|XN_PU|XN_SL|XP_CS|XP_IE|XP_PD|XP_PDRV0|XP_PDRV1|XP_PU|XP_SL|YN_CS|YN_IE|YN_PD|YN_PDRV0|YN_PDRV1|YN_PU|YN_SL|YP_CS|YP_IE|YP_PD|YP_PDRV0|YP_PDRV1|YP_PU|YP_SL|ZN_CS|ZN_IE|ZN_PD|ZN_PDRV0|ZN_PDRV1|ZN_PU|ZN_SL|ZP_CS|ZP_IE|ZP_PD|ZP_PDRV0|ZP_PDRV1|ZP_PU|ZP_SL
+ \$10907 \$10920
+ VSS|XN_CS|XN_IE|XN_PD|XN_PDRV0|XN_PDRV1|XN_PU|XN_SL|XP_CS|XP_IE|XP_PD|XP_PDRV0|XP_PDRV1|XP_PU|XP_SL|YN_CS|YN_IE|YN_PD|YN_PDRV0|YN_PDRV1|YN_PU|YN_SL|YP_CS|YP_IE|YP_PD|YP_PDRV0|YP_PDRV1|YP_PU|YP_SL|ZN_CS|ZN_IE|ZN_PD|ZN_PDRV0|ZN_PDRV1|ZN_PU|ZN_SL|ZP_CS|ZP_IE|ZP_PD|ZP_PDRV0|ZP_PDRV1|ZP_PU|ZP_SL
+ nfet_06v0 L=1U W=1U AS=0.33P AD=0.44P PS=1.66U PD=2.88U
M$1684
+ VSS|XN_CS|XN_IE|XN_PD|XN_PDRV0|XN_PDRV1|XN_PU|XN_SL|XP_CS|XP_IE|XP_PD|XP_PDRV0|XP_PDRV1|XP_PU|XP_SL|YN_CS|YN_IE|YN_PD|YN_PDRV0|YN_PDRV1|YN_PU|YN_SL|YP_CS|YP_IE|YP_PD|YP_PDRV0|YP_PDRV1|YP_PU|YP_SL|ZN_CS|ZN_IE|ZN_PD|ZN_PDRV0|ZN_PDRV1|ZN_PU|ZN_SL|ZP_CS|ZP_IE|ZP_PD|ZP_PDRV0|ZP_PDRV1|ZP_PU|ZP_SL
+ \$10908 \$7345
+ VSS|XN_CS|XN_IE|XN_PD|XN_PDRV0|XN_PDRV1|XN_PU|XN_SL|XP_CS|XP_IE|XP_PD|XP_PDRV0|XP_PDRV1|XP_PU|XP_SL|YN_CS|YN_IE|YN_PD|YN_PDRV0|YN_PDRV1|YN_PU|YN_SL|YP_CS|YP_IE|YP_PD|YP_PDRV0|YP_PDRV1|YP_PU|YP_SL|ZN_CS|ZN_IE|ZN_PD|ZN_PDRV0|ZN_PDRV1|ZN_PU|ZN_SL|ZP_CS|ZP_IE|ZP_PD|ZP_PDRV0|ZP_PDRV1|ZP_PU|ZP_SL
+ nfet_06v0 L=1U W=1U AS=0.44P AD=0.44P PS=2.88U PD=2.88U
M$1685 \$10909 \$10907 \$10908
+ VSS|XN_CS|XN_IE|XN_PD|XN_PDRV0|XN_PDRV1|XN_PU|XN_SL|XP_CS|XP_IE|XP_PD|XP_PDRV0|XP_PDRV1|XP_PU|XP_SL|YN_CS|YN_IE|YN_PD|YN_PDRV0|YN_PDRV1|YN_PU|YN_SL|YP_CS|YP_IE|YP_PD|YP_PDRV0|YP_PDRV1|YP_PU|YP_SL|ZN_CS|ZN_IE|ZN_PD|ZN_PDRV0|ZN_PDRV1|ZN_PU|ZN_SL|ZP_CS|ZP_IE|ZP_PD|ZP_PDRV0|ZP_PDRV1|ZP_PU|ZP_SL
+ nfet_06v0 L=1U W=1U AS=0.44P AD=0.25P PS=2.88U PD=1.5U
M$1686
+ VSS|XN_CS|XN_IE|XN_PD|XN_PDRV0|XN_PDRV1|XN_PU|XN_SL|XP_CS|XP_IE|XP_PD|XP_PDRV0|XP_PDRV1|XP_PU|XP_SL|YN_CS|YN_IE|YN_PD|YN_PDRV0|YN_PDRV1|YN_PU|YN_SL|YP_CS|YP_IE|YP_PD|YP_PDRV0|YP_PDRV1|YP_PU|YP_SL|ZN_CS|ZN_IE|ZN_PD|ZN_PDRV0|ZN_PDRV1|ZN_PU|ZN_SL|ZP_CS|ZP_IE|ZP_PD|ZP_PDRV0|ZP_PDRV1|ZP_PU|ZP_SL
+ \$10888 \$10909
+ VSS|XN_CS|XN_IE|XN_PD|XN_PDRV0|XN_PDRV1|XN_PU|XN_SL|XP_CS|XP_IE|XP_PD|XP_PDRV0|XP_PDRV1|XP_PU|XP_SL|YN_CS|YN_IE|YN_PD|YN_PDRV0|YN_PDRV1|YN_PU|YN_SL|YP_CS|YP_IE|YP_PD|YP_PDRV0|YP_PDRV1|YP_PU|YP_SL|ZN_CS|ZN_IE|ZN_PD|ZN_PDRV0|ZN_PDRV1|ZN_PU|ZN_SL|ZP_CS|ZP_IE|ZP_PD|ZP_PDRV0|ZP_PDRV1|ZP_PU|ZP_SL
+ nfet_06v0 L=1U W=1U AS=0.25P AD=0.44P PS=1.5U PD=2.88U
M$1687
+ VSS|XN_CS|XN_IE|XN_PD|XN_PDRV0|XN_PDRV1|XN_PU|XN_SL|XP_CS|XP_IE|XP_PD|XP_PDRV0|XP_PDRV1|XP_PU|XP_SL|YN_CS|YN_IE|YN_PD|YN_PDRV0|YN_PDRV1|YN_PU|YN_SL|YP_CS|YP_IE|YP_PD|YP_PDRV0|YP_PDRV1|YP_PU|YP_SL|ZN_CS|ZN_IE|ZN_PD|ZN_PDRV0|ZN_PDRV1|ZN_PU|ZN_SL|ZP_CS|ZP_IE|ZP_PD|ZP_PDRV0|ZP_PDRV1|ZP_PU|ZP_SL
+ VDD|XN_OE|XP_OE|YN_OE|YP_OE|ZN_OE|ZP_OE
+ VSS|XN_CS|XN_IE|XN_PD|XN_PDRV0|XN_PDRV1|XN_PU|XN_SL|XP_CS|XP_IE|XP_PD|XP_PDRV0|XP_PDRV1|XP_PU|XP_SL|YN_CS|YN_IE|YN_PD|YN_PDRV0|YN_PDRV1|YN_PU|YN_SL|YP_CS|YP_IE|YP_PD|YP_PDRV0|YP_PDRV1|YP_PU|YP_SL|ZN_CS|ZN_IE|ZN_PD|ZN_PDRV0|ZN_PDRV1|ZN_PU|ZN_SL|ZP_CS|ZP_IE|ZP_PD|ZP_PDRV0|ZP_PDRV1|ZP_PU|ZP_SL
+ VSS|XN_CS|XN_IE|XN_PD|XN_PDRV0|XN_PDRV1|XN_PU|XN_SL|XP_CS|XP_IE|XP_PD|XP_PDRV0|XP_PDRV1|XP_PU|XP_SL|YN_CS|YN_IE|YN_PD|YN_PDRV0|YN_PDRV1|YN_PU|YN_SL|YP_CS|YP_IE|YP_PD|YP_PDRV0|YP_PDRV1|YP_PU|YP_SL|ZN_CS|ZN_IE|ZN_PD|ZN_PDRV0|ZN_PDRV1|ZN_PU|ZN_SL|ZP_CS|ZP_IE|ZP_PD|ZP_PDRV0|ZP_PDRV1|ZP_PU|ZP_SL
+ nfet_06v0 L=2U W=1U AS=0.44P AD=0.44P PS=2.88U PD=2.88U
M$1688
+ VSS|XN_CS|XN_IE|XN_PD|XN_PDRV0|XN_PDRV1|XN_PU|XN_SL|XP_CS|XP_IE|XP_PD|XP_PDRV0|XP_PDRV1|XP_PU|XP_SL|YN_CS|YN_IE|YN_PD|YN_PDRV0|YN_PDRV1|YN_PU|YN_SL|YP_CS|YP_IE|YP_PD|YP_PDRV0|YP_PDRV1|YP_PU|YP_SL|ZN_CS|ZN_IE|ZN_PD|ZN_PDRV0|ZN_PDRV1|ZN_PU|ZN_SL|ZP_CS|ZP_IE|ZP_PD|ZP_PDRV0|ZP_PDRV1|ZP_PU|ZP_SL
+ VDD|XN_OE|XP_OE|YN_OE|YP_OE|ZN_OE|ZP_OE
+ VSS|XN_CS|XN_IE|XN_PD|XN_PDRV0|XN_PDRV1|XN_PU|XN_SL|XP_CS|XP_IE|XP_PD|XP_PDRV0|XP_PDRV1|XP_PU|XP_SL|YN_CS|YN_IE|YN_PD|YN_PDRV0|YN_PDRV1|YN_PU|YN_SL|YP_CS|YP_IE|YP_PD|YP_PDRV0|YP_PDRV1|YP_PU|YP_SL|ZN_CS|ZN_IE|ZN_PD|ZN_PDRV0|ZN_PDRV1|ZN_PU|ZN_SL|ZP_CS|ZP_IE|ZP_PD|ZP_PDRV0|ZP_PDRV1|ZP_PU|ZP_SL
+ VSS|XN_CS|XN_IE|XN_PD|XN_PDRV0|XN_PDRV1|XN_PU|XN_SL|XP_CS|XP_IE|XP_PD|XP_PDRV0|XP_PDRV1|XP_PU|XP_SL|YN_CS|YN_IE|YN_PD|YN_PDRV0|YN_PDRV1|YN_PU|YN_SL|YP_CS|YP_IE|YP_PD|YP_PDRV0|YP_PDRV1|YP_PU|YP_SL|ZN_CS|ZN_IE|ZN_PD|ZN_PDRV0|ZN_PDRV1|ZN_PU|ZN_SL|ZP_CS|ZP_IE|ZP_PD|ZP_PDRV0|ZP_PDRV1|ZP_PU|ZP_SL
+ nfet_06v0 L=2U W=9.75U AS=4.29P AD=4.29P PS=20.38U PD=20.38U
M$1689 \$12671 \$12671
+ VSS|XN_CS|XN_IE|XN_PD|XN_PDRV0|XN_PDRV1|XN_PU|XN_SL|XP_CS|XP_IE|XP_PD|XP_PDRV0|XP_PDRV1|XP_PU|XP_SL|YN_CS|YN_IE|YN_PD|YN_PDRV0|YN_PDRV1|YN_PU|YN_SL|YP_CS|YP_IE|YP_PD|YP_PDRV0|YP_PDRV1|YP_PU|YP_SL|ZN_CS|ZN_IE|ZN_PD|ZN_PDRV0|ZN_PDRV1|ZN_PU|ZN_SL|ZP_CS|ZP_IE|ZP_PD|ZP_PDRV0|ZP_PDRV1|ZP_PU|ZP_SL
+ VSS|XN_CS|XN_IE|XN_PD|XN_PDRV0|XN_PDRV1|XN_PU|XN_SL|XP_CS|XP_IE|XP_PD|XP_PDRV0|XP_PDRV1|XP_PU|XP_SL|YN_CS|YN_IE|YN_PD|YN_PDRV0|YN_PDRV1|YN_PU|YN_SL|YP_CS|YP_IE|YP_PD|YP_PDRV0|YP_PDRV1|YP_PU|YP_SL|ZN_CS|ZN_IE|ZN_PD|ZN_PDRV0|ZN_PDRV1|ZN_PU|ZN_SL|ZP_CS|ZP_IE|ZP_PD|ZP_PDRV0|ZP_PDRV1|ZP_PU|ZP_SL
+ nfet_06v0 L=1U W=1U AS=0.44P AD=0.44P PS=2.88U PD=2.88U
M$1690 \$12711 \$12658
+ VSS|XN_CS|XN_IE|XN_PD|XN_PDRV0|XN_PDRV1|XN_PU|XN_SL|XP_CS|XP_IE|XP_PD|XP_PDRV0|XP_PDRV1|XP_PU|XP_SL|YN_CS|YN_IE|YN_PD|YN_PDRV0|YN_PDRV1|YN_PU|YN_SL|YP_CS|YP_IE|YP_PD|YP_PDRV0|YP_PDRV1|YP_PU|YP_SL|ZN_CS|ZN_IE|ZN_PD|ZN_PDRV0|ZN_PDRV1|ZN_PU|ZN_SL|ZP_CS|ZP_IE|ZP_PD|ZP_PDRV0|ZP_PDRV1|ZP_PU|ZP_SL
+ VSS|XN_CS|XN_IE|XN_PD|XN_PDRV0|XN_PDRV1|XN_PU|XN_SL|XP_CS|XP_IE|XP_PD|XP_PDRV0|XP_PDRV1|XP_PU|XP_SL|YN_CS|YN_IE|YN_PD|YN_PDRV0|YN_PDRV1|YN_PU|YN_SL|YP_CS|YP_IE|YP_PD|YP_PDRV0|YP_PDRV1|YP_PU|YP_SL|ZN_CS|ZN_IE|ZN_PD|ZN_PDRV0|ZN_PDRV1|ZN_PU|ZN_SL|ZP_CS|ZP_IE|ZP_PD|ZP_PDRV0|ZP_PDRV1|ZP_PU|ZP_SL
+ nfet_06v0 L=1U W=5U AS=2.2P AD=1.25P PS=10.88U PD=5.5U
M$1691 \$12658 \$12671 \$12711
+ VSS|XN_CS|XN_IE|XN_PD|XN_PDRV0|XN_PDRV1|XN_PU|XN_SL|XP_CS|XP_IE|XP_PD|XP_PDRV0|XP_PDRV1|XP_PU|XP_SL|YN_CS|YN_IE|YN_PD|YN_PDRV0|YN_PDRV1|YN_PU|YN_SL|YP_CS|YP_IE|YP_PD|YP_PDRV0|YP_PDRV1|YP_PU|YP_SL|ZN_CS|ZN_IE|ZN_PD|ZN_PDRV0|ZN_PDRV1|ZN_PU|ZN_SL|ZP_CS|ZP_IE|ZP_PD|ZP_PDRV0|ZP_PDRV1|ZP_PU|ZP_SL
+ nfet_06v0 L=1U W=5U AS=1.25P AD=2.2P PS=5.5U PD=10.88U
M$1692 \$12701 \$13279
+ VSS|XN_CS|XN_IE|XN_PD|XN_PDRV0|XN_PDRV1|XN_PU|XN_SL|XP_CS|XP_IE|XP_PD|XP_PDRV0|XP_PDRV1|XP_PU|XP_SL|YN_CS|YN_IE|YN_PD|YN_PDRV0|YN_PDRV1|YN_PU|YN_SL|YP_CS|YP_IE|YP_PD|YP_PDRV0|YP_PDRV1|YP_PU|YP_SL|ZN_CS|ZN_IE|ZN_PD|ZN_PDRV0|ZN_PDRV1|ZN_PU|ZN_SL|ZP_CS|ZP_IE|ZP_PD|ZP_PDRV0|ZP_PDRV1|ZP_PU|ZP_SL
+ VSS|XN_CS|XN_IE|XN_PD|XN_PDRV0|XN_PDRV1|XN_PU|XN_SL|XP_CS|XP_IE|XP_PD|XP_PDRV0|XP_PDRV1|XP_PU|XP_SL|YN_CS|YN_IE|YN_PD|YN_PDRV0|YN_PDRV1|YN_PU|YN_SL|YP_CS|YP_IE|YP_PD|YP_PDRV0|YP_PDRV1|YP_PU|YP_SL|ZN_CS|ZN_IE|ZN_PD|ZN_PDRV0|ZN_PDRV1|ZN_PU|ZN_SL|ZP_CS|ZP_IE|ZP_PD|ZP_PDRV0|ZP_PDRV1|ZP_PU|ZP_SL
+ nfet_06v0 L=1U W=1U AS=0.44P AD=0.25P PS=2.88U PD=1.5U
M$1693 \$13200 \$13279 \$12701
+ VSS|XN_CS|XN_IE|XN_PD|XN_PDRV0|XN_PDRV1|XN_PU|XN_SL|XP_CS|XP_IE|XP_PD|XP_PDRV0|XP_PDRV1|XP_PU|XP_SL|YN_CS|YN_IE|YN_PD|YN_PDRV0|YN_PDRV1|YN_PU|YN_SL|YP_CS|YP_IE|YP_PD|YP_PDRV0|YP_PDRV1|YP_PU|YP_SL|ZN_CS|ZN_IE|ZN_PD|ZN_PDRV0|ZN_PDRV1|ZN_PU|ZN_SL|ZP_CS|ZP_IE|ZP_PD|ZP_PDRV0|ZP_PDRV1|ZP_PU|ZP_SL
+ nfet_06v0 L=1U W=1U AS=0.25P AD=0.44P PS=1.5U PD=2.88U
M$1694 \$12702 \$13279
+ VSS|XN_CS|XN_IE|XN_PD|XN_PDRV0|XN_PDRV1|XN_PU|XN_SL|XP_CS|XP_IE|XP_PD|XP_PDRV0|XP_PDRV1|XP_PU|XP_SL|YN_CS|YN_IE|YN_PD|YN_PDRV0|YN_PDRV1|YN_PU|YN_SL|YP_CS|YP_IE|YP_PD|YP_PDRV0|YP_PDRV1|YP_PU|YP_SL|ZN_CS|ZN_IE|ZN_PD|ZN_PDRV0|ZN_PDRV1|ZN_PU|ZN_SL|ZP_CS|ZP_IE|ZP_PD|ZP_PDRV0|ZP_PDRV1|ZP_PU|ZP_SL
+ VSS|XN_CS|XN_IE|XN_PD|XN_PDRV0|XN_PDRV1|XN_PU|XN_SL|XP_CS|XP_IE|XP_PD|XP_PDRV0|XP_PDRV1|XP_PU|XP_SL|YN_CS|YN_IE|YN_PD|YN_PDRV0|YN_PDRV1|YN_PU|YN_SL|YP_CS|YP_IE|YP_PD|YP_PDRV0|YP_PDRV1|YP_PU|YP_SL|ZN_CS|ZN_IE|ZN_PD|ZN_PDRV0|ZN_PDRV1|ZN_PU|ZN_SL|ZP_CS|ZP_IE|ZP_PD|ZP_PDRV0|ZP_PDRV1|ZP_PU|ZP_SL
+ nfet_06v0 L=1U W=1U AS=0.44P AD=0.25P PS=2.88U PD=1.5U
M$1695 \$13279 \$13279 \$12702
+ VSS|XN_CS|XN_IE|XN_PD|XN_PDRV0|XN_PDRV1|XN_PU|XN_SL|XP_CS|XP_IE|XP_PD|XP_PDRV0|XP_PDRV1|XP_PU|XP_SL|YN_CS|YN_IE|YN_PD|YN_PDRV0|YN_PDRV1|YN_PU|YN_SL|YP_CS|YP_IE|YP_PD|YP_PDRV0|YP_PDRV1|YP_PU|YP_SL|ZN_CS|ZN_IE|ZN_PD|ZN_PDRV0|ZN_PDRV1|ZN_PU|ZN_SL|ZP_CS|ZP_IE|ZP_PD|ZP_PDRV0|ZP_PDRV1|ZP_PU|ZP_SL
+ nfet_06v0 L=1U W=1U AS=0.25P AD=0.44P PS=1.5U PD=2.88U
M$1696 \$12712 \$12658
+ VSS|XN_CS|XN_IE|XN_PD|XN_PDRV0|XN_PDRV1|XN_PU|XN_SL|XP_CS|XP_IE|XP_PD|XP_PDRV0|XP_PDRV1|XP_PU|XP_SL|YN_CS|YN_IE|YN_PD|YN_PDRV0|YN_PDRV1|YN_PU|YN_SL|YP_CS|YP_IE|YP_PD|YP_PDRV0|YP_PDRV1|YP_PU|YP_SL|ZN_CS|ZN_IE|ZN_PD|ZN_PDRV0|ZN_PDRV1|ZN_PU|ZN_SL|ZP_CS|ZP_IE|ZP_PD|ZP_PDRV0|ZP_PDRV1|ZP_PU|ZP_SL
+ VSS|XN_CS|XN_IE|XN_PD|XN_PDRV0|XN_PDRV1|XN_PU|XN_SL|XP_CS|XP_IE|XP_PD|XP_PDRV0|XP_PDRV1|XP_PU|XP_SL|YN_CS|YN_IE|YN_PD|YN_PDRV0|YN_PDRV1|YN_PU|YN_SL|YP_CS|YP_IE|YP_PD|YP_PDRV0|YP_PDRV1|YP_PU|YP_SL|ZN_CS|ZN_IE|ZN_PD|ZN_PDRV0|ZN_PDRV1|ZN_PU|ZN_SL|ZP_CS|ZP_IE|ZP_PD|ZP_PDRV0|ZP_PDRV1|ZP_PU|ZP_SL
+ nfet_06v0 L=1U W=5U AS=2.2P AD=1.25P PS=10.88U PD=5.5U
M$1697 \$12672 \$12671 \$12712
+ VSS|XN_CS|XN_IE|XN_PD|XN_PDRV0|XN_PDRV1|XN_PU|XN_SL|XP_CS|XP_IE|XP_PD|XP_PDRV0|XP_PDRV1|XP_PU|XP_SL|YN_CS|YN_IE|YN_PD|YN_PDRV0|YN_PDRV1|YN_PU|YN_SL|YP_CS|YP_IE|YP_PD|YP_PDRV0|YP_PDRV1|YP_PU|YP_SL|ZN_CS|ZN_IE|ZN_PD|ZN_PDRV0|ZN_PDRV1|ZN_PU|ZN_SL|ZP_CS|ZP_IE|ZP_PD|ZP_PDRV0|ZP_PDRV1|ZP_PU|ZP_SL
+ nfet_06v0 L=1U W=5U AS=1.25P AD=1.65P PS=5.5U PD=5.66U
M$1698 \$12713 \$12671 \$12672
+ VSS|XN_CS|XN_IE|XN_PD|XN_PDRV0|XN_PDRV1|XN_PU|XN_SL|XP_CS|XP_IE|XP_PD|XP_PDRV0|XP_PDRV1|XP_PU|XP_SL|YN_CS|YN_IE|YN_PD|YN_PDRV0|YN_PDRV1|YN_PU|YN_SL|YP_CS|YP_IE|YP_PD|YP_PDRV0|YP_PDRV1|YP_PU|YP_SL|ZN_CS|ZN_IE|ZN_PD|ZN_PDRV0|ZN_PDRV1|ZN_PU|ZN_SL|ZP_CS|ZP_IE|ZP_PD|ZP_PDRV0|ZP_PDRV1|ZP_PU|ZP_SL
+ nfet_06v0 L=1U W=5U AS=1.65P AD=1.25P PS=5.66U PD=5.5U
M$1699
+ VSS|XN_CS|XN_IE|XN_PD|XN_PDRV0|XN_PDRV1|XN_PU|XN_SL|XP_CS|XP_IE|XP_PD|XP_PDRV0|XP_PDRV1|XP_PU|XP_SL|YN_CS|YN_IE|YN_PD|YN_PDRV0|YN_PDRV1|YN_PU|YN_SL|YP_CS|YP_IE|YP_PD|YP_PDRV0|YP_PDRV1|YP_PU|YP_SL|ZN_CS|ZN_IE|ZN_PD|ZN_PDRV0|ZN_PDRV1|ZN_PU|ZN_SL|ZP_CS|ZP_IE|ZP_PD|ZP_PDRV0|ZP_PDRV1|ZP_PU|ZP_SL
+ \$12658 \$12713
+ VSS|XN_CS|XN_IE|XN_PD|XN_PDRV0|XN_PDRV1|XN_PU|XN_SL|XP_CS|XP_IE|XP_PD|XP_PDRV0|XP_PDRV1|XP_PU|XP_SL|YN_CS|YN_IE|YN_PD|YN_PDRV0|YN_PDRV1|YN_PU|YN_SL|YP_CS|YP_IE|YP_PD|YP_PDRV0|YP_PDRV1|YP_PU|YP_SL|ZN_CS|ZN_IE|ZN_PD|ZN_PDRV0|ZN_PDRV1|ZN_PU|ZN_SL|ZP_CS|ZP_IE|ZP_PD|ZP_PDRV0|ZP_PDRV1|ZP_PU|ZP_SL
+ nfet_06v0 L=1U W=5U AS=1.25P AD=2.2P PS=5.5U PD=10.88U
M$1700 \$12673 \$4864 \$12672
+ VSS|XN_CS|XN_IE|XN_PD|XN_PDRV0|XN_PDRV1|XN_PU|XN_SL|XP_CS|XP_IE|XP_PD|XP_PDRV0|XP_PDRV1|XP_PU|XP_SL|YN_CS|YN_IE|YN_PD|YN_PDRV0|YN_PDRV1|YN_PU|YN_SL|YP_CS|YP_IE|YP_PD|YP_PDRV0|YP_PDRV1|YP_PU|YP_SL|ZN_CS|ZN_IE|ZN_PD|ZN_PDRV0|ZN_PDRV1|ZN_PU|ZN_SL|ZP_CS|ZP_IE|ZP_PD|ZP_PDRV0|ZP_PDRV1|ZP_PU|ZP_SL
+ nfet_06v0 L=1U W=5U AS=2.2P AD=1.3P PS=10.88U PD=5.52U
M$1701 \$12672 \$4864 \$12673
+ VSS|XN_CS|XN_IE|XN_PD|XN_PDRV0|XN_PDRV1|XN_PU|XN_SL|XP_CS|XP_IE|XP_PD|XP_PDRV0|XP_PDRV1|XP_PU|XP_SL|YN_CS|YN_IE|YN_PD|YN_PDRV0|YN_PDRV1|YN_PU|YN_SL|YP_CS|YP_IE|YP_PD|YP_PDRV0|YP_PDRV1|YP_PU|YP_SL|ZN_CS|ZN_IE|ZN_PD|ZN_PDRV0|ZN_PDRV1|ZN_PU|ZN_SL|ZP_CS|ZP_IE|ZP_PD|ZP_PDRV0|ZP_PDRV1|ZP_PU|ZP_SL
+ nfet_06v0 L=1U W=5U AS=1.3P AD=2.2P PS=5.52U PD=10.88U
M$1702 \$12674 \$4880 \$12672
+ VSS|XN_CS|XN_IE|XN_PD|XN_PDRV0|XN_PDRV1|XN_PU|XN_SL|XP_CS|XP_IE|XP_PD|XP_PDRV0|XP_PDRV1|XP_PU|XP_SL|YN_CS|YN_IE|YN_PD|YN_PDRV0|YN_PDRV1|YN_PU|YN_SL|YP_CS|YP_IE|YP_PD|YP_PDRV0|YP_PDRV1|YP_PU|YP_SL|ZN_CS|ZN_IE|ZN_PD|ZN_PDRV0|ZN_PDRV1|ZN_PU|ZN_SL|ZP_CS|ZP_IE|ZP_PD|ZP_PDRV0|ZP_PDRV1|ZP_PU|ZP_SL
+ nfet_06v0 L=1U W=5U AS=2.2P AD=1.3P PS=10.88U PD=5.52U
M$1703 \$12672 \$4880 \$12674
+ VSS|XN_CS|XN_IE|XN_PD|XN_PDRV0|XN_PDRV1|XN_PU|XN_SL|XP_CS|XP_IE|XP_PD|XP_PDRV0|XP_PDRV1|XP_PU|XP_SL|YN_CS|YN_IE|YN_PD|YN_PDRV0|YN_PDRV1|YN_PU|YN_SL|YP_CS|YP_IE|YP_PD|YP_PDRV0|YP_PDRV1|YP_PU|YP_SL|ZN_CS|ZN_IE|ZN_PD|ZN_PDRV0|ZN_PDRV1|ZN_PU|ZN_SL|ZP_CS|ZP_IE|ZP_PD|ZP_PDRV0|ZP_PDRV1|ZP_PU|ZP_SL
+ nfet_06v0 L=1U W=5U AS=1.3P AD=2.2P PS=5.52U PD=10.88U
M$1704 \$12676 \$12671 \$12675
+ VSS|XN_CS|XN_IE|XN_PD|XN_PDRV0|XN_PDRV1|XN_PU|XN_SL|XP_CS|XP_IE|XP_PD|XP_PDRV0|XP_PDRV1|XP_PU|XP_SL|YN_CS|YN_IE|YN_PD|YN_PDRV0|YN_PDRV1|YN_PU|YN_SL|YP_CS|YP_IE|YP_PD|YP_PDRV0|YP_PDRV1|YP_PU|YP_SL|ZN_CS|ZN_IE|ZN_PD|ZN_PDRV0|ZN_PDRV1|ZN_PU|ZN_SL|ZP_CS|ZP_IE|ZP_PD|ZP_PDRV0|ZP_PDRV1|ZP_PU|ZP_SL
+ nfet_06v0 L=1U W=2.5U AS=1.1P AD=0.65P PS=5.88U PD=3.02U
M$1705 \$12675 \$12671 \$12676
+ VSS|XN_CS|XN_IE|XN_PD|XN_PDRV0|XN_PDRV1|XN_PU|XN_SL|XP_CS|XP_IE|XP_PD|XP_PDRV0|XP_PDRV1|XP_PU|XP_SL|YN_CS|YN_IE|YN_PD|YN_PDRV0|YN_PDRV1|YN_PU|YN_SL|YP_CS|YP_IE|YP_PD|YP_PDRV0|YP_PDRV1|YP_PU|YP_SL|ZN_CS|ZN_IE|ZN_PD|ZN_PDRV0|ZN_PDRV1|ZN_PU|ZN_SL|ZP_CS|ZP_IE|ZP_PD|ZP_PDRV0|ZP_PDRV1|ZP_PU|ZP_SL
+ nfet_06v0 L=1U W=2.5U AS=0.65P AD=1.1P PS=3.02U PD=5.88U
M$1706 \$12678 \$12671 \$12677
+ VSS|XN_CS|XN_IE|XN_PD|XN_PDRV0|XN_PDRV1|XN_PU|XN_SL|XP_CS|XP_IE|XP_PD|XP_PDRV0|XP_PDRV1|XP_PU|XP_SL|YN_CS|YN_IE|YN_PD|YN_PDRV0|YN_PDRV1|YN_PU|YN_SL|YP_CS|YP_IE|YP_PD|YP_PDRV0|YP_PDRV1|YP_PU|YP_SL|ZN_CS|ZN_IE|ZN_PD|ZN_PDRV0|ZN_PDRV1|ZN_PU|ZN_SL|ZP_CS|ZP_IE|ZP_PD|ZP_PDRV0|ZP_PDRV1|ZP_PU|ZP_SL
+ nfet_06v0 L=1U W=2.5U AS=1.1P AD=0.65P PS=5.88U PD=3.02U
M$1707 \$12677 \$12671 \$12678
+ VSS|XN_CS|XN_IE|XN_PD|XN_PDRV0|XN_PDRV1|XN_PU|XN_SL|XP_CS|XP_IE|XP_PD|XP_PDRV0|XP_PDRV1|XP_PU|XP_SL|YN_CS|YN_IE|YN_PD|YN_PDRV0|YN_PDRV1|YN_PU|YN_SL|YP_CS|YP_IE|YP_PD|YP_PDRV0|YP_PDRV1|YP_PU|YP_SL|ZN_CS|ZN_IE|ZN_PD|ZN_PDRV0|ZN_PDRV1|ZN_PU|ZN_SL|ZP_CS|ZP_IE|ZP_PD|ZP_PDRV0|ZP_PDRV1|ZP_PU|ZP_SL
+ nfet_06v0 L=1U W=2.5U AS=0.65P AD=1.1P PS=3.02U PD=5.88U
M$1708 \$12675 \$12676
+ VSS|XN_CS|XN_IE|XN_PD|XN_PDRV0|XN_PDRV1|XN_PU|XN_SL|XP_CS|XP_IE|XP_PD|XP_PDRV0|XP_PDRV1|XP_PU|XP_SL|YN_CS|YN_IE|YN_PD|YN_PDRV0|YN_PDRV1|YN_PU|YN_SL|YP_CS|YP_IE|YP_PD|YP_PDRV0|YP_PDRV1|YP_PU|YP_SL|ZN_CS|ZN_IE|ZN_PD|ZN_PDRV0|ZN_PDRV1|ZN_PU|ZN_SL|ZP_CS|ZP_IE|ZP_PD|ZP_PDRV0|ZP_PDRV1|ZP_PU|ZP_SL
+ VSS|XN_CS|XN_IE|XN_PD|XN_PDRV0|XN_PDRV1|XN_PU|XN_SL|XP_CS|XP_IE|XP_PD|XP_PDRV0|XP_PDRV1|XP_PU|XP_SL|YN_CS|YN_IE|YN_PD|YN_PDRV0|YN_PDRV1|YN_PU|YN_SL|YP_CS|YP_IE|YP_PD|YP_PDRV0|YP_PDRV1|YP_PU|YP_SL|ZN_CS|ZN_IE|ZN_PD|ZN_PDRV0|ZN_PDRV1|ZN_PU|ZN_SL|ZP_CS|ZP_IE|ZP_PD|ZP_PDRV0|ZP_PDRV1|ZP_PU|ZP_SL
+ nfet_06v0 L=1U W=2.5U AS=1.1P AD=0.65P PS=5.88U PD=3.02U
M$1709
+ VSS|XN_CS|XN_IE|XN_PD|XN_PDRV0|XN_PDRV1|XN_PU|XN_SL|XP_CS|XP_IE|XP_PD|XP_PDRV0|XP_PDRV1|XP_PU|XP_SL|YN_CS|YN_IE|YN_PD|YN_PDRV0|YN_PDRV1|YN_PU|YN_SL|YP_CS|YP_IE|YP_PD|YP_PDRV0|YP_PDRV1|YP_PU|YP_SL|ZN_CS|ZN_IE|ZN_PD|ZN_PDRV0|ZN_PDRV1|ZN_PU|ZN_SL|ZP_CS|ZP_IE|ZP_PD|ZP_PDRV0|ZP_PDRV1|ZP_PU|ZP_SL
+ \$12676 \$12675
+ VSS|XN_CS|XN_IE|XN_PD|XN_PDRV0|XN_PDRV1|XN_PU|XN_SL|XP_CS|XP_IE|XP_PD|XP_PDRV0|XP_PDRV1|XP_PU|XP_SL|YN_CS|YN_IE|YN_PD|YN_PDRV0|YN_PDRV1|YN_PU|YN_SL|YP_CS|YP_IE|YP_PD|YP_PDRV0|YP_PDRV1|YP_PU|YP_SL|ZN_CS|ZN_IE|ZN_PD|ZN_PDRV0|ZN_PDRV1|ZN_PU|ZN_SL|ZP_CS|ZP_IE|ZP_PD|ZP_PDRV0|ZP_PDRV1|ZP_PU|ZP_SL
+ nfet_06v0 L=1U W=2.5U AS=0.65P AD=0.65P PS=3.02U PD=3.02U
M$1710 \$12675 \$12676
+ VSS|XN_CS|XN_IE|XN_PD|XN_PDRV0|XN_PDRV1|XN_PU|XN_SL|XP_CS|XP_IE|XP_PD|XP_PDRV0|XP_PDRV1|XP_PU|XP_SL|YN_CS|YN_IE|YN_PD|YN_PDRV0|YN_PDRV1|YN_PU|YN_SL|YP_CS|YP_IE|YP_PD|YP_PDRV0|YP_PDRV1|YP_PU|YP_SL|ZN_CS|ZN_IE|ZN_PD|ZN_PDRV0|ZN_PDRV1|ZN_PU|ZN_SL|ZP_CS|ZP_IE|ZP_PD|ZP_PDRV0|ZP_PDRV1|ZP_PU|ZP_SL
+ VSS|XN_CS|XN_IE|XN_PD|XN_PDRV0|XN_PDRV1|XN_PU|XN_SL|XP_CS|XP_IE|XP_PD|XP_PDRV0|XP_PDRV1|XP_PU|XP_SL|YN_CS|YN_IE|YN_PD|YN_PDRV0|YN_PDRV1|YN_PU|YN_SL|YP_CS|YP_IE|YP_PD|YP_PDRV0|YP_PDRV1|YP_PU|YP_SL|ZN_CS|ZN_IE|ZN_PD|ZN_PDRV0|ZN_PDRV1|ZN_PU|ZN_SL|ZP_CS|ZP_IE|ZP_PD|ZP_PDRV0|ZP_PDRV1|ZP_PU|ZP_SL
+ nfet_06v0 L=1U W=2.5U AS=0.65P AD=0.65P PS=3.02U PD=3.02U
M$1711
+ VSS|XN_CS|XN_IE|XN_PD|XN_PDRV0|XN_PDRV1|XN_PU|XN_SL|XP_CS|XP_IE|XP_PD|XP_PDRV0|XP_PDRV1|XP_PU|XP_SL|YN_CS|YN_IE|YN_PD|YN_PDRV0|YN_PDRV1|YN_PU|YN_SL|YP_CS|YP_IE|YP_PD|YP_PDRV0|YP_PDRV1|YP_PU|YP_SL|ZN_CS|ZN_IE|ZN_PD|ZN_PDRV0|ZN_PDRV1|ZN_PU|ZN_SL|ZP_CS|ZP_IE|ZP_PD|ZP_PDRV0|ZP_PDRV1|ZP_PU|ZP_SL
+ \$12676 \$12675
+ VSS|XN_CS|XN_IE|XN_PD|XN_PDRV0|XN_PDRV1|XN_PU|XN_SL|XP_CS|XP_IE|XP_PD|XP_PDRV0|XP_PDRV1|XP_PU|XP_SL|YN_CS|YN_IE|YN_PD|YN_PDRV0|YN_PDRV1|YN_PU|YN_SL|YP_CS|YP_IE|YP_PD|YP_PDRV0|YP_PDRV1|YP_PU|YP_SL|ZN_CS|ZN_IE|ZN_PD|ZN_PDRV0|ZN_PDRV1|ZN_PU|ZN_SL|ZP_CS|ZP_IE|ZP_PD|ZP_PDRV0|ZP_PDRV1|ZP_PU|ZP_SL
+ nfet_06v0 L=1U W=2.5U AS=0.65P AD=1.1P PS=3.02U PD=5.88U
M$1712 \$12677 \$12676
+ VSS|XN_CS|XN_IE|XN_PD|XN_PDRV0|XN_PDRV1|XN_PU|XN_SL|XP_CS|XP_IE|XP_PD|XP_PDRV0|XP_PDRV1|XP_PU|XP_SL|YN_CS|YN_IE|YN_PD|YN_PDRV0|YN_PDRV1|YN_PU|YN_SL|YP_CS|YP_IE|YP_PD|YP_PDRV0|YP_PDRV1|YP_PU|YP_SL|ZN_CS|ZN_IE|ZN_PD|ZN_PDRV0|ZN_PDRV1|ZN_PU|ZN_SL|ZP_CS|ZP_IE|ZP_PD|ZP_PDRV0|ZP_PDRV1|ZP_PU|ZP_SL
+ VSS|XN_CS|XN_IE|XN_PD|XN_PDRV0|XN_PDRV1|XN_PU|XN_SL|XP_CS|XP_IE|XP_PD|XP_PDRV0|XP_PDRV1|XP_PU|XP_SL|YN_CS|YN_IE|YN_PD|YN_PDRV0|YN_PDRV1|YN_PU|YN_SL|YP_CS|YP_IE|YP_PD|YP_PDRV0|YP_PDRV1|YP_PU|YP_SL|ZN_CS|ZN_IE|ZN_PD|ZN_PDRV0|ZN_PDRV1|ZN_PU|ZN_SL|ZP_CS|ZP_IE|ZP_PD|ZP_PDRV0|ZP_PDRV1|ZP_PU|ZP_SL
+ nfet_06v0 L=1U W=2.5U AS=1.1P AD=0.65P PS=5.88U PD=3.02U
M$1713
+ VSS|XN_CS|XN_IE|XN_PD|XN_PDRV0|XN_PDRV1|XN_PU|XN_SL|XP_CS|XP_IE|XP_PD|XP_PDRV0|XP_PDRV1|XP_PU|XP_SL|YN_CS|YN_IE|YN_PD|YN_PDRV0|YN_PDRV1|YN_PU|YN_SL|YP_CS|YP_IE|YP_PD|YP_PDRV0|YP_PDRV1|YP_PU|YP_SL|ZN_CS|ZN_IE|ZN_PD|ZN_PDRV0|ZN_PDRV1|ZN_PU|ZN_SL|ZP_CS|ZP_IE|ZP_PD|ZP_PDRV0|ZP_PDRV1|ZP_PU|ZP_SL
+ \$12676 \$12677
+ VSS|XN_CS|XN_IE|XN_PD|XN_PDRV0|XN_PDRV1|XN_PU|XN_SL|XP_CS|XP_IE|XP_PD|XP_PDRV0|XP_PDRV1|XP_PU|XP_SL|YN_CS|YN_IE|YN_PD|YN_PDRV0|YN_PDRV1|YN_PU|YN_SL|YP_CS|YP_IE|YP_PD|YP_PDRV0|YP_PDRV1|YP_PU|YP_SL|ZN_CS|ZN_IE|ZN_PD|ZN_PDRV0|ZN_PDRV1|ZN_PU|ZN_SL|ZP_CS|ZP_IE|ZP_PD|ZP_PDRV0|ZP_PDRV1|ZP_PU|ZP_SL
+ nfet_06v0 L=1U W=2.5U AS=0.65P AD=0.65P PS=3.02U PD=3.02U
M$1714 \$12677 \$12676
+ VSS|XN_CS|XN_IE|XN_PD|XN_PDRV0|XN_PDRV1|XN_PU|XN_SL|XP_CS|XP_IE|XP_PD|XP_PDRV0|XP_PDRV1|XP_PU|XP_SL|YN_CS|YN_IE|YN_PD|YN_PDRV0|YN_PDRV1|YN_PU|YN_SL|YP_CS|YP_IE|YP_PD|YP_PDRV0|YP_PDRV1|YP_PU|YP_SL|ZN_CS|ZN_IE|ZN_PD|ZN_PDRV0|ZN_PDRV1|ZN_PU|ZN_SL|ZP_CS|ZP_IE|ZP_PD|ZP_PDRV0|ZP_PDRV1|ZP_PU|ZP_SL
+ VSS|XN_CS|XN_IE|XN_PD|XN_PDRV0|XN_PDRV1|XN_PU|XN_SL|XP_CS|XP_IE|XP_PD|XP_PDRV0|XP_PDRV1|XP_PU|XP_SL|YN_CS|YN_IE|YN_PD|YN_PDRV0|YN_PDRV1|YN_PU|YN_SL|YP_CS|YP_IE|YP_PD|YP_PDRV0|YP_PDRV1|YP_PU|YP_SL|ZN_CS|ZN_IE|ZN_PD|ZN_PDRV0|ZN_PDRV1|ZN_PU|ZN_SL|ZP_CS|ZP_IE|ZP_PD|ZP_PDRV0|ZP_PDRV1|ZP_PU|ZP_SL
+ nfet_06v0 L=1U W=2.5U AS=0.65P AD=0.65P PS=3.02U PD=3.02U
M$1715
+ VSS|XN_CS|XN_IE|XN_PD|XN_PDRV0|XN_PDRV1|XN_PU|XN_SL|XP_CS|XP_IE|XP_PD|XP_PDRV0|XP_PDRV1|XP_PU|XP_SL|YN_CS|YN_IE|YN_PD|YN_PDRV0|YN_PDRV1|YN_PU|YN_SL|YP_CS|YP_IE|YP_PD|YP_PDRV0|YP_PDRV1|YP_PU|YP_SL|ZN_CS|ZN_IE|ZN_PD|ZN_PDRV0|ZN_PDRV1|ZN_PU|ZN_SL|ZP_CS|ZP_IE|ZP_PD|ZP_PDRV0|ZP_PDRV1|ZP_PU|ZP_SL
+ \$12676 \$12677
+ VSS|XN_CS|XN_IE|XN_PD|XN_PDRV0|XN_PDRV1|XN_PU|XN_SL|XP_CS|XP_IE|XP_PD|XP_PDRV0|XP_PDRV1|XP_PU|XP_SL|YN_CS|YN_IE|YN_PD|YN_PDRV0|YN_PDRV1|YN_PU|YN_SL|YP_CS|YP_IE|YP_PD|YP_PDRV0|YP_PDRV1|YP_PU|YP_SL|ZN_CS|ZN_IE|ZN_PD|ZN_PDRV0|ZN_PDRV1|ZN_PU|ZN_SL|ZP_CS|ZP_IE|ZP_PD|ZP_PDRV0|ZP_PDRV1|ZP_PU|ZP_SL
+ nfet_06v0 L=1U W=2.5U AS=0.65P AD=1.1P PS=3.02U PD=5.88U
M$1716 \$12744 \$12708 \$12676
+ VSS|XN_CS|XN_IE|XN_PD|XN_PDRV0|XN_PDRV1|XN_PU|XN_SL|XP_CS|XP_IE|XP_PD|XP_PDRV0|XP_PDRV1|XP_PU|XP_SL|YN_CS|YN_IE|YN_PD|YN_PDRV0|YN_PDRV1|YN_PU|YN_SL|YP_CS|YP_IE|YP_PD|YP_PDRV0|YP_PDRV1|YP_PU|YP_SL|ZN_CS|ZN_IE|ZN_PD|ZN_PDRV0|ZN_PDRV1|ZN_PU|ZN_SL|ZP_CS|ZP_IE|ZP_PD|ZP_PDRV0|ZP_PDRV1|ZP_PU|ZP_SL
+ nfet_06v0 L=1U W=2.5U AS=1.1P AD=1.1P PS=5.88U PD=5.88U
M$1717 \$12659 \$12708 \$12678
+ VSS|XN_CS|XN_IE|XN_PD|XN_PDRV0|XN_PDRV1|XN_PU|XN_SL|XP_CS|XP_IE|XP_PD|XP_PDRV0|XP_PDRV1|XP_PU|XP_SL|YN_CS|YN_IE|YN_PD|YN_PDRV0|YN_PDRV1|YN_PU|YN_SL|YP_CS|YP_IE|YP_PD|YP_PDRV0|YP_PDRV1|YP_PU|YP_SL|ZN_CS|ZN_IE|ZN_PD|ZN_PDRV0|ZN_PDRV1|ZN_PU|ZN_SL|ZP_CS|ZP_IE|ZP_PD|ZP_PDRV0|ZP_PDRV1|ZP_PU|ZP_SL
+ nfet_06v0 L=1U W=2.5U AS=1.1P AD=1.1P PS=5.88U PD=5.88U
M$1718 \$12714 \$12658
+ VSS|XN_CS|XN_IE|XN_PD|XN_PDRV0|XN_PDRV1|XN_PU|XN_SL|XP_CS|XP_IE|XP_PD|XP_PDRV0|XP_PDRV1|XP_PU|XP_SL|YN_CS|YN_IE|YN_PD|YN_PDRV0|YN_PDRV1|YN_PU|YN_SL|YP_CS|YP_IE|YP_PD|YP_PDRV0|YP_PDRV1|YP_PU|YP_SL|ZN_CS|ZN_IE|ZN_PD|ZN_PDRV0|ZN_PDRV1|ZN_PU|ZN_SL|ZP_CS|ZP_IE|ZP_PD|ZP_PDRV0|ZP_PDRV1|ZP_PU|ZP_SL
+ VSS|XN_CS|XN_IE|XN_PD|XN_PDRV0|XN_PDRV1|XN_PU|XN_SL|XP_CS|XP_IE|XP_PD|XP_PDRV0|XP_PDRV1|XP_PU|XP_SL|YN_CS|YN_IE|YN_PD|YN_PDRV0|YN_PDRV1|YN_PU|YN_SL|YP_CS|YP_IE|YP_PD|YP_PDRV0|YP_PDRV1|YP_PU|YP_SL|ZN_CS|ZN_IE|ZN_PD|ZN_PDRV0|ZN_PDRV1|ZN_PU|ZN_SL|ZP_CS|ZP_IE|ZP_PD|ZP_PDRV0|ZP_PDRV1|ZP_PU|ZP_SL
+ nfet_06v0 L=1U W=5U AS=2.2P AD=1.25P PS=10.88U PD=5.5U
M$1719 \$12660 \$12671 \$12714
+ VSS|XN_CS|XN_IE|XN_PD|XN_PDRV0|XN_PDRV1|XN_PU|XN_SL|XP_CS|XP_IE|XP_PD|XP_PDRV0|XP_PDRV1|XP_PU|XP_SL|YN_CS|YN_IE|YN_PD|YN_PDRV0|YN_PDRV1|YN_PU|YN_SL|YP_CS|YP_IE|YP_PD|YP_PDRV0|YP_PDRV1|YP_PU|YP_SL|ZN_CS|ZN_IE|ZN_PD|ZN_PDRV0|ZN_PDRV1|ZN_PU|ZN_SL|ZP_CS|ZP_IE|ZP_PD|ZP_PDRV0|ZP_PDRV1|ZP_PU|ZP_SL
+ nfet_06v0 L=1U W=5U AS=1.25P AD=2.2P PS=5.5U PD=10.88U
M$1720 \$12715 \$12661
+ VSS|XN_CS|XN_IE|XN_PD|XN_PDRV0|XN_PDRV1|XN_PU|XN_SL|XP_CS|XP_IE|XP_PD|XP_PDRV0|XP_PDRV1|XP_PU|XP_SL|YN_CS|YN_IE|YN_PD|YN_PDRV0|YN_PDRV1|YN_PU|YN_SL|YP_CS|YP_IE|YP_PD|YP_PDRV0|YP_PDRV1|YP_PU|YP_SL|ZN_CS|ZN_IE|ZN_PD|ZN_PDRV0|ZN_PDRV1|ZN_PU|ZN_SL|ZP_CS|ZP_IE|ZP_PD|ZP_PDRV0|ZP_PDRV1|ZP_PU|ZP_SL
+ VSS|XN_CS|XN_IE|XN_PD|XN_PDRV0|XN_PDRV1|XN_PU|XN_SL|XP_CS|XP_IE|XP_PD|XP_PDRV0|XP_PDRV1|XP_PU|XP_SL|YN_CS|YN_IE|YN_PD|YN_PDRV0|YN_PDRV1|YN_PU|YN_SL|YP_CS|YP_IE|YP_PD|YP_PDRV0|YP_PDRV1|YP_PU|YP_SL|ZN_CS|ZN_IE|ZN_PD|ZN_PDRV0|ZN_PDRV1|ZN_PU|ZN_SL|ZP_CS|ZP_IE|ZP_PD|ZP_PDRV0|ZP_PDRV1|ZP_PU|ZP_SL
+ nfet_06v0 L=1U W=5U AS=2.2P AD=1.25P PS=10.88U PD=5.5U
M$1721 \$12661 \$12671 \$12715
+ VSS|XN_CS|XN_IE|XN_PD|XN_PDRV0|XN_PDRV1|XN_PU|XN_SL|XP_CS|XP_IE|XP_PD|XP_PDRV0|XP_PDRV1|XP_PU|XP_SL|YN_CS|YN_IE|YN_PD|YN_PDRV0|YN_PDRV1|YN_PU|YN_SL|YP_CS|YP_IE|YP_PD|YP_PDRV0|YP_PDRV1|YP_PU|YP_SL|ZN_CS|ZN_IE|ZN_PD|ZN_PDRV0|ZN_PDRV1|ZN_PU|ZN_SL|ZP_CS|ZP_IE|ZP_PD|ZP_PDRV0|ZP_PDRV1|ZP_PU|ZP_SL
+ nfet_06v0 L=1U W=5U AS=1.25P AD=1.65P PS=5.5U PD=5.66U
M$1722 \$12708 \$12708 \$12661
+ VSS|XN_CS|XN_IE|XN_PD|XN_PDRV0|XN_PDRV1|XN_PU|XN_SL|XP_CS|XP_IE|XP_PD|XP_PDRV0|XP_PDRV1|XP_PU|XP_SL|YN_CS|YN_IE|YN_PD|YN_PDRV0|YN_PDRV1|YN_PU|YN_SL|YP_CS|YP_IE|YP_PD|YP_PDRV0|YP_PDRV1|YP_PU|YP_SL|ZN_CS|ZN_IE|ZN_PD|ZN_PDRV0|ZN_PDRV1|ZN_PU|ZN_SL|ZP_CS|ZP_IE|ZP_PD|ZP_PDRV0|ZP_PDRV1|ZP_PU|ZP_SL
+ nfet_06v0 L=1U W=5U AS=1.65P AD=2.2P PS=5.66U PD=10.88U
M$1723 \$12679 \$12678
+ VSS|XN_CS|XN_IE|XN_PD|XN_PDRV0|XN_PDRV1|XN_PU|XN_SL|XP_CS|XP_IE|XP_PD|XP_PDRV0|XP_PDRV1|XP_PU|XP_SL|YN_CS|YN_IE|YN_PD|YN_PDRV0|YN_PDRV1|YN_PU|YN_SL|YP_CS|YP_IE|YP_PD|YP_PDRV0|YP_PDRV1|YP_PU|YP_SL|ZN_CS|ZN_IE|ZN_PD|ZN_PDRV0|ZN_PDRV1|ZN_PU|ZN_SL|ZP_CS|ZP_IE|ZP_PD|ZP_PDRV0|ZP_PDRV1|ZP_PU|ZP_SL
+ VSS|XN_CS|XN_IE|XN_PD|XN_PDRV0|XN_PDRV1|XN_PU|XN_SL|XP_CS|XP_IE|XP_PD|XP_PDRV0|XP_PDRV1|XP_PU|XP_SL|YN_CS|YN_IE|YN_PD|YN_PDRV0|YN_PDRV1|YN_PU|YN_SL|YP_CS|YP_IE|YP_PD|YP_PDRV0|YP_PDRV1|YP_PU|YP_SL|ZN_CS|ZN_IE|ZN_PD|ZN_PDRV0|ZN_PDRV1|ZN_PU|ZN_SL|ZP_CS|ZP_IE|ZP_PD|ZP_PDRV0|ZP_PDRV1|ZP_PU|ZP_SL
+ nfet_06v0 L=1U W=5U AS=2.2P AD=1.3P PS=10.88U PD=5.52U
M$1724
+ VSS|XN_CS|XN_IE|XN_PD|XN_PDRV0|XN_PDRV1|XN_PU|XN_SL|XP_CS|XP_IE|XP_PD|XP_PDRV0|XP_PDRV1|XP_PU|XP_SL|YN_CS|YN_IE|YN_PD|YN_PDRV0|YN_PDRV1|YN_PU|YN_SL|YP_CS|YP_IE|YP_PD|YP_PDRV0|YP_PDRV1|YP_PU|YP_SL|ZN_CS|ZN_IE|ZN_PD|ZN_PDRV0|ZN_PDRV1|ZN_PU|ZN_SL|ZP_CS|ZP_IE|ZP_PD|ZP_PDRV0|ZP_PDRV1|ZP_PU|ZP_SL
+ \$12678 \$12679
+ VSS|XN_CS|XN_IE|XN_PD|XN_PDRV0|XN_PDRV1|XN_PU|XN_SL|XP_CS|XP_IE|XP_PD|XP_PDRV0|XP_PDRV1|XP_PU|XP_SL|YN_CS|YN_IE|YN_PD|YN_PDRV0|YN_PDRV1|YN_PU|YN_SL|YP_CS|YP_IE|YP_PD|YP_PDRV0|YP_PDRV1|YP_PU|YP_SL|ZN_CS|ZN_IE|ZN_PD|ZN_PDRV0|ZN_PDRV1|ZN_PU|ZN_SL|ZP_CS|ZP_IE|ZP_PD|ZP_PDRV0|ZP_PDRV1|ZP_PU|ZP_SL
+ nfet_06v0 L=1U W=5U AS=1.3P AD=1.3P PS=5.52U PD=5.52U
M$1725 \$12679 \$12678
+ VSS|XN_CS|XN_IE|XN_PD|XN_PDRV0|XN_PDRV1|XN_PU|XN_SL|XP_CS|XP_IE|XP_PD|XP_PDRV0|XP_PDRV1|XP_PU|XP_SL|YN_CS|YN_IE|YN_PD|YN_PDRV0|YN_PDRV1|YN_PU|YN_SL|YP_CS|YP_IE|YP_PD|YP_PDRV0|YP_PDRV1|YP_PU|YP_SL|ZN_CS|ZN_IE|ZN_PD|ZN_PDRV0|ZN_PDRV1|ZN_PU|ZN_SL|ZP_CS|ZP_IE|ZP_PD|ZP_PDRV0|ZP_PDRV1|ZP_PU|ZP_SL
+ VSS|XN_CS|XN_IE|XN_PD|XN_PDRV0|XN_PDRV1|XN_PU|XN_SL|XP_CS|XP_IE|XP_PD|XP_PDRV0|XP_PDRV1|XP_PU|XP_SL|YN_CS|YN_IE|YN_PD|YN_PDRV0|YN_PDRV1|YN_PU|YN_SL|YP_CS|YP_IE|YP_PD|YP_PDRV0|YP_PDRV1|YP_PU|YP_SL|ZN_CS|ZN_IE|ZN_PD|ZN_PDRV0|ZN_PDRV1|ZN_PU|ZN_SL|ZP_CS|ZP_IE|ZP_PD|ZP_PDRV0|ZP_PDRV1|ZP_PU|ZP_SL
+ nfet_06v0 L=1U W=5U AS=1.3P AD=2.2P PS=5.52U PD=10.88U
M$1726
+ VSS|XN_CS|XN_IE|XN_PD|XN_PDRV0|XN_PDRV1|XN_PU|XN_SL|XP_CS|XP_IE|XP_PD|XP_PDRV0|XP_PDRV1|XP_PU|XP_SL|YN_CS|YN_IE|YN_PD|YN_PDRV0|YN_PDRV1|YN_PU|YN_SL|YP_CS|YP_IE|YP_PD|YP_PDRV0|YP_PDRV1|YP_PU|YP_SL|ZN_CS|ZN_IE|ZN_PD|ZN_PDRV0|ZN_PDRV1|ZN_PU|ZN_SL|ZP_CS|ZP_IE|ZP_PD|ZP_PDRV0|ZP_PDRV1|ZP_PU|ZP_SL
+ VDD|XN_OE|XP_OE|YN_OE|YP_OE|ZN_OE|ZP_OE
+ VSS|XN_CS|XN_IE|XN_PD|XN_PDRV0|XN_PDRV1|XN_PU|XN_SL|XP_CS|XP_IE|XP_PD|XP_PDRV0|XP_PDRV1|XP_PU|XP_SL|YN_CS|YN_IE|YN_PD|YN_PDRV0|YN_PDRV1|YN_PU|YN_SL|YP_CS|YP_IE|YP_PD|YP_PDRV0|YP_PDRV1|YP_PU|YP_SL|ZN_CS|ZN_IE|ZN_PD|ZN_PDRV0|ZN_PDRV1|ZN_PU|ZN_SL|ZP_CS|ZP_IE|ZP_PD|ZP_PDRV0|ZP_PDRV1|ZP_PU|ZP_SL
+ VSS|XN_CS|XN_IE|XN_PD|XN_PDRV0|XN_PDRV1|XN_PU|XN_SL|XP_CS|XP_IE|XP_PD|XP_PDRV0|XP_PDRV1|XP_PU|XP_SL|YN_CS|YN_IE|YN_PD|YN_PDRV0|YN_PDRV1|YN_PU|YN_SL|YP_CS|YP_IE|YP_PD|YP_PDRV0|YP_PDRV1|YP_PU|YP_SL|ZN_CS|ZN_IE|ZN_PD|ZN_PDRV0|ZN_PDRV1|ZN_PU|ZN_SL|ZP_CS|ZP_IE|ZP_PD|ZP_PDRV0|ZP_PDRV1|ZP_PU|ZP_SL
+ nfet_06v0 L=2U W=9.75U AS=4.29P AD=4.29P PS=20.38U PD=20.38U
M$1727
+ VSS|XN_CS|XN_IE|XN_PD|XN_PDRV0|XN_PDRV1|XN_PU|XN_SL|XP_CS|XP_IE|XP_PD|XP_PDRV0|XP_PDRV1|XP_PU|XP_SL|YN_CS|YN_IE|YN_PD|YN_PDRV0|YN_PDRV1|YN_PU|YN_SL|YP_CS|YP_IE|YP_PD|YP_PDRV0|YP_PDRV1|YP_PU|YP_SL|ZN_CS|ZN_IE|ZN_PD|ZN_PDRV0|ZN_PDRV1|ZN_PU|ZN_SL|ZP_CS|ZP_IE|ZP_PD|ZP_PDRV0|ZP_PDRV1|ZP_PU|ZP_SL
+ VDD|XN_OE|XP_OE|YN_OE|YP_OE|ZN_OE|ZP_OE
+ VSS|XN_CS|XN_IE|XN_PD|XN_PDRV0|XN_PDRV1|XN_PU|XN_SL|XP_CS|XP_IE|XP_PD|XP_PDRV0|XP_PDRV1|XP_PU|XP_SL|YN_CS|YN_IE|YN_PD|YN_PDRV0|YN_PDRV1|YN_PU|YN_SL|YP_CS|YP_IE|YP_PD|YP_PDRV0|YP_PDRV1|YP_PU|YP_SL|ZN_CS|ZN_IE|ZN_PD|ZN_PDRV0|ZN_PDRV1|ZN_PU|ZN_SL|ZP_CS|ZP_IE|ZP_PD|ZP_PDRV0|ZP_PDRV1|ZP_PU|ZP_SL
+ VSS|XN_CS|XN_IE|XN_PD|XN_PDRV0|XN_PDRV1|XN_PU|XN_SL|XP_CS|XP_IE|XP_PD|XP_PDRV0|XP_PDRV1|XP_PU|XP_SL|YN_CS|YN_IE|YN_PD|YN_PDRV0|YN_PDRV1|YN_PU|YN_SL|YP_CS|YP_IE|YP_PD|YP_PDRV0|YP_PDRV1|YP_PU|YP_SL|ZN_CS|ZN_IE|ZN_PD|ZN_PDRV0|ZN_PDRV1|ZN_PU|ZN_SL|ZP_CS|ZP_IE|ZP_PD|ZP_PDRV0|ZP_PDRV1|ZP_PU|ZP_SL
+ nfet_06v0 L=2U W=9.75U AS=4.29P AD=4.29P PS=20.38U PD=20.38U
M$1728 \$12680 \$12680
+ VSS|XN_CS|XN_IE|XN_PD|XN_PDRV0|XN_PDRV1|XN_PU|XN_SL|XP_CS|XP_IE|XP_PD|XP_PDRV0|XP_PDRV1|XP_PU|XP_SL|YN_CS|YN_IE|YN_PD|YN_PDRV0|YN_PDRV1|YN_PU|YN_SL|YP_CS|YP_IE|YP_PD|YP_PDRV0|YP_PDRV1|YP_PU|YP_SL|ZN_CS|ZN_IE|ZN_PD|ZN_PDRV0|ZN_PDRV1|ZN_PU|ZN_SL|ZP_CS|ZP_IE|ZP_PD|ZP_PDRV0|ZP_PDRV1|ZP_PU|ZP_SL
+ VSS|XN_CS|XN_IE|XN_PD|XN_PDRV0|XN_PDRV1|XN_PU|XN_SL|XP_CS|XP_IE|XP_PD|XP_PDRV0|XP_PDRV1|XP_PU|XP_SL|YN_CS|YN_IE|YN_PD|YN_PDRV0|YN_PDRV1|YN_PU|YN_SL|YP_CS|YP_IE|YP_PD|YP_PDRV0|YP_PDRV1|YP_PU|YP_SL|ZN_CS|ZN_IE|ZN_PD|ZN_PDRV0|ZN_PDRV1|ZN_PU|ZN_SL|ZP_CS|ZP_IE|ZP_PD|ZP_PDRV0|ZP_PDRV1|ZP_PU|ZP_SL
+ nfet_06v0 L=1U W=1U AS=0.44P AD=0.44P PS=2.88U PD=2.88U
M$1729 \$12716 \$12662
+ VSS|XN_CS|XN_IE|XN_PD|XN_PDRV0|XN_PDRV1|XN_PU|XN_SL|XP_CS|XP_IE|XP_PD|XP_PDRV0|XP_PDRV1|XP_PU|XP_SL|YN_CS|YN_IE|YN_PD|YN_PDRV0|YN_PDRV1|YN_PU|YN_SL|YP_CS|YP_IE|YP_PD|YP_PDRV0|YP_PDRV1|YP_PU|YP_SL|ZN_CS|ZN_IE|ZN_PD|ZN_PDRV0|ZN_PDRV1|ZN_PU|ZN_SL|ZP_CS|ZP_IE|ZP_PD|ZP_PDRV0|ZP_PDRV1|ZP_PU|ZP_SL
+ VSS|XN_CS|XN_IE|XN_PD|XN_PDRV0|XN_PDRV1|XN_PU|XN_SL|XP_CS|XP_IE|XP_PD|XP_PDRV0|XP_PDRV1|XP_PU|XP_SL|YN_CS|YN_IE|YN_PD|YN_PDRV0|YN_PDRV1|YN_PU|YN_SL|YP_CS|YP_IE|YP_PD|YP_PDRV0|YP_PDRV1|YP_PU|YP_SL|ZN_CS|ZN_IE|ZN_PD|ZN_PDRV0|ZN_PDRV1|ZN_PU|ZN_SL|ZP_CS|ZP_IE|ZP_PD|ZP_PDRV0|ZP_PDRV1|ZP_PU|ZP_SL
+ nfet_06v0 L=1U W=5U AS=2.2P AD=1.25P PS=10.88U PD=5.5U
M$1730 \$12662 \$12680 \$12716
+ VSS|XN_CS|XN_IE|XN_PD|XN_PDRV0|XN_PDRV1|XN_PU|XN_SL|XP_CS|XP_IE|XP_PD|XP_PDRV0|XP_PDRV1|XP_PU|XP_SL|YN_CS|YN_IE|YN_PD|YN_PDRV0|YN_PDRV1|YN_PU|YN_SL|YP_CS|YP_IE|YP_PD|YP_PDRV0|YP_PDRV1|YP_PU|YP_SL|ZN_CS|ZN_IE|ZN_PD|ZN_PDRV0|ZN_PDRV1|ZN_PU|ZN_SL|ZP_CS|ZP_IE|ZP_PD|ZP_PDRV0|ZP_PDRV1|ZP_PU|ZP_SL
+ nfet_06v0 L=1U W=5U AS=1.25P AD=2.2P PS=5.5U PD=10.88U
M$1731 \$12706 \$13281
+ VSS|XN_CS|XN_IE|XN_PD|XN_PDRV0|XN_PDRV1|XN_PU|XN_SL|XP_CS|XP_IE|XP_PD|XP_PDRV0|XP_PDRV1|XP_PU|XP_SL|YN_CS|YN_IE|YN_PD|YN_PDRV0|YN_PDRV1|YN_PU|YN_SL|YP_CS|YP_IE|YP_PD|YP_PDRV0|YP_PDRV1|YP_PU|YP_SL|ZN_CS|ZN_IE|ZN_PD|ZN_PDRV0|ZN_PDRV1|ZN_PU|ZN_SL|ZP_CS|ZP_IE|ZP_PD|ZP_PDRV0|ZP_PDRV1|ZP_PU|ZP_SL
+ VSS|XN_CS|XN_IE|XN_PD|XN_PDRV0|XN_PDRV1|XN_PU|XN_SL|XP_CS|XP_IE|XP_PD|XP_PDRV0|XP_PDRV1|XP_PU|XP_SL|YN_CS|YN_IE|YN_PD|YN_PDRV0|YN_PDRV1|YN_PU|YN_SL|YP_CS|YP_IE|YP_PD|YP_PDRV0|YP_PDRV1|YP_PU|YP_SL|ZN_CS|ZN_IE|ZN_PD|ZN_PDRV0|ZN_PDRV1|ZN_PU|ZN_SL|ZP_CS|ZP_IE|ZP_PD|ZP_PDRV0|ZP_PDRV1|ZP_PU|ZP_SL
+ nfet_06v0 L=1U W=1U AS=0.44P AD=0.25P PS=2.88U PD=1.5U
M$1732 \$13201 \$13281 \$12706
+ VSS|XN_CS|XN_IE|XN_PD|XN_PDRV0|XN_PDRV1|XN_PU|XN_SL|XP_CS|XP_IE|XP_PD|XP_PDRV0|XP_PDRV1|XP_PU|XP_SL|YN_CS|YN_IE|YN_PD|YN_PDRV0|YN_PDRV1|YN_PU|YN_SL|YP_CS|YP_IE|YP_PD|YP_PDRV0|YP_PDRV1|YP_PU|YP_SL|ZN_CS|ZN_IE|ZN_PD|ZN_PDRV0|ZN_PDRV1|ZN_PU|ZN_SL|ZP_CS|ZP_IE|ZP_PD|ZP_PDRV0|ZP_PDRV1|ZP_PU|ZP_SL
+ nfet_06v0 L=1U W=1U AS=0.25P AD=0.44P PS=1.5U PD=2.88U
M$1733 \$12707 \$13281
+ VSS|XN_CS|XN_IE|XN_PD|XN_PDRV0|XN_PDRV1|XN_PU|XN_SL|XP_CS|XP_IE|XP_PD|XP_PDRV0|XP_PDRV1|XP_PU|XP_SL|YN_CS|YN_IE|YN_PD|YN_PDRV0|YN_PDRV1|YN_PU|YN_SL|YP_CS|YP_IE|YP_PD|YP_PDRV0|YP_PDRV1|YP_PU|YP_SL|ZN_CS|ZN_IE|ZN_PD|ZN_PDRV0|ZN_PDRV1|ZN_PU|ZN_SL|ZP_CS|ZP_IE|ZP_PD|ZP_PDRV0|ZP_PDRV1|ZP_PU|ZP_SL
+ VSS|XN_CS|XN_IE|XN_PD|XN_PDRV0|XN_PDRV1|XN_PU|XN_SL|XP_CS|XP_IE|XP_PD|XP_PDRV0|XP_PDRV1|XP_PU|XP_SL|YN_CS|YN_IE|YN_PD|YN_PDRV0|YN_PDRV1|YN_PU|YN_SL|YP_CS|YP_IE|YP_PD|YP_PDRV0|YP_PDRV1|YP_PU|YP_SL|ZN_CS|ZN_IE|ZN_PD|ZN_PDRV0|ZN_PDRV1|ZN_PU|ZN_SL|ZP_CS|ZP_IE|ZP_PD|ZP_PDRV0|ZP_PDRV1|ZP_PU|ZP_SL
+ nfet_06v0 L=1U W=1U AS=0.44P AD=0.25P PS=2.88U PD=1.5U
M$1734 \$13281 \$13281 \$12707
+ VSS|XN_CS|XN_IE|XN_PD|XN_PDRV0|XN_PDRV1|XN_PU|XN_SL|XP_CS|XP_IE|XP_PD|XP_PDRV0|XP_PDRV1|XP_PU|XP_SL|YN_CS|YN_IE|YN_PD|YN_PDRV0|YN_PDRV1|YN_PU|YN_SL|YP_CS|YP_IE|YP_PD|YP_PDRV0|YP_PDRV1|YP_PU|YP_SL|ZN_CS|ZN_IE|ZN_PD|ZN_PDRV0|ZN_PDRV1|ZN_PU|ZN_SL|ZP_CS|ZP_IE|ZP_PD|ZP_PDRV0|ZP_PDRV1|ZP_PU|ZP_SL
+ nfet_06v0 L=1U W=1U AS=0.25P AD=0.44P PS=1.5U PD=2.88U
M$1735 \$12717 \$12662
+ VSS|XN_CS|XN_IE|XN_PD|XN_PDRV0|XN_PDRV1|XN_PU|XN_SL|XP_CS|XP_IE|XP_PD|XP_PDRV0|XP_PDRV1|XP_PU|XP_SL|YN_CS|YN_IE|YN_PD|YN_PDRV0|YN_PDRV1|YN_PU|YN_SL|YP_CS|YP_IE|YP_PD|YP_PDRV0|YP_PDRV1|YP_PU|YP_SL|ZN_CS|ZN_IE|ZN_PD|ZN_PDRV0|ZN_PDRV1|ZN_PU|ZN_SL|ZP_CS|ZP_IE|ZP_PD|ZP_PDRV0|ZP_PDRV1|ZP_PU|ZP_SL
+ VSS|XN_CS|XN_IE|XN_PD|XN_PDRV0|XN_PDRV1|XN_PU|XN_SL|XP_CS|XP_IE|XP_PD|XP_PDRV0|XP_PDRV1|XP_PU|XP_SL|YN_CS|YN_IE|YN_PD|YN_PDRV0|YN_PDRV1|YN_PU|YN_SL|YP_CS|YP_IE|YP_PD|YP_PDRV0|YP_PDRV1|YP_PU|YP_SL|ZN_CS|ZN_IE|ZN_PD|ZN_PDRV0|ZN_PDRV1|ZN_PU|ZN_SL|ZP_CS|ZP_IE|ZP_PD|ZP_PDRV0|ZP_PDRV1|ZP_PU|ZP_SL
+ nfet_06v0 L=1U W=5U AS=2.2P AD=1.25P PS=10.88U PD=5.5U
M$1736 \$12681 \$12680 \$12717
+ VSS|XN_CS|XN_IE|XN_PD|XN_PDRV0|XN_PDRV1|XN_PU|XN_SL|XP_CS|XP_IE|XP_PD|XP_PDRV0|XP_PDRV1|XP_PU|XP_SL|YN_CS|YN_IE|YN_PD|YN_PDRV0|YN_PDRV1|YN_PU|YN_SL|YP_CS|YP_IE|YP_PD|YP_PDRV0|YP_PDRV1|YP_PU|YP_SL|ZN_CS|ZN_IE|ZN_PD|ZN_PDRV0|ZN_PDRV1|ZN_PU|ZN_SL|ZP_CS|ZP_IE|ZP_PD|ZP_PDRV0|ZP_PDRV1|ZP_PU|ZP_SL
+ nfet_06v0 L=1U W=5U AS=1.25P AD=1.65P PS=5.5U PD=5.66U
M$1737 \$12718 \$12680 \$12681
+ VSS|XN_CS|XN_IE|XN_PD|XN_PDRV0|XN_PDRV1|XN_PU|XN_SL|XP_CS|XP_IE|XP_PD|XP_PDRV0|XP_PDRV1|XP_PU|XP_SL|YN_CS|YN_IE|YN_PD|YN_PDRV0|YN_PDRV1|YN_PU|YN_SL|YP_CS|YP_IE|YP_PD|YP_PDRV0|YP_PDRV1|YP_PU|YP_SL|ZN_CS|ZN_IE|ZN_PD|ZN_PDRV0|ZN_PDRV1|ZN_PU|ZN_SL|ZP_CS|ZP_IE|ZP_PD|ZP_PDRV0|ZP_PDRV1|ZP_PU|ZP_SL
+ nfet_06v0 L=1U W=5U AS=1.65P AD=1.25P PS=5.66U PD=5.5U
M$1738
+ VSS|XN_CS|XN_IE|XN_PD|XN_PDRV0|XN_PDRV1|XN_PU|XN_SL|XP_CS|XP_IE|XP_PD|XP_PDRV0|XP_PDRV1|XP_PU|XP_SL|YN_CS|YN_IE|YN_PD|YN_PDRV0|YN_PDRV1|YN_PU|YN_SL|YP_CS|YP_IE|YP_PD|YP_PDRV0|YP_PDRV1|YP_PU|YP_SL|ZN_CS|ZN_IE|ZN_PD|ZN_PDRV0|ZN_PDRV1|ZN_PU|ZN_SL|ZP_CS|ZP_IE|ZP_PD|ZP_PDRV0|ZP_PDRV1|ZP_PU|ZP_SL
+ \$12662 \$12718
+ VSS|XN_CS|XN_IE|XN_PD|XN_PDRV0|XN_PDRV1|XN_PU|XN_SL|XP_CS|XP_IE|XP_PD|XP_PDRV0|XP_PDRV1|XP_PU|XP_SL|YN_CS|YN_IE|YN_PD|YN_PDRV0|YN_PDRV1|YN_PU|YN_SL|YP_CS|YP_IE|YP_PD|YP_PDRV0|YP_PDRV1|YP_PU|YP_SL|ZN_CS|ZN_IE|ZN_PD|ZN_PDRV0|ZN_PDRV1|ZN_PU|ZN_SL|ZP_CS|ZP_IE|ZP_PD|ZP_PDRV0|ZP_PDRV1|ZP_PU|ZP_SL
+ nfet_06v0 L=1U W=5U AS=1.25P AD=2.2P PS=5.5U PD=10.88U
M$1739 \$12682 \$4872 \$12681
+ VSS|XN_CS|XN_IE|XN_PD|XN_PDRV0|XN_PDRV1|XN_PU|XN_SL|XP_CS|XP_IE|XP_PD|XP_PDRV0|XP_PDRV1|XP_PU|XP_SL|YN_CS|YN_IE|YN_PD|YN_PDRV0|YN_PDRV1|YN_PU|YN_SL|YP_CS|YP_IE|YP_PD|YP_PDRV0|YP_PDRV1|YP_PU|YP_SL|ZN_CS|ZN_IE|ZN_PD|ZN_PDRV0|ZN_PDRV1|ZN_PU|ZN_SL|ZP_CS|ZP_IE|ZP_PD|ZP_PDRV0|ZP_PDRV1|ZP_PU|ZP_SL
+ nfet_06v0 L=1U W=5U AS=2.2P AD=1.3P PS=10.88U PD=5.52U
M$1740 \$12681 \$4872 \$12682
+ VSS|XN_CS|XN_IE|XN_PD|XN_PDRV0|XN_PDRV1|XN_PU|XN_SL|XP_CS|XP_IE|XP_PD|XP_PDRV0|XP_PDRV1|XP_PU|XP_SL|YN_CS|YN_IE|YN_PD|YN_PDRV0|YN_PDRV1|YN_PU|YN_SL|YP_CS|YP_IE|YP_PD|YP_PDRV0|YP_PDRV1|YP_PU|YP_SL|ZN_CS|ZN_IE|ZN_PD|ZN_PDRV0|ZN_PDRV1|ZN_PU|ZN_SL|ZP_CS|ZP_IE|ZP_PD|ZP_PDRV0|ZP_PDRV1|ZP_PU|ZP_SL
+ nfet_06v0 L=1U W=5U AS=1.3P AD=2.2P PS=5.52U PD=10.88U
M$1741 \$12683 \$4880 \$12681
+ VSS|XN_CS|XN_IE|XN_PD|XN_PDRV0|XN_PDRV1|XN_PU|XN_SL|XP_CS|XP_IE|XP_PD|XP_PDRV0|XP_PDRV1|XP_PU|XP_SL|YN_CS|YN_IE|YN_PD|YN_PDRV0|YN_PDRV1|YN_PU|YN_SL|YP_CS|YP_IE|YP_PD|YP_PDRV0|YP_PDRV1|YP_PU|YP_SL|ZN_CS|ZN_IE|ZN_PD|ZN_PDRV0|ZN_PDRV1|ZN_PU|ZN_SL|ZP_CS|ZP_IE|ZP_PD|ZP_PDRV0|ZP_PDRV1|ZP_PU|ZP_SL
+ nfet_06v0 L=1U W=5U AS=2.2P AD=1.3P PS=10.88U PD=5.52U
M$1742 \$12681 \$4880 \$12683
+ VSS|XN_CS|XN_IE|XN_PD|XN_PDRV0|XN_PDRV1|XN_PU|XN_SL|XP_CS|XP_IE|XP_PD|XP_PDRV0|XP_PDRV1|XP_PU|XP_SL|YN_CS|YN_IE|YN_PD|YN_PDRV0|YN_PDRV1|YN_PU|YN_SL|YP_CS|YP_IE|YP_PD|YP_PDRV0|YP_PDRV1|YP_PU|YP_SL|ZN_CS|ZN_IE|ZN_PD|ZN_PDRV0|ZN_PDRV1|ZN_PU|ZN_SL|ZP_CS|ZP_IE|ZP_PD|ZP_PDRV0|ZP_PDRV1|ZP_PU|ZP_SL
+ nfet_06v0 L=1U W=5U AS=1.3P AD=2.2P PS=5.52U PD=10.88U
M$1743 \$12685 \$12680 \$12684
+ VSS|XN_CS|XN_IE|XN_PD|XN_PDRV0|XN_PDRV1|XN_PU|XN_SL|XP_CS|XP_IE|XP_PD|XP_PDRV0|XP_PDRV1|XP_PU|XP_SL|YN_CS|YN_IE|YN_PD|YN_PDRV0|YN_PDRV1|YN_PU|YN_SL|YP_CS|YP_IE|YP_PD|YP_PDRV0|YP_PDRV1|YP_PU|YP_SL|ZN_CS|ZN_IE|ZN_PD|ZN_PDRV0|ZN_PDRV1|ZN_PU|ZN_SL|ZP_CS|ZP_IE|ZP_PD|ZP_PDRV0|ZP_PDRV1|ZP_PU|ZP_SL
+ nfet_06v0 L=1U W=2.5U AS=1.1P AD=0.65P PS=5.88U PD=3.02U
M$1744 \$12684 \$12680 \$12685
+ VSS|XN_CS|XN_IE|XN_PD|XN_PDRV0|XN_PDRV1|XN_PU|XN_SL|XP_CS|XP_IE|XP_PD|XP_PDRV0|XP_PDRV1|XP_PU|XP_SL|YN_CS|YN_IE|YN_PD|YN_PDRV0|YN_PDRV1|YN_PU|YN_SL|YP_CS|YP_IE|YP_PD|YP_PDRV0|YP_PDRV1|YP_PU|YP_SL|ZN_CS|ZN_IE|ZN_PD|ZN_PDRV0|ZN_PDRV1|ZN_PU|ZN_SL|ZP_CS|ZP_IE|ZP_PD|ZP_PDRV0|ZP_PDRV1|ZP_PU|ZP_SL
+ nfet_06v0 L=1U W=2.5U AS=0.65P AD=1.1P PS=3.02U PD=5.88U
M$1745 \$12687 \$12680 \$12686
+ VSS|XN_CS|XN_IE|XN_PD|XN_PDRV0|XN_PDRV1|XN_PU|XN_SL|XP_CS|XP_IE|XP_PD|XP_PDRV0|XP_PDRV1|XP_PU|XP_SL|YN_CS|YN_IE|YN_PD|YN_PDRV0|YN_PDRV1|YN_PU|YN_SL|YP_CS|YP_IE|YP_PD|YP_PDRV0|YP_PDRV1|YP_PU|YP_SL|ZN_CS|ZN_IE|ZN_PD|ZN_PDRV0|ZN_PDRV1|ZN_PU|ZN_SL|ZP_CS|ZP_IE|ZP_PD|ZP_PDRV0|ZP_PDRV1|ZP_PU|ZP_SL
+ nfet_06v0 L=1U W=2.5U AS=1.1P AD=0.65P PS=5.88U PD=3.02U
M$1746 \$12686 \$12680 \$12687
+ VSS|XN_CS|XN_IE|XN_PD|XN_PDRV0|XN_PDRV1|XN_PU|XN_SL|XP_CS|XP_IE|XP_PD|XP_PDRV0|XP_PDRV1|XP_PU|XP_SL|YN_CS|YN_IE|YN_PD|YN_PDRV0|YN_PDRV1|YN_PU|YN_SL|YP_CS|YP_IE|YP_PD|YP_PDRV0|YP_PDRV1|YP_PU|YP_SL|ZN_CS|ZN_IE|ZN_PD|ZN_PDRV0|ZN_PDRV1|ZN_PU|ZN_SL|ZP_CS|ZP_IE|ZP_PD|ZP_PDRV0|ZP_PDRV1|ZP_PU|ZP_SL
+ nfet_06v0 L=1U W=2.5U AS=0.65P AD=1.1P PS=3.02U PD=5.88U
M$1747 \$12684 \$12685
+ VSS|XN_CS|XN_IE|XN_PD|XN_PDRV0|XN_PDRV1|XN_PU|XN_SL|XP_CS|XP_IE|XP_PD|XP_PDRV0|XP_PDRV1|XP_PU|XP_SL|YN_CS|YN_IE|YN_PD|YN_PDRV0|YN_PDRV1|YN_PU|YN_SL|YP_CS|YP_IE|YP_PD|YP_PDRV0|YP_PDRV1|YP_PU|YP_SL|ZN_CS|ZN_IE|ZN_PD|ZN_PDRV0|ZN_PDRV1|ZN_PU|ZN_SL|ZP_CS|ZP_IE|ZP_PD|ZP_PDRV0|ZP_PDRV1|ZP_PU|ZP_SL
+ VSS|XN_CS|XN_IE|XN_PD|XN_PDRV0|XN_PDRV1|XN_PU|XN_SL|XP_CS|XP_IE|XP_PD|XP_PDRV0|XP_PDRV1|XP_PU|XP_SL|YN_CS|YN_IE|YN_PD|YN_PDRV0|YN_PDRV1|YN_PU|YN_SL|YP_CS|YP_IE|YP_PD|YP_PDRV0|YP_PDRV1|YP_PU|YP_SL|ZN_CS|ZN_IE|ZN_PD|ZN_PDRV0|ZN_PDRV1|ZN_PU|ZN_SL|ZP_CS|ZP_IE|ZP_PD|ZP_PDRV0|ZP_PDRV1|ZP_PU|ZP_SL
+ nfet_06v0 L=1U W=2.5U AS=1.1P AD=0.65P PS=5.88U PD=3.02U
M$1748
+ VSS|XN_CS|XN_IE|XN_PD|XN_PDRV0|XN_PDRV1|XN_PU|XN_SL|XP_CS|XP_IE|XP_PD|XP_PDRV0|XP_PDRV1|XP_PU|XP_SL|YN_CS|YN_IE|YN_PD|YN_PDRV0|YN_PDRV1|YN_PU|YN_SL|YP_CS|YP_IE|YP_PD|YP_PDRV0|YP_PDRV1|YP_PU|YP_SL|ZN_CS|ZN_IE|ZN_PD|ZN_PDRV0|ZN_PDRV1|ZN_PU|ZN_SL|ZP_CS|ZP_IE|ZP_PD|ZP_PDRV0|ZP_PDRV1|ZP_PU|ZP_SL
+ \$12685 \$12684
+ VSS|XN_CS|XN_IE|XN_PD|XN_PDRV0|XN_PDRV1|XN_PU|XN_SL|XP_CS|XP_IE|XP_PD|XP_PDRV0|XP_PDRV1|XP_PU|XP_SL|YN_CS|YN_IE|YN_PD|YN_PDRV0|YN_PDRV1|YN_PU|YN_SL|YP_CS|YP_IE|YP_PD|YP_PDRV0|YP_PDRV1|YP_PU|YP_SL|ZN_CS|ZN_IE|ZN_PD|ZN_PDRV0|ZN_PDRV1|ZN_PU|ZN_SL|ZP_CS|ZP_IE|ZP_PD|ZP_PDRV0|ZP_PDRV1|ZP_PU|ZP_SL
+ nfet_06v0 L=1U W=2.5U AS=0.65P AD=0.65P PS=3.02U PD=3.02U
M$1749 \$12684 \$12685
+ VSS|XN_CS|XN_IE|XN_PD|XN_PDRV0|XN_PDRV1|XN_PU|XN_SL|XP_CS|XP_IE|XP_PD|XP_PDRV0|XP_PDRV1|XP_PU|XP_SL|YN_CS|YN_IE|YN_PD|YN_PDRV0|YN_PDRV1|YN_PU|YN_SL|YP_CS|YP_IE|YP_PD|YP_PDRV0|YP_PDRV1|YP_PU|YP_SL|ZN_CS|ZN_IE|ZN_PD|ZN_PDRV0|ZN_PDRV1|ZN_PU|ZN_SL|ZP_CS|ZP_IE|ZP_PD|ZP_PDRV0|ZP_PDRV1|ZP_PU|ZP_SL
+ VSS|XN_CS|XN_IE|XN_PD|XN_PDRV0|XN_PDRV1|XN_PU|XN_SL|XP_CS|XP_IE|XP_PD|XP_PDRV0|XP_PDRV1|XP_PU|XP_SL|YN_CS|YN_IE|YN_PD|YN_PDRV0|YN_PDRV1|YN_PU|YN_SL|YP_CS|YP_IE|YP_PD|YP_PDRV0|YP_PDRV1|YP_PU|YP_SL|ZN_CS|ZN_IE|ZN_PD|ZN_PDRV0|ZN_PDRV1|ZN_PU|ZN_SL|ZP_CS|ZP_IE|ZP_PD|ZP_PDRV0|ZP_PDRV1|ZP_PU|ZP_SL
+ nfet_06v0 L=1U W=2.5U AS=0.65P AD=0.65P PS=3.02U PD=3.02U
M$1750
+ VSS|XN_CS|XN_IE|XN_PD|XN_PDRV0|XN_PDRV1|XN_PU|XN_SL|XP_CS|XP_IE|XP_PD|XP_PDRV0|XP_PDRV1|XP_PU|XP_SL|YN_CS|YN_IE|YN_PD|YN_PDRV0|YN_PDRV1|YN_PU|YN_SL|YP_CS|YP_IE|YP_PD|YP_PDRV0|YP_PDRV1|YP_PU|YP_SL|ZN_CS|ZN_IE|ZN_PD|ZN_PDRV0|ZN_PDRV1|ZN_PU|ZN_SL|ZP_CS|ZP_IE|ZP_PD|ZP_PDRV0|ZP_PDRV1|ZP_PU|ZP_SL
+ \$12685 \$12684
+ VSS|XN_CS|XN_IE|XN_PD|XN_PDRV0|XN_PDRV1|XN_PU|XN_SL|XP_CS|XP_IE|XP_PD|XP_PDRV0|XP_PDRV1|XP_PU|XP_SL|YN_CS|YN_IE|YN_PD|YN_PDRV0|YN_PDRV1|YN_PU|YN_SL|YP_CS|YP_IE|YP_PD|YP_PDRV0|YP_PDRV1|YP_PU|YP_SL|ZN_CS|ZN_IE|ZN_PD|ZN_PDRV0|ZN_PDRV1|ZN_PU|ZN_SL|ZP_CS|ZP_IE|ZP_PD|ZP_PDRV0|ZP_PDRV1|ZP_PU|ZP_SL
+ nfet_06v0 L=1U W=2.5U AS=0.65P AD=1.1P PS=3.02U PD=5.88U
M$1751 \$12686 \$12685
+ VSS|XN_CS|XN_IE|XN_PD|XN_PDRV0|XN_PDRV1|XN_PU|XN_SL|XP_CS|XP_IE|XP_PD|XP_PDRV0|XP_PDRV1|XP_PU|XP_SL|YN_CS|YN_IE|YN_PD|YN_PDRV0|YN_PDRV1|YN_PU|YN_SL|YP_CS|YP_IE|YP_PD|YP_PDRV0|YP_PDRV1|YP_PU|YP_SL|ZN_CS|ZN_IE|ZN_PD|ZN_PDRV0|ZN_PDRV1|ZN_PU|ZN_SL|ZP_CS|ZP_IE|ZP_PD|ZP_PDRV0|ZP_PDRV1|ZP_PU|ZP_SL
+ VSS|XN_CS|XN_IE|XN_PD|XN_PDRV0|XN_PDRV1|XN_PU|XN_SL|XP_CS|XP_IE|XP_PD|XP_PDRV0|XP_PDRV1|XP_PU|XP_SL|YN_CS|YN_IE|YN_PD|YN_PDRV0|YN_PDRV1|YN_PU|YN_SL|YP_CS|YP_IE|YP_PD|YP_PDRV0|YP_PDRV1|YP_PU|YP_SL|ZN_CS|ZN_IE|ZN_PD|ZN_PDRV0|ZN_PDRV1|ZN_PU|ZN_SL|ZP_CS|ZP_IE|ZP_PD|ZP_PDRV0|ZP_PDRV1|ZP_PU|ZP_SL
+ nfet_06v0 L=1U W=2.5U AS=1.1P AD=0.65P PS=5.88U PD=3.02U
M$1752
+ VSS|XN_CS|XN_IE|XN_PD|XN_PDRV0|XN_PDRV1|XN_PU|XN_SL|XP_CS|XP_IE|XP_PD|XP_PDRV0|XP_PDRV1|XP_PU|XP_SL|YN_CS|YN_IE|YN_PD|YN_PDRV0|YN_PDRV1|YN_PU|YN_SL|YP_CS|YP_IE|YP_PD|YP_PDRV0|YP_PDRV1|YP_PU|YP_SL|ZN_CS|ZN_IE|ZN_PD|ZN_PDRV0|ZN_PDRV1|ZN_PU|ZN_SL|ZP_CS|ZP_IE|ZP_PD|ZP_PDRV0|ZP_PDRV1|ZP_PU|ZP_SL
+ \$12685 \$12686
+ VSS|XN_CS|XN_IE|XN_PD|XN_PDRV0|XN_PDRV1|XN_PU|XN_SL|XP_CS|XP_IE|XP_PD|XP_PDRV0|XP_PDRV1|XP_PU|XP_SL|YN_CS|YN_IE|YN_PD|YN_PDRV0|YN_PDRV1|YN_PU|YN_SL|YP_CS|YP_IE|YP_PD|YP_PDRV0|YP_PDRV1|YP_PU|YP_SL|ZN_CS|ZN_IE|ZN_PD|ZN_PDRV0|ZN_PDRV1|ZN_PU|ZN_SL|ZP_CS|ZP_IE|ZP_PD|ZP_PDRV0|ZP_PDRV1|ZP_PU|ZP_SL
+ nfet_06v0 L=1U W=2.5U AS=0.65P AD=0.65P PS=3.02U PD=3.02U
M$1753 \$12686 \$12685
+ VSS|XN_CS|XN_IE|XN_PD|XN_PDRV0|XN_PDRV1|XN_PU|XN_SL|XP_CS|XP_IE|XP_PD|XP_PDRV0|XP_PDRV1|XP_PU|XP_SL|YN_CS|YN_IE|YN_PD|YN_PDRV0|YN_PDRV1|YN_PU|YN_SL|YP_CS|YP_IE|YP_PD|YP_PDRV0|YP_PDRV1|YP_PU|YP_SL|ZN_CS|ZN_IE|ZN_PD|ZN_PDRV0|ZN_PDRV1|ZN_PU|ZN_SL|ZP_CS|ZP_IE|ZP_PD|ZP_PDRV0|ZP_PDRV1|ZP_PU|ZP_SL
+ VSS|XN_CS|XN_IE|XN_PD|XN_PDRV0|XN_PDRV1|XN_PU|XN_SL|XP_CS|XP_IE|XP_PD|XP_PDRV0|XP_PDRV1|XP_PU|XP_SL|YN_CS|YN_IE|YN_PD|YN_PDRV0|YN_PDRV1|YN_PU|YN_SL|YP_CS|YP_IE|YP_PD|YP_PDRV0|YP_PDRV1|YP_PU|YP_SL|ZN_CS|ZN_IE|ZN_PD|ZN_PDRV0|ZN_PDRV1|ZN_PU|ZN_SL|ZP_CS|ZP_IE|ZP_PD|ZP_PDRV0|ZP_PDRV1|ZP_PU|ZP_SL
+ nfet_06v0 L=1U W=2.5U AS=0.65P AD=0.65P PS=3.02U PD=3.02U
M$1754
+ VSS|XN_CS|XN_IE|XN_PD|XN_PDRV0|XN_PDRV1|XN_PU|XN_SL|XP_CS|XP_IE|XP_PD|XP_PDRV0|XP_PDRV1|XP_PU|XP_SL|YN_CS|YN_IE|YN_PD|YN_PDRV0|YN_PDRV1|YN_PU|YN_SL|YP_CS|YP_IE|YP_PD|YP_PDRV0|YP_PDRV1|YP_PU|YP_SL|ZN_CS|ZN_IE|ZN_PD|ZN_PDRV0|ZN_PDRV1|ZN_PU|ZN_SL|ZP_CS|ZP_IE|ZP_PD|ZP_PDRV0|ZP_PDRV1|ZP_PU|ZP_SL
+ \$12685 \$12686
+ VSS|XN_CS|XN_IE|XN_PD|XN_PDRV0|XN_PDRV1|XN_PU|XN_SL|XP_CS|XP_IE|XP_PD|XP_PDRV0|XP_PDRV1|XP_PU|XP_SL|YN_CS|YN_IE|YN_PD|YN_PDRV0|YN_PDRV1|YN_PU|YN_SL|YP_CS|YP_IE|YP_PD|YP_PDRV0|YP_PDRV1|YP_PU|YP_SL|ZN_CS|ZN_IE|ZN_PD|ZN_PDRV0|ZN_PDRV1|ZN_PU|ZN_SL|ZP_CS|ZP_IE|ZP_PD|ZP_PDRV0|ZP_PDRV1|ZP_PU|ZP_SL
+ nfet_06v0 L=1U W=2.5U AS=0.65P AD=1.1P PS=3.02U PD=5.88U
M$1755 \$12746 \$12709 \$12685
+ VSS|XN_CS|XN_IE|XN_PD|XN_PDRV0|XN_PDRV1|XN_PU|XN_SL|XP_CS|XP_IE|XP_PD|XP_PDRV0|XP_PDRV1|XP_PU|XP_SL|YN_CS|YN_IE|YN_PD|YN_PDRV0|YN_PDRV1|YN_PU|YN_SL|YP_CS|YP_IE|YP_PD|YP_PDRV0|YP_PDRV1|YP_PU|YP_SL|ZN_CS|ZN_IE|ZN_PD|ZN_PDRV0|ZN_PDRV1|ZN_PU|ZN_SL|ZP_CS|ZP_IE|ZP_PD|ZP_PDRV0|ZP_PDRV1|ZP_PU|ZP_SL
+ nfet_06v0 L=1U W=2.5U AS=1.1P AD=1.1P PS=5.88U PD=5.88U
M$1756 \$12663 \$12709 \$12687
+ VSS|XN_CS|XN_IE|XN_PD|XN_PDRV0|XN_PDRV1|XN_PU|XN_SL|XP_CS|XP_IE|XP_PD|XP_PDRV0|XP_PDRV1|XP_PU|XP_SL|YN_CS|YN_IE|YN_PD|YN_PDRV0|YN_PDRV1|YN_PU|YN_SL|YP_CS|YP_IE|YP_PD|YP_PDRV0|YP_PDRV1|YP_PU|YP_SL|ZN_CS|ZN_IE|ZN_PD|ZN_PDRV0|ZN_PDRV1|ZN_PU|ZN_SL|ZP_CS|ZP_IE|ZP_PD|ZP_PDRV0|ZP_PDRV1|ZP_PU|ZP_SL
+ nfet_06v0 L=1U W=2.5U AS=1.1P AD=1.1P PS=5.88U PD=5.88U
M$1757 \$12723 \$12662
+ VSS|XN_CS|XN_IE|XN_PD|XN_PDRV0|XN_PDRV1|XN_PU|XN_SL|XP_CS|XP_IE|XP_PD|XP_PDRV0|XP_PDRV1|XP_PU|XP_SL|YN_CS|YN_IE|YN_PD|YN_PDRV0|YN_PDRV1|YN_PU|YN_SL|YP_CS|YP_IE|YP_PD|YP_PDRV0|YP_PDRV1|YP_PU|YP_SL|ZN_CS|ZN_IE|ZN_PD|ZN_PDRV0|ZN_PDRV1|ZN_PU|ZN_SL|ZP_CS|ZP_IE|ZP_PD|ZP_PDRV0|ZP_PDRV1|ZP_PU|ZP_SL
+ VSS|XN_CS|XN_IE|XN_PD|XN_PDRV0|XN_PDRV1|XN_PU|XN_SL|XP_CS|XP_IE|XP_PD|XP_PDRV0|XP_PDRV1|XP_PU|XP_SL|YN_CS|YN_IE|YN_PD|YN_PDRV0|YN_PDRV1|YN_PU|YN_SL|YP_CS|YP_IE|YP_PD|YP_PDRV0|YP_PDRV1|YP_PU|YP_SL|ZN_CS|ZN_IE|ZN_PD|ZN_PDRV0|ZN_PDRV1|ZN_PU|ZN_SL|ZP_CS|ZP_IE|ZP_PD|ZP_PDRV0|ZP_PDRV1|ZP_PU|ZP_SL
+ nfet_06v0 L=1U W=5U AS=2.2P AD=1.25P PS=10.88U PD=5.5U
M$1758 \$12664 \$12680 \$12723
+ VSS|XN_CS|XN_IE|XN_PD|XN_PDRV0|XN_PDRV1|XN_PU|XN_SL|XP_CS|XP_IE|XP_PD|XP_PDRV0|XP_PDRV1|XP_PU|XP_SL|YN_CS|YN_IE|YN_PD|YN_PDRV0|YN_PDRV1|YN_PU|YN_SL|YP_CS|YP_IE|YP_PD|YP_PDRV0|YP_PDRV1|YP_PU|YP_SL|ZN_CS|ZN_IE|ZN_PD|ZN_PDRV0|ZN_PDRV1|ZN_PU|ZN_SL|ZP_CS|ZP_IE|ZP_PD|ZP_PDRV0|ZP_PDRV1|ZP_PU|ZP_SL
+ nfet_06v0 L=1U W=5U AS=1.25P AD=2.2P PS=5.5U PD=10.88U
M$1759 \$12724 \$12665
+ VSS|XN_CS|XN_IE|XN_PD|XN_PDRV0|XN_PDRV1|XN_PU|XN_SL|XP_CS|XP_IE|XP_PD|XP_PDRV0|XP_PDRV1|XP_PU|XP_SL|YN_CS|YN_IE|YN_PD|YN_PDRV0|YN_PDRV1|YN_PU|YN_SL|YP_CS|YP_IE|YP_PD|YP_PDRV0|YP_PDRV1|YP_PU|YP_SL|ZN_CS|ZN_IE|ZN_PD|ZN_PDRV0|ZN_PDRV1|ZN_PU|ZN_SL|ZP_CS|ZP_IE|ZP_PD|ZP_PDRV0|ZP_PDRV1|ZP_PU|ZP_SL
+ VSS|XN_CS|XN_IE|XN_PD|XN_PDRV0|XN_PDRV1|XN_PU|XN_SL|XP_CS|XP_IE|XP_PD|XP_PDRV0|XP_PDRV1|XP_PU|XP_SL|YN_CS|YN_IE|YN_PD|YN_PDRV0|YN_PDRV1|YN_PU|YN_SL|YP_CS|YP_IE|YP_PD|YP_PDRV0|YP_PDRV1|YP_PU|YP_SL|ZN_CS|ZN_IE|ZN_PD|ZN_PDRV0|ZN_PDRV1|ZN_PU|ZN_SL|ZP_CS|ZP_IE|ZP_PD|ZP_PDRV0|ZP_PDRV1|ZP_PU|ZP_SL
+ nfet_06v0 L=1U W=5U AS=2.2P AD=1.25P PS=10.88U PD=5.5U
M$1760 \$12665 \$12680 \$12724
+ VSS|XN_CS|XN_IE|XN_PD|XN_PDRV0|XN_PDRV1|XN_PU|XN_SL|XP_CS|XP_IE|XP_PD|XP_PDRV0|XP_PDRV1|XP_PU|XP_SL|YN_CS|YN_IE|YN_PD|YN_PDRV0|YN_PDRV1|YN_PU|YN_SL|YP_CS|YP_IE|YP_PD|YP_PDRV0|YP_PDRV1|YP_PU|YP_SL|ZN_CS|ZN_IE|ZN_PD|ZN_PDRV0|ZN_PDRV1|ZN_PU|ZN_SL|ZP_CS|ZP_IE|ZP_PD|ZP_PDRV0|ZP_PDRV1|ZP_PU|ZP_SL
+ nfet_06v0 L=1U W=5U AS=1.25P AD=1.65P PS=5.5U PD=5.66U
M$1761 \$12709 \$12709 \$12665
+ VSS|XN_CS|XN_IE|XN_PD|XN_PDRV0|XN_PDRV1|XN_PU|XN_SL|XP_CS|XP_IE|XP_PD|XP_PDRV0|XP_PDRV1|XP_PU|XP_SL|YN_CS|YN_IE|YN_PD|YN_PDRV0|YN_PDRV1|YN_PU|YN_SL|YP_CS|YP_IE|YP_PD|YP_PDRV0|YP_PDRV1|YP_PU|YP_SL|ZN_CS|ZN_IE|ZN_PD|ZN_PDRV0|ZN_PDRV1|ZN_PU|ZN_SL|ZP_CS|ZP_IE|ZP_PD|ZP_PDRV0|ZP_PDRV1|ZP_PU|ZP_SL
+ nfet_06v0 L=1U W=5U AS=1.65P AD=2.2P PS=5.66U PD=10.88U
M$1762 \$12688 \$12687
+ VSS|XN_CS|XN_IE|XN_PD|XN_PDRV0|XN_PDRV1|XN_PU|XN_SL|XP_CS|XP_IE|XP_PD|XP_PDRV0|XP_PDRV1|XP_PU|XP_SL|YN_CS|YN_IE|YN_PD|YN_PDRV0|YN_PDRV1|YN_PU|YN_SL|YP_CS|YP_IE|YP_PD|YP_PDRV0|YP_PDRV1|YP_PU|YP_SL|ZN_CS|ZN_IE|ZN_PD|ZN_PDRV0|ZN_PDRV1|ZN_PU|ZN_SL|ZP_CS|ZP_IE|ZP_PD|ZP_PDRV0|ZP_PDRV1|ZP_PU|ZP_SL
+ VSS|XN_CS|XN_IE|XN_PD|XN_PDRV0|XN_PDRV1|XN_PU|XN_SL|XP_CS|XP_IE|XP_PD|XP_PDRV0|XP_PDRV1|XP_PU|XP_SL|YN_CS|YN_IE|YN_PD|YN_PDRV0|YN_PDRV1|YN_PU|YN_SL|YP_CS|YP_IE|YP_PD|YP_PDRV0|YP_PDRV1|YP_PU|YP_SL|ZN_CS|ZN_IE|ZN_PD|ZN_PDRV0|ZN_PDRV1|ZN_PU|ZN_SL|ZP_CS|ZP_IE|ZP_PD|ZP_PDRV0|ZP_PDRV1|ZP_PU|ZP_SL
+ nfet_06v0 L=1U W=5U AS=2.2P AD=1.3P PS=10.88U PD=5.52U
M$1763
+ VSS|XN_CS|XN_IE|XN_PD|XN_PDRV0|XN_PDRV1|XN_PU|XN_SL|XP_CS|XP_IE|XP_PD|XP_PDRV0|XP_PDRV1|XP_PU|XP_SL|YN_CS|YN_IE|YN_PD|YN_PDRV0|YN_PDRV1|YN_PU|YN_SL|YP_CS|YP_IE|YP_PD|YP_PDRV0|YP_PDRV1|YP_PU|YP_SL|ZN_CS|ZN_IE|ZN_PD|ZN_PDRV0|ZN_PDRV1|ZN_PU|ZN_SL|ZP_CS|ZP_IE|ZP_PD|ZP_PDRV0|ZP_PDRV1|ZP_PU|ZP_SL
+ \$12687 \$12688
+ VSS|XN_CS|XN_IE|XN_PD|XN_PDRV0|XN_PDRV1|XN_PU|XN_SL|XP_CS|XP_IE|XP_PD|XP_PDRV0|XP_PDRV1|XP_PU|XP_SL|YN_CS|YN_IE|YN_PD|YN_PDRV0|YN_PDRV1|YN_PU|YN_SL|YP_CS|YP_IE|YP_PD|YP_PDRV0|YP_PDRV1|YP_PU|YP_SL|ZN_CS|ZN_IE|ZN_PD|ZN_PDRV0|ZN_PDRV1|ZN_PU|ZN_SL|ZP_CS|ZP_IE|ZP_PD|ZP_PDRV0|ZP_PDRV1|ZP_PU|ZP_SL
+ nfet_06v0 L=1U W=5U AS=1.3P AD=1.3P PS=5.52U PD=5.52U
M$1764 \$12688 \$12687
+ VSS|XN_CS|XN_IE|XN_PD|XN_PDRV0|XN_PDRV1|XN_PU|XN_SL|XP_CS|XP_IE|XP_PD|XP_PDRV0|XP_PDRV1|XP_PU|XP_SL|YN_CS|YN_IE|YN_PD|YN_PDRV0|YN_PDRV1|YN_PU|YN_SL|YP_CS|YP_IE|YP_PD|YP_PDRV0|YP_PDRV1|YP_PU|YP_SL|ZN_CS|ZN_IE|ZN_PD|ZN_PDRV0|ZN_PDRV1|ZN_PU|ZN_SL|ZP_CS|ZP_IE|ZP_PD|ZP_PDRV0|ZP_PDRV1|ZP_PU|ZP_SL
+ VSS|XN_CS|XN_IE|XN_PD|XN_PDRV0|XN_PDRV1|XN_PU|XN_SL|XP_CS|XP_IE|XP_PD|XP_PDRV0|XP_PDRV1|XP_PU|XP_SL|YN_CS|YN_IE|YN_PD|YN_PDRV0|YN_PDRV1|YN_PU|YN_SL|YP_CS|YP_IE|YP_PD|YP_PDRV0|YP_PDRV1|YP_PU|YP_SL|ZN_CS|ZN_IE|ZN_PD|ZN_PDRV0|ZN_PDRV1|ZN_PU|ZN_SL|ZP_CS|ZP_IE|ZP_PD|ZP_PDRV0|ZP_PDRV1|ZP_PU|ZP_SL
+ nfet_06v0 L=1U W=5U AS=1.3P AD=2.2P PS=5.52U PD=10.88U
M$1765
+ VSS|XN_CS|XN_IE|XN_PD|XN_PDRV0|XN_PDRV1|XN_PU|XN_SL|XP_CS|XP_IE|XP_PD|XP_PDRV0|XP_PDRV1|XP_PU|XP_SL|YN_CS|YN_IE|YN_PD|YN_PDRV0|YN_PDRV1|YN_PU|YN_SL|YP_CS|YP_IE|YP_PD|YP_PDRV0|YP_PDRV1|YP_PU|YP_SL|ZN_CS|ZN_IE|ZN_PD|ZN_PDRV0|ZN_PDRV1|ZN_PU|ZN_SL|ZP_CS|ZP_IE|ZP_PD|ZP_PDRV0|ZP_PDRV1|ZP_PU|ZP_SL
+ VDD|XN_OE|XP_OE|YN_OE|YP_OE|ZN_OE|ZP_OE
+ VSS|XN_CS|XN_IE|XN_PD|XN_PDRV0|XN_PDRV1|XN_PU|XN_SL|XP_CS|XP_IE|XP_PD|XP_PDRV0|XP_PDRV1|XP_PU|XP_SL|YN_CS|YN_IE|YN_PD|YN_PDRV0|YN_PDRV1|YN_PU|YN_SL|YP_CS|YP_IE|YP_PD|YP_PDRV0|YP_PDRV1|YP_PU|YP_SL|ZN_CS|ZN_IE|ZN_PD|ZN_PDRV0|ZN_PDRV1|ZN_PU|ZN_SL|ZP_CS|ZP_IE|ZP_PD|ZP_PDRV0|ZP_PDRV1|ZP_PU|ZP_SL
+ VSS|XN_CS|XN_IE|XN_PD|XN_PDRV0|XN_PDRV1|XN_PU|XN_SL|XP_CS|XP_IE|XP_PD|XP_PDRV0|XP_PDRV1|XP_PU|XP_SL|YN_CS|YN_IE|YN_PD|YN_PDRV0|YN_PDRV1|YN_PU|YN_SL|YP_CS|YP_IE|YP_PD|YP_PDRV0|YP_PDRV1|YP_PU|YP_SL|ZN_CS|ZN_IE|ZN_PD|ZN_PDRV0|ZN_PDRV1|ZN_PU|ZN_SL|ZP_CS|ZP_IE|ZP_PD|ZP_PDRV0|ZP_PDRV1|ZP_PU|ZP_SL
+ nfet_06v0 L=2U W=9.75U AS=4.29P AD=4.29P PS=20.38U PD=20.38U
M$1766
+ VSS|XN_CS|XN_IE|XN_PD|XN_PDRV0|XN_PDRV1|XN_PU|XN_SL|XP_CS|XP_IE|XP_PD|XP_PDRV0|XP_PDRV1|XP_PU|XP_SL|YN_CS|YN_IE|YN_PD|YN_PDRV0|YN_PDRV1|YN_PU|YN_SL|YP_CS|YP_IE|YP_PD|YP_PDRV0|YP_PDRV1|YP_PU|YP_SL|ZN_CS|ZN_IE|ZN_PD|ZN_PDRV0|ZN_PDRV1|ZN_PU|ZN_SL|ZP_CS|ZP_IE|ZP_PD|ZP_PDRV0|ZP_PDRV1|ZP_PU|ZP_SL
+ VDD|XN_OE|XP_OE|YN_OE|YP_OE|ZN_OE|ZP_OE
+ VSS|XN_CS|XN_IE|XN_PD|XN_PDRV0|XN_PDRV1|XN_PU|XN_SL|XP_CS|XP_IE|XP_PD|XP_PDRV0|XP_PDRV1|XP_PU|XP_SL|YN_CS|YN_IE|YN_PD|YN_PDRV0|YN_PDRV1|YN_PU|YN_SL|YP_CS|YP_IE|YP_PD|YP_PDRV0|YP_PDRV1|YP_PU|YP_SL|ZN_CS|ZN_IE|ZN_PD|ZN_PDRV0|ZN_PDRV1|ZN_PU|ZN_SL|ZP_CS|ZP_IE|ZP_PD|ZP_PDRV0|ZP_PDRV1|ZP_PU|ZP_SL
+ VSS|XN_CS|XN_IE|XN_PD|XN_PDRV0|XN_PDRV1|XN_PU|XN_SL|XP_CS|XP_IE|XP_PD|XP_PDRV0|XP_PDRV1|XP_PU|XP_SL|YN_CS|YN_IE|YN_PD|YN_PDRV0|YN_PDRV1|YN_PU|YN_SL|YP_CS|YP_IE|YP_PD|YP_PDRV0|YP_PDRV1|YP_PU|YP_SL|ZN_CS|ZN_IE|ZN_PD|ZN_PDRV0|ZN_PDRV1|ZN_PU|ZN_SL|ZP_CS|ZP_IE|ZP_PD|ZP_PDRV0|ZP_PDRV1|ZP_PU|ZP_SL
+ nfet_06v0 L=2U W=9.75U AS=4.29P AD=4.29P PS=20.38U PD=20.38U
M$1767 \$12689 \$12689
+ VSS|XN_CS|XN_IE|XN_PD|XN_PDRV0|XN_PDRV1|XN_PU|XN_SL|XP_CS|XP_IE|XP_PD|XP_PDRV0|XP_PDRV1|XP_PU|XP_SL|YN_CS|YN_IE|YN_PD|YN_PDRV0|YN_PDRV1|YN_PU|YN_SL|YP_CS|YP_IE|YP_PD|YP_PDRV0|YP_PDRV1|YP_PU|YP_SL|ZN_CS|ZN_IE|ZN_PD|ZN_PDRV0|ZN_PDRV1|ZN_PU|ZN_SL|ZP_CS|ZP_IE|ZP_PD|ZP_PDRV0|ZP_PDRV1|ZP_PU|ZP_SL
+ VSS|XN_CS|XN_IE|XN_PD|XN_PDRV0|XN_PDRV1|XN_PU|XN_SL|XP_CS|XP_IE|XP_PD|XP_PDRV0|XP_PDRV1|XP_PU|XP_SL|YN_CS|YN_IE|YN_PD|YN_PDRV0|YN_PDRV1|YN_PU|YN_SL|YP_CS|YP_IE|YP_PD|YP_PDRV0|YP_PDRV1|YP_PU|YP_SL|ZN_CS|ZN_IE|ZN_PD|ZN_PDRV0|ZN_PDRV1|ZN_PU|ZN_SL|ZP_CS|ZP_IE|ZP_PD|ZP_PDRV0|ZP_PDRV1|ZP_PU|ZP_SL
+ nfet_06v0 L=1U W=1U AS=0.44P AD=0.44P PS=2.88U PD=2.88U
M$1768 \$12725 \$12666
+ VSS|XN_CS|XN_IE|XN_PD|XN_PDRV0|XN_PDRV1|XN_PU|XN_SL|XP_CS|XP_IE|XP_PD|XP_PDRV0|XP_PDRV1|XP_PU|XP_SL|YN_CS|YN_IE|YN_PD|YN_PDRV0|YN_PDRV1|YN_PU|YN_SL|YP_CS|YP_IE|YP_PD|YP_PDRV0|YP_PDRV1|YP_PU|YP_SL|ZN_CS|ZN_IE|ZN_PD|ZN_PDRV0|ZN_PDRV1|ZN_PU|ZN_SL|ZP_CS|ZP_IE|ZP_PD|ZP_PDRV0|ZP_PDRV1|ZP_PU|ZP_SL
+ VSS|XN_CS|XN_IE|XN_PD|XN_PDRV0|XN_PDRV1|XN_PU|XN_SL|XP_CS|XP_IE|XP_PD|XP_PDRV0|XP_PDRV1|XP_PU|XP_SL|YN_CS|YN_IE|YN_PD|YN_PDRV0|YN_PDRV1|YN_PU|YN_SL|YP_CS|YP_IE|YP_PD|YP_PDRV0|YP_PDRV1|YP_PU|YP_SL|ZN_CS|ZN_IE|ZN_PD|ZN_PDRV0|ZN_PDRV1|ZN_PU|ZN_SL|ZP_CS|ZP_IE|ZP_PD|ZP_PDRV0|ZP_PDRV1|ZP_PU|ZP_SL
+ nfet_06v0 L=1U W=5U AS=2.2P AD=1.25P PS=10.88U PD=5.5U
M$1769 \$12666 \$12689 \$12725
+ VSS|XN_CS|XN_IE|XN_PD|XN_PDRV0|XN_PDRV1|XN_PU|XN_SL|XP_CS|XP_IE|XP_PD|XP_PDRV0|XP_PDRV1|XP_PU|XP_SL|YN_CS|YN_IE|YN_PD|YN_PDRV0|YN_PDRV1|YN_PU|YN_SL|YP_CS|YP_IE|YP_PD|YP_PDRV0|YP_PDRV1|YP_PU|YP_SL|ZN_CS|ZN_IE|ZN_PD|ZN_PDRV0|ZN_PDRV1|ZN_PU|ZN_SL|ZP_CS|ZP_IE|ZP_PD|ZP_PDRV0|ZP_PDRV1|ZP_PU|ZP_SL
+ nfet_06v0 L=1U W=5U AS=1.25P AD=2.2P PS=5.5U PD=10.88U
M$1770 \$12705 \$13283
+ VSS|XN_CS|XN_IE|XN_PD|XN_PDRV0|XN_PDRV1|XN_PU|XN_SL|XP_CS|XP_IE|XP_PD|XP_PDRV0|XP_PDRV1|XP_PU|XP_SL|YN_CS|YN_IE|YN_PD|YN_PDRV0|YN_PDRV1|YN_PU|YN_SL|YP_CS|YP_IE|YP_PD|YP_PDRV0|YP_PDRV1|YP_PU|YP_SL|ZN_CS|ZN_IE|ZN_PD|ZN_PDRV0|ZN_PDRV1|ZN_PU|ZN_SL|ZP_CS|ZP_IE|ZP_PD|ZP_PDRV0|ZP_PDRV1|ZP_PU|ZP_SL
+ VSS|XN_CS|XN_IE|XN_PD|XN_PDRV0|XN_PDRV1|XN_PU|XN_SL|XP_CS|XP_IE|XP_PD|XP_PDRV0|XP_PDRV1|XP_PU|XP_SL|YN_CS|YN_IE|YN_PD|YN_PDRV0|YN_PDRV1|YN_PU|YN_SL|YP_CS|YP_IE|YP_PD|YP_PDRV0|YP_PDRV1|YP_PU|YP_SL|ZN_CS|ZN_IE|ZN_PD|ZN_PDRV0|ZN_PDRV1|ZN_PU|ZN_SL|ZP_CS|ZP_IE|ZP_PD|ZP_PDRV0|ZP_PDRV1|ZP_PU|ZP_SL
+ nfet_06v0 L=1U W=1U AS=0.44P AD=0.25P PS=2.88U PD=1.5U
M$1771 \$13202 \$13283 \$12705
+ VSS|XN_CS|XN_IE|XN_PD|XN_PDRV0|XN_PDRV1|XN_PU|XN_SL|XP_CS|XP_IE|XP_PD|XP_PDRV0|XP_PDRV1|XP_PU|XP_SL|YN_CS|YN_IE|YN_PD|YN_PDRV0|YN_PDRV1|YN_PU|YN_SL|YP_CS|YP_IE|YP_PD|YP_PDRV0|YP_PDRV1|YP_PU|YP_SL|ZN_CS|ZN_IE|ZN_PD|ZN_PDRV0|ZN_PDRV1|ZN_PU|ZN_SL|ZP_CS|ZP_IE|ZP_PD|ZP_PDRV0|ZP_PDRV1|ZP_PU|ZP_SL
+ nfet_06v0 L=1U W=1U AS=0.25P AD=0.44P PS=1.5U PD=2.88U
M$1772 \$12704 \$13283
+ VSS|XN_CS|XN_IE|XN_PD|XN_PDRV0|XN_PDRV1|XN_PU|XN_SL|XP_CS|XP_IE|XP_PD|XP_PDRV0|XP_PDRV1|XP_PU|XP_SL|YN_CS|YN_IE|YN_PD|YN_PDRV0|YN_PDRV1|YN_PU|YN_SL|YP_CS|YP_IE|YP_PD|YP_PDRV0|YP_PDRV1|YP_PU|YP_SL|ZN_CS|ZN_IE|ZN_PD|ZN_PDRV0|ZN_PDRV1|ZN_PU|ZN_SL|ZP_CS|ZP_IE|ZP_PD|ZP_PDRV0|ZP_PDRV1|ZP_PU|ZP_SL
+ VSS|XN_CS|XN_IE|XN_PD|XN_PDRV0|XN_PDRV1|XN_PU|XN_SL|XP_CS|XP_IE|XP_PD|XP_PDRV0|XP_PDRV1|XP_PU|XP_SL|YN_CS|YN_IE|YN_PD|YN_PDRV0|YN_PDRV1|YN_PU|YN_SL|YP_CS|YP_IE|YP_PD|YP_PDRV0|YP_PDRV1|YP_PU|YP_SL|ZN_CS|ZN_IE|ZN_PD|ZN_PDRV0|ZN_PDRV1|ZN_PU|ZN_SL|ZP_CS|ZP_IE|ZP_PD|ZP_PDRV0|ZP_PDRV1|ZP_PU|ZP_SL
+ nfet_06v0 L=1U W=1U AS=0.44P AD=0.25P PS=2.88U PD=1.5U
M$1773 \$13283 \$13283 \$12704
+ VSS|XN_CS|XN_IE|XN_PD|XN_PDRV0|XN_PDRV1|XN_PU|XN_SL|XP_CS|XP_IE|XP_PD|XP_PDRV0|XP_PDRV1|XP_PU|XP_SL|YN_CS|YN_IE|YN_PD|YN_PDRV0|YN_PDRV1|YN_PU|YN_SL|YP_CS|YP_IE|YP_PD|YP_PDRV0|YP_PDRV1|YP_PU|YP_SL|ZN_CS|ZN_IE|ZN_PD|ZN_PDRV0|ZN_PDRV1|ZN_PU|ZN_SL|ZP_CS|ZP_IE|ZP_PD|ZP_PDRV0|ZP_PDRV1|ZP_PU|ZP_SL
+ nfet_06v0 L=1U W=1U AS=0.25P AD=0.44P PS=1.5U PD=2.88U
M$1774 \$12722 \$12666
+ VSS|XN_CS|XN_IE|XN_PD|XN_PDRV0|XN_PDRV1|XN_PU|XN_SL|XP_CS|XP_IE|XP_PD|XP_PDRV0|XP_PDRV1|XP_PU|XP_SL|YN_CS|YN_IE|YN_PD|YN_PDRV0|YN_PDRV1|YN_PU|YN_SL|YP_CS|YP_IE|YP_PD|YP_PDRV0|YP_PDRV1|YP_PU|YP_SL|ZN_CS|ZN_IE|ZN_PD|ZN_PDRV0|ZN_PDRV1|ZN_PU|ZN_SL|ZP_CS|ZP_IE|ZP_PD|ZP_PDRV0|ZP_PDRV1|ZP_PU|ZP_SL
+ VSS|XN_CS|XN_IE|XN_PD|XN_PDRV0|XN_PDRV1|XN_PU|XN_SL|XP_CS|XP_IE|XP_PD|XP_PDRV0|XP_PDRV1|XP_PU|XP_SL|YN_CS|YN_IE|YN_PD|YN_PDRV0|YN_PDRV1|YN_PU|YN_SL|YP_CS|YP_IE|YP_PD|YP_PDRV0|YP_PDRV1|YP_PU|YP_SL|ZN_CS|ZN_IE|ZN_PD|ZN_PDRV0|ZN_PDRV1|ZN_PU|ZN_SL|ZP_CS|ZP_IE|ZP_PD|ZP_PDRV0|ZP_PDRV1|ZP_PU|ZP_SL
+ nfet_06v0 L=1U W=5U AS=2.2P AD=1.25P PS=10.88U PD=5.5U
M$1775 \$12690 \$12689 \$12722
+ VSS|XN_CS|XN_IE|XN_PD|XN_PDRV0|XN_PDRV1|XN_PU|XN_SL|XP_CS|XP_IE|XP_PD|XP_PDRV0|XP_PDRV1|XP_PU|XP_SL|YN_CS|YN_IE|YN_PD|YN_PDRV0|YN_PDRV1|YN_PU|YN_SL|YP_CS|YP_IE|YP_PD|YP_PDRV0|YP_PDRV1|YP_PU|YP_SL|ZN_CS|ZN_IE|ZN_PD|ZN_PDRV0|ZN_PDRV1|ZN_PU|ZN_SL|ZP_CS|ZP_IE|ZP_PD|ZP_PDRV0|ZP_PDRV1|ZP_PU|ZP_SL
+ nfet_06v0 L=1U W=5U AS=1.25P AD=1.65P PS=5.5U PD=5.66U
M$1776 \$12721 \$12689 \$12690
+ VSS|XN_CS|XN_IE|XN_PD|XN_PDRV0|XN_PDRV1|XN_PU|XN_SL|XP_CS|XP_IE|XP_PD|XP_PDRV0|XP_PDRV1|XP_PU|XP_SL|YN_CS|YN_IE|YN_PD|YN_PDRV0|YN_PDRV1|YN_PU|YN_SL|YP_CS|YP_IE|YP_PD|YP_PDRV0|YP_PDRV1|YP_PU|YP_SL|ZN_CS|ZN_IE|ZN_PD|ZN_PDRV0|ZN_PDRV1|ZN_PU|ZN_SL|ZP_CS|ZP_IE|ZP_PD|ZP_PDRV0|ZP_PDRV1|ZP_PU|ZP_SL
+ nfet_06v0 L=1U W=5U AS=1.65P AD=1.25P PS=5.66U PD=5.5U
M$1777
+ VSS|XN_CS|XN_IE|XN_PD|XN_PDRV0|XN_PDRV1|XN_PU|XN_SL|XP_CS|XP_IE|XP_PD|XP_PDRV0|XP_PDRV1|XP_PU|XP_SL|YN_CS|YN_IE|YN_PD|YN_PDRV0|YN_PDRV1|YN_PU|YN_SL|YP_CS|YP_IE|YP_PD|YP_PDRV0|YP_PDRV1|YP_PU|YP_SL|ZN_CS|ZN_IE|ZN_PD|ZN_PDRV0|ZN_PDRV1|ZN_PU|ZN_SL|ZP_CS|ZP_IE|ZP_PD|ZP_PDRV0|ZP_PDRV1|ZP_PU|ZP_SL
+ \$12666 \$12721
+ VSS|XN_CS|XN_IE|XN_PD|XN_PDRV0|XN_PDRV1|XN_PU|XN_SL|XP_CS|XP_IE|XP_PD|XP_PDRV0|XP_PDRV1|XP_PU|XP_SL|YN_CS|YN_IE|YN_PD|YN_PDRV0|YN_PDRV1|YN_PU|YN_SL|YP_CS|YP_IE|YP_PD|YP_PDRV0|YP_PDRV1|YP_PU|YP_SL|ZN_CS|ZN_IE|ZN_PD|ZN_PDRV0|ZN_PDRV1|ZN_PU|ZN_SL|ZP_CS|ZP_IE|ZP_PD|ZP_PDRV0|ZP_PDRV1|ZP_PU|ZP_SL
+ nfet_06v0 L=1U W=5U AS=1.25P AD=2.2P PS=5.5U PD=10.88U
M$1778 \$12691 \$4872 \$12690
+ VSS|XN_CS|XN_IE|XN_PD|XN_PDRV0|XN_PDRV1|XN_PU|XN_SL|XP_CS|XP_IE|XP_PD|XP_PDRV0|XP_PDRV1|XP_PU|XP_SL|YN_CS|YN_IE|YN_PD|YN_PDRV0|YN_PDRV1|YN_PU|YN_SL|YP_CS|YP_IE|YP_PD|YP_PDRV0|YP_PDRV1|YP_PU|YP_SL|ZN_CS|ZN_IE|ZN_PD|ZN_PDRV0|ZN_PDRV1|ZN_PU|ZN_SL|ZP_CS|ZP_IE|ZP_PD|ZP_PDRV0|ZP_PDRV1|ZP_PU|ZP_SL
+ nfet_06v0 L=1U W=5U AS=2.2P AD=1.3P PS=10.88U PD=5.52U
M$1779 \$12690 \$4872 \$12691
+ VSS|XN_CS|XN_IE|XN_PD|XN_PDRV0|XN_PDRV1|XN_PU|XN_SL|XP_CS|XP_IE|XP_PD|XP_PDRV0|XP_PDRV1|XP_PU|XP_SL|YN_CS|YN_IE|YN_PD|YN_PDRV0|YN_PDRV1|YN_PU|YN_SL|YP_CS|YP_IE|YP_PD|YP_PDRV0|YP_PDRV1|YP_PU|YP_SL|ZN_CS|ZN_IE|ZN_PD|ZN_PDRV0|ZN_PDRV1|ZN_PU|ZN_SL|ZP_CS|ZP_IE|ZP_PD|ZP_PDRV0|ZP_PDRV1|ZP_PU|ZP_SL
+ nfet_06v0 L=1U W=5U AS=1.3P AD=2.2P PS=5.52U PD=10.88U
M$1780 \$12692 \$4864 \$12690
+ VSS|XN_CS|XN_IE|XN_PD|XN_PDRV0|XN_PDRV1|XN_PU|XN_SL|XP_CS|XP_IE|XP_PD|XP_PDRV0|XP_PDRV1|XP_PU|XP_SL|YN_CS|YN_IE|YN_PD|YN_PDRV0|YN_PDRV1|YN_PU|YN_SL|YP_CS|YP_IE|YP_PD|YP_PDRV0|YP_PDRV1|YP_PU|YP_SL|ZN_CS|ZN_IE|ZN_PD|ZN_PDRV0|ZN_PDRV1|ZN_PU|ZN_SL|ZP_CS|ZP_IE|ZP_PD|ZP_PDRV0|ZP_PDRV1|ZP_PU|ZP_SL
+ nfet_06v0 L=1U W=5U AS=2.2P AD=1.3P PS=10.88U PD=5.52U
M$1781 \$12690 \$4864 \$12692
+ VSS|XN_CS|XN_IE|XN_PD|XN_PDRV0|XN_PDRV1|XN_PU|XN_SL|XP_CS|XP_IE|XP_PD|XP_PDRV0|XP_PDRV1|XP_PU|XP_SL|YN_CS|YN_IE|YN_PD|YN_PDRV0|YN_PDRV1|YN_PU|YN_SL|YP_CS|YP_IE|YP_PD|YP_PDRV0|YP_PDRV1|YP_PU|YP_SL|ZN_CS|ZN_IE|ZN_PD|ZN_PDRV0|ZN_PDRV1|ZN_PU|ZN_SL|ZP_CS|ZP_IE|ZP_PD|ZP_PDRV0|ZP_PDRV1|ZP_PU|ZP_SL
+ nfet_06v0 L=1U W=5U AS=1.3P AD=2.2P PS=5.52U PD=10.88U
M$1782 \$12694 \$12689 \$12693
+ VSS|XN_CS|XN_IE|XN_PD|XN_PDRV0|XN_PDRV1|XN_PU|XN_SL|XP_CS|XP_IE|XP_PD|XP_PDRV0|XP_PDRV1|XP_PU|XP_SL|YN_CS|YN_IE|YN_PD|YN_PDRV0|YN_PDRV1|YN_PU|YN_SL|YP_CS|YP_IE|YP_PD|YP_PDRV0|YP_PDRV1|YP_PU|YP_SL|ZN_CS|ZN_IE|ZN_PD|ZN_PDRV0|ZN_PDRV1|ZN_PU|ZN_SL|ZP_CS|ZP_IE|ZP_PD|ZP_PDRV0|ZP_PDRV1|ZP_PU|ZP_SL
+ nfet_06v0 L=1U W=2.5U AS=1.1P AD=0.65P PS=5.88U PD=3.02U
M$1783 \$12693 \$12689 \$12694
+ VSS|XN_CS|XN_IE|XN_PD|XN_PDRV0|XN_PDRV1|XN_PU|XN_SL|XP_CS|XP_IE|XP_PD|XP_PDRV0|XP_PDRV1|XP_PU|XP_SL|YN_CS|YN_IE|YN_PD|YN_PDRV0|YN_PDRV1|YN_PU|YN_SL|YP_CS|YP_IE|YP_PD|YP_PDRV0|YP_PDRV1|YP_PU|YP_SL|ZN_CS|ZN_IE|ZN_PD|ZN_PDRV0|ZN_PDRV1|ZN_PU|ZN_SL|ZP_CS|ZP_IE|ZP_PD|ZP_PDRV0|ZP_PDRV1|ZP_PU|ZP_SL
+ nfet_06v0 L=1U W=2.5U AS=0.65P AD=1.1P PS=3.02U PD=5.88U
M$1784 \$12696 \$12689 \$12695
+ VSS|XN_CS|XN_IE|XN_PD|XN_PDRV0|XN_PDRV1|XN_PU|XN_SL|XP_CS|XP_IE|XP_PD|XP_PDRV0|XP_PDRV1|XP_PU|XP_SL|YN_CS|YN_IE|YN_PD|YN_PDRV0|YN_PDRV1|YN_PU|YN_SL|YP_CS|YP_IE|YP_PD|YP_PDRV0|YP_PDRV1|YP_PU|YP_SL|ZN_CS|ZN_IE|ZN_PD|ZN_PDRV0|ZN_PDRV1|ZN_PU|ZN_SL|ZP_CS|ZP_IE|ZP_PD|ZP_PDRV0|ZP_PDRV1|ZP_PU|ZP_SL
+ nfet_06v0 L=1U W=2.5U AS=1.1P AD=0.65P PS=5.88U PD=3.02U
M$1785 \$12695 \$12689 \$12696
+ VSS|XN_CS|XN_IE|XN_PD|XN_PDRV0|XN_PDRV1|XN_PU|XN_SL|XP_CS|XP_IE|XP_PD|XP_PDRV0|XP_PDRV1|XP_PU|XP_SL|YN_CS|YN_IE|YN_PD|YN_PDRV0|YN_PDRV1|YN_PU|YN_SL|YP_CS|YP_IE|YP_PD|YP_PDRV0|YP_PDRV1|YP_PU|YP_SL|ZN_CS|ZN_IE|ZN_PD|ZN_PDRV0|ZN_PDRV1|ZN_PU|ZN_SL|ZP_CS|ZP_IE|ZP_PD|ZP_PDRV0|ZP_PDRV1|ZP_PU|ZP_SL
+ nfet_06v0 L=1U W=2.5U AS=0.65P AD=1.1P PS=3.02U PD=5.88U
M$1786 \$12693 \$12694
+ VSS|XN_CS|XN_IE|XN_PD|XN_PDRV0|XN_PDRV1|XN_PU|XN_SL|XP_CS|XP_IE|XP_PD|XP_PDRV0|XP_PDRV1|XP_PU|XP_SL|YN_CS|YN_IE|YN_PD|YN_PDRV0|YN_PDRV1|YN_PU|YN_SL|YP_CS|YP_IE|YP_PD|YP_PDRV0|YP_PDRV1|YP_PU|YP_SL|ZN_CS|ZN_IE|ZN_PD|ZN_PDRV0|ZN_PDRV1|ZN_PU|ZN_SL|ZP_CS|ZP_IE|ZP_PD|ZP_PDRV0|ZP_PDRV1|ZP_PU|ZP_SL
+ VSS|XN_CS|XN_IE|XN_PD|XN_PDRV0|XN_PDRV1|XN_PU|XN_SL|XP_CS|XP_IE|XP_PD|XP_PDRV0|XP_PDRV1|XP_PU|XP_SL|YN_CS|YN_IE|YN_PD|YN_PDRV0|YN_PDRV1|YN_PU|YN_SL|YP_CS|YP_IE|YP_PD|YP_PDRV0|YP_PDRV1|YP_PU|YP_SL|ZN_CS|ZN_IE|ZN_PD|ZN_PDRV0|ZN_PDRV1|ZN_PU|ZN_SL|ZP_CS|ZP_IE|ZP_PD|ZP_PDRV0|ZP_PDRV1|ZP_PU|ZP_SL
+ nfet_06v0 L=1U W=2.5U AS=1.1P AD=0.65P PS=5.88U PD=3.02U
M$1787
+ VSS|XN_CS|XN_IE|XN_PD|XN_PDRV0|XN_PDRV1|XN_PU|XN_SL|XP_CS|XP_IE|XP_PD|XP_PDRV0|XP_PDRV1|XP_PU|XP_SL|YN_CS|YN_IE|YN_PD|YN_PDRV0|YN_PDRV1|YN_PU|YN_SL|YP_CS|YP_IE|YP_PD|YP_PDRV0|YP_PDRV1|YP_PU|YP_SL|ZN_CS|ZN_IE|ZN_PD|ZN_PDRV0|ZN_PDRV1|ZN_PU|ZN_SL|ZP_CS|ZP_IE|ZP_PD|ZP_PDRV0|ZP_PDRV1|ZP_PU|ZP_SL
+ \$12694 \$12693
+ VSS|XN_CS|XN_IE|XN_PD|XN_PDRV0|XN_PDRV1|XN_PU|XN_SL|XP_CS|XP_IE|XP_PD|XP_PDRV0|XP_PDRV1|XP_PU|XP_SL|YN_CS|YN_IE|YN_PD|YN_PDRV0|YN_PDRV1|YN_PU|YN_SL|YP_CS|YP_IE|YP_PD|YP_PDRV0|YP_PDRV1|YP_PU|YP_SL|ZN_CS|ZN_IE|ZN_PD|ZN_PDRV0|ZN_PDRV1|ZN_PU|ZN_SL|ZP_CS|ZP_IE|ZP_PD|ZP_PDRV0|ZP_PDRV1|ZP_PU|ZP_SL
+ nfet_06v0 L=1U W=2.5U AS=0.65P AD=0.65P PS=3.02U PD=3.02U
M$1788 \$12693 \$12694
+ VSS|XN_CS|XN_IE|XN_PD|XN_PDRV0|XN_PDRV1|XN_PU|XN_SL|XP_CS|XP_IE|XP_PD|XP_PDRV0|XP_PDRV1|XP_PU|XP_SL|YN_CS|YN_IE|YN_PD|YN_PDRV0|YN_PDRV1|YN_PU|YN_SL|YP_CS|YP_IE|YP_PD|YP_PDRV0|YP_PDRV1|YP_PU|YP_SL|ZN_CS|ZN_IE|ZN_PD|ZN_PDRV0|ZN_PDRV1|ZN_PU|ZN_SL|ZP_CS|ZP_IE|ZP_PD|ZP_PDRV0|ZP_PDRV1|ZP_PU|ZP_SL
+ VSS|XN_CS|XN_IE|XN_PD|XN_PDRV0|XN_PDRV1|XN_PU|XN_SL|XP_CS|XP_IE|XP_PD|XP_PDRV0|XP_PDRV1|XP_PU|XP_SL|YN_CS|YN_IE|YN_PD|YN_PDRV0|YN_PDRV1|YN_PU|YN_SL|YP_CS|YP_IE|YP_PD|YP_PDRV0|YP_PDRV1|YP_PU|YP_SL|ZN_CS|ZN_IE|ZN_PD|ZN_PDRV0|ZN_PDRV1|ZN_PU|ZN_SL|ZP_CS|ZP_IE|ZP_PD|ZP_PDRV0|ZP_PDRV1|ZP_PU|ZP_SL
+ nfet_06v0 L=1U W=2.5U AS=0.65P AD=0.65P PS=3.02U PD=3.02U
M$1789
+ VSS|XN_CS|XN_IE|XN_PD|XN_PDRV0|XN_PDRV1|XN_PU|XN_SL|XP_CS|XP_IE|XP_PD|XP_PDRV0|XP_PDRV1|XP_PU|XP_SL|YN_CS|YN_IE|YN_PD|YN_PDRV0|YN_PDRV1|YN_PU|YN_SL|YP_CS|YP_IE|YP_PD|YP_PDRV0|YP_PDRV1|YP_PU|YP_SL|ZN_CS|ZN_IE|ZN_PD|ZN_PDRV0|ZN_PDRV1|ZN_PU|ZN_SL|ZP_CS|ZP_IE|ZP_PD|ZP_PDRV0|ZP_PDRV1|ZP_PU|ZP_SL
+ \$12694 \$12693
+ VSS|XN_CS|XN_IE|XN_PD|XN_PDRV0|XN_PDRV1|XN_PU|XN_SL|XP_CS|XP_IE|XP_PD|XP_PDRV0|XP_PDRV1|XP_PU|XP_SL|YN_CS|YN_IE|YN_PD|YN_PDRV0|YN_PDRV1|YN_PU|YN_SL|YP_CS|YP_IE|YP_PD|YP_PDRV0|YP_PDRV1|YP_PU|YP_SL|ZN_CS|ZN_IE|ZN_PD|ZN_PDRV0|ZN_PDRV1|ZN_PU|ZN_SL|ZP_CS|ZP_IE|ZP_PD|ZP_PDRV0|ZP_PDRV1|ZP_PU|ZP_SL
+ nfet_06v0 L=1U W=2.5U AS=0.65P AD=1.1P PS=3.02U PD=5.88U
M$1790 \$12695 \$12694
+ VSS|XN_CS|XN_IE|XN_PD|XN_PDRV0|XN_PDRV1|XN_PU|XN_SL|XP_CS|XP_IE|XP_PD|XP_PDRV0|XP_PDRV1|XP_PU|XP_SL|YN_CS|YN_IE|YN_PD|YN_PDRV0|YN_PDRV1|YN_PU|YN_SL|YP_CS|YP_IE|YP_PD|YP_PDRV0|YP_PDRV1|YP_PU|YP_SL|ZN_CS|ZN_IE|ZN_PD|ZN_PDRV0|ZN_PDRV1|ZN_PU|ZN_SL|ZP_CS|ZP_IE|ZP_PD|ZP_PDRV0|ZP_PDRV1|ZP_PU|ZP_SL
+ VSS|XN_CS|XN_IE|XN_PD|XN_PDRV0|XN_PDRV1|XN_PU|XN_SL|XP_CS|XP_IE|XP_PD|XP_PDRV0|XP_PDRV1|XP_PU|XP_SL|YN_CS|YN_IE|YN_PD|YN_PDRV0|YN_PDRV1|YN_PU|YN_SL|YP_CS|YP_IE|YP_PD|YP_PDRV0|YP_PDRV1|YP_PU|YP_SL|ZN_CS|ZN_IE|ZN_PD|ZN_PDRV0|ZN_PDRV1|ZN_PU|ZN_SL|ZP_CS|ZP_IE|ZP_PD|ZP_PDRV0|ZP_PDRV1|ZP_PU|ZP_SL
+ nfet_06v0 L=1U W=2.5U AS=1.1P AD=0.65P PS=5.88U PD=3.02U
M$1791
+ VSS|XN_CS|XN_IE|XN_PD|XN_PDRV0|XN_PDRV1|XN_PU|XN_SL|XP_CS|XP_IE|XP_PD|XP_PDRV0|XP_PDRV1|XP_PU|XP_SL|YN_CS|YN_IE|YN_PD|YN_PDRV0|YN_PDRV1|YN_PU|YN_SL|YP_CS|YP_IE|YP_PD|YP_PDRV0|YP_PDRV1|YP_PU|YP_SL|ZN_CS|ZN_IE|ZN_PD|ZN_PDRV0|ZN_PDRV1|ZN_PU|ZN_SL|ZP_CS|ZP_IE|ZP_PD|ZP_PDRV0|ZP_PDRV1|ZP_PU|ZP_SL
+ \$12694 \$12695
+ VSS|XN_CS|XN_IE|XN_PD|XN_PDRV0|XN_PDRV1|XN_PU|XN_SL|XP_CS|XP_IE|XP_PD|XP_PDRV0|XP_PDRV1|XP_PU|XP_SL|YN_CS|YN_IE|YN_PD|YN_PDRV0|YN_PDRV1|YN_PU|YN_SL|YP_CS|YP_IE|YP_PD|YP_PDRV0|YP_PDRV1|YP_PU|YP_SL|ZN_CS|ZN_IE|ZN_PD|ZN_PDRV0|ZN_PDRV1|ZN_PU|ZN_SL|ZP_CS|ZP_IE|ZP_PD|ZP_PDRV0|ZP_PDRV1|ZP_PU|ZP_SL
+ nfet_06v0 L=1U W=2.5U AS=0.65P AD=0.65P PS=3.02U PD=3.02U
M$1792 \$12695 \$12694
+ VSS|XN_CS|XN_IE|XN_PD|XN_PDRV0|XN_PDRV1|XN_PU|XN_SL|XP_CS|XP_IE|XP_PD|XP_PDRV0|XP_PDRV1|XP_PU|XP_SL|YN_CS|YN_IE|YN_PD|YN_PDRV0|YN_PDRV1|YN_PU|YN_SL|YP_CS|YP_IE|YP_PD|YP_PDRV0|YP_PDRV1|YP_PU|YP_SL|ZN_CS|ZN_IE|ZN_PD|ZN_PDRV0|ZN_PDRV1|ZN_PU|ZN_SL|ZP_CS|ZP_IE|ZP_PD|ZP_PDRV0|ZP_PDRV1|ZP_PU|ZP_SL
+ VSS|XN_CS|XN_IE|XN_PD|XN_PDRV0|XN_PDRV1|XN_PU|XN_SL|XP_CS|XP_IE|XP_PD|XP_PDRV0|XP_PDRV1|XP_PU|XP_SL|YN_CS|YN_IE|YN_PD|YN_PDRV0|YN_PDRV1|YN_PU|YN_SL|YP_CS|YP_IE|YP_PD|YP_PDRV0|YP_PDRV1|YP_PU|YP_SL|ZN_CS|ZN_IE|ZN_PD|ZN_PDRV0|ZN_PDRV1|ZN_PU|ZN_SL|ZP_CS|ZP_IE|ZP_PD|ZP_PDRV0|ZP_PDRV1|ZP_PU|ZP_SL
+ nfet_06v0 L=1U W=2.5U AS=0.65P AD=0.65P PS=3.02U PD=3.02U
M$1793
+ VSS|XN_CS|XN_IE|XN_PD|XN_PDRV0|XN_PDRV1|XN_PU|XN_SL|XP_CS|XP_IE|XP_PD|XP_PDRV0|XP_PDRV1|XP_PU|XP_SL|YN_CS|YN_IE|YN_PD|YN_PDRV0|YN_PDRV1|YN_PU|YN_SL|YP_CS|YP_IE|YP_PD|YP_PDRV0|YP_PDRV1|YP_PU|YP_SL|ZN_CS|ZN_IE|ZN_PD|ZN_PDRV0|ZN_PDRV1|ZN_PU|ZN_SL|ZP_CS|ZP_IE|ZP_PD|ZP_PDRV0|ZP_PDRV1|ZP_PU|ZP_SL
+ \$12694 \$12695
+ VSS|XN_CS|XN_IE|XN_PD|XN_PDRV0|XN_PDRV1|XN_PU|XN_SL|XP_CS|XP_IE|XP_PD|XP_PDRV0|XP_PDRV1|XP_PU|XP_SL|YN_CS|YN_IE|YN_PD|YN_PDRV0|YN_PDRV1|YN_PU|YN_SL|YP_CS|YP_IE|YP_PD|YP_PDRV0|YP_PDRV1|YP_PU|YP_SL|ZN_CS|ZN_IE|ZN_PD|ZN_PDRV0|ZN_PDRV1|ZN_PU|ZN_SL|ZP_CS|ZP_IE|ZP_PD|ZP_PDRV0|ZP_PDRV1|ZP_PU|ZP_SL
+ nfet_06v0 L=1U W=2.5U AS=0.65P AD=1.1P PS=3.02U PD=5.88U
M$1794 \$12748 \$12710 \$12694
+ VSS|XN_CS|XN_IE|XN_PD|XN_PDRV0|XN_PDRV1|XN_PU|XN_SL|XP_CS|XP_IE|XP_PD|XP_PDRV0|XP_PDRV1|XP_PU|XP_SL|YN_CS|YN_IE|YN_PD|YN_PDRV0|YN_PDRV1|YN_PU|YN_SL|YP_CS|YP_IE|YP_PD|YP_PDRV0|YP_PDRV1|YP_PU|YP_SL|ZN_CS|ZN_IE|ZN_PD|ZN_PDRV0|ZN_PDRV1|ZN_PU|ZN_SL|ZP_CS|ZP_IE|ZP_PD|ZP_PDRV0|ZP_PDRV1|ZP_PU|ZP_SL
+ nfet_06v0 L=1U W=2.5U AS=1.1P AD=1.1P PS=5.88U PD=5.88U
M$1795 \$12667 \$12710 \$12696
+ VSS|XN_CS|XN_IE|XN_PD|XN_PDRV0|XN_PDRV1|XN_PU|XN_SL|XP_CS|XP_IE|XP_PD|XP_PDRV0|XP_PDRV1|XP_PU|XP_SL|YN_CS|YN_IE|YN_PD|YN_PDRV0|YN_PDRV1|YN_PU|YN_SL|YP_CS|YP_IE|YP_PD|YP_PDRV0|YP_PDRV1|YP_PU|YP_SL|ZN_CS|ZN_IE|ZN_PD|ZN_PDRV0|ZN_PDRV1|ZN_PU|ZN_SL|ZP_CS|ZP_IE|ZP_PD|ZP_PDRV0|ZP_PDRV1|ZP_PU|ZP_SL
+ nfet_06v0 L=1U W=2.5U AS=1.1P AD=1.1P PS=5.88U PD=5.88U
M$1796 \$12720 \$12666
+ VSS|XN_CS|XN_IE|XN_PD|XN_PDRV0|XN_PDRV1|XN_PU|XN_SL|XP_CS|XP_IE|XP_PD|XP_PDRV0|XP_PDRV1|XP_PU|XP_SL|YN_CS|YN_IE|YN_PD|YN_PDRV0|YN_PDRV1|YN_PU|YN_SL|YP_CS|YP_IE|YP_PD|YP_PDRV0|YP_PDRV1|YP_PU|YP_SL|ZN_CS|ZN_IE|ZN_PD|ZN_PDRV0|ZN_PDRV1|ZN_PU|ZN_SL|ZP_CS|ZP_IE|ZP_PD|ZP_PDRV0|ZP_PDRV1|ZP_PU|ZP_SL
+ VSS|XN_CS|XN_IE|XN_PD|XN_PDRV0|XN_PDRV1|XN_PU|XN_SL|XP_CS|XP_IE|XP_PD|XP_PDRV0|XP_PDRV1|XP_PU|XP_SL|YN_CS|YN_IE|YN_PD|YN_PDRV0|YN_PDRV1|YN_PU|YN_SL|YP_CS|YP_IE|YP_PD|YP_PDRV0|YP_PDRV1|YP_PU|YP_SL|ZN_CS|ZN_IE|ZN_PD|ZN_PDRV0|ZN_PDRV1|ZN_PU|ZN_SL|ZP_CS|ZP_IE|ZP_PD|ZP_PDRV0|ZP_PDRV1|ZP_PU|ZP_SL
+ nfet_06v0 L=1U W=5U AS=2.2P AD=1.25P PS=10.88U PD=5.5U
M$1797 \$12668 \$12689 \$12720
+ VSS|XN_CS|XN_IE|XN_PD|XN_PDRV0|XN_PDRV1|XN_PU|XN_SL|XP_CS|XP_IE|XP_PD|XP_PDRV0|XP_PDRV1|XP_PU|XP_SL|YN_CS|YN_IE|YN_PD|YN_PDRV0|YN_PDRV1|YN_PU|YN_SL|YP_CS|YP_IE|YP_PD|YP_PDRV0|YP_PDRV1|YP_PU|YP_SL|ZN_CS|ZN_IE|ZN_PD|ZN_PDRV0|ZN_PDRV1|ZN_PU|ZN_SL|ZP_CS|ZP_IE|ZP_PD|ZP_PDRV0|ZP_PDRV1|ZP_PU|ZP_SL
+ nfet_06v0 L=1U W=5U AS=1.25P AD=2.2P PS=5.5U PD=10.88U
M$1798 \$12719 \$12669
+ VSS|XN_CS|XN_IE|XN_PD|XN_PDRV0|XN_PDRV1|XN_PU|XN_SL|XP_CS|XP_IE|XP_PD|XP_PDRV0|XP_PDRV1|XP_PU|XP_SL|YN_CS|YN_IE|YN_PD|YN_PDRV0|YN_PDRV1|YN_PU|YN_SL|YP_CS|YP_IE|YP_PD|YP_PDRV0|YP_PDRV1|YP_PU|YP_SL|ZN_CS|ZN_IE|ZN_PD|ZN_PDRV0|ZN_PDRV1|ZN_PU|ZN_SL|ZP_CS|ZP_IE|ZP_PD|ZP_PDRV0|ZP_PDRV1|ZP_PU|ZP_SL
+ VSS|XN_CS|XN_IE|XN_PD|XN_PDRV0|XN_PDRV1|XN_PU|XN_SL|XP_CS|XP_IE|XP_PD|XP_PDRV0|XP_PDRV1|XP_PU|XP_SL|YN_CS|YN_IE|YN_PD|YN_PDRV0|YN_PDRV1|YN_PU|YN_SL|YP_CS|YP_IE|YP_PD|YP_PDRV0|YP_PDRV1|YP_PU|YP_SL|ZN_CS|ZN_IE|ZN_PD|ZN_PDRV0|ZN_PDRV1|ZN_PU|ZN_SL|ZP_CS|ZP_IE|ZP_PD|ZP_PDRV0|ZP_PDRV1|ZP_PU|ZP_SL
+ nfet_06v0 L=1U W=5U AS=2.2P AD=1.25P PS=10.88U PD=5.5U
M$1799 \$12669 \$12689 \$12719
+ VSS|XN_CS|XN_IE|XN_PD|XN_PDRV0|XN_PDRV1|XN_PU|XN_SL|XP_CS|XP_IE|XP_PD|XP_PDRV0|XP_PDRV1|XP_PU|XP_SL|YN_CS|YN_IE|YN_PD|YN_PDRV0|YN_PDRV1|YN_PU|YN_SL|YP_CS|YP_IE|YP_PD|YP_PDRV0|YP_PDRV1|YP_PU|YP_SL|ZN_CS|ZN_IE|ZN_PD|ZN_PDRV0|ZN_PDRV1|ZN_PU|ZN_SL|ZP_CS|ZP_IE|ZP_PD|ZP_PDRV0|ZP_PDRV1|ZP_PU|ZP_SL
+ nfet_06v0 L=1U W=5U AS=1.25P AD=1.65P PS=5.5U PD=5.66U
M$1800 \$12710 \$12710 \$12669
+ VSS|XN_CS|XN_IE|XN_PD|XN_PDRV0|XN_PDRV1|XN_PU|XN_SL|XP_CS|XP_IE|XP_PD|XP_PDRV0|XP_PDRV1|XP_PU|XP_SL|YN_CS|YN_IE|YN_PD|YN_PDRV0|YN_PDRV1|YN_PU|YN_SL|YP_CS|YP_IE|YP_PD|YP_PDRV0|YP_PDRV1|YP_PU|YP_SL|ZN_CS|ZN_IE|ZN_PD|ZN_PDRV0|ZN_PDRV1|ZN_PU|ZN_SL|ZP_CS|ZP_IE|ZP_PD|ZP_PDRV0|ZP_PDRV1|ZP_PU|ZP_SL
+ nfet_06v0 L=1U W=5U AS=1.65P AD=2.2P PS=5.66U PD=10.88U
M$1801 \$12697 \$12696
+ VSS|XN_CS|XN_IE|XN_PD|XN_PDRV0|XN_PDRV1|XN_PU|XN_SL|XP_CS|XP_IE|XP_PD|XP_PDRV0|XP_PDRV1|XP_PU|XP_SL|YN_CS|YN_IE|YN_PD|YN_PDRV0|YN_PDRV1|YN_PU|YN_SL|YP_CS|YP_IE|YP_PD|YP_PDRV0|YP_PDRV1|YP_PU|YP_SL|ZN_CS|ZN_IE|ZN_PD|ZN_PDRV0|ZN_PDRV1|ZN_PU|ZN_SL|ZP_CS|ZP_IE|ZP_PD|ZP_PDRV0|ZP_PDRV1|ZP_PU|ZP_SL
+ VSS|XN_CS|XN_IE|XN_PD|XN_PDRV0|XN_PDRV1|XN_PU|XN_SL|XP_CS|XP_IE|XP_PD|XP_PDRV0|XP_PDRV1|XP_PU|XP_SL|YN_CS|YN_IE|YN_PD|YN_PDRV0|YN_PDRV1|YN_PU|YN_SL|YP_CS|YP_IE|YP_PD|YP_PDRV0|YP_PDRV1|YP_PU|YP_SL|ZN_CS|ZN_IE|ZN_PD|ZN_PDRV0|ZN_PDRV1|ZN_PU|ZN_SL|ZP_CS|ZP_IE|ZP_PD|ZP_PDRV0|ZP_PDRV1|ZP_PU|ZP_SL
+ nfet_06v0 L=1U W=5U AS=2.2P AD=1.3P PS=10.88U PD=5.52U
M$1802
+ VSS|XN_CS|XN_IE|XN_PD|XN_PDRV0|XN_PDRV1|XN_PU|XN_SL|XP_CS|XP_IE|XP_PD|XP_PDRV0|XP_PDRV1|XP_PU|XP_SL|YN_CS|YN_IE|YN_PD|YN_PDRV0|YN_PDRV1|YN_PU|YN_SL|YP_CS|YP_IE|YP_PD|YP_PDRV0|YP_PDRV1|YP_PU|YP_SL|ZN_CS|ZN_IE|ZN_PD|ZN_PDRV0|ZN_PDRV1|ZN_PU|ZN_SL|ZP_CS|ZP_IE|ZP_PD|ZP_PDRV0|ZP_PDRV1|ZP_PU|ZP_SL
+ \$12696 \$12697
+ VSS|XN_CS|XN_IE|XN_PD|XN_PDRV0|XN_PDRV1|XN_PU|XN_SL|XP_CS|XP_IE|XP_PD|XP_PDRV0|XP_PDRV1|XP_PU|XP_SL|YN_CS|YN_IE|YN_PD|YN_PDRV0|YN_PDRV1|YN_PU|YN_SL|YP_CS|YP_IE|YP_PD|YP_PDRV0|YP_PDRV1|YP_PU|YP_SL|ZN_CS|ZN_IE|ZN_PD|ZN_PDRV0|ZN_PDRV1|ZN_PU|ZN_SL|ZP_CS|ZP_IE|ZP_PD|ZP_PDRV0|ZP_PDRV1|ZP_PU|ZP_SL
+ nfet_06v0 L=1U W=5U AS=1.3P AD=1.3P PS=5.52U PD=5.52U
M$1803 \$12697 \$12696
+ VSS|XN_CS|XN_IE|XN_PD|XN_PDRV0|XN_PDRV1|XN_PU|XN_SL|XP_CS|XP_IE|XP_PD|XP_PDRV0|XP_PDRV1|XP_PU|XP_SL|YN_CS|YN_IE|YN_PD|YN_PDRV0|YN_PDRV1|YN_PU|YN_SL|YP_CS|YP_IE|YP_PD|YP_PDRV0|YP_PDRV1|YP_PU|YP_SL|ZN_CS|ZN_IE|ZN_PD|ZN_PDRV0|ZN_PDRV1|ZN_PU|ZN_SL|ZP_CS|ZP_IE|ZP_PD|ZP_PDRV0|ZP_PDRV1|ZP_PU|ZP_SL
+ VSS|XN_CS|XN_IE|XN_PD|XN_PDRV0|XN_PDRV1|XN_PU|XN_SL|XP_CS|XP_IE|XP_PD|XP_PDRV0|XP_PDRV1|XP_PU|XP_SL|YN_CS|YN_IE|YN_PD|YN_PDRV0|YN_PDRV1|YN_PU|YN_SL|YP_CS|YP_IE|YP_PD|YP_PDRV0|YP_PDRV1|YP_PU|YP_SL|ZN_CS|ZN_IE|ZN_PD|ZN_PDRV0|ZN_PDRV1|ZN_PU|ZN_SL|ZP_CS|ZP_IE|ZP_PD|ZP_PDRV0|ZP_PDRV1|ZP_PU|ZP_SL
+ nfet_06v0 L=1U W=5U AS=1.3P AD=2.2P PS=5.52U PD=10.88U
M$1804
+ VSS|XN_CS|XN_IE|XN_PD|XN_PDRV0|XN_PDRV1|XN_PU|XN_SL|XP_CS|XP_IE|XP_PD|XP_PDRV0|XP_PDRV1|XP_PU|XP_SL|YN_CS|YN_IE|YN_PD|YN_PDRV0|YN_PDRV1|YN_PU|YN_SL|YP_CS|YP_IE|YP_PD|YP_PDRV0|YP_PDRV1|YP_PU|YP_SL|ZN_CS|ZN_IE|ZN_PD|ZN_PDRV0|ZN_PDRV1|ZN_PU|ZN_SL|ZP_CS|ZP_IE|ZP_PD|ZP_PDRV0|ZP_PDRV1|ZP_PU|ZP_SL
+ VDD|XN_OE|XP_OE|YN_OE|YP_OE|ZN_OE|ZP_OE
+ VSS|XN_CS|XN_IE|XN_PD|XN_PDRV0|XN_PDRV1|XN_PU|XN_SL|XP_CS|XP_IE|XP_PD|XP_PDRV0|XP_PDRV1|XP_PU|XP_SL|YN_CS|YN_IE|YN_PD|YN_PDRV0|YN_PDRV1|YN_PU|YN_SL|YP_CS|YP_IE|YP_PD|YP_PDRV0|YP_PDRV1|YP_PU|YP_SL|ZN_CS|ZN_IE|ZN_PD|ZN_PDRV0|ZN_PDRV1|ZN_PU|ZN_SL|ZP_CS|ZP_IE|ZP_PD|ZP_PDRV0|ZP_PDRV1|ZP_PU|ZP_SL
+ VSS|XN_CS|XN_IE|XN_PD|XN_PDRV0|XN_PDRV1|XN_PU|XN_SL|XP_CS|XP_IE|XP_PD|XP_PDRV0|XP_PDRV1|XP_PU|XP_SL|YN_CS|YN_IE|YN_PD|YN_PDRV0|YN_PDRV1|YN_PU|YN_SL|YP_CS|YP_IE|YP_PD|YP_PDRV0|YP_PDRV1|YP_PU|YP_SL|ZN_CS|ZN_IE|ZN_PD|ZN_PDRV0|ZN_PDRV1|ZN_PU|ZN_SL|ZP_CS|ZP_IE|ZP_PD|ZP_PDRV0|ZP_PDRV1|ZP_PU|ZP_SL
+ nfet_06v0 L=2U W=9.75U AS=4.29P AD=4.29P PS=20.38U PD=20.38U
M$1805
+ VSS|XN_CS|XN_IE|XN_PD|XN_PDRV0|XN_PDRV1|XN_PU|XN_SL|XP_CS|XP_IE|XP_PD|XP_PDRV0|XP_PDRV1|XP_PU|XP_SL|YN_CS|YN_IE|YN_PD|YN_PDRV0|YN_PDRV1|YN_PU|YN_SL|YP_CS|YP_IE|YP_PD|YP_PDRV0|YP_PDRV1|YP_PU|YP_SL|ZN_CS|ZN_IE|ZN_PD|ZN_PDRV0|ZN_PDRV1|ZN_PU|ZN_SL|ZP_CS|ZP_IE|ZP_PD|ZP_PDRV0|ZP_PDRV1|ZP_PU|ZP_SL
+ VDD|XN_OE|XP_OE|YN_OE|YP_OE|ZN_OE|ZP_OE
+ VSS|XN_CS|XN_IE|XN_PD|XN_PDRV0|XN_PDRV1|XN_PU|XN_SL|XP_CS|XP_IE|XP_PD|XP_PDRV0|XP_PDRV1|XP_PU|XP_SL|YN_CS|YN_IE|YN_PD|YN_PDRV0|YN_PDRV1|YN_PU|YN_SL|YP_CS|YP_IE|YP_PD|YP_PDRV0|YP_PDRV1|YP_PU|YP_SL|ZN_CS|ZN_IE|ZN_PD|ZN_PDRV0|ZN_PDRV1|ZN_PU|ZN_SL|ZP_CS|ZP_IE|ZP_PD|ZP_PDRV0|ZP_PDRV1|ZP_PU|ZP_SL
+ VSS|XN_CS|XN_IE|XN_PD|XN_PDRV0|XN_PDRV1|XN_PU|XN_SL|XP_CS|XP_IE|XP_PD|XP_PDRV0|XP_PDRV1|XP_PU|XP_SL|YN_CS|YN_IE|YN_PD|YN_PDRV0|YN_PDRV1|YN_PU|YN_SL|YP_CS|YP_IE|YP_PD|YP_PDRV0|YP_PDRV1|YP_PU|YP_SL|ZN_CS|ZN_IE|ZN_PD|ZN_PDRV0|ZN_PDRV1|ZN_PU|ZN_SL|ZP_CS|ZP_IE|ZP_PD|ZP_PDRV0|ZP_PDRV1|ZP_PU|ZP_SL
+ nfet_06v0 L=2U W=9.75U AS=4.29P AD=4.29P PS=20.38U PD=20.38U
M$1806
+ VSS|XN_CS|XN_IE|XN_PD|XN_PDRV0|XN_PDRV1|XN_PU|XN_SL|XP_CS|XP_IE|XP_PD|XP_PDRV0|XP_PDRV1|XP_PU|XP_SL|YN_CS|YN_IE|YN_PD|YN_PDRV0|YN_PDRV1|YN_PU|YN_SL|YP_CS|YP_IE|YP_PD|YP_PDRV0|YP_PDRV1|YP_PU|YP_SL|ZN_CS|ZN_IE|ZN_PD|ZN_PDRV0|ZN_PDRV1|ZN_PU|ZN_SL|ZP_CS|ZP_IE|ZP_PD|ZP_PDRV0|ZP_PDRV1|ZP_PU|ZP_SL
+ \$12679 \$12670
+ VSS|XN_CS|XN_IE|XN_PD|XN_PDRV0|XN_PDRV1|XN_PU|XN_SL|XP_CS|XP_IE|XP_PD|XP_PDRV0|XP_PDRV1|XP_PU|XP_SL|YN_CS|YN_IE|YN_PD|YN_PDRV0|YN_PDRV1|YN_PU|YN_SL|YP_CS|YP_IE|YP_PD|YP_PDRV0|YP_PDRV1|YP_PU|YP_SL|ZN_CS|ZN_IE|ZN_PD|ZN_PDRV0|ZN_PDRV1|ZN_PU|ZN_SL|ZP_CS|ZP_IE|ZP_PD|ZP_PDRV0|ZP_PDRV1|ZP_PU|ZP_SL
+ nfet_06v0 L=1U W=1U AS=0.44P AD=0.44P PS=2.88U PD=2.88U
M$1807 \$10861 \$10862
+ VSS|XN_CS|XN_IE|XN_PD|XN_PDRV0|XN_PDRV1|XN_PU|XN_SL|XP_CS|XP_IE|XP_PD|XP_PDRV0|XP_PDRV1|XP_PU|XP_SL|YN_CS|YN_IE|YN_PD|YN_PDRV0|YN_PDRV1|YN_PU|YN_SL|YP_CS|YP_IE|YP_PD|YP_PDRV0|YP_PDRV1|YP_PU|YP_SL|ZN_CS|ZN_IE|ZN_PD|ZN_PDRV0|ZN_PDRV1|ZN_PU|ZN_SL|ZP_CS|ZP_IE|ZP_PD|ZP_PDRV0|ZP_PDRV1|ZP_PU|ZP_SL
+ VSS|XN_CS|XN_IE|XN_PD|XN_PDRV0|XN_PDRV1|XN_PU|XN_SL|XP_CS|XP_IE|XP_PD|XP_PDRV0|XP_PDRV1|XP_PU|XP_SL|YN_CS|YN_IE|YN_PD|YN_PDRV0|YN_PDRV1|YN_PU|YN_SL|YP_CS|YP_IE|YP_PD|YP_PDRV0|YP_PDRV1|YP_PU|YP_SL|ZN_CS|ZN_IE|ZN_PD|ZN_PDRV0|ZN_PDRV1|ZN_PU|ZN_SL|ZP_CS|ZP_IE|ZP_PD|ZP_PDRV0|ZP_PDRV1|ZP_PU|ZP_SL
+ nfet_06v0 L=1U W=1.24U AS=0.5456P AD=0.5456P PS=3.36U PD=3.36U
M$1808 Z \$10945 \$10878
+ VSS|XN_CS|XN_IE|XN_PD|XN_PDRV0|XN_PDRV1|XN_PU|XN_SL|XP_CS|XP_IE|XP_PD|XP_PDRV0|XP_PDRV1|XP_PU|XP_SL|YN_CS|YN_IE|YN_PD|YN_PDRV0|YN_PDRV1|YN_PU|YN_SL|YP_CS|YP_IE|YP_PD|YP_PDRV0|YP_PDRV1|YP_PU|YP_SL|ZN_CS|ZN_IE|ZN_PD|ZN_PDRV0|ZN_PDRV1|ZN_PU|ZN_SL|ZP_CS|ZP_IE|ZP_PD|ZP_PDRV0|ZP_PDRV1|ZP_PU|ZP_SL
+ nfet_06v0 L=1U W=2.48U AS=1.0912P AD=0.6448P PS=5.84U PD=3U
M$1809 \$10878 \$10945 Z
+ VSS|XN_CS|XN_IE|XN_PD|XN_PDRV0|XN_PDRV1|XN_PU|XN_SL|XP_CS|XP_IE|XP_PD|XP_PDRV0|XP_PDRV1|XP_PU|XP_SL|YN_CS|YN_IE|YN_PD|YN_PDRV0|YN_PDRV1|YN_PU|YN_SL|YP_CS|YP_IE|YP_PD|YP_PDRV0|YP_PDRV1|YP_PU|YP_SL|ZN_CS|ZN_IE|ZN_PD|ZN_PDRV0|ZN_PDRV1|ZN_PU|ZN_SL|ZP_CS|ZP_IE|ZP_PD|ZP_PDRV0|ZP_PDRV1|ZP_PU|ZP_SL
+ nfet_06v0 L=1U W=2.48U AS=0.6448P AD=1.0912P PS=3U PD=5.84U
M$1810
+ VSS|XN_CS|XN_IE|XN_PD|XN_PDRV0|XN_PDRV1|XN_PU|XN_SL|XP_CS|XP_IE|XP_PD|XP_PDRV0|XP_PDRV1|XP_PU|XP_SL|YN_CS|YN_IE|YN_PD|YN_PDRV0|YN_PDRV1|YN_PU|YN_SL|YP_CS|YP_IE|YP_PD|YP_PDRV0|YP_PDRV1|YP_PU|YP_SL|ZN_CS|ZN_IE|ZN_PD|ZN_PDRV0|ZN_PDRV1|ZN_PU|ZN_SL|ZP_CS|ZP_IE|ZP_PD|ZP_PDRV0|ZP_PDRV1|ZP_PU|ZP_SL
+ \$12698 \$9147
+ VSS|XN_CS|XN_IE|XN_PD|XN_PDRV0|XN_PDRV1|XN_PU|XN_SL|XP_CS|XP_IE|XP_PD|XP_PDRV0|XP_PDRV1|XP_PU|XP_SL|YN_CS|YN_IE|YN_PD|YN_PDRV0|YN_PDRV1|YN_PU|YN_SL|YP_CS|YP_IE|YP_PD|YP_PDRV0|YP_PDRV1|YP_PU|YP_SL|ZN_CS|ZN_IE|ZN_PD|ZN_PDRV0|ZN_PDRV1|ZN_PU|ZN_SL|ZP_CS|ZP_IE|ZP_PD|ZP_PDRV0|ZP_PDRV1|ZP_PU|ZP_SL
+ nfet_06v0 L=1U W=1U AS=0.44P AD=0.44P PS=2.88U PD=2.88U
M$1811 \$10878 \$10862
+ VSS|XN_CS|XN_IE|XN_PD|XN_PDRV0|XN_PDRV1|XN_PU|XN_SL|XP_CS|XP_IE|XP_PD|XP_PDRV0|XP_PDRV1|XP_PU|XP_SL|YN_CS|YN_IE|YN_PD|YN_PDRV0|YN_PDRV1|YN_PU|YN_SL|YP_CS|YP_IE|YP_PD|YP_PDRV0|YP_PDRV1|YP_PU|YP_SL|ZN_CS|ZN_IE|ZN_PD|ZN_PDRV0|ZN_PDRV1|ZN_PU|ZN_SL|ZP_CS|ZP_IE|ZP_PD|ZP_PDRV0|ZP_PDRV1|ZP_PU|ZP_SL
+ VSS|XN_CS|XN_IE|XN_PD|XN_PDRV0|XN_PDRV1|XN_PU|XN_SL|XP_CS|XP_IE|XP_PD|XP_PDRV0|XP_PDRV1|XP_PU|XP_SL|YN_CS|YN_IE|YN_PD|YN_PDRV0|YN_PDRV1|YN_PU|YN_SL|YP_CS|YP_IE|YP_PD|YP_PDRV0|YP_PDRV1|YP_PU|YP_SL|ZN_CS|ZN_IE|ZN_PD|ZN_PDRV0|ZN_PDRV1|ZN_PU|ZN_SL|ZP_CS|ZP_IE|ZP_PD|ZP_PDRV0|ZP_PDRV1|ZP_PU|ZP_SL
+ nfet_06v0 L=1U W=1.24U AS=0.5456P AD=0.5456P PS=3.36U PD=3.36U
M$1812 \$12703 \$12670 \$12698
+ VSS|XN_CS|XN_IE|XN_PD|XN_PDRV0|XN_PDRV1|XN_PU|XN_SL|XP_CS|XP_IE|XP_PD|XP_PDRV0|XP_PDRV1|XP_PU|XP_SL|YN_CS|YN_IE|YN_PD|YN_PDRV0|YN_PDRV1|YN_PU|YN_SL|YP_CS|YP_IE|YP_PD|YP_PDRV0|YP_PDRV1|YP_PU|YP_SL|ZN_CS|ZN_IE|ZN_PD|ZN_PDRV0|ZN_PDRV1|ZN_PU|ZN_SL|ZP_CS|ZP_IE|ZP_PD|ZP_PDRV0|ZP_PDRV1|ZP_PU|ZP_SL
+ nfet_06v0 L=1U W=1U AS=0.44P AD=0.25P PS=2.88U PD=1.5U
M$1813
+ VSS|XN_CS|XN_IE|XN_PD|XN_PDRV0|XN_PDRV1|XN_PU|XN_SL|XP_CS|XP_IE|XP_PD|XP_PDRV0|XP_PDRV1|XP_PU|XP_SL|YN_CS|YN_IE|YN_PD|YN_PDRV0|YN_PDRV1|YN_PU|YN_SL|YP_CS|YP_IE|YP_PD|YP_PDRV0|YP_PDRV1|YP_PU|YP_SL|ZN_CS|ZN_IE|ZN_PD|ZN_PDRV0|ZN_PDRV1|ZN_PU|ZN_SL|ZP_CS|ZP_IE|ZP_PD|ZP_PDRV0|ZP_PDRV1|ZP_PU|ZP_SL
+ \$12697 \$12703
+ VSS|XN_CS|XN_IE|XN_PD|XN_PDRV0|XN_PDRV1|XN_PU|XN_SL|XP_CS|XP_IE|XP_PD|XP_PDRV0|XP_PDRV1|XP_PU|XP_SL|YN_CS|YN_IE|YN_PD|YN_PDRV0|YN_PDRV1|YN_PU|YN_SL|YP_CS|YP_IE|YP_PD|YP_PDRV0|YP_PDRV1|YP_PU|YP_SL|ZN_CS|ZN_IE|ZN_PD|ZN_PDRV0|ZN_PDRV1|ZN_PU|ZN_SL|ZP_CS|ZP_IE|ZP_PD|ZP_PDRV0|ZP_PDRV1|ZP_PU|ZP_SL
+ nfet_06v0 L=1U W=1U AS=0.25P AD=0.44P PS=1.5U PD=2.88U
M$1814 Z \$9107 \$10958
+ VSS|XN_CS|XN_IE|XN_PD|XN_PDRV0|XN_PDRV1|XN_PU|XN_SL|XP_CS|XP_IE|XP_PD|XP_PDRV0|XP_PDRV1|XP_PU|XP_SL|YN_CS|YN_IE|YN_PD|YN_PDRV0|YN_PDRV1|YN_PU|YN_SL|YP_CS|YP_IE|YP_PD|YP_PDRV0|YP_PDRV1|YP_PU|YP_SL|ZN_CS|ZN_IE|ZN_PD|ZN_PDRV0|ZN_PDRV1|ZN_PU|ZN_SL|ZP_CS|ZP_IE|ZP_PD|ZP_PDRV0|ZP_PDRV1|ZP_PU|ZP_SL
+ nfet_06v0 L=1U W=2.48U AS=1.0912P AD=0.6448P PS=5.84U PD=3U
M$1815 \$10958 \$9107 Z
+ VSS|XN_CS|XN_IE|XN_PD|XN_PDRV0|XN_PDRV1|XN_PU|XN_SL|XP_CS|XP_IE|XP_PD|XP_PDRV0|XP_PDRV1|XP_PU|XP_SL|YN_CS|YN_IE|YN_PD|YN_PDRV0|YN_PDRV1|YN_PU|YN_SL|YP_CS|YP_IE|YP_PD|YP_PDRV0|YP_PDRV1|YP_PU|YP_SL|ZN_CS|ZN_IE|ZN_PD|ZN_PDRV0|ZN_PDRV1|ZN_PU|ZN_SL|ZP_CS|ZP_IE|ZP_PD|ZP_PDRV0|ZP_PDRV1|ZP_PU|ZP_SL
+ nfet_06v0 L=1U W=2.48U AS=0.6448P AD=1.0912P PS=3U PD=5.84U
M$1816 \$10922 \$10862
+ VSS|XN_CS|XN_IE|XN_PD|XN_PDRV0|XN_PDRV1|XN_PU|XN_SL|XP_CS|XP_IE|XP_PD|XP_PDRV0|XP_PDRV1|XP_PU|XP_SL|YN_CS|YN_IE|YN_PD|YN_PDRV0|YN_PDRV1|YN_PU|YN_SL|YP_CS|YP_IE|YP_PD|YP_PDRV0|YP_PDRV1|YP_PU|YP_SL|ZN_CS|ZN_IE|ZN_PD|ZN_PDRV0|ZN_PDRV1|ZN_PU|ZN_SL|ZP_CS|ZP_IE|ZP_PD|ZP_PDRV0|ZP_PDRV1|ZP_PU|ZP_SL
+ VSS|XN_CS|XN_IE|XN_PD|XN_PDRV0|XN_PDRV1|XN_PU|XN_SL|XP_CS|XP_IE|XP_PD|XP_PDRV0|XP_PDRV1|XP_PU|XP_SL|YN_CS|YN_IE|YN_PD|YN_PDRV0|YN_PDRV1|YN_PU|YN_SL|YP_CS|YP_IE|YP_PD|YP_PDRV0|YP_PDRV1|YP_PU|YP_SL|ZN_CS|ZN_IE|ZN_PD|ZN_PDRV0|ZN_PDRV1|ZN_PU|ZN_SL|ZP_CS|ZP_IE|ZP_PD|ZP_PDRV0|ZP_PDRV1|ZP_PU|ZP_SL
+ nfet_06v0 L=1U W=0.7U AS=0.308P AD=0.175P PS=2.28U PD=1.2U
M$1817 \$10921 \$10862 \$10922
+ VSS|XN_CS|XN_IE|XN_PD|XN_PDRV0|XN_PDRV1|XN_PU|XN_SL|XP_CS|XP_IE|XP_PD|XP_PDRV0|XP_PDRV1|XP_PU|XP_SL|YN_CS|YN_IE|YN_PD|YN_PDRV0|YN_PDRV1|YN_PU|YN_SL|YP_CS|YP_IE|YP_PD|YP_PDRV0|YP_PDRV1|YP_PU|YP_SL|ZN_CS|ZN_IE|ZN_PD|ZN_PDRV0|ZN_PDRV1|ZN_PU|ZN_SL|ZP_CS|ZP_IE|ZP_PD|ZP_PDRV0|ZP_PDRV1|ZP_PU|ZP_SL
+ nfet_06v0 L=1U W=0.7U AS=0.175P AD=0.175P PS=1.2U PD=1.2U
M$1818 \$10923 \$10862 \$10921
+ VSS|XN_CS|XN_IE|XN_PD|XN_PDRV0|XN_PDRV1|XN_PU|XN_SL|XP_CS|XP_IE|XP_PD|XP_PDRV0|XP_PDRV1|XP_PU|XP_SL|YN_CS|YN_IE|YN_PD|YN_PDRV0|YN_PDRV1|YN_PU|YN_SL|YP_CS|YP_IE|YP_PD|YP_PDRV0|YP_PDRV1|YP_PU|YP_SL|ZN_CS|ZN_IE|ZN_PD|ZN_PDRV0|ZN_PDRV1|ZN_PU|ZN_SL|ZP_CS|ZP_IE|ZP_PD|ZP_PDRV0|ZP_PDRV1|ZP_PU|ZP_SL
+ nfet_06v0 L=1U W=0.7U AS=0.175P AD=0.175P PS=1.2U PD=1.2U
M$1819 \$10862 \$10862 \$10923
+ VSS|XN_CS|XN_IE|XN_PD|XN_PDRV0|XN_PDRV1|XN_PU|XN_SL|XP_CS|XP_IE|XP_PD|XP_PDRV0|XP_PDRV1|XP_PU|XP_SL|YN_CS|YN_IE|YN_PD|YN_PDRV0|YN_PDRV1|YN_PU|YN_SL|YP_CS|YP_IE|YP_PD|YP_PDRV0|YP_PDRV1|YP_PU|YP_SL|ZN_CS|ZN_IE|ZN_PD|ZN_PDRV0|ZN_PDRV1|ZN_PU|ZN_SL|ZP_CS|ZP_IE|ZP_PD|ZP_PDRV0|ZP_PDRV1|ZP_PU|ZP_SL
+ nfet_06v0 L=1U W=0.7U AS=0.175P AD=0.308P PS=1.2U PD=2.28U
M$1820 \$10945 \$12697
+ VSS|XN_CS|XN_IE|XN_PD|XN_PDRV0|XN_PDRV1|XN_PU|XN_SL|XP_CS|XP_IE|XP_PD|XP_PDRV0|XP_PDRV1|XP_PU|XP_SL|YN_CS|YN_IE|YN_PD|YN_PDRV0|YN_PDRV1|YN_PU|YN_SL|YP_CS|YP_IE|YP_PD|YP_PDRV0|YP_PDRV1|YP_PU|YP_SL|ZN_CS|ZN_IE|ZN_PD|ZN_PDRV0|ZN_PDRV1|ZN_PU|ZN_SL|ZP_CS|ZP_IE|ZP_PD|ZP_PDRV0|ZP_PDRV1|ZP_PU|ZP_SL
+ VSS|XN_CS|XN_IE|XN_PD|XN_PDRV0|XN_PDRV1|XN_PU|XN_SL|XP_CS|XP_IE|XP_PD|XP_PDRV0|XP_PDRV1|XP_PU|XP_SL|YN_CS|YN_IE|YN_PD|YN_PDRV0|YN_PDRV1|YN_PU|YN_SL|YP_CS|YP_IE|YP_PD|YP_PDRV0|YP_PDRV1|YP_PU|YP_SL|ZN_CS|ZN_IE|ZN_PD|ZN_PDRV0|ZN_PDRV1|ZN_PU|ZN_SL|ZP_CS|ZP_IE|ZP_PD|ZP_PDRV0|ZP_PDRV1|ZP_PU|ZP_SL
+ nfet_06v0 L=1U W=1U AS=0.44P AD=0.33P PS=2.88U PD=1.66U
M$1821
+ VSS|XN_CS|XN_IE|XN_PD|XN_PDRV0|XN_PDRV1|XN_PU|XN_SL|XP_CS|XP_IE|XP_PD|XP_PDRV0|XP_PDRV1|XP_PU|XP_SL|YN_CS|YN_IE|YN_PD|YN_PDRV0|YN_PDRV1|YN_PU|YN_SL|YP_CS|YP_IE|YP_PD|YP_PDRV0|YP_PDRV1|YP_PU|YP_SL|ZN_CS|ZN_IE|ZN_PD|ZN_PDRV0|ZN_PDRV1|ZN_PU|ZN_SL|ZP_CS|ZP_IE|ZP_PD|ZP_PDRV0|ZP_PDRV1|ZP_PU|ZP_SL
+ \$12688 \$10945
+ VSS|XN_CS|XN_IE|XN_PD|XN_PDRV0|XN_PDRV1|XN_PU|XN_SL|XP_CS|XP_IE|XP_PD|XP_PDRV0|XP_PDRV1|XP_PU|XP_SL|YN_CS|YN_IE|YN_PD|YN_PDRV0|YN_PDRV1|YN_PU|YN_SL|YP_CS|YP_IE|YP_PD|YP_PDRV0|YP_PDRV1|YP_PU|YP_SL|ZN_CS|ZN_IE|ZN_PD|ZN_PDRV0|ZN_PDRV1|ZN_PU|ZN_SL|ZP_CS|ZP_IE|ZP_PD|ZP_PDRV0|ZP_PDRV1|ZP_PU|ZP_SL
+ nfet_06v0 L=1U W=1U AS=0.33P AD=0.44P PS=1.66U PD=2.88U
M$1822 \$10958 \$10862
+ VSS|XN_CS|XN_IE|XN_PD|XN_PDRV0|XN_PDRV1|XN_PU|XN_SL|XP_CS|XP_IE|XP_PD|XP_PDRV0|XP_PDRV1|XP_PU|XP_SL|YN_CS|YN_IE|YN_PD|YN_PDRV0|YN_PDRV1|YN_PU|YN_SL|YP_CS|YP_IE|YP_PD|YP_PDRV0|YP_PDRV1|YP_PU|YP_SL|ZN_CS|ZN_IE|ZN_PD|ZN_PDRV0|ZN_PDRV1|ZN_PU|ZN_SL|ZP_CS|ZP_IE|ZP_PD|ZP_PDRV0|ZP_PDRV1|ZP_PU|ZP_SL
+ VSS|XN_CS|XN_IE|XN_PD|XN_PDRV0|XN_PDRV1|XN_PU|XN_SL|XP_CS|XP_IE|XP_PD|XP_PDRV0|XP_PDRV1|XP_PU|XP_SL|YN_CS|YN_IE|YN_PD|YN_PDRV0|YN_PDRV1|YN_PU|YN_SL|YP_CS|YP_IE|YP_PD|YP_PDRV0|YP_PDRV1|YP_PU|YP_SL|ZN_CS|ZN_IE|ZN_PD|ZN_PDRV0|ZN_PDRV1|ZN_PU|ZN_SL|ZP_CS|ZP_IE|ZP_PD|ZP_PDRV0|ZP_PDRV1|ZP_PU|ZP_SL
+ nfet_06v0 L=1U W=1.24U AS=0.5456P AD=0.5456P PS=3.36U PD=3.36U
M$1823 Z Z \$10959
+ VSS|XN_CS|XN_IE|XN_PD|XN_PDRV0|XN_PDRV1|XN_PU|XN_SL|XP_CS|XP_IE|XP_PD|XP_PDRV0|XP_PDRV1|XP_PU|XP_SL|YN_CS|YN_IE|YN_PD|YN_PDRV0|YN_PDRV1|YN_PU|YN_SL|YP_CS|YP_IE|YP_PD|YP_PDRV0|YP_PDRV1|YP_PU|YP_SL|ZN_CS|ZN_IE|ZN_PD|ZN_PDRV0|ZN_PDRV1|ZN_PU|ZN_SL|ZP_CS|ZP_IE|ZP_PD|ZP_PDRV0|ZP_PDRV1|ZP_PU|ZP_SL
+ nfet_06v0 L=1U W=2U AS=0.88P AD=0.52P PS=4.88U PD=2.52U
M$1824 \$10959 Z Z
+ VSS|XN_CS|XN_IE|XN_PD|XN_PDRV0|XN_PDRV1|XN_PU|XN_SL|XP_CS|XP_IE|XP_PD|XP_PDRV0|XP_PDRV1|XP_PU|XP_SL|YN_CS|YN_IE|YN_PD|YN_PDRV0|YN_PDRV1|YN_PU|YN_SL|YP_CS|YP_IE|YP_PD|YP_PDRV0|YP_PDRV1|YP_PU|YP_SL|ZN_CS|ZN_IE|ZN_PD|ZN_PDRV0|ZN_PDRV1|ZN_PU|ZN_SL|ZP_CS|ZP_IE|ZP_PD|ZP_PDRV0|ZP_PDRV1|ZP_PU|ZP_SL
+ nfet_06v0 L=1U W=2U AS=0.52P AD=0.88P PS=2.52U PD=4.88U
M$1825
+ VSS|XN_CS|XN_IE|XN_PD|XN_PDRV0|XN_PDRV1|XN_PU|XN_SL|XP_CS|XP_IE|XP_PD|XP_PDRV0|XP_PDRV1|XP_PU|XP_SL|YN_CS|YN_IE|YN_PD|YN_PDRV0|YN_PDRV1|YN_PU|YN_SL|YP_CS|YP_IE|YP_PD|YP_PDRV0|YP_PDRV1|YP_PU|YP_SL|ZN_CS|ZN_IE|ZN_PD|ZN_PDRV0|ZN_PDRV1|ZN_PU|ZN_SL|ZP_CS|ZP_IE|ZP_PD|ZP_PDRV0|ZP_PDRV1|ZP_PU|ZP_SL
+ \$12699 \$7344
+ VSS|XN_CS|XN_IE|XN_PD|XN_PDRV0|XN_PDRV1|XN_PU|XN_SL|XP_CS|XP_IE|XP_PD|XP_PDRV0|XP_PDRV1|XP_PU|XP_SL|YN_CS|YN_IE|YN_PD|YN_PDRV0|YN_PDRV1|YN_PU|YN_SL|YP_CS|YP_IE|YP_PD|YP_PDRV0|YP_PDRV1|YP_PU|YP_SL|ZN_CS|ZN_IE|ZN_PD|ZN_PDRV0|ZN_PDRV1|ZN_PU|ZN_SL|ZP_CS|ZP_IE|ZP_PD|ZP_PDRV0|ZP_PDRV1|ZP_PU|ZP_SL
+ nfet_06v0 L=1U W=1U AS=0.44P AD=0.44P PS=2.88U PD=2.88U
M$1826 Z VDD|XN_OE|XP_OE|YN_OE|YP_OE|ZN_OE|ZP_OE \$10863
+ VSS|XN_CS|XN_IE|XN_PD|XN_PDRV0|XN_PDRV1|XN_PU|XN_SL|XP_CS|XP_IE|XP_PD|XP_PDRV0|XP_PDRV1|XP_PU|XP_SL|YN_CS|YN_IE|YN_PD|YN_PDRV0|YN_PDRV1|YN_PU|YN_SL|YP_CS|YP_IE|YP_PD|YP_PDRV0|YP_PDRV1|YP_PU|YP_SL|ZN_CS|ZN_IE|ZN_PD|ZN_PDRV0|ZN_PDRV1|ZN_PU|ZN_SL|ZP_CS|ZP_IE|ZP_PD|ZP_PDRV0|ZP_PDRV1|ZP_PU|ZP_SL
+ nfet_06v0 L=1U W=2.48U AS=1.0912P AD=0.6448P PS=5.84U PD=3U
M$1827 \$10863 VDD|XN_OE|XP_OE|YN_OE|YP_OE|ZN_OE|ZP_OE Z
+ VSS|XN_CS|XN_IE|XN_PD|XN_PDRV0|XN_PDRV1|XN_PU|XN_SL|XP_CS|XP_IE|XP_PD|XP_PDRV0|XP_PDRV1|XP_PU|XP_SL|YN_CS|YN_IE|YN_PD|YN_PDRV0|YN_PDRV1|YN_PU|YN_SL|YP_CS|YP_IE|YP_PD|YP_PDRV0|YP_PDRV1|YP_PU|YP_SL|ZN_CS|ZN_IE|ZN_PD|ZN_PDRV0|ZN_PDRV1|ZN_PU|ZN_SL|ZP_CS|ZP_IE|ZP_PD|ZP_PDRV0|ZP_PDRV1|ZP_PU|ZP_SL
+ nfet_06v0 L=1U W=2.48U AS=0.6448P AD=1.0912P PS=3U PD=5.84U
M$1828 \$12700 \$12688 \$12699
+ VSS|XN_CS|XN_IE|XN_PD|XN_PDRV0|XN_PDRV1|XN_PU|XN_SL|XP_CS|XP_IE|XP_PD|XP_PDRV0|XP_PDRV1|XP_PU|XP_SL|YN_CS|YN_IE|YN_PD|YN_PDRV0|YN_PDRV1|YN_PU|YN_SL|YP_CS|YP_IE|YP_PD|YP_PDRV0|YP_PDRV1|YP_PU|YP_SL|ZN_CS|ZN_IE|ZN_PD|ZN_PDRV0|ZN_PDRV1|ZN_PU|ZN_SL|ZP_CS|ZP_IE|ZP_PD|ZP_PDRV0|ZP_PDRV1|ZP_PU|ZP_SL
+ nfet_06v0 L=1U W=1U AS=0.44P AD=0.25P PS=2.88U PD=1.5U
M$1829
+ VSS|XN_CS|XN_IE|XN_PD|XN_PDRV0|XN_PDRV1|XN_PU|XN_SL|XP_CS|XP_IE|XP_PD|XP_PDRV0|XP_PDRV1|XP_PU|XP_SL|YN_CS|YN_IE|YN_PD|YN_PDRV0|YN_PDRV1|YN_PU|YN_SL|YP_CS|YP_IE|YP_PD|YP_PDRV0|YP_PDRV1|YP_PU|YP_SL|ZN_CS|ZN_IE|ZN_PD|ZN_PDRV0|ZN_PDRV1|ZN_PU|ZN_SL|ZP_CS|ZP_IE|ZP_PD|ZP_PDRV0|ZP_PDRV1|ZP_PU|ZP_SL
+ \$12679 \$12700
+ VSS|XN_CS|XN_IE|XN_PD|XN_PDRV0|XN_PDRV1|XN_PU|XN_SL|XP_CS|XP_IE|XP_PD|XP_PDRV0|XP_PDRV1|XP_PU|XP_SL|YN_CS|YN_IE|YN_PD|YN_PDRV0|YN_PDRV1|YN_PU|YN_SL|YP_CS|YP_IE|YP_PD|YP_PDRV0|YP_PDRV1|YP_PU|YP_SL|ZN_CS|ZN_IE|ZN_PD|ZN_PDRV0|ZN_PDRV1|ZN_PU|ZN_SL|ZP_CS|ZP_IE|ZP_PD|ZP_PDRV0|ZP_PDRV1|ZP_PU|ZP_SL
+ nfet_06v0 L=1U W=1U AS=0.25P AD=0.44P PS=1.5U PD=2.88U
M$1830 \$10961 Z
+ VSS|XN_CS|XN_IE|XN_PD|XN_PDRV0|XN_PDRV1|XN_PU|XN_SL|XP_CS|XP_IE|XP_PD|XP_PDRV0|XP_PDRV1|XP_PU|XP_SL|YN_CS|YN_IE|YN_PD|YN_PDRV0|YN_PDRV1|YN_PU|YN_SL|YP_CS|YP_IE|YP_PD|YP_PDRV0|YP_PDRV1|YP_PU|YP_SL|ZN_CS|ZN_IE|ZN_PD|ZN_PDRV0|ZN_PDRV1|ZN_PU|ZN_SL|ZP_CS|ZP_IE|ZP_PD|ZP_PDRV0|ZP_PDRV1|ZP_PU|ZP_SL
+ VSS|XN_CS|XN_IE|XN_PD|XN_PDRV0|XN_PDRV1|XN_PU|XN_SL|XP_CS|XP_IE|XP_PD|XP_PDRV0|XP_PDRV1|XP_PU|XP_SL|YN_CS|YN_IE|YN_PD|YN_PDRV0|YN_PDRV1|YN_PU|YN_SL|YP_CS|YP_IE|YP_PD|YP_PDRV0|YP_PDRV1|YP_PU|YP_SL|ZN_CS|ZN_IE|ZN_PD|ZN_PDRV0|ZN_PDRV1|ZN_PU|ZN_SL|ZP_CS|ZP_IE|ZP_PD|ZP_PDRV0|ZP_PDRV1|ZP_PU|ZP_SL
+ nfet_06v0 L=1U W=2U AS=0.88P AD=0.5P PS=4.88U PD=2.5U
M$1831 \$10959 Z \$10961
+ VSS|XN_CS|XN_IE|XN_PD|XN_PDRV0|XN_PDRV1|XN_PU|XN_SL|XP_CS|XP_IE|XP_PD|XP_PDRV0|XP_PDRV1|XP_PU|XP_SL|YN_CS|YN_IE|YN_PD|YN_PDRV0|YN_PDRV1|YN_PU|YN_SL|YP_CS|YP_IE|YP_PD|YP_PDRV0|YP_PDRV1|YP_PU|YP_SL|ZN_CS|ZN_IE|ZN_PD|ZN_PDRV0|ZN_PDRV1|ZN_PU|ZN_SL|ZP_CS|ZP_IE|ZP_PD|ZP_PDRV0|ZP_PDRV1|ZP_PU|ZP_SL
+ nfet_06v0 L=1U W=2U AS=0.5P AD=0.88P PS=2.5U PD=4.88U
M$1832 \$10863 \$10862
+ VSS|XN_CS|XN_IE|XN_PD|XN_PDRV0|XN_PDRV1|XN_PU|XN_SL|XP_CS|XP_IE|XP_PD|XP_PDRV0|XP_PDRV1|XP_PU|XP_SL|YN_CS|YN_IE|YN_PD|YN_PDRV0|YN_PDRV1|YN_PU|YN_SL|YP_CS|YP_IE|YP_PD|YP_PDRV0|YP_PDRV1|YP_PU|YP_SL|ZN_CS|ZN_IE|ZN_PD|ZN_PDRV0|ZN_PDRV1|ZN_PU|ZN_SL|ZP_CS|ZP_IE|ZP_PD|ZP_PDRV0|ZP_PDRV1|ZP_PU|ZP_SL
+ VSS|XN_CS|XN_IE|XN_PD|XN_PDRV0|XN_PDRV1|XN_PU|XN_SL|XP_CS|XP_IE|XP_PD|XP_PDRV0|XP_PDRV1|XP_PU|XP_SL|YN_CS|YN_IE|YN_PD|YN_PDRV0|YN_PDRV1|YN_PU|YN_SL|YP_CS|YP_IE|YP_PD|YP_PDRV0|YP_PDRV1|YP_PU|YP_SL|ZN_CS|ZN_IE|ZN_PD|ZN_PDRV0|ZN_PDRV1|ZN_PU|ZN_SL|ZP_CS|ZP_IE|ZP_PD|ZP_PDRV0|ZP_PDRV1|ZP_PU|ZP_SL
+ nfet_06v0 L=1U W=1.24U AS=0.5456P AD=0.5456P PS=3.36U PD=3.36U
M$1833 Z \$7305 \$10960
+ VSS|XN_CS|XN_IE|XN_PD|XN_PDRV0|XN_PDRV1|XN_PU|XN_SL|XP_CS|XP_IE|XP_PD|XP_PDRV0|XP_PDRV1|XP_PU|XP_SL|YN_CS|YN_IE|YN_PD|YN_PDRV0|YN_PDRV1|YN_PU|YN_SL|YP_CS|YP_IE|YP_PD|YP_PDRV0|YP_PDRV1|YP_PU|YP_SL|ZN_CS|ZN_IE|ZN_PD|ZN_PDRV0|ZN_PDRV1|ZN_PU|ZN_SL|ZP_CS|ZP_IE|ZP_PD|ZP_PDRV0|ZP_PDRV1|ZP_PU|ZP_SL
+ nfet_06v0 L=1U W=2.48U AS=1.0912P AD=0.6448P PS=5.84U PD=3U
M$1834 \$10960 \$7305 Z
+ VSS|XN_CS|XN_IE|XN_PD|XN_PDRV0|XN_PDRV1|XN_PU|XN_SL|XP_CS|XP_IE|XP_PD|XP_PDRV0|XP_PDRV1|XP_PU|XP_SL|YN_CS|YN_IE|YN_PD|YN_PDRV0|YN_PDRV1|YN_PU|YN_SL|YP_CS|YP_IE|YP_PD|YP_PDRV0|YP_PDRV1|YP_PU|YP_SL|ZN_CS|ZN_IE|ZN_PD|ZN_PDRV0|ZN_PDRV1|ZN_PU|ZN_SL|ZP_CS|ZP_IE|ZP_PD|ZP_PDRV0|ZP_PDRV1|ZP_PU|ZP_SL
+ nfet_06v0 L=1U W=2.48U AS=0.6448P AD=1.0912P PS=3U PD=5.84U
M$1835 \$10960 \$10862
+ VSS|XN_CS|XN_IE|XN_PD|XN_PDRV0|XN_PDRV1|XN_PU|XN_SL|XP_CS|XP_IE|XP_PD|XP_PDRV0|XP_PDRV1|XP_PU|XP_SL|YN_CS|YN_IE|YN_PD|YN_PDRV0|YN_PDRV1|YN_PU|YN_SL|YP_CS|YP_IE|YP_PD|YP_PDRV0|YP_PDRV1|YP_PU|YP_SL|ZN_CS|ZN_IE|ZN_PD|ZN_PDRV0|ZN_PDRV1|ZN_PU|ZN_SL|ZP_CS|ZP_IE|ZP_PD|ZP_PDRV0|ZP_PDRV1|ZP_PU|ZP_SL
+ VSS|XN_CS|XN_IE|XN_PD|XN_PDRV0|XN_PDRV1|XN_PU|XN_SL|XP_CS|XP_IE|XP_PD|XP_PDRV0|XP_PDRV1|XP_PU|XP_SL|YN_CS|YN_IE|YN_PD|YN_PDRV0|YN_PDRV1|YN_PU|YN_SL|YP_CS|YP_IE|YP_PD|YP_PDRV0|YP_PDRV1|YP_PU|YP_SL|ZN_CS|ZN_IE|ZN_PD|ZN_PDRV0|ZN_PDRV1|ZN_PU|ZN_SL|ZP_CS|ZP_IE|ZP_PD|ZP_PDRV0|ZP_PDRV1|ZP_PU|ZP_SL
+ nfet_06v0 L=1U W=1.24U AS=0.5456P AD=0.5456P PS=3.36U PD=3.36U
M$1836 Z \$10920 \$10861
+ VSS|XN_CS|XN_IE|XN_PD|XN_PDRV0|XN_PDRV1|XN_PU|XN_SL|XP_CS|XP_IE|XP_PD|XP_PDRV0|XP_PDRV1|XP_PU|XP_SL|YN_CS|YN_IE|YN_PD|YN_PDRV0|YN_PDRV1|YN_PU|YN_SL|YP_CS|YP_IE|YP_PD|YP_PDRV0|YP_PDRV1|YP_PU|YP_SL|ZN_CS|ZN_IE|ZN_PD|ZN_PDRV0|ZN_PDRV1|ZN_PU|ZN_SL|ZP_CS|ZP_IE|ZP_PD|ZP_PDRV0|ZP_PDRV1|ZP_PU|ZP_SL
+ nfet_06v0 L=1U W=2.48U AS=1.0912P AD=0.6448P PS=5.84U PD=3U
M$1837 \$10861 \$10920 Z
+ VSS|XN_CS|XN_IE|XN_PD|XN_PDRV0|XN_PDRV1|XN_PU|XN_SL|XP_CS|XP_IE|XP_PD|XP_PDRV0|XP_PDRV1|XP_PU|XP_SL|YN_CS|YN_IE|YN_PD|YN_PDRV0|YN_PDRV1|YN_PU|YN_SL|YP_CS|YP_IE|YP_PD|YP_PDRV0|YP_PDRV1|YP_PU|YP_SL|ZN_CS|ZN_IE|ZN_PD|ZN_PDRV0|ZN_PDRV1|ZN_PU|ZN_SL|ZP_CS|ZP_IE|ZP_PD|ZP_PDRV0|ZP_PDRV1|ZP_PU|ZP_SL
+ nfet_06v0 L=1U W=2.48U AS=0.6448P AD=1.0912P PS=3U PD=5.84U
M$1838
+ VSS|XN_CS|XN_IE|XN_PD|XN_PDRV0|XN_PDRV1|XN_PU|XN_SL|XP_CS|XP_IE|XP_PD|XP_PDRV0|XP_PDRV1|XP_PU|XP_SL|YN_CS|YN_IE|YN_PD|YN_PDRV0|YN_PDRV1|YN_PU|YN_SL|YP_CS|YP_IE|YP_PD|YP_PDRV0|YP_PDRV1|YP_PU|YP_SL|ZN_CS|ZN_IE|ZN_PD|ZN_PDRV0|ZN_PDRV1|ZN_PU|ZN_SL|ZP_CS|ZP_IE|ZP_PD|ZP_PDRV0|ZP_PDRV1|ZP_PU|ZP_SL
+ VDD|XN_OE|XP_OE|YN_OE|YP_OE|ZN_OE|ZP_OE
+ VSS|XN_CS|XN_IE|XN_PD|XN_PDRV0|XN_PDRV1|XN_PU|XN_SL|XP_CS|XP_IE|XP_PD|XP_PDRV0|XP_PDRV1|XP_PU|XP_SL|YN_CS|YN_IE|YN_PD|YN_PDRV0|YN_PDRV1|YN_PU|YN_SL|YP_CS|YP_IE|YP_PD|YP_PDRV0|YP_PDRV1|YP_PU|YP_SL|ZN_CS|ZN_IE|ZN_PD|ZN_PDRV0|ZN_PDRV1|ZN_PU|ZN_SL|ZP_CS|ZP_IE|ZP_PD|ZP_PDRV0|ZP_PDRV1|ZP_PU|ZP_SL
+ VSS|XN_CS|XN_IE|XN_PD|XN_PDRV0|XN_PDRV1|XN_PU|XN_SL|XP_CS|XP_IE|XP_PD|XP_PDRV0|XP_PDRV1|XP_PU|XP_SL|YN_CS|YN_IE|YN_PD|YN_PDRV0|YN_PDRV1|YN_PU|YN_SL|YP_CS|YP_IE|YP_PD|YP_PDRV0|YP_PDRV1|YP_PU|YP_SL|ZN_CS|ZN_IE|ZN_PD|ZN_PDRV0|ZN_PDRV1|ZN_PU|ZN_SL|ZP_CS|ZP_IE|ZP_PD|ZP_PDRV0|ZP_PDRV1|ZP_PU|ZP_SL
+ nfet_06v0 L=2U W=1U AS=0.44P AD=0.44P PS=2.88U PD=2.88U
M$1839
+ VSS|XN_CS|XN_IE|XN_PD|XN_PDRV0|XN_PDRV1|XN_PU|XN_SL|XP_CS|XP_IE|XP_PD|XP_PDRV0|XP_PDRV1|XP_PU|XP_SL|YN_CS|YN_IE|YN_PD|YN_PDRV0|YN_PDRV1|YN_PU|YN_SL|YP_CS|YP_IE|YP_PD|YP_PDRV0|YP_PDRV1|YP_PU|YP_SL|ZN_CS|ZN_IE|ZN_PD|ZN_PDRV0|ZN_PDRV1|ZN_PU|ZN_SL|ZP_CS|ZP_IE|ZP_PD|ZP_PDRV0|ZP_PDRV1|ZP_PU|ZP_SL
+ VDD|XN_OE|XP_OE|YN_OE|YP_OE|ZN_OE|ZP_OE
+ VSS|XN_CS|XN_IE|XN_PD|XN_PDRV0|XN_PDRV1|XN_PU|XN_SL|XP_CS|XP_IE|XP_PD|XP_PDRV0|XP_PDRV1|XP_PU|XP_SL|YN_CS|YN_IE|YN_PD|YN_PDRV0|YN_PDRV1|YN_PU|YN_SL|YP_CS|YP_IE|YP_PD|YP_PDRV0|YP_PDRV1|YP_PU|YP_SL|ZN_CS|ZN_IE|ZN_PD|ZN_PDRV0|ZN_PDRV1|ZN_PU|ZN_SL|ZP_CS|ZP_IE|ZP_PD|ZP_PDRV0|ZP_PDRV1|ZP_PU|ZP_SL
+ VSS|XN_CS|XN_IE|XN_PD|XN_PDRV0|XN_PDRV1|XN_PU|XN_SL|XP_CS|XP_IE|XP_PD|XP_PDRV0|XP_PDRV1|XP_PU|XP_SL|YN_CS|YN_IE|YN_PD|YN_PDRV0|YN_PDRV1|YN_PU|YN_SL|YP_CS|YP_IE|YP_PD|YP_PDRV0|YP_PDRV1|YP_PU|YP_SL|ZN_CS|ZN_IE|ZN_PD|ZN_PDRV0|ZN_PDRV1|ZN_PU|ZN_SL|ZP_CS|ZP_IE|ZP_PD|ZP_PDRV0|ZP_PDRV1|ZP_PU|ZP_SL
+ nfet_06v0 L=2U W=1U AS=0.44P AD=0.44P PS=2.88U PD=2.88U
M$1840
+ VSS|XN_CS|XN_IE|XN_PD|XN_PDRV0|XN_PDRV1|XN_PU|XN_SL|XP_CS|XP_IE|XP_PD|XP_PDRV0|XP_PDRV1|XP_PU|XP_SL|YN_CS|YN_IE|YN_PD|YN_PDRV0|YN_PDRV1|YN_PU|YN_SL|YP_CS|YP_IE|YP_PD|YP_PDRV0|YP_PDRV1|YP_PU|YP_SL|ZN_CS|ZN_IE|ZN_PD|ZN_PDRV0|ZN_PDRV1|ZN_PU|ZN_SL|ZP_CS|ZP_IE|ZP_PD|ZP_PDRV0|ZP_PDRV1|ZP_PU|ZP_SL
+ VDD|XN_OE|XP_OE|YN_OE|YP_OE|ZN_OE|ZP_OE
+ VSS|XN_CS|XN_IE|XN_PD|XN_PDRV0|XN_PDRV1|XN_PU|XN_SL|XP_CS|XP_IE|XP_PD|XP_PDRV0|XP_PDRV1|XP_PU|XP_SL|YN_CS|YN_IE|YN_PD|YN_PDRV0|YN_PDRV1|YN_PU|YN_SL|YP_CS|YP_IE|YP_PD|YP_PDRV0|YP_PDRV1|YP_PU|YP_SL|ZN_CS|ZN_IE|ZN_PD|ZN_PDRV0|ZN_PDRV1|ZN_PU|ZN_SL|ZP_CS|ZP_IE|ZP_PD|ZP_PDRV0|ZP_PDRV1|ZP_PU|ZP_SL
+ VSS|XN_CS|XN_IE|XN_PD|XN_PDRV0|XN_PDRV1|XN_PU|XN_SL|XP_CS|XP_IE|XP_PD|XP_PDRV0|XP_PDRV1|XP_PU|XP_SL|YN_CS|YN_IE|YN_PD|YN_PDRV0|YN_PDRV1|YN_PU|YN_SL|YP_CS|YP_IE|YP_PD|YP_PDRV0|YP_PDRV1|YP_PU|YP_SL|ZN_CS|ZN_IE|ZN_PD|ZN_PDRV0|ZN_PDRV1|ZN_PU|ZN_SL|ZP_CS|ZP_IE|ZP_PD|ZP_PDRV0|ZP_PDRV1|ZP_PU|ZP_SL
+ nfet_06v0 L=2U W=1U AS=0.44P AD=0.44P PS=2.88U PD=2.88U
M$1841
+ VSS|XN_CS|XN_IE|XN_PD|XN_PDRV0|XN_PDRV1|XN_PU|XN_SL|XP_CS|XP_IE|XP_PD|XP_PDRV0|XP_PDRV1|XP_PU|XP_SL|YN_CS|YN_IE|YN_PD|YN_PDRV0|YN_PDRV1|YN_PU|YN_SL|YP_CS|YP_IE|YP_PD|YP_PDRV0|YP_PDRV1|YP_PU|YP_SL|ZN_CS|ZN_IE|ZN_PD|ZN_PDRV0|ZN_PDRV1|ZN_PU|ZN_SL|ZP_CS|ZP_IE|ZP_PD|ZP_PDRV0|ZP_PDRV1|ZP_PU|ZP_SL
+ VDD|XN_OE|XP_OE|YN_OE|YP_OE|ZN_OE|ZP_OE
+ VSS|XN_CS|XN_IE|XN_PD|XN_PDRV0|XN_PDRV1|XN_PU|XN_SL|XP_CS|XP_IE|XP_PD|XP_PDRV0|XP_PDRV1|XP_PU|XP_SL|YN_CS|YN_IE|YN_PD|YN_PDRV0|YN_PDRV1|YN_PU|YN_SL|YP_CS|YP_IE|YP_PD|YP_PDRV0|YP_PDRV1|YP_PU|YP_SL|ZN_CS|ZN_IE|ZN_PD|ZN_PDRV0|ZN_PDRV1|ZN_PU|ZN_SL|ZP_CS|ZP_IE|ZP_PD|ZP_PDRV0|ZP_PDRV1|ZP_PU|ZP_SL
+ VSS|XN_CS|XN_IE|XN_PD|XN_PDRV0|XN_PDRV1|XN_PU|XN_SL|XP_CS|XP_IE|XP_PD|XP_PDRV0|XP_PDRV1|XP_PU|XP_SL|YN_CS|YN_IE|YN_PD|YN_PDRV0|YN_PDRV1|YN_PU|YN_SL|YP_CS|YP_IE|YP_PD|YP_PDRV0|YP_PDRV1|YP_PU|YP_SL|ZN_CS|ZN_IE|ZN_PD|ZN_PDRV0|ZN_PDRV1|ZN_PU|ZN_SL|ZP_CS|ZP_IE|ZP_PD|ZP_PDRV0|ZP_PDRV1|ZP_PU|ZP_SL
+ nfet_06v0 L=2U W=9.75U AS=4.29P AD=4.29P PS=20.38U PD=20.38U
M$1842
+ VSS|XN_CS|XN_IE|XN_PD|XN_PDRV0|XN_PDRV1|XN_PU|XN_SL|XP_CS|XP_IE|XP_PD|XP_PDRV0|XP_PDRV1|XP_PU|XP_SL|YN_CS|YN_IE|YN_PD|YN_PDRV0|YN_PDRV1|YN_PU|YN_SL|YP_CS|YP_IE|YP_PD|YP_PDRV0|YP_PDRV1|YP_PU|YP_SL|ZN_CS|ZN_IE|ZN_PD|ZN_PDRV0|ZN_PDRV1|ZN_PU|ZN_SL|ZP_CS|ZP_IE|ZP_PD|ZP_PDRV0|ZP_PDRV1|ZP_PU|ZP_SL
+ VDD|XN_OE|XP_OE|YN_OE|YP_OE|ZN_OE|ZP_OE
+ VSS|XN_CS|XN_IE|XN_PD|XN_PDRV0|XN_PDRV1|XN_PU|XN_SL|XP_CS|XP_IE|XP_PD|XP_PDRV0|XP_PDRV1|XP_PU|XP_SL|YN_CS|YN_IE|YN_PD|YN_PDRV0|YN_PDRV1|YN_PU|YN_SL|YP_CS|YP_IE|YP_PD|YP_PDRV0|YP_PDRV1|YP_PU|YP_SL|ZN_CS|ZN_IE|ZN_PD|ZN_PDRV0|ZN_PDRV1|ZN_PU|ZN_SL|ZP_CS|ZP_IE|ZP_PD|ZP_PDRV0|ZP_PDRV1|ZP_PU|ZP_SL
+ VSS|XN_CS|XN_IE|XN_PD|XN_PDRV0|XN_PDRV1|XN_PU|XN_SL|XP_CS|XP_IE|XP_PD|XP_PDRV0|XP_PDRV1|XP_PU|XP_SL|YN_CS|YN_IE|YN_PD|YN_PDRV0|YN_PDRV1|YN_PU|YN_SL|YP_CS|YP_IE|YP_PD|YP_PDRV0|YP_PDRV1|YP_PU|YP_SL|ZN_CS|ZN_IE|ZN_PD|ZN_PDRV0|ZN_PDRV1|ZN_PU|ZN_SL|ZP_CS|ZP_IE|ZP_PD|ZP_PDRV0|ZP_PDRV1|ZP_PU|ZP_SL
+ nfet_06v0 L=2U W=9.75U AS=4.29P AD=4.29P PS=20.38U PD=20.38U
M$1843
+ VSS|XN_CS|XN_IE|XN_PD|XN_PDRV0|XN_PDRV1|XN_PU|XN_SL|XP_CS|XP_IE|XP_PD|XP_PDRV0|XP_PDRV1|XP_PU|XP_SL|YN_CS|YN_IE|YN_PD|YN_PDRV0|YN_PDRV1|YN_PU|YN_SL|YP_CS|YP_IE|YP_PD|YP_PDRV0|YP_PDRV1|YP_PU|YP_SL|ZN_CS|ZN_IE|ZN_PD|ZN_PDRV0|ZN_PDRV1|ZN_PU|ZN_SL|ZP_CS|ZP_IE|ZP_PD|ZP_PDRV0|ZP_PDRV1|ZP_PU|ZP_SL
+ VDD|XN_OE|XP_OE|YN_OE|YP_OE|ZN_OE|ZP_OE
+ VSS|XN_CS|XN_IE|XN_PD|XN_PDRV0|XN_PDRV1|XN_PU|XN_SL|XP_CS|XP_IE|XP_PD|XP_PDRV0|XP_PDRV1|XP_PU|XP_SL|YN_CS|YN_IE|YN_PD|YN_PDRV0|YN_PDRV1|YN_PU|YN_SL|YP_CS|YP_IE|YP_PD|YP_PDRV0|YP_PDRV1|YP_PU|YP_SL|ZN_CS|ZN_IE|ZN_PD|ZN_PDRV0|ZN_PDRV1|ZN_PU|ZN_SL|ZP_CS|ZP_IE|ZP_PD|ZP_PDRV0|ZP_PDRV1|ZP_PU|ZP_SL
+ VSS|XN_CS|XN_IE|XN_PD|XN_PDRV0|XN_PDRV1|XN_PU|XN_SL|XP_CS|XP_IE|XP_PD|XP_PDRV0|XP_PDRV1|XP_PU|XP_SL|YN_CS|YN_IE|YN_PD|YN_PDRV0|YN_PDRV1|YN_PU|YN_SL|YP_CS|YP_IE|YP_PD|YP_PDRV0|YP_PDRV1|YP_PU|YP_SL|ZN_CS|ZN_IE|ZN_PD|ZN_PDRV0|ZN_PDRV1|ZN_PU|ZN_SL|ZP_CS|ZP_IE|ZP_PD|ZP_PDRV0|ZP_PDRV1|ZP_PU|ZP_SL
+ nfet_06v0 L=2U W=9.75U AS=4.29P AD=4.29P PS=20.38U PD=20.38U
M$1844
+ VSS|XN_CS|XN_IE|XN_PD|XN_PDRV0|XN_PDRV1|XN_PU|XN_SL|XP_CS|XP_IE|XP_PD|XP_PDRV0|XP_PDRV1|XP_PU|XP_SL|YN_CS|YN_IE|YN_PD|YN_PDRV0|YN_PDRV1|YN_PU|YN_SL|YP_CS|YP_IE|YP_PD|YP_PDRV0|YP_PDRV1|YP_PU|YP_SL|ZN_CS|ZN_IE|ZN_PD|ZN_PDRV0|ZN_PDRV1|ZN_PU|ZN_SL|ZP_CS|ZP_IE|ZP_PD|ZP_PDRV0|ZP_PDRV1|ZP_PU|ZP_SL
+ VDD|XN_OE|XP_OE|YN_OE|YP_OE|ZN_OE|ZP_OE
+ VSS|XN_CS|XN_IE|XN_PD|XN_PDRV0|XN_PDRV1|XN_PU|XN_SL|XP_CS|XP_IE|XP_PD|XP_PDRV0|XP_PDRV1|XP_PU|XP_SL|YN_CS|YN_IE|YN_PD|YN_PDRV0|YN_PDRV1|YN_PU|YN_SL|YP_CS|YP_IE|YP_PD|YP_PDRV0|YP_PDRV1|YP_PU|YP_SL|ZN_CS|ZN_IE|ZN_PD|ZN_PDRV0|ZN_PDRV1|ZN_PU|ZN_SL|ZP_CS|ZP_IE|ZP_PD|ZP_PDRV0|ZP_PDRV1|ZP_PU|ZP_SL
+ VSS|XN_CS|XN_IE|XN_PD|XN_PDRV0|XN_PDRV1|XN_PU|XN_SL|XP_CS|XP_IE|XP_PD|XP_PDRV0|XP_PDRV1|XP_PU|XP_SL|YN_CS|YN_IE|YN_PD|YN_PDRV0|YN_PDRV1|YN_PU|YN_SL|YP_CS|YP_IE|YP_PD|YP_PDRV0|YP_PDRV1|YP_PU|YP_SL|ZN_CS|ZN_IE|ZN_PD|ZN_PDRV0|ZN_PDRV1|ZN_PU|ZN_SL|ZP_CS|ZP_IE|ZP_PD|ZP_PDRV0|ZP_PDRV1|ZP_PU|ZP_SL
+ nfet_06v0 L=2U W=9.75U AS=4.29P AD=4.29P PS=20.38U PD=20.38U
M$1845
+ VSS|XN_CS|XN_IE|XN_PD|XN_PDRV0|XN_PDRV1|XN_PU|XN_SL|XP_CS|XP_IE|XP_PD|XP_PDRV0|XP_PDRV1|XP_PU|XP_SL|YN_CS|YN_IE|YN_PD|YN_PDRV0|YN_PDRV1|YN_PU|YN_SL|YP_CS|YP_IE|YP_PD|YP_PDRV0|YP_PDRV1|YP_PU|YP_SL|ZN_CS|ZN_IE|ZN_PD|ZN_PDRV0|ZN_PDRV1|ZN_PU|ZN_SL|ZP_CS|ZP_IE|ZP_PD|ZP_PDRV0|ZP_PDRV1|ZP_PU|ZP_SL
+ VDD|XN_OE|XP_OE|YN_OE|YP_OE|ZN_OE|ZP_OE
+ VSS|XN_CS|XN_IE|XN_PD|XN_PDRV0|XN_PDRV1|XN_PU|XN_SL|XP_CS|XP_IE|XP_PD|XP_PDRV0|XP_PDRV1|XP_PU|XP_SL|YN_CS|YN_IE|YN_PD|YN_PDRV0|YN_PDRV1|YN_PU|YN_SL|YP_CS|YP_IE|YP_PD|YP_PDRV0|YP_PDRV1|YP_PU|YP_SL|ZN_CS|ZN_IE|ZN_PD|ZN_PDRV0|ZN_PDRV1|ZN_PU|ZN_SL|ZP_CS|ZP_IE|ZP_PD|ZP_PDRV0|ZP_PDRV1|ZP_PU|ZP_SL
+ VSS|XN_CS|XN_IE|XN_PD|XN_PDRV0|XN_PDRV1|XN_PU|XN_SL|XP_CS|XP_IE|XP_PD|XP_PDRV0|XP_PDRV1|XP_PU|XP_SL|YN_CS|YN_IE|YN_PD|YN_PDRV0|YN_PDRV1|YN_PU|YN_SL|YP_CS|YP_IE|YP_PD|YP_PDRV0|YP_PDRV1|YP_PU|YP_SL|ZN_CS|ZN_IE|ZN_PD|ZN_PDRV0|ZN_PDRV1|ZN_PU|ZN_SL|ZP_CS|ZP_IE|ZP_PD|ZP_PDRV0|ZP_PDRV1|ZP_PU|ZP_SL
+ nfet_06v0 L=2U W=9.75U AS=4.29P AD=4.29P PS=20.38U PD=20.38U
M$1846
+ VSS|XN_CS|XN_IE|XN_PD|XN_PDRV0|XN_PDRV1|XN_PU|XN_SL|XP_CS|XP_IE|XP_PD|XP_PDRV0|XP_PDRV1|XP_PU|XP_SL|YN_CS|YN_IE|YN_PD|YN_PDRV0|YN_PDRV1|YN_PU|YN_SL|YP_CS|YP_IE|YP_PD|YP_PDRV0|YP_PDRV1|YP_PU|YP_SL|ZN_CS|ZN_IE|ZN_PD|ZN_PDRV0|ZN_PDRV1|ZN_PU|ZN_SL|ZP_CS|ZP_IE|ZP_PD|ZP_PDRV0|ZP_PDRV1|ZP_PU|ZP_SL
+ VDD|XN_OE|XP_OE|YN_OE|YP_OE|ZN_OE|ZP_OE
+ VSS|XN_CS|XN_IE|XN_PD|XN_PDRV0|XN_PDRV1|XN_PU|XN_SL|XP_CS|XP_IE|XP_PD|XP_PDRV0|XP_PDRV1|XP_PU|XP_SL|YN_CS|YN_IE|YN_PD|YN_PDRV0|YN_PDRV1|YN_PU|YN_SL|YP_CS|YP_IE|YP_PD|YP_PDRV0|YP_PDRV1|YP_PU|YP_SL|ZN_CS|ZN_IE|ZN_PD|ZN_PDRV0|ZN_PDRV1|ZN_PU|ZN_SL|ZP_CS|ZP_IE|ZP_PD|ZP_PDRV0|ZP_PDRV1|ZP_PU|ZP_SL
+ VSS|XN_CS|XN_IE|XN_PD|XN_PDRV0|XN_PDRV1|XN_PU|XN_SL|XP_CS|XP_IE|XP_PD|XP_PDRV0|XP_PDRV1|XP_PU|XP_SL|YN_CS|YN_IE|YN_PD|YN_PDRV0|YN_PDRV1|YN_PU|YN_SL|YP_CS|YP_IE|YP_PD|YP_PDRV0|YP_PDRV1|YP_PU|YP_SL|ZN_CS|ZN_IE|ZN_PD|ZN_PDRV0|ZN_PDRV1|ZN_PU|ZN_SL|ZP_CS|ZP_IE|ZP_PD|ZP_PDRV0|ZP_PDRV1|ZP_PU|ZP_SL
+ nfet_06v0 L=2U W=9.75U AS=4.29P AD=4.29P PS=20.38U PD=20.38U
M$1847
+ VSS|XN_CS|XN_IE|XN_PD|XN_PDRV0|XN_PDRV1|XN_PU|XN_SL|XP_CS|XP_IE|XP_PD|XP_PDRV0|XP_PDRV1|XP_PU|XP_SL|YN_CS|YN_IE|YN_PD|YN_PDRV0|YN_PDRV1|YN_PU|YN_SL|YP_CS|YP_IE|YP_PD|YP_PDRV0|YP_PDRV1|YP_PU|YP_SL|ZN_CS|ZN_IE|ZN_PD|ZN_PDRV0|ZN_PDRV1|ZN_PU|ZN_SL|ZP_CS|ZP_IE|ZP_PD|ZP_PDRV0|ZP_PDRV1|ZP_PU|ZP_SL
+ VDD|XN_OE|XP_OE|YN_OE|YP_OE|ZN_OE|ZP_OE
+ VSS|XN_CS|XN_IE|XN_PD|XN_PDRV0|XN_PDRV1|XN_PU|XN_SL|XP_CS|XP_IE|XP_PD|XP_PDRV0|XP_PDRV1|XP_PU|XP_SL|YN_CS|YN_IE|YN_PD|YN_PDRV0|YN_PDRV1|YN_PU|YN_SL|YP_CS|YP_IE|YP_PD|YP_PDRV0|YP_PDRV1|YP_PU|YP_SL|ZN_CS|ZN_IE|ZN_PD|ZN_PDRV0|ZN_PDRV1|ZN_PU|ZN_SL|ZP_CS|ZP_IE|ZP_PD|ZP_PDRV0|ZP_PDRV1|ZP_PU|ZP_SL
+ VSS|XN_CS|XN_IE|XN_PD|XN_PDRV0|XN_PDRV1|XN_PU|XN_SL|XP_CS|XP_IE|XP_PD|XP_PDRV0|XP_PDRV1|XP_PU|XP_SL|YN_CS|YN_IE|YN_PD|YN_PDRV0|YN_PDRV1|YN_PU|YN_SL|YP_CS|YP_IE|YP_PD|YP_PDRV0|YP_PDRV1|YP_PU|YP_SL|ZN_CS|ZN_IE|ZN_PD|ZN_PDRV0|ZN_PDRV1|ZN_PU|ZN_SL|ZP_CS|ZP_IE|ZP_PD|ZP_PDRV0|ZP_PDRV1|ZP_PU|ZP_SL
+ nfet_06v0 L=2U W=9.75U AS=4.29P AD=4.29P PS=20.38U PD=20.38U
M$1848
+ VSS|XN_CS|XN_IE|XN_PD|XN_PDRV0|XN_PDRV1|XN_PU|XN_SL|XP_CS|XP_IE|XP_PD|XP_PDRV0|XP_PDRV1|XP_PU|XP_SL|YN_CS|YN_IE|YN_PD|YN_PDRV0|YN_PDRV1|YN_PU|YN_SL|YP_CS|YP_IE|YP_PD|YP_PDRV0|YP_PDRV1|YP_PU|YP_SL|ZN_CS|ZN_IE|ZN_PD|ZN_PDRV0|ZN_PDRV1|ZN_PU|ZN_SL|ZP_CS|ZP_IE|ZP_PD|ZP_PDRV0|ZP_PDRV1|ZP_PU|ZP_SL
+ VDD|XN_OE|XP_OE|YN_OE|YP_OE|ZN_OE|ZP_OE
+ VSS|XN_CS|XN_IE|XN_PD|XN_PDRV0|XN_PDRV1|XN_PU|XN_SL|XP_CS|XP_IE|XP_PD|XP_PDRV0|XP_PDRV1|XP_PU|XP_SL|YN_CS|YN_IE|YN_PD|YN_PDRV0|YN_PDRV1|YN_PU|YN_SL|YP_CS|YP_IE|YP_PD|YP_PDRV0|YP_PDRV1|YP_PU|YP_SL|ZN_CS|ZN_IE|ZN_PD|ZN_PDRV0|ZN_PDRV1|ZN_PU|ZN_SL|ZP_CS|ZP_IE|ZP_PD|ZP_PDRV0|ZP_PDRV1|ZP_PU|ZP_SL
+ VSS|XN_CS|XN_IE|XN_PD|XN_PDRV0|XN_PDRV1|XN_PU|XN_SL|XP_CS|XP_IE|XP_PD|XP_PDRV0|XP_PDRV1|XP_PU|XP_SL|YN_CS|YN_IE|YN_PD|YN_PDRV0|YN_PDRV1|YN_PU|YN_SL|YP_CS|YP_IE|YP_PD|YP_PDRV0|YP_PDRV1|YP_PU|YP_SL|ZN_CS|ZN_IE|ZN_PD|ZN_PDRV0|ZN_PDRV1|ZN_PU|ZN_SL|ZP_CS|ZP_IE|ZP_PD|ZP_PDRV0|ZP_PDRV1|ZP_PU|ZP_SL
+ nfet_06v0 L=2U W=1U AS=0.44P AD=0.44P PS=2.88U PD=2.88U
M$1849
+ VSS|XN_CS|XN_IE|XN_PD|XN_PDRV0|XN_PDRV1|XN_PU|XN_SL|XP_CS|XP_IE|XP_PD|XP_PDRV0|XP_PDRV1|XP_PU|XP_SL|YN_CS|YN_IE|YN_PD|YN_PDRV0|YN_PDRV1|YN_PU|YN_SL|YP_CS|YP_IE|YP_PD|YP_PDRV0|YP_PDRV1|YP_PU|YP_SL|ZN_CS|ZN_IE|ZN_PD|ZN_PDRV0|ZN_PDRV1|ZN_PU|ZN_SL|ZP_CS|ZP_IE|ZP_PD|ZP_PDRV0|ZP_PDRV1|ZP_PU|ZP_SL
+ VDD|XN_OE|XP_OE|YN_OE|YP_OE|ZN_OE|ZP_OE
+ VSS|XN_CS|XN_IE|XN_PD|XN_PDRV0|XN_PDRV1|XN_PU|XN_SL|XP_CS|XP_IE|XP_PD|XP_PDRV0|XP_PDRV1|XP_PU|XP_SL|YN_CS|YN_IE|YN_PD|YN_PDRV0|YN_PDRV1|YN_PU|YN_SL|YP_CS|YP_IE|YP_PD|YP_PDRV0|YP_PDRV1|YP_PU|YP_SL|ZN_CS|ZN_IE|ZN_PD|ZN_PDRV0|ZN_PDRV1|ZN_PU|ZN_SL|ZP_CS|ZP_IE|ZP_PD|ZP_PDRV0|ZP_PDRV1|ZP_PU|ZP_SL
+ VSS|XN_CS|XN_IE|XN_PD|XN_PDRV0|XN_PDRV1|XN_PU|XN_SL|XP_CS|XP_IE|XP_PD|XP_PDRV0|XP_PDRV1|XP_PU|XP_SL|YN_CS|YN_IE|YN_PD|YN_PDRV0|YN_PDRV1|YN_PU|YN_SL|YP_CS|YP_IE|YP_PD|YP_PDRV0|YP_PDRV1|YP_PU|YP_SL|ZN_CS|ZN_IE|ZN_PD|ZN_PDRV0|ZN_PDRV1|ZN_PU|ZN_SL|ZP_CS|ZP_IE|ZP_PD|ZP_PDRV0|ZP_PDRV1|ZP_PU|ZP_SL
+ nfet_06v0 L=2U W=1U AS=0.44P AD=0.44P PS=2.88U PD=2.88U
M$1850
+ VSS|XN_CS|XN_IE|XN_PD|XN_PDRV0|XN_PDRV1|XN_PU|XN_SL|XP_CS|XP_IE|XP_PD|XP_PDRV0|XP_PDRV1|XP_PU|XP_SL|YN_CS|YN_IE|YN_PD|YN_PDRV0|YN_PDRV1|YN_PU|YN_SL|YP_CS|YP_IE|YP_PD|YP_PDRV0|YP_PDRV1|YP_PU|YP_SL|ZN_CS|ZN_IE|ZN_PD|ZN_PDRV0|ZN_PDRV1|ZN_PU|ZN_SL|ZP_CS|ZP_IE|ZP_PD|ZP_PDRV0|ZP_PDRV1|ZP_PU|ZP_SL
+ VDD|XN_OE|XP_OE|YN_OE|YP_OE|ZN_OE|ZP_OE
+ VSS|XN_CS|XN_IE|XN_PD|XN_PDRV0|XN_PDRV1|XN_PU|XN_SL|XP_CS|XP_IE|XP_PD|XP_PDRV0|XP_PDRV1|XP_PU|XP_SL|YN_CS|YN_IE|YN_PD|YN_PDRV0|YN_PDRV1|YN_PU|YN_SL|YP_CS|YP_IE|YP_PD|YP_PDRV0|YP_PDRV1|YP_PU|YP_SL|ZN_CS|ZN_IE|ZN_PD|ZN_PDRV0|ZN_PDRV1|ZN_PU|ZN_SL|ZP_CS|ZP_IE|ZP_PD|ZP_PDRV0|ZP_PDRV1|ZP_PU|ZP_SL
+ VSS|XN_CS|XN_IE|XN_PD|XN_PDRV0|XN_PDRV1|XN_PU|XN_SL|XP_CS|XP_IE|XP_PD|XP_PDRV0|XP_PDRV1|XP_PU|XP_SL|YN_CS|YN_IE|YN_PD|YN_PDRV0|YN_PDRV1|YN_PU|YN_SL|YP_CS|YP_IE|YP_PD|YP_PDRV0|YP_PDRV1|YP_PU|YP_SL|ZN_CS|ZN_IE|ZN_PD|ZN_PDRV0|ZN_PDRV1|ZN_PU|ZN_SL|ZP_CS|ZP_IE|ZP_PD|ZP_PDRV0|ZP_PDRV1|ZP_PU|ZP_SL
+ nfet_06v0 L=2U W=1U AS=0.44P AD=0.44P PS=2.88U PD=2.88U
M$1851
+ VSS|XN_CS|XN_IE|XN_PD|XN_PDRV0|XN_PDRV1|XN_PU|XN_SL|XP_CS|XP_IE|XP_PD|XP_PDRV0|XP_PDRV1|XP_PU|XP_SL|YN_CS|YN_IE|YN_PD|YN_PDRV0|YN_PDRV1|YN_PU|YN_SL|YP_CS|YP_IE|YP_PD|YP_PDRV0|YP_PDRV1|YP_PU|YP_SL|ZN_CS|ZN_IE|ZN_PD|ZN_PDRV0|ZN_PDRV1|ZN_PU|ZN_SL|ZP_CS|ZP_IE|ZP_PD|ZP_PDRV0|ZP_PDRV1|ZP_PU|ZP_SL
+ VDD|XN_OE|XP_OE|YN_OE|YP_OE|ZN_OE|ZP_OE
+ VSS|XN_CS|XN_IE|XN_PD|XN_PDRV0|XN_PDRV1|XN_PU|XN_SL|XP_CS|XP_IE|XP_PD|XP_PDRV0|XP_PDRV1|XP_PU|XP_SL|YN_CS|YN_IE|YN_PD|YN_PDRV0|YN_PDRV1|YN_PU|YN_SL|YP_CS|YP_IE|YP_PD|YP_PDRV0|YP_PDRV1|YP_PU|YP_SL|ZN_CS|ZN_IE|ZN_PD|ZN_PDRV0|ZN_PDRV1|ZN_PU|ZN_SL|ZP_CS|ZP_IE|ZP_PD|ZP_PDRV0|ZP_PDRV1|ZP_PU|ZP_SL
+ VSS|XN_CS|XN_IE|XN_PD|XN_PDRV0|XN_PDRV1|XN_PU|XN_SL|XP_CS|XP_IE|XP_PD|XP_PDRV0|XP_PDRV1|XP_PU|XP_SL|YN_CS|YN_IE|YN_PD|YN_PDRV0|YN_PDRV1|YN_PU|YN_SL|YP_CS|YP_IE|YP_PD|YP_PDRV0|YP_PDRV1|YP_PU|YP_SL|ZN_CS|ZN_IE|ZN_PD|ZN_PDRV0|ZN_PDRV1|ZN_PU|ZN_SL|ZP_CS|ZP_IE|ZP_PD|ZP_PDRV0|ZP_PDRV1|ZP_PU|ZP_SL
+ nfet_06v0 L=2U W=1U AS=0.44P AD=0.44P PS=2.88U PD=2.88U
M$1852
+ VSS|XN_CS|XN_IE|XN_PD|XN_PDRV0|XN_PDRV1|XN_PU|XN_SL|XP_CS|XP_IE|XP_PD|XP_PDRV0|XP_PDRV1|XP_PU|XP_SL|YN_CS|YN_IE|YN_PD|YN_PDRV0|YN_PDRV1|YN_PU|YN_SL|YP_CS|YP_IE|YP_PD|YP_PDRV0|YP_PDRV1|YP_PU|YP_SL|ZN_CS|ZN_IE|ZN_PD|ZN_PDRV0|ZN_PDRV1|ZN_PU|ZN_SL|ZP_CS|ZP_IE|ZP_PD|ZP_PDRV0|ZP_PDRV1|ZP_PU|ZP_SL
+ VDD|XN_OE|XP_OE|YN_OE|YP_OE|ZN_OE|ZP_OE
+ VSS|XN_CS|XN_IE|XN_PD|XN_PDRV0|XN_PDRV1|XN_PU|XN_SL|XP_CS|XP_IE|XP_PD|XP_PDRV0|XP_PDRV1|XP_PU|XP_SL|YN_CS|YN_IE|YN_PD|YN_PDRV0|YN_PDRV1|YN_PU|YN_SL|YP_CS|YP_IE|YP_PD|YP_PDRV0|YP_PDRV1|YP_PU|YP_SL|ZN_CS|ZN_IE|ZN_PD|ZN_PDRV0|ZN_PDRV1|ZN_PU|ZN_SL|ZP_CS|ZP_IE|ZP_PD|ZP_PDRV0|ZP_PDRV1|ZP_PU|ZP_SL
+ VSS|XN_CS|XN_IE|XN_PD|XN_PDRV0|XN_PDRV1|XN_PU|XN_SL|XP_CS|XP_IE|XP_PD|XP_PDRV0|XP_PDRV1|XP_PU|XP_SL|YN_CS|YN_IE|YN_PD|YN_PDRV0|YN_PDRV1|YN_PU|YN_SL|YP_CS|YP_IE|YP_PD|YP_PDRV0|YP_PDRV1|YP_PU|YP_SL|ZN_CS|ZN_IE|ZN_PD|ZN_PDRV0|ZN_PDRV1|ZN_PU|ZN_SL|ZP_CS|ZP_IE|ZP_PD|ZP_PDRV0|ZP_PDRV1|ZP_PU|ZP_SL
+ nfet_06v0 L=2U W=1U AS=0.44P AD=0.44P PS=2.88U PD=2.88U
M$1853
+ VSS|XN_CS|XN_IE|XN_PD|XN_PDRV0|XN_PDRV1|XN_PU|XN_SL|XP_CS|XP_IE|XP_PD|XP_PDRV0|XP_PDRV1|XP_PU|XP_SL|YN_CS|YN_IE|YN_PD|YN_PDRV0|YN_PDRV1|YN_PU|YN_SL|YP_CS|YP_IE|YP_PD|YP_PDRV0|YP_PDRV1|YP_PU|YP_SL|ZN_CS|ZN_IE|ZN_PD|ZN_PDRV0|ZN_PDRV1|ZN_PU|ZN_SL|ZP_CS|ZP_IE|ZP_PD|ZP_PDRV0|ZP_PDRV1|ZP_PU|ZP_SL
+ VDD|XN_OE|XP_OE|YN_OE|YP_OE|ZN_OE|ZP_OE
+ VSS|XN_CS|XN_IE|XN_PD|XN_PDRV0|XN_PDRV1|XN_PU|XN_SL|XP_CS|XP_IE|XP_PD|XP_PDRV0|XP_PDRV1|XP_PU|XP_SL|YN_CS|YN_IE|YN_PD|YN_PDRV0|YN_PDRV1|YN_PU|YN_SL|YP_CS|YP_IE|YP_PD|YP_PDRV0|YP_PDRV1|YP_PU|YP_SL|ZN_CS|ZN_IE|ZN_PD|ZN_PDRV0|ZN_PDRV1|ZN_PU|ZN_SL|ZP_CS|ZP_IE|ZP_PD|ZP_PDRV0|ZP_PDRV1|ZP_PU|ZP_SL
+ VSS|XN_CS|XN_IE|XN_PD|XN_PDRV0|XN_PDRV1|XN_PU|XN_SL|XP_CS|XP_IE|XP_PD|XP_PDRV0|XP_PDRV1|XP_PU|XP_SL|YN_CS|YN_IE|YN_PD|YN_PDRV0|YN_PDRV1|YN_PU|YN_SL|YP_CS|YP_IE|YP_PD|YP_PDRV0|YP_PDRV1|YP_PU|YP_SL|ZN_CS|ZN_IE|ZN_PD|ZN_PDRV0|ZN_PDRV1|ZN_PU|ZN_SL|ZP_CS|ZP_IE|ZP_PD|ZP_PDRV0|ZP_PDRV1|ZP_PU|ZP_SL
+ nfet_06v0 L=2U W=1U AS=0.44P AD=0.44P PS=2.88U PD=2.88U
M$1854
+ VSS|XN_CS|XN_IE|XN_PD|XN_PDRV0|XN_PDRV1|XN_PU|XN_SL|XP_CS|XP_IE|XP_PD|XP_PDRV0|XP_PDRV1|XP_PU|XP_SL|YN_CS|YN_IE|YN_PD|YN_PDRV0|YN_PDRV1|YN_PU|YN_SL|YP_CS|YP_IE|YP_PD|YP_PDRV0|YP_PDRV1|YP_PU|YP_SL|ZN_CS|ZN_IE|ZN_PD|ZN_PDRV0|ZN_PDRV1|ZN_PU|ZN_SL|ZP_CS|ZP_IE|ZP_PD|ZP_PDRV0|ZP_PDRV1|ZP_PU|ZP_SL
+ VDD|XN_OE|XP_OE|YN_OE|YP_OE|ZN_OE|ZP_OE
+ VSS|XN_CS|XN_IE|XN_PD|XN_PDRV0|XN_PDRV1|XN_PU|XN_SL|XP_CS|XP_IE|XP_PD|XP_PDRV0|XP_PDRV1|XP_PU|XP_SL|YN_CS|YN_IE|YN_PD|YN_PDRV0|YN_PDRV1|YN_PU|YN_SL|YP_CS|YP_IE|YP_PD|YP_PDRV0|YP_PDRV1|YP_PU|YP_SL|ZN_CS|ZN_IE|ZN_PD|ZN_PDRV0|ZN_PDRV1|ZN_PU|ZN_SL|ZP_CS|ZP_IE|ZP_PD|ZP_PDRV0|ZP_PDRV1|ZP_PU|ZP_SL
+ VSS|XN_CS|XN_IE|XN_PD|XN_PDRV0|XN_PDRV1|XN_PU|XN_SL|XP_CS|XP_IE|XP_PD|XP_PDRV0|XP_PDRV1|XP_PU|XP_SL|YN_CS|YN_IE|YN_PD|YN_PDRV0|YN_PDRV1|YN_PU|YN_SL|YP_CS|YP_IE|YP_PD|YP_PDRV0|YP_PDRV1|YP_PU|YP_SL|ZN_CS|ZN_IE|ZN_PD|ZN_PDRV0|ZN_PDRV1|ZN_PU|ZN_SL|ZP_CS|ZP_IE|ZP_PD|ZP_PDRV0|ZP_PDRV1|ZP_PU|ZP_SL
+ nfet_06v0 L=2U W=1U AS=0.44P AD=0.44P PS=2.88U PD=2.88U
M$1855
+ VSS|XN_CS|XN_IE|XN_PD|XN_PDRV0|XN_PDRV1|XN_PU|XN_SL|XP_CS|XP_IE|XP_PD|XP_PDRV0|XP_PDRV1|XP_PU|XP_SL|YN_CS|YN_IE|YN_PD|YN_PDRV0|YN_PDRV1|YN_PU|YN_SL|YP_CS|YP_IE|YP_PD|YP_PDRV0|YP_PDRV1|YP_PU|YP_SL|ZN_CS|ZN_IE|ZN_PD|ZN_PDRV0|ZN_PDRV1|ZN_PU|ZN_SL|ZP_CS|ZP_IE|ZP_PD|ZP_PDRV0|ZP_PDRV1|ZP_PU|ZP_SL
+ VDD|XN_OE|XP_OE|YN_OE|YP_OE|ZN_OE|ZP_OE
+ VSS|XN_CS|XN_IE|XN_PD|XN_PDRV0|XN_PDRV1|XN_PU|XN_SL|XP_CS|XP_IE|XP_PD|XP_PDRV0|XP_PDRV1|XP_PU|XP_SL|YN_CS|YN_IE|YN_PD|YN_PDRV0|YN_PDRV1|YN_PU|YN_SL|YP_CS|YP_IE|YP_PD|YP_PDRV0|YP_PDRV1|YP_PU|YP_SL|ZN_CS|ZN_IE|ZN_PD|ZN_PDRV0|ZN_PDRV1|ZN_PU|ZN_SL|ZP_CS|ZP_IE|ZP_PD|ZP_PDRV0|ZP_PDRV1|ZP_PU|ZP_SL
+ VSS|XN_CS|XN_IE|XN_PD|XN_PDRV0|XN_PDRV1|XN_PU|XN_SL|XP_CS|XP_IE|XP_PD|XP_PDRV0|XP_PDRV1|XP_PU|XP_SL|YN_CS|YN_IE|YN_PD|YN_PDRV0|YN_PDRV1|YN_PU|YN_SL|YP_CS|YP_IE|YP_PD|YP_PDRV0|YP_PDRV1|YP_PU|YP_SL|ZN_CS|ZN_IE|ZN_PD|ZN_PDRV0|ZN_PDRV1|ZN_PU|ZN_SL|ZP_CS|ZP_IE|ZP_PD|ZP_PDRV0|ZP_PDRV1|ZP_PU|ZP_SL
+ nfet_06v0 L=2U W=1U AS=0.44P AD=0.44P PS=2.88U PD=2.88U
M$1856
+ VSS|XN_CS|XN_IE|XN_PD|XN_PDRV0|XN_PDRV1|XN_PU|XN_SL|XP_CS|XP_IE|XP_PD|XP_PDRV0|XP_PDRV1|XP_PU|XP_SL|YN_CS|YN_IE|YN_PD|YN_PDRV0|YN_PDRV1|YN_PU|YN_SL|YP_CS|YP_IE|YP_PD|YP_PDRV0|YP_PDRV1|YP_PU|YP_SL|ZN_CS|ZN_IE|ZN_PD|ZN_PDRV0|ZN_PDRV1|ZN_PU|ZN_SL|ZP_CS|ZP_IE|ZP_PD|ZP_PDRV0|ZP_PDRV1|ZP_PU|ZP_SL
+ VDD|XN_OE|XP_OE|YN_OE|YP_OE|ZN_OE|ZP_OE
+ VSS|XN_CS|XN_IE|XN_PD|XN_PDRV0|XN_PDRV1|XN_PU|XN_SL|XP_CS|XP_IE|XP_PD|XP_PDRV0|XP_PDRV1|XP_PU|XP_SL|YN_CS|YN_IE|YN_PD|YN_PDRV0|YN_PDRV1|YN_PU|YN_SL|YP_CS|YP_IE|YP_PD|YP_PDRV0|YP_PDRV1|YP_PU|YP_SL|ZN_CS|ZN_IE|ZN_PD|ZN_PDRV0|ZN_PDRV1|ZN_PU|ZN_SL|ZP_CS|ZP_IE|ZP_PD|ZP_PDRV0|ZP_PDRV1|ZP_PU|ZP_SL
+ VSS|XN_CS|XN_IE|XN_PD|XN_PDRV0|XN_PDRV1|XN_PU|XN_SL|XP_CS|XP_IE|XP_PD|XP_PDRV0|XP_PDRV1|XP_PU|XP_SL|YN_CS|YN_IE|YN_PD|YN_PDRV0|YN_PDRV1|YN_PU|YN_SL|YP_CS|YP_IE|YP_PD|YP_PDRV0|YP_PDRV1|YP_PU|YP_SL|ZN_CS|ZN_IE|ZN_PD|ZN_PDRV0|ZN_PDRV1|ZN_PU|ZN_SL|ZP_CS|ZP_IE|ZP_PD|ZP_PDRV0|ZP_PDRV1|ZP_PU|ZP_SL
+ nfet_06v0 L=2U W=1U AS=0.44P AD=0.44P PS=2.88U PD=2.88U
M$1857
+ VSS|XN_CS|XN_IE|XN_PD|XN_PDRV0|XN_PDRV1|XN_PU|XN_SL|XP_CS|XP_IE|XP_PD|XP_PDRV0|XP_PDRV1|XP_PU|XP_SL|YN_CS|YN_IE|YN_PD|YN_PDRV0|YN_PDRV1|YN_PU|YN_SL|YP_CS|YP_IE|YP_PD|YP_PDRV0|YP_PDRV1|YP_PU|YP_SL|ZN_CS|ZN_IE|ZN_PD|ZN_PDRV0|ZN_PDRV1|ZN_PU|ZN_SL|ZP_CS|ZP_IE|ZP_PD|ZP_PDRV0|ZP_PDRV1|ZP_PU|ZP_SL
+ VDD|XN_OE|XP_OE|YN_OE|YP_OE|ZN_OE|ZP_OE
+ VSS|XN_CS|XN_IE|XN_PD|XN_PDRV0|XN_PDRV1|XN_PU|XN_SL|XP_CS|XP_IE|XP_PD|XP_PDRV0|XP_PDRV1|XP_PU|XP_SL|YN_CS|YN_IE|YN_PD|YN_PDRV0|YN_PDRV1|YN_PU|YN_SL|YP_CS|YP_IE|YP_PD|YP_PDRV0|YP_PDRV1|YP_PU|YP_SL|ZN_CS|ZN_IE|ZN_PD|ZN_PDRV0|ZN_PDRV1|ZN_PU|ZN_SL|ZP_CS|ZP_IE|ZP_PD|ZP_PDRV0|ZP_PDRV1|ZP_PU|ZP_SL
+ VSS|XN_CS|XN_IE|XN_PD|XN_PDRV0|XN_PDRV1|XN_PU|XN_SL|XP_CS|XP_IE|XP_PD|XP_PDRV0|XP_PDRV1|XP_PU|XP_SL|YN_CS|YN_IE|YN_PD|YN_PDRV0|YN_PDRV1|YN_PU|YN_SL|YP_CS|YP_IE|YP_PD|YP_PDRV0|YP_PDRV1|YP_PU|YP_SL|ZN_CS|ZN_IE|ZN_PD|ZN_PDRV0|ZN_PDRV1|ZN_PU|ZN_SL|ZP_CS|ZP_IE|ZP_PD|ZP_PDRV0|ZP_PDRV1|ZP_PU|ZP_SL
+ nfet_06v0 L=2U W=1U AS=0.44P AD=0.44P PS=2.88U PD=2.88U
M$1858
+ VSS|XN_CS|XN_IE|XN_PD|XN_PDRV0|XN_PDRV1|XN_PU|XN_SL|XP_CS|XP_IE|XP_PD|XP_PDRV0|XP_PDRV1|XP_PU|XP_SL|YN_CS|YN_IE|YN_PD|YN_PDRV0|YN_PDRV1|YN_PU|YN_SL|YP_CS|YP_IE|YP_PD|YP_PDRV0|YP_PDRV1|YP_PU|YP_SL|ZN_CS|ZN_IE|ZN_PD|ZN_PDRV0|ZN_PDRV1|ZN_PU|ZN_SL|ZP_CS|ZP_IE|ZP_PD|ZP_PDRV0|ZP_PDRV1|ZP_PU|ZP_SL
+ VDD|XN_OE|XP_OE|YN_OE|YP_OE|ZN_OE|ZP_OE
+ VSS|XN_CS|XN_IE|XN_PD|XN_PDRV0|XN_PDRV1|XN_PU|XN_SL|XP_CS|XP_IE|XP_PD|XP_PDRV0|XP_PDRV1|XP_PU|XP_SL|YN_CS|YN_IE|YN_PD|YN_PDRV0|YN_PDRV1|YN_PU|YN_SL|YP_CS|YP_IE|YP_PD|YP_PDRV0|YP_PDRV1|YP_PU|YP_SL|ZN_CS|ZN_IE|ZN_PD|ZN_PDRV0|ZN_PDRV1|ZN_PU|ZN_SL|ZP_CS|ZP_IE|ZP_PD|ZP_PDRV0|ZP_PDRV1|ZP_PU|ZP_SL
+ VSS|XN_CS|XN_IE|XN_PD|XN_PDRV0|XN_PDRV1|XN_PU|XN_SL|XP_CS|XP_IE|XP_PD|XP_PDRV0|XP_PDRV1|XP_PU|XP_SL|YN_CS|YN_IE|YN_PD|YN_PDRV0|YN_PDRV1|YN_PU|YN_SL|YP_CS|YP_IE|YP_PD|YP_PDRV0|YP_PDRV1|YP_PU|YP_SL|ZN_CS|ZN_IE|ZN_PD|ZN_PDRV0|ZN_PDRV1|ZN_PU|ZN_SL|ZP_CS|ZP_IE|ZP_PD|ZP_PDRV0|ZP_PDRV1|ZP_PU|ZP_SL
+ nfet_06v0 L=2U W=1U AS=0.44P AD=0.44P PS=2.88U PD=2.88U
M$1859
+ VSS|XN_CS|XN_IE|XN_PD|XN_PDRV0|XN_PDRV1|XN_PU|XN_SL|XP_CS|XP_IE|XP_PD|XP_PDRV0|XP_PDRV1|XP_PU|XP_SL|YN_CS|YN_IE|YN_PD|YN_PDRV0|YN_PDRV1|YN_PU|YN_SL|YP_CS|YP_IE|YP_PD|YP_PDRV0|YP_PDRV1|YP_PU|YP_SL|ZN_CS|ZN_IE|ZN_PD|ZN_PDRV0|ZN_PDRV1|ZN_PU|ZN_SL|ZP_CS|ZP_IE|ZP_PD|ZP_PDRV0|ZP_PDRV1|ZP_PU|ZP_SL
+ VDD|XN_OE|XP_OE|YN_OE|YP_OE|ZN_OE|ZP_OE
+ VSS|XN_CS|XN_IE|XN_PD|XN_PDRV0|XN_PDRV1|XN_PU|XN_SL|XP_CS|XP_IE|XP_PD|XP_PDRV0|XP_PDRV1|XP_PU|XP_SL|YN_CS|YN_IE|YN_PD|YN_PDRV0|YN_PDRV1|YN_PU|YN_SL|YP_CS|YP_IE|YP_PD|YP_PDRV0|YP_PDRV1|YP_PU|YP_SL|ZN_CS|ZN_IE|ZN_PD|ZN_PDRV0|ZN_PDRV1|ZN_PU|ZN_SL|ZP_CS|ZP_IE|ZP_PD|ZP_PDRV0|ZP_PDRV1|ZP_PU|ZP_SL
+ VSS|XN_CS|XN_IE|XN_PD|XN_PDRV0|XN_PDRV1|XN_PU|XN_SL|XP_CS|XP_IE|XP_PD|XP_PDRV0|XP_PDRV1|XP_PU|XP_SL|YN_CS|YN_IE|YN_PD|YN_PDRV0|YN_PDRV1|YN_PU|YN_SL|YP_CS|YP_IE|YP_PD|YP_PDRV0|YP_PDRV1|YP_PU|YP_SL|ZN_CS|ZN_IE|ZN_PD|ZN_PDRV0|ZN_PDRV1|ZN_PU|ZN_SL|ZP_CS|ZP_IE|ZP_PD|ZP_PDRV0|ZP_PDRV1|ZP_PU|ZP_SL
+ nfet_06v0 L=2U W=1U AS=0.44P AD=0.44P PS=2.88U PD=2.88U
M$1860
+ VSS|XN_CS|XN_IE|XN_PD|XN_PDRV0|XN_PDRV1|XN_PU|XN_SL|XP_CS|XP_IE|XP_PD|XP_PDRV0|XP_PDRV1|XP_PU|XP_SL|YN_CS|YN_IE|YN_PD|YN_PDRV0|YN_PDRV1|YN_PU|YN_SL|YP_CS|YP_IE|YP_PD|YP_PDRV0|YP_PDRV1|YP_PU|YP_SL|ZN_CS|ZN_IE|ZN_PD|ZN_PDRV0|ZN_PDRV1|ZN_PU|ZN_SL|ZP_CS|ZP_IE|ZP_PD|ZP_PDRV0|ZP_PDRV1|ZP_PU|ZP_SL
+ VDD|XN_OE|XP_OE|YN_OE|YP_OE|ZN_OE|ZP_OE
+ VSS|XN_CS|XN_IE|XN_PD|XN_PDRV0|XN_PDRV1|XN_PU|XN_SL|XP_CS|XP_IE|XP_PD|XP_PDRV0|XP_PDRV1|XP_PU|XP_SL|YN_CS|YN_IE|YN_PD|YN_PDRV0|YN_PDRV1|YN_PU|YN_SL|YP_CS|YP_IE|YP_PD|YP_PDRV0|YP_PDRV1|YP_PU|YP_SL|ZN_CS|ZN_IE|ZN_PD|ZN_PDRV0|ZN_PDRV1|ZN_PU|ZN_SL|ZP_CS|ZP_IE|ZP_PD|ZP_PDRV0|ZP_PDRV1|ZP_PU|ZP_SL
+ VSS|XN_CS|XN_IE|XN_PD|XN_PDRV0|XN_PDRV1|XN_PU|XN_SL|XP_CS|XP_IE|XP_PD|XP_PDRV0|XP_PDRV1|XP_PU|XP_SL|YN_CS|YN_IE|YN_PD|YN_PDRV0|YN_PDRV1|YN_PU|YN_SL|YP_CS|YP_IE|YP_PD|YP_PDRV0|YP_PDRV1|YP_PU|YP_SL|ZN_CS|ZN_IE|ZN_PD|ZN_PDRV0|ZN_PDRV1|ZN_PU|ZN_SL|ZP_CS|ZP_IE|ZP_PD|ZP_PDRV0|ZP_PDRV1|ZP_PU|ZP_SL
+ nfet_06v0 L=2U W=1U AS=0.44P AD=0.44P PS=2.88U PD=2.88U
D$1861
+ VSS|XN_CS|XN_IE|XN_PD|XN_PDRV0|XN_PDRV1|XN_PU|XN_SL|XP_CS|XP_IE|XP_PD|XP_PDRV0|XP_PDRV1|XP_PU|XP_SL|YN_CS|YN_IE|YN_PD|YN_PDRV0|YN_PDRV1|YN_PU|YN_SL|YP_CS|YP_IE|YP_PD|YP_PDRV0|YP_PDRV1|YP_PU|YP_SL|ZN_CS|ZN_IE|ZN_PD|ZN_PDRV0|ZN_PDRV1|ZN_PU|ZN_SL|ZP_CS|ZP_IE|ZP_PD|ZP_PDRV0|ZP_PDRV1|ZP_PU|ZP_SL
+ \$14438 diode_nd2ps_06v0 A=100P P=40U
D$1862
+ VSS|XN_CS|XN_IE|XN_PD|XN_PDRV0|XN_PDRV1|XN_PU|XN_SL|XP_CS|XP_IE|XP_PD|XP_PDRV0|XP_PDRV1|XP_PU|XP_SL|YN_CS|YN_IE|YN_PD|YN_PDRV0|YN_PDRV1|YN_PU|YN_SL|YP_CS|YP_IE|YP_PD|YP_PDRV0|YP_PDRV1|YP_PU|YP_SL|ZN_CS|ZN_IE|ZN_PD|ZN_PDRV0|ZN_PDRV1|ZN_PU|ZN_SL|ZP_CS|ZP_IE|ZP_PD|ZP_PDRV0|ZP_PDRV1|ZP_PU|ZP_SL
+ \$14438 diode_nd2ps_06v0 A=100P P=40U
D$1863
+ VSS|XN_CS|XN_IE|XN_PD|XN_PDRV0|XN_PDRV1|XN_PU|XN_SL|XP_CS|XP_IE|XP_PD|XP_PDRV0|XP_PDRV1|XP_PU|XP_SL|YN_CS|YN_IE|YN_PD|YN_PDRV0|YN_PDRV1|YN_PU|YN_SL|YP_CS|YP_IE|YP_PD|YP_PDRV0|YP_PDRV1|YP_PU|YP_SL|ZN_CS|ZN_IE|ZN_PD|ZN_PDRV0|ZN_PDRV1|ZN_PU|ZN_SL|ZP_CS|ZP_IE|ZP_PD|ZP_PDRV0|ZP_PDRV1|ZP_PU|ZP_SL
+ \$14438 diode_nd2ps_06v0 A=100P P=40U
D$1864
+ VSS|XN_CS|XN_IE|XN_PD|XN_PDRV0|XN_PDRV1|XN_PU|XN_SL|XP_CS|XP_IE|XP_PD|XP_PDRV0|XP_PDRV1|XP_PU|XP_SL|YN_CS|YN_IE|YN_PD|YN_PDRV0|YN_PDRV1|YN_PU|YN_SL|YP_CS|YP_IE|YP_PD|YP_PDRV0|YP_PDRV1|YP_PU|YP_SL|ZN_CS|ZN_IE|ZN_PD|ZN_PDRV0|ZN_PDRV1|ZN_PU|ZN_SL|ZP_CS|ZP_IE|ZP_PD|ZP_PDRV0|ZP_PDRV1|ZP_PU|ZP_SL
+ \$14438 diode_nd2ps_06v0 A=100P P=40U
D$1865
+ VSS|XN_CS|XN_IE|XN_PD|XN_PDRV0|XN_PDRV1|XN_PU|XN_SL|XP_CS|XP_IE|XP_PD|XP_PDRV0|XP_PDRV1|XP_PU|XP_SL|YN_CS|YN_IE|YN_PD|YN_PDRV0|YN_PDRV1|YN_PU|YN_SL|YP_CS|YP_IE|YP_PD|YP_PDRV0|YP_PDRV1|YP_PU|YP_SL|ZN_CS|ZN_IE|ZN_PD|ZN_PDRV0|ZN_PDRV1|ZN_PU|ZN_SL|ZP_CS|ZP_IE|ZP_PD|ZP_PDRV0|ZP_PDRV1|ZP_PU|ZP_SL
+ \$14440 diode_nd2ps_06v0 A=100P P=40U
D$1866
+ VSS|XN_CS|XN_IE|XN_PD|XN_PDRV0|XN_PDRV1|XN_PU|XN_SL|XP_CS|XP_IE|XP_PD|XP_PDRV0|XP_PDRV1|XP_PU|XP_SL|YN_CS|YN_IE|YN_PD|YN_PDRV0|YN_PDRV1|YN_PU|YN_SL|YP_CS|YP_IE|YP_PD|YP_PDRV0|YP_PDRV1|YP_PU|YP_SL|ZN_CS|ZN_IE|ZN_PD|ZN_PDRV0|ZN_PDRV1|ZN_PU|ZN_SL|ZP_CS|ZP_IE|ZP_PD|ZP_PDRV0|ZP_PDRV1|ZP_PU|ZP_SL
+ \$14440 diode_nd2ps_06v0 A=100P P=40U
D$1867
+ VSS|XN_CS|XN_IE|XN_PD|XN_PDRV0|XN_PDRV1|XN_PU|XN_SL|XP_CS|XP_IE|XP_PD|XP_PDRV0|XP_PDRV1|XP_PU|XP_SL|YN_CS|YN_IE|YN_PD|YN_PDRV0|YN_PDRV1|YN_PU|YN_SL|YP_CS|YP_IE|YP_PD|YP_PDRV0|YP_PDRV1|YP_PU|YP_SL|ZN_CS|ZN_IE|ZN_PD|ZN_PDRV0|ZN_PDRV1|ZN_PU|ZN_SL|ZP_CS|ZP_IE|ZP_PD|ZP_PDRV0|ZP_PDRV1|ZP_PU|ZP_SL
+ \$14440 diode_nd2ps_06v0 A=100P P=40U
D$1868
+ VSS|XN_CS|XN_IE|XN_PD|XN_PDRV0|XN_PDRV1|XN_PU|XN_SL|XP_CS|XP_IE|XP_PD|XP_PDRV0|XP_PDRV1|XP_PU|XP_SL|YN_CS|YN_IE|YN_PD|YN_PDRV0|YN_PDRV1|YN_PU|YN_SL|YP_CS|YP_IE|YP_PD|YP_PDRV0|YP_PDRV1|YP_PU|YP_SL|ZN_CS|ZN_IE|ZN_PD|ZN_PDRV0|ZN_PDRV1|ZN_PU|ZN_SL|ZP_CS|ZP_IE|ZP_PD|ZP_PDRV0|ZP_PDRV1|ZP_PU|ZP_SL
+ \$14440 diode_nd2ps_06v0 A=100P P=40U
D$1869
+ VSS|XN_CS|XN_IE|XN_PD|XN_PDRV0|XN_PDRV1|XN_PU|XN_SL|XP_CS|XP_IE|XP_PD|XP_PDRV0|XP_PDRV1|XP_PU|XP_SL|YN_CS|YN_IE|YN_PD|YN_PDRV0|YN_PDRV1|YN_PU|YN_SL|YP_CS|YP_IE|YP_PD|YP_PDRV0|YP_PDRV1|YP_PU|YP_SL|ZN_CS|ZN_IE|ZN_PD|ZN_PDRV0|ZN_PDRV1|ZN_PU|ZN_SL|ZP_CS|ZP_IE|ZP_PD|ZP_PDRV0|ZP_PDRV1|ZP_PU|ZP_SL
+ \$14435 diode_nd2ps_06v0 A=100P P=40U
D$1870
+ VSS|XN_CS|XN_IE|XN_PD|XN_PDRV0|XN_PDRV1|XN_PU|XN_SL|XP_CS|XP_IE|XP_PD|XP_PDRV0|XP_PDRV1|XP_PU|XP_SL|YN_CS|YN_IE|YN_PD|YN_PDRV0|YN_PDRV1|YN_PU|YN_SL|YP_CS|YP_IE|YP_PD|YP_PDRV0|YP_PDRV1|YP_PU|YP_SL|ZN_CS|ZN_IE|ZN_PD|ZN_PDRV0|ZN_PDRV1|ZN_PU|ZN_SL|ZP_CS|ZP_IE|ZP_PD|ZP_PDRV0|ZP_PDRV1|ZP_PU|ZP_SL
+ \$14435 diode_nd2ps_06v0 A=100P P=40U
D$1871
+ VSS|XN_CS|XN_IE|XN_PD|XN_PDRV0|XN_PDRV1|XN_PU|XN_SL|XP_CS|XP_IE|XP_PD|XP_PDRV0|XP_PDRV1|XP_PU|XP_SL|YN_CS|YN_IE|YN_PD|YN_PDRV0|YN_PDRV1|YN_PU|YN_SL|YP_CS|YP_IE|YP_PD|YP_PDRV0|YP_PDRV1|YP_PU|YP_SL|ZN_CS|ZN_IE|ZN_PD|ZN_PDRV0|ZN_PDRV1|ZN_PU|ZN_SL|ZP_CS|ZP_IE|ZP_PD|ZP_PDRV0|ZP_PDRV1|ZP_PU|ZP_SL
+ \$14435 diode_nd2ps_06v0 A=100P P=40U
D$1872
+ VSS|XN_CS|XN_IE|XN_PD|XN_PDRV0|XN_PDRV1|XN_PU|XN_SL|XP_CS|XP_IE|XP_PD|XP_PDRV0|XP_PDRV1|XP_PU|XP_SL|YN_CS|YN_IE|YN_PD|YN_PDRV0|YN_PDRV1|YN_PU|YN_SL|YP_CS|YP_IE|YP_PD|YP_PDRV0|YP_PDRV1|YP_PU|YP_SL|ZN_CS|ZN_IE|ZN_PD|ZN_PDRV0|ZN_PDRV1|ZN_PU|ZN_SL|ZP_CS|ZP_IE|ZP_PD|ZP_PDRV0|ZP_PDRV1|ZP_PU|ZP_SL
+ \$14435 diode_nd2ps_06v0 A=100P P=40U
D$1873
+ VSS|XN_CS|XN_IE|XN_PD|XN_PDRV0|XN_PDRV1|XN_PU|XN_SL|XP_CS|XP_IE|XP_PD|XP_PDRV0|XP_PDRV1|XP_PU|XP_SL|YN_CS|YN_IE|YN_PD|YN_PDRV0|YN_PDRV1|YN_PU|YN_SL|YP_CS|YP_IE|YP_PD|YP_PDRV0|YP_PDRV1|YP_PU|YP_SL|ZN_CS|ZN_IE|ZN_PD|ZN_PDRV0|ZN_PDRV1|ZN_PU|ZN_SL|ZP_CS|ZP_IE|ZP_PD|ZP_PDRV0|ZP_PDRV1|ZP_PU|ZP_SL
+ X diode_nd2ps_06v0 A=100P P=40U
D$1874
+ VSS|XN_CS|XN_IE|XN_PD|XN_PDRV0|XN_PDRV1|XN_PU|XN_SL|XP_CS|XP_IE|XP_PD|XP_PDRV0|XP_PDRV1|XP_PU|XP_SL|YN_CS|YN_IE|YN_PD|YN_PDRV0|YN_PDRV1|YN_PU|YN_SL|YP_CS|YP_IE|YP_PD|YP_PDRV0|YP_PDRV1|YP_PU|YP_SL|ZN_CS|ZN_IE|ZN_PD|ZN_PDRV0|ZN_PDRV1|ZN_PU|ZN_SL|ZP_CS|ZP_IE|ZP_PD|ZP_PDRV0|ZP_PDRV1|ZP_PU|ZP_SL
+ X diode_nd2ps_06v0 A=100P P=40U
D$1875
+ VSS|XN_CS|XN_IE|XN_PD|XN_PDRV0|XN_PDRV1|XN_PU|XN_SL|XP_CS|XP_IE|XP_PD|XP_PDRV0|XP_PDRV1|XP_PU|XP_SL|YN_CS|YN_IE|YN_PD|YN_PDRV0|YN_PDRV1|YN_PU|YN_SL|YP_CS|YP_IE|YP_PD|YP_PDRV0|YP_PDRV1|YP_PU|YP_SL|ZN_CS|ZN_IE|ZN_PD|ZN_PDRV0|ZN_PDRV1|ZN_PU|ZN_SL|ZP_CS|ZP_IE|ZP_PD|ZP_PDRV0|ZP_PDRV1|ZP_PU|ZP_SL
+ X diode_nd2ps_06v0 A=100P P=40U
D$1876
+ VSS|XN_CS|XN_IE|XN_PD|XN_PDRV0|XN_PDRV1|XN_PU|XN_SL|XP_CS|XP_IE|XP_PD|XP_PDRV0|XP_PDRV1|XP_PU|XP_SL|YN_CS|YN_IE|YN_PD|YN_PDRV0|YN_PDRV1|YN_PU|YN_SL|YP_CS|YP_IE|YP_PD|YP_PDRV0|YP_PDRV1|YP_PU|YP_SL|ZN_CS|ZN_IE|ZN_PD|ZN_PDRV0|ZN_PDRV1|ZN_PU|ZN_SL|ZP_CS|ZP_IE|ZP_PD|ZP_PDRV0|ZP_PDRV1|ZP_PU|ZP_SL
+ X diode_nd2ps_06v0 A=100P P=40U
D$1877
+ VSS|XN_CS|XN_IE|XN_PD|XN_PDRV0|XN_PDRV1|XN_PU|XN_SL|XP_CS|XP_IE|XP_PD|XP_PDRV0|XP_PDRV1|XP_PU|XP_SL|YN_CS|YN_IE|YN_PD|YN_PDRV0|YN_PDRV1|YN_PU|YN_SL|YP_CS|YP_IE|YP_PD|YP_PDRV0|YP_PDRV1|YP_PU|YP_SL|ZN_CS|ZN_IE|ZN_PD|ZN_PDRV0|ZN_PDRV1|ZN_PU|ZN_SL|ZP_CS|ZP_IE|ZP_PD|ZP_PDRV0|ZP_PDRV1|ZP_PU|ZP_SL
+ \$14436 diode_nd2ps_06v0 A=100P P=40U
D$1878
+ VSS|XN_CS|XN_IE|XN_PD|XN_PDRV0|XN_PDRV1|XN_PU|XN_SL|XP_CS|XP_IE|XP_PD|XP_PDRV0|XP_PDRV1|XP_PU|XP_SL|YN_CS|YN_IE|YN_PD|YN_PDRV0|YN_PDRV1|YN_PU|YN_SL|YP_CS|YP_IE|YP_PD|YP_PDRV0|YP_PDRV1|YP_PU|YP_SL|ZN_CS|ZN_IE|ZN_PD|ZN_PDRV0|ZN_PDRV1|ZN_PU|ZN_SL|ZP_CS|ZP_IE|ZP_PD|ZP_PDRV0|ZP_PDRV1|ZP_PU|ZP_SL
+ \$14436 diode_nd2ps_06v0 A=100P P=40U
D$1879
+ VSS|XN_CS|XN_IE|XN_PD|XN_PDRV0|XN_PDRV1|XN_PU|XN_SL|XP_CS|XP_IE|XP_PD|XP_PDRV0|XP_PDRV1|XP_PU|XP_SL|YN_CS|YN_IE|YN_PD|YN_PDRV0|YN_PDRV1|YN_PU|YN_SL|YP_CS|YP_IE|YP_PD|YP_PDRV0|YP_PDRV1|YP_PU|YP_SL|ZN_CS|ZN_IE|ZN_PD|ZN_PDRV0|ZN_PDRV1|ZN_PU|ZN_SL|ZP_CS|ZP_IE|ZP_PD|ZP_PDRV0|ZP_PDRV1|ZP_PU|ZP_SL
+ \$14436 diode_nd2ps_06v0 A=100P P=40U
D$1880
+ VSS|XN_CS|XN_IE|XN_PD|XN_PDRV0|XN_PDRV1|XN_PU|XN_SL|XP_CS|XP_IE|XP_PD|XP_PDRV0|XP_PDRV1|XP_PU|XP_SL|YN_CS|YN_IE|YN_PD|YN_PDRV0|YN_PDRV1|YN_PU|YN_SL|YP_CS|YP_IE|YP_PD|YP_PDRV0|YP_PDRV1|YP_PU|YP_SL|ZN_CS|ZN_IE|ZN_PD|ZN_PDRV0|ZN_PDRV1|ZN_PU|ZN_SL|ZP_CS|ZP_IE|ZP_PD|ZP_PDRV0|ZP_PDRV1|ZP_PU|ZP_SL
+ \$14436 diode_nd2ps_06v0 A=100P P=40U
D$1881
+ VSS|XN_CS|XN_IE|XN_PD|XN_PDRV0|XN_PDRV1|XN_PU|XN_SL|XP_CS|XP_IE|XP_PD|XP_PDRV0|XP_PDRV1|XP_PU|XP_SL|YN_CS|YN_IE|YN_PD|YN_PDRV0|YN_PDRV1|YN_PU|YN_SL|YP_CS|YP_IE|YP_PD|YP_PDRV0|YP_PDRV1|YP_PU|YP_SL|ZN_CS|ZN_IE|ZN_PD|ZN_PDRV0|ZN_PDRV1|ZN_PU|ZN_SL|ZP_CS|ZP_IE|ZP_PD|ZP_PDRV0|ZP_PDRV1|ZP_PU|ZP_SL
+ \$14439 diode_nd2ps_06v0 A=100P P=40U
D$1882
+ VSS|XN_CS|XN_IE|XN_PD|XN_PDRV0|XN_PDRV1|XN_PU|XN_SL|XP_CS|XP_IE|XP_PD|XP_PDRV0|XP_PDRV1|XP_PU|XP_SL|YN_CS|YN_IE|YN_PD|YN_PDRV0|YN_PDRV1|YN_PU|YN_SL|YP_CS|YP_IE|YP_PD|YP_PDRV0|YP_PDRV1|YP_PU|YP_SL|ZN_CS|ZN_IE|ZN_PD|ZN_PDRV0|ZN_PDRV1|ZN_PU|ZN_SL|ZP_CS|ZP_IE|ZP_PD|ZP_PDRV0|ZP_PDRV1|ZP_PU|ZP_SL
+ \$14439 diode_nd2ps_06v0 A=100P P=40U
D$1883
+ VSS|XN_CS|XN_IE|XN_PD|XN_PDRV0|XN_PDRV1|XN_PU|XN_SL|XP_CS|XP_IE|XP_PD|XP_PDRV0|XP_PDRV1|XP_PU|XP_SL|YN_CS|YN_IE|YN_PD|YN_PDRV0|YN_PDRV1|YN_PU|YN_SL|YP_CS|YP_IE|YP_PD|YP_PDRV0|YP_PDRV1|YP_PU|YP_SL|ZN_CS|ZN_IE|ZN_PD|ZN_PDRV0|ZN_PDRV1|ZN_PU|ZN_SL|ZP_CS|ZP_IE|ZP_PD|ZP_PDRV0|ZP_PDRV1|ZP_PU|ZP_SL
+ \$14439 diode_nd2ps_06v0 A=100P P=40U
D$1884
+ VSS|XN_CS|XN_IE|XN_PD|XN_PDRV0|XN_PDRV1|XN_PU|XN_SL|XP_CS|XP_IE|XP_PD|XP_PDRV0|XP_PDRV1|XP_PU|XP_SL|YN_CS|YN_IE|YN_PD|YN_PDRV0|YN_PDRV1|YN_PU|YN_SL|YP_CS|YP_IE|YP_PD|YP_PDRV0|YP_PDRV1|YP_PU|YP_SL|ZN_CS|ZN_IE|ZN_PD|ZN_PDRV0|ZN_PDRV1|ZN_PU|ZN_SL|ZP_CS|ZP_IE|ZP_PD|ZP_PDRV0|ZP_PDRV1|ZP_PU|ZP_SL
+ \$14439 diode_nd2ps_06v0 A=100P P=40U
D$1885
+ VSS|XN_CS|XN_IE|XN_PD|XN_PDRV0|XN_PDRV1|XN_PU|XN_SL|XP_CS|XP_IE|XP_PD|XP_PDRV0|XP_PDRV1|XP_PU|XP_SL|YN_CS|YN_IE|YN_PD|YN_PDRV0|YN_PDRV1|YN_PU|YN_SL|YP_CS|YP_IE|YP_PD|YP_PDRV0|YP_PDRV1|YP_PU|YP_SL|ZN_CS|ZN_IE|ZN_PD|ZN_PDRV0|ZN_PDRV1|ZN_PU|ZN_SL|ZP_CS|ZP_IE|ZP_PD|ZP_PDRV0|ZP_PDRV1|ZP_PU|ZP_SL
+ S4N diode_nd2ps_06v0 A=100P P=40U
D$1886
+ VSS|XN_CS|XN_IE|XN_PD|XN_PDRV0|XN_PDRV1|XN_PU|XN_SL|XP_CS|XP_IE|XP_PD|XP_PDRV0|XP_PDRV1|XP_PU|XP_SL|YN_CS|YN_IE|YN_PD|YN_PDRV0|YN_PDRV1|YN_PU|YN_SL|YP_CS|YP_IE|YP_PD|YP_PDRV0|YP_PDRV1|YP_PU|YP_SL|ZN_CS|ZN_IE|ZN_PD|ZN_PDRV0|ZN_PDRV1|ZN_PU|ZN_SL|ZP_CS|ZP_IE|ZP_PD|ZP_PDRV0|ZP_PDRV1|ZP_PU|ZP_SL
+ S4N diode_nd2ps_06v0 A=100P P=40U
D$1887
+ VSS|XN_CS|XN_IE|XN_PD|XN_PDRV0|XN_PDRV1|XN_PU|XN_SL|XP_CS|XP_IE|XP_PD|XP_PDRV0|XP_PDRV1|XP_PU|XP_SL|YN_CS|YN_IE|YN_PD|YN_PDRV0|YN_PDRV1|YN_PU|YN_SL|YP_CS|YP_IE|YP_PD|YP_PDRV0|YP_PDRV1|YP_PU|YP_SL|ZN_CS|ZN_IE|ZN_PD|ZN_PDRV0|ZN_PDRV1|ZN_PU|ZN_SL|ZP_CS|ZP_IE|ZP_PD|ZP_PDRV0|ZP_PDRV1|ZP_PU|ZP_SL
+ S4N diode_nd2ps_06v0 A=100P P=40U
D$1888
+ VSS|XN_CS|XN_IE|XN_PD|XN_PDRV0|XN_PDRV1|XN_PU|XN_SL|XP_CS|XP_IE|XP_PD|XP_PDRV0|XP_PDRV1|XP_PU|XP_SL|YN_CS|YN_IE|YN_PD|YN_PDRV0|YN_PDRV1|YN_PU|YN_SL|YP_CS|YP_IE|YP_PD|YP_PDRV0|YP_PDRV1|YP_PU|YP_SL|ZN_CS|ZN_IE|ZN_PD|ZN_PDRV0|ZN_PDRV1|ZN_PU|ZN_SL|ZP_CS|ZP_IE|ZP_PD|ZP_PDRV0|ZP_PDRV1|ZP_PU|ZP_SL
+ S4N diode_nd2ps_06v0 A=100P P=40U
D$1889
+ VSS|XN_CS|XN_IE|XN_PD|XN_PDRV0|XN_PDRV1|XN_PU|XN_SL|XP_CS|XP_IE|XP_PD|XP_PDRV0|XP_PDRV1|XP_PU|XP_SL|YN_CS|YN_IE|YN_PD|YN_PDRV0|YN_PDRV1|YN_PU|YN_SL|YP_CS|YP_IE|YP_PD|YP_PDRV0|YP_PDRV1|YP_PU|YP_SL|ZN_CS|ZN_IE|ZN_PD|ZN_PDRV0|ZN_PDRV1|ZN_PU|ZN_SL|ZP_CS|ZP_IE|ZP_PD|ZP_PDRV0|ZP_PDRV1|ZP_PU|ZP_SL
+ Y diode_nd2ps_06v0 A=100P P=40U
D$1890
+ VSS|XN_CS|XN_IE|XN_PD|XN_PDRV0|XN_PDRV1|XN_PU|XN_SL|XP_CS|XP_IE|XP_PD|XP_PDRV0|XP_PDRV1|XP_PU|XP_SL|YN_CS|YN_IE|YN_PD|YN_PDRV0|YN_PDRV1|YN_PU|YN_SL|YP_CS|YP_IE|YP_PD|YP_PDRV0|YP_PDRV1|YP_PU|YP_SL|ZN_CS|ZN_IE|ZN_PD|ZN_PDRV0|ZN_PDRV1|ZN_PU|ZN_SL|ZP_CS|ZP_IE|ZP_PD|ZP_PDRV0|ZP_PDRV1|ZP_PU|ZP_SL
+ Y diode_nd2ps_06v0 A=100P P=40U
D$1891
+ VSS|XN_CS|XN_IE|XN_PD|XN_PDRV0|XN_PDRV1|XN_PU|XN_SL|XP_CS|XP_IE|XP_PD|XP_PDRV0|XP_PDRV1|XP_PU|XP_SL|YN_CS|YN_IE|YN_PD|YN_PDRV0|YN_PDRV1|YN_PU|YN_SL|YP_CS|YP_IE|YP_PD|YP_PDRV0|YP_PDRV1|YP_PU|YP_SL|ZN_CS|ZN_IE|ZN_PD|ZN_PDRV0|ZN_PDRV1|ZN_PU|ZN_SL|ZP_CS|ZP_IE|ZP_PD|ZP_PDRV0|ZP_PDRV1|ZP_PU|ZP_SL
+ Y diode_nd2ps_06v0 A=100P P=40U
D$1892
+ VSS|XN_CS|XN_IE|XN_PD|XN_PDRV0|XN_PDRV1|XN_PU|XN_SL|XP_CS|XP_IE|XP_PD|XP_PDRV0|XP_PDRV1|XP_PU|XP_SL|YN_CS|YN_IE|YN_PD|YN_PDRV0|YN_PDRV1|YN_PU|YN_SL|YP_CS|YP_IE|YP_PD|YP_PDRV0|YP_PDRV1|YP_PU|YP_SL|ZN_CS|ZN_IE|ZN_PD|ZN_PDRV0|ZN_PDRV1|ZN_PU|ZN_SL|ZP_CS|ZP_IE|ZP_PD|ZP_PDRV0|ZP_PDRV1|ZP_PU|ZP_SL
+ Y diode_nd2ps_06v0 A=100P P=40U
D$1893
+ VSS|XN_CS|XN_IE|XN_PD|XN_PDRV0|XN_PDRV1|XN_PU|XN_SL|XP_CS|XP_IE|XP_PD|XP_PDRV0|XP_PDRV1|XP_PU|XP_SL|YN_CS|YN_IE|YN_PD|YN_PDRV0|YN_PDRV1|YN_PU|YN_SL|YP_CS|YP_IE|YP_PD|YP_PDRV0|YP_PDRV1|YP_PU|YP_SL|ZN_CS|ZN_IE|ZN_PD|ZN_PDRV0|ZN_PDRV1|ZN_PU|ZN_SL|ZP_CS|ZP_IE|ZP_PD|ZP_PDRV0|ZP_PDRV1|ZP_PU|ZP_SL
+ Z diode_nd2ps_06v0 A=100P P=40U
D$1894
+ VSS|XN_CS|XN_IE|XN_PD|XN_PDRV0|XN_PDRV1|XN_PU|XN_SL|XP_CS|XP_IE|XP_PD|XP_PDRV0|XP_PDRV1|XP_PU|XP_SL|YN_CS|YN_IE|YN_PD|YN_PDRV0|YN_PDRV1|YN_PU|YN_SL|YP_CS|YP_IE|YP_PD|YP_PDRV0|YP_PDRV1|YP_PU|YP_SL|ZN_CS|ZN_IE|ZN_PD|ZN_PDRV0|ZN_PDRV1|ZN_PU|ZN_SL|ZP_CS|ZP_IE|ZP_PD|ZP_PDRV0|ZP_PDRV1|ZP_PU|ZP_SL
+ Z diode_nd2ps_06v0 A=100P P=40U
D$1895
+ VSS|XN_CS|XN_IE|XN_PD|XN_PDRV0|XN_PDRV1|XN_PU|XN_SL|XP_CS|XP_IE|XP_PD|XP_PDRV0|XP_PDRV1|XP_PU|XP_SL|YN_CS|YN_IE|YN_PD|YN_PDRV0|YN_PDRV1|YN_PU|YN_SL|YP_CS|YP_IE|YP_PD|YP_PDRV0|YP_PDRV1|YP_PU|YP_SL|ZN_CS|ZN_IE|ZN_PD|ZN_PDRV0|ZN_PDRV1|ZN_PU|ZN_SL|ZP_CS|ZP_IE|ZP_PD|ZP_PDRV0|ZP_PDRV1|ZP_PU|ZP_SL
+ Z diode_nd2ps_06v0 A=100P P=40U
D$1896
+ VSS|XN_CS|XN_IE|XN_PD|XN_PDRV0|XN_PDRV1|XN_PU|XN_SL|XP_CS|XP_IE|XP_PD|XP_PDRV0|XP_PDRV1|XP_PU|XP_SL|YN_CS|YN_IE|YN_PD|YN_PDRV0|YN_PDRV1|YN_PU|YN_SL|YP_CS|YP_IE|YP_PD|YP_PDRV0|YP_PDRV1|YP_PU|YP_SL|ZN_CS|ZN_IE|ZN_PD|ZN_PDRV0|ZN_PDRV1|ZN_PU|ZN_SL|ZP_CS|ZP_IE|ZP_PD|ZP_PDRV0|ZP_PDRV1|ZP_PU|ZP_SL
+ Z diode_nd2ps_06v0 A=100P P=40U
D$1897
+ VSS|XN_CS|XN_IE|XN_PD|XN_PDRV0|XN_PDRV1|XN_PU|XN_SL|XP_CS|XP_IE|XP_PD|XP_PDRV0|XP_PDRV1|XP_PU|XP_SL|YN_CS|YN_IE|YN_PD|YN_PDRV0|YN_PDRV1|YN_PU|YN_SL|YP_CS|YP_IE|YP_PD|YP_PDRV0|YP_PDRV1|YP_PU|YP_SL|ZN_CS|ZN_IE|ZN_PD|ZN_PDRV0|ZN_PDRV1|ZN_PU|ZN_SL|ZP_CS|ZP_IE|ZP_PD|ZP_PDRV0|ZP_PDRV1|ZP_PU|ZP_SL
+ S4P diode_nd2ps_06v0 A=100P P=40U
D$1898
+ VSS|XN_CS|XN_IE|XN_PD|XN_PDRV0|XN_PDRV1|XN_PU|XN_SL|XP_CS|XP_IE|XP_PD|XP_PDRV0|XP_PDRV1|XP_PU|XP_SL|YN_CS|YN_IE|YN_PD|YN_PDRV0|YN_PDRV1|YN_PU|YN_SL|YP_CS|YP_IE|YP_PD|YP_PDRV0|YP_PDRV1|YP_PU|YP_SL|ZN_CS|ZN_IE|ZN_PD|ZN_PDRV0|ZN_PDRV1|ZN_PU|ZN_SL|ZP_CS|ZP_IE|ZP_PD|ZP_PDRV0|ZP_PDRV1|ZP_PU|ZP_SL
+ S4P diode_nd2ps_06v0 A=100P P=40U
D$1899
+ VSS|XN_CS|XN_IE|XN_PD|XN_PDRV0|XN_PDRV1|XN_PU|XN_SL|XP_CS|XP_IE|XP_PD|XP_PDRV0|XP_PDRV1|XP_PU|XP_SL|YN_CS|YN_IE|YN_PD|YN_PDRV0|YN_PDRV1|YN_PU|YN_SL|YP_CS|YP_IE|YP_PD|YP_PDRV0|YP_PDRV1|YP_PU|YP_SL|ZN_CS|ZN_IE|ZN_PD|ZN_PDRV0|ZN_PDRV1|ZN_PU|ZN_SL|ZP_CS|ZP_IE|ZP_PD|ZP_PDRV0|ZP_PDRV1|ZP_PU|ZP_SL
+ S4P diode_nd2ps_06v0 A=100P P=40U
D$1900
+ VSS|XN_CS|XN_IE|XN_PD|XN_PDRV0|XN_PDRV1|XN_PU|XN_SL|XP_CS|XP_IE|XP_PD|XP_PDRV0|XP_PDRV1|XP_PU|XP_SL|YN_CS|YN_IE|YN_PD|YN_PDRV0|YN_PDRV1|YN_PU|YN_SL|YP_CS|YP_IE|YP_PD|YP_PDRV0|YP_PDRV1|YP_PU|YP_SL|ZN_CS|ZN_IE|ZN_PD|ZN_PDRV0|ZN_PDRV1|ZN_PU|ZN_SL|ZP_CS|ZP_IE|ZP_PD|ZP_PDRV0|ZP_PDRV1|ZP_PU|ZP_SL
+ S4P diode_nd2ps_06v0 A=100P P=40U
D$1901
+ VSS|XN_CS|XN_IE|XN_PD|XN_PDRV0|XN_PDRV1|XN_PU|XN_SL|XP_CS|XP_IE|XP_PD|XP_PDRV0|XP_PDRV1|XP_PU|XP_SL|YN_CS|YN_IE|YN_PD|YN_PDRV0|YN_PDRV1|YN_PU|YN_SL|YP_CS|YP_IE|YP_PD|YP_PDRV0|YP_PDRV1|YP_PU|YP_SL|ZN_CS|ZN_IE|ZN_PD|ZN_PDRV0|ZN_PDRV1|ZN_PU|ZN_SL|ZP_CS|ZP_IE|ZP_PD|ZP_PDRV0|ZP_PDRV1|ZP_PU|ZP_SL
+ \$14437 diode_nd2ps_06v0 A=100P P=40U
D$1902
+ VSS|XN_CS|XN_IE|XN_PD|XN_PDRV0|XN_PDRV1|XN_PU|XN_SL|XP_CS|XP_IE|XP_PD|XP_PDRV0|XP_PDRV1|XP_PU|XP_SL|YN_CS|YN_IE|YN_PD|YN_PDRV0|YN_PDRV1|YN_PU|YN_SL|YP_CS|YP_IE|YP_PD|YP_PDRV0|YP_PDRV1|YP_PU|YP_SL|ZN_CS|ZN_IE|ZN_PD|ZN_PDRV0|ZN_PDRV1|ZN_PU|ZN_SL|ZP_CS|ZP_IE|ZP_PD|ZP_PDRV0|ZP_PDRV1|ZP_PU|ZP_SL
+ \$14437 diode_nd2ps_06v0 A=100P P=40U
D$1903
+ VSS|XN_CS|XN_IE|XN_PD|XN_PDRV0|XN_PDRV1|XN_PU|XN_SL|XP_CS|XP_IE|XP_PD|XP_PDRV0|XP_PDRV1|XP_PU|XP_SL|YN_CS|YN_IE|YN_PD|YN_PDRV0|YN_PDRV1|YN_PU|YN_SL|YP_CS|YP_IE|YP_PD|YP_PDRV0|YP_PDRV1|YP_PU|YP_SL|ZN_CS|ZN_IE|ZN_PD|ZN_PDRV0|ZN_PDRV1|ZN_PU|ZN_SL|ZP_CS|ZP_IE|ZP_PD|ZP_PDRV0|ZP_PDRV1|ZP_PU|ZP_SL
+ \$14437 diode_nd2ps_06v0 A=100P P=40U
D$1904
+ VSS|XN_CS|XN_IE|XN_PD|XN_PDRV0|XN_PDRV1|XN_PU|XN_SL|XP_CS|XP_IE|XP_PD|XP_PDRV0|XP_PDRV1|XP_PU|XP_SL|YN_CS|YN_IE|YN_PD|YN_PDRV0|YN_PDRV1|YN_PU|YN_SL|YP_CS|YP_IE|YP_PD|YP_PDRV0|YP_PDRV1|YP_PU|YP_SL|ZN_CS|ZN_IE|ZN_PD|ZN_PDRV0|ZN_PDRV1|ZN_PU|ZN_SL|ZP_CS|ZP_IE|ZP_PD|ZP_PDRV0|ZP_PDRV1|ZP_PU|ZP_SL
+ \$14437 diode_nd2ps_06v0 A=100P P=40U
D$1905 S4P \$5 diode_pd2nw_06v0 A=100P P=40U
D$1906 S4P \$5 diode_pd2nw_06v0 A=100P P=40U
D$1907 S4P \$5 diode_pd2nw_06v0 A=100P P=40U
D$1908 S4P \$5 diode_pd2nw_06v0 A=100P P=40U
D$1909 S4N \$9 diode_pd2nw_06v0 A=100P P=40U
D$1910 S4N \$9 diode_pd2nw_06v0 A=100P P=40U
D$1911 S4N \$9 diode_pd2nw_06v0 A=100P P=40U
D$1912 S4N \$9 diode_pd2nw_06v0 A=100P P=40U
D$1913 Z \$13 diode_pd2nw_06v0 A=100P P=40U
D$1914 Z \$13 diode_pd2nw_06v0 A=100P P=40U
D$1915 Z \$13 diode_pd2nw_06v0 A=100P P=40U
D$1916 Z \$13 diode_pd2nw_06v0 A=100P P=40U
D$1917 Y \$4549 diode_pd2nw_06v0 A=100P P=40U
D$1918 Y \$4549 diode_pd2nw_06v0 A=100P P=40U
D$1919 Y \$4549 diode_pd2nw_06v0 A=100P P=40U
D$1920 Y \$4549 diode_pd2nw_06v0 A=100P P=40U
D$1921 X \$14442 diode_pd2nw_06v0 A=100P P=40U
D$1922 X \$14442 diode_pd2nw_06v0 A=100P P=40U
D$1923 X \$14442 diode_pd2nw_06v0 A=100P P=40U
D$1924 X \$14442 diode_pd2nw_06v0 A=100P P=40U
D$1925 \$14435 S1N diode_pd2nw_06v0 A=100P P=40U
D$1926 \$14435 S1N diode_pd2nw_06v0 A=100P P=40U
D$1927 \$14435 S1N diode_pd2nw_06v0 A=100P P=40U
D$1928 \$14435 S1N diode_pd2nw_06v0 A=100P P=40U
D$1929 \$14436 S1P diode_pd2nw_06v0 A=100P P=40U
D$1930 \$14436 S1P diode_pd2nw_06v0 A=100P P=40U
D$1931 \$14436 S1P diode_pd2nw_06v0 A=100P P=40U
D$1932 \$14436 S1P diode_pd2nw_06v0 A=100P P=40U
D$1933 \$14437 S3P diode_pd2nw_06v0 A=100P P=40U
D$1934 \$14437 S3P diode_pd2nw_06v0 A=100P P=40U
D$1935 \$14437 S3P diode_pd2nw_06v0 A=100P P=40U
D$1936 \$14437 S3P diode_pd2nw_06v0 A=100P P=40U
D$1937 \$14438 S3N diode_pd2nw_06v0 A=100P P=40U
D$1938 \$14438 S3N diode_pd2nw_06v0 A=100P P=40U
D$1939 \$14438 S3N diode_pd2nw_06v0 A=100P P=40U
D$1940 \$14438 S3N diode_pd2nw_06v0 A=100P P=40U
D$1941 \$14439 S2N diode_pd2nw_06v0 A=100P P=40U
D$1942 \$14439 S2N diode_pd2nw_06v0 A=100P P=40U
D$1943 \$14439 S2N diode_pd2nw_06v0 A=100P P=40U
D$1944 \$14439 S2N diode_pd2nw_06v0 A=100P P=40U
D$1945 \$14440 S2P diode_pd2nw_06v0 A=100P P=40U
D$1946 \$14440 S2P diode_pd2nw_06v0 A=100P P=40U
D$1947 \$14440 S2P diode_pd2nw_06v0 A=100P P=40U
D$1948 \$14440 S2P diode_pd2nw_06v0 A=100P P=40U
R$1949 S4P S4P \$5 87.5 ppolyf_u L=10U W=40U
R$1950 S4N S4N \$9 87.5 ppolyf_u L=10U W=40U
R$1951 Z Z \$13 87.5 ppolyf_u L=10U W=40U
R$1952 Y Y \$4549 87.5 ppolyf_u L=10U W=40U
R$1953 X X \$14442 87.5 ppolyf_u L=10U W=40U
R$1954 \$14435 S1N S1N 87.5 ppolyf_u L=10U W=40U
R$1955 \$14436 S1P S1P 87.5 ppolyf_u L=10U W=40U
R$1956 \$14437 S3P S3P 87.5 ppolyf_u L=10U W=40U
R$1957 \$14438 S3N S3N 87.5 ppolyf_u L=10U W=40U
R$1958 \$14439 S2N S2N 87.5 ppolyf_u L=10U W=40U
R$1959 \$14440 S2P S2P 87.5 ppolyf_u L=10U W=40U
R$1960 \$2139 \$30
+ VSS|XN_CS|XN_IE|XN_PD|XN_PDRV0|XN_PDRV1|XN_PU|XN_SL|XP_CS|XP_IE|XP_PD|XP_PDRV0|XP_PDRV1|XP_PU|XP_SL|YN_CS|YN_IE|YN_PD|YN_PDRV0|YN_PDRV1|YN_PU|YN_SL|YP_CS|YP_IE|YP_PD|YP_PDRV0|YP_PDRV1|YP_PU|YP_SL|ZN_CS|ZN_IE|ZN_PD|ZN_PDRV0|ZN_PDRV1|ZN_PU|ZN_SL|ZP_CS|ZP_IE|ZP_PD|ZP_PDRV0|ZP_PDRV1|ZP_PU|ZP_SL
+ 76450 ppolyf_u_1k L=76.45U W=1U
R$1961 \$2139 \$2140
+ VSS|XN_CS|XN_IE|XN_PD|XN_PDRV0|XN_PDRV1|XN_PU|XN_SL|XP_CS|XP_IE|XP_PD|XP_PDRV0|XP_PDRV1|XP_PU|XP_SL|YN_CS|YN_IE|YN_PD|YN_PDRV0|YN_PDRV1|YN_PU|YN_SL|YP_CS|YP_IE|YP_PD|YP_PDRV0|YP_PDRV1|YP_PU|YP_SL|ZN_CS|ZN_IE|ZN_PD|ZN_PDRV0|ZN_PDRV1|ZN_PU|ZN_SL|ZP_CS|ZP_IE|ZP_PD|ZP_PDRV0|ZP_PDRV1|ZP_PU|ZP_SL
+ 76450 ppolyf_u_1k L=76.45U W=1U
R$1962 \$2138 \$2140
+ VSS|XN_CS|XN_IE|XN_PD|XN_PDRV0|XN_PDRV1|XN_PU|XN_SL|XP_CS|XP_IE|XP_PD|XP_PDRV0|XP_PDRV1|XP_PU|XP_SL|YN_CS|YN_IE|YN_PD|YN_PDRV0|YN_PDRV1|YN_PU|YN_SL|YP_CS|YP_IE|YP_PD|YP_PDRV0|YP_PDRV1|YP_PU|YP_SL|ZN_CS|ZN_IE|ZN_PD|ZN_PDRV0|ZN_PDRV1|ZN_PU|ZN_SL|ZP_CS|ZP_IE|ZP_PD|ZP_PDRV0|ZP_PDRV1|ZP_PU|ZP_SL
+ 76450 ppolyf_u_1k L=76.45U W=1U
R$1963 \$2138 \$1136
+ VSS|XN_CS|XN_IE|XN_PD|XN_PDRV0|XN_PDRV1|XN_PU|XN_SL|XP_CS|XP_IE|XP_PD|XP_PDRV0|XP_PDRV1|XP_PU|XP_SL|YN_CS|YN_IE|YN_PD|YN_PDRV0|YN_PDRV1|YN_PU|YN_SL|YP_CS|YP_IE|YP_PD|YP_PDRV0|YP_PDRV1|YP_PU|YP_SL|ZN_CS|ZN_IE|ZN_PD|ZN_PDRV0|ZN_PDRV1|ZN_PU|ZN_SL|ZP_CS|ZP_IE|ZP_PD|ZP_PDRV0|ZP_PDRV1|ZP_PU|ZP_SL
+ 76450 ppolyf_u_1k L=76.45U W=1U
R$1964 \$120 \$1136
+ VSS|XN_CS|XN_IE|XN_PD|XN_PDRV0|XN_PDRV1|XN_PU|XN_SL|XP_CS|XP_IE|XP_PD|XP_PDRV0|XP_PDRV1|XP_PU|XP_SL|YN_CS|YN_IE|YN_PD|YN_PDRV0|YN_PDRV1|YN_PU|YN_SL|YP_CS|YP_IE|YP_PD|YP_PDRV0|YP_PDRV1|YP_PU|YP_SL|ZN_CS|ZN_IE|ZN_PD|ZN_PDRV0|ZN_PDRV1|ZN_PU|ZN_SL|ZP_CS|ZP_IE|ZP_PD|ZP_PDRV0|ZP_PDRV1|ZP_PU|ZP_SL
+ 76450 ppolyf_u_1k L=76.45U W=1U
R$1965 \$2142 \$1137
+ VSS|XN_CS|XN_IE|XN_PD|XN_PDRV0|XN_PDRV1|XN_PU|XN_SL|XP_CS|XP_IE|XP_PD|XP_PDRV0|XP_PDRV1|XP_PU|XP_SL|YN_CS|YN_IE|YN_PD|YN_PDRV0|YN_PDRV1|YN_PU|YN_SL|YP_CS|YP_IE|YP_PD|YP_PDRV0|YP_PDRV1|YP_PU|YP_SL|ZN_CS|ZN_IE|ZN_PD|ZN_PDRV0|ZN_PDRV1|ZN_PU|ZN_SL|ZP_CS|ZP_IE|ZP_PD|ZP_PDRV0|ZP_PDRV1|ZP_PU|ZP_SL
+ 76450 ppolyf_u_1k L=76.45U W=1U
R$1966 \$2142 \$2143
+ VSS|XN_CS|XN_IE|XN_PD|XN_PDRV0|XN_PDRV1|XN_PU|XN_SL|XP_CS|XP_IE|XP_PD|XP_PDRV0|XP_PDRV1|XP_PU|XP_SL|YN_CS|YN_IE|YN_PD|YN_PDRV0|YN_PDRV1|YN_PU|YN_SL|YP_CS|YP_IE|YP_PD|YP_PDRV0|YP_PDRV1|YP_PU|YP_SL|ZN_CS|ZN_IE|ZN_PD|ZN_PDRV0|ZN_PDRV1|ZN_PU|ZN_SL|ZP_CS|ZP_IE|ZP_PD|ZP_PDRV0|ZP_PDRV1|ZP_PU|ZP_SL
+ 76450 ppolyf_u_1k L=76.45U W=1U
R$1967 \$122 \$1137
+ VSS|XN_CS|XN_IE|XN_PD|XN_PDRV0|XN_PDRV1|XN_PU|XN_SL|XP_CS|XP_IE|XP_PD|XP_PDRV0|XP_PDRV1|XP_PU|XP_SL|YN_CS|YN_IE|YN_PD|YN_PDRV0|YN_PDRV1|YN_PU|YN_SL|YP_CS|YP_IE|YP_PD|YP_PDRV0|YP_PDRV1|YP_PU|YP_SL|ZN_CS|ZN_IE|ZN_PD|ZN_PDRV0|ZN_PDRV1|ZN_PU|ZN_SL|ZP_CS|ZP_IE|ZP_PD|ZP_PDRV0|ZP_PDRV1|ZP_PU|ZP_SL
+ 76450 ppolyf_u_1k L=76.45U W=1U
R$1968 \$2141 \$2143
+ VSS|XN_CS|XN_IE|XN_PD|XN_PDRV0|XN_PDRV1|XN_PU|XN_SL|XP_CS|XP_IE|XP_PD|XP_PDRV0|XP_PDRV1|XP_PU|XP_SL|YN_CS|YN_IE|YN_PD|YN_PDRV0|YN_PDRV1|YN_PU|YN_SL|YP_CS|YP_IE|YP_PD|YP_PDRV0|YP_PDRV1|YP_PU|YP_SL|ZN_CS|ZN_IE|ZN_PD|ZN_PDRV0|ZN_PDRV1|ZN_PU|ZN_SL|ZP_CS|ZP_IE|ZP_PD|ZP_PDRV0|ZP_PDRV1|ZP_PU|ZP_SL
+ 76450 ppolyf_u_1k L=76.45U W=1U
R$1969 \$2141 \$38
+ VSS|XN_CS|XN_IE|XN_PD|XN_PDRV0|XN_PDRV1|XN_PU|XN_SL|XP_CS|XP_IE|XP_PD|XP_PDRV0|XP_PDRV1|XP_PU|XP_SL|YN_CS|YN_IE|YN_PD|YN_PDRV0|YN_PDRV1|YN_PU|YN_SL|YP_CS|YP_IE|YP_PD|YP_PDRV0|YP_PDRV1|YP_PU|YP_SL|ZN_CS|ZN_IE|ZN_PD|ZN_PDRV0|ZN_PDRV1|ZN_PU|ZN_SL|ZP_CS|ZP_IE|ZP_PD|ZP_PDRV0|ZP_PDRV1|ZP_PU|ZP_SL
+ 76450 ppolyf_u_1k L=76.45U W=1U
R$1970 \$2145 \$2146
+ VSS|XN_CS|XN_IE|XN_PD|XN_PDRV0|XN_PDRV1|XN_PU|XN_SL|XP_CS|XP_IE|XP_PD|XP_PDRV0|XP_PDRV1|XP_PU|XP_SL|YN_CS|YN_IE|YN_PD|YN_PDRV0|YN_PDRV1|YN_PU|YN_SL|YP_CS|YP_IE|YP_PD|YP_PDRV0|YP_PDRV1|YP_PU|YP_SL|ZN_CS|ZN_IE|ZN_PD|ZN_PDRV0|ZN_PDRV1|ZN_PU|ZN_SL|ZP_CS|ZP_IE|ZP_PD|ZP_PDRV0|ZP_PDRV1|ZP_PU|ZP_SL
+ 76450 ppolyf_u_1k L=76.45U W=1U
R$1971 \$2145 \$1138
+ VSS|XN_CS|XN_IE|XN_PD|XN_PDRV0|XN_PDRV1|XN_PU|XN_SL|XP_CS|XP_IE|XP_PD|XP_PDRV0|XP_PDRV1|XP_PU|XP_SL|YN_CS|YN_IE|YN_PD|YN_PDRV0|YN_PDRV1|YN_PU|YN_SL|YP_CS|YP_IE|YP_PD|YP_PDRV0|YP_PDRV1|YP_PU|YP_SL|ZN_CS|ZN_IE|ZN_PD|ZN_PDRV0|ZN_PDRV1|ZN_PU|ZN_SL|ZP_CS|ZP_IE|ZP_PD|ZP_PDRV0|ZP_PDRV1|ZP_PU|ZP_SL
+ 76450 ppolyf_u_1k L=76.45U W=1U
R$1972 \$2144 \$2146
+ VSS|XN_CS|XN_IE|XN_PD|XN_PDRV0|XN_PDRV1|XN_PU|XN_SL|XP_CS|XP_IE|XP_PD|XP_PDRV0|XP_PDRV1|XP_PU|XP_SL|YN_CS|YN_IE|YN_PD|YN_PDRV0|YN_PDRV1|YN_PU|YN_SL|YP_CS|YP_IE|YP_PD|YP_PDRV0|YP_PDRV1|YP_PU|YP_SL|ZN_CS|ZN_IE|ZN_PD|ZN_PDRV0|ZN_PDRV1|ZN_PU|ZN_SL|ZP_CS|ZP_IE|ZP_PD|ZP_PDRV0|ZP_PDRV1|ZP_PU|ZP_SL
+ 76450 ppolyf_u_1k L=76.45U W=1U
R$1973 \$124 \$1138
+ VSS|XN_CS|XN_IE|XN_PD|XN_PDRV0|XN_PDRV1|XN_PU|XN_SL|XP_CS|XP_IE|XP_PD|XP_PDRV0|XP_PDRV1|XP_PU|XP_SL|YN_CS|YN_IE|YN_PD|YN_PDRV0|YN_PDRV1|YN_PU|YN_SL|YP_CS|YP_IE|YP_PD|YP_PDRV0|YP_PDRV1|YP_PU|YP_SL|ZN_CS|ZN_IE|ZN_PD|ZN_PDRV0|ZN_PDRV1|ZN_PU|ZN_SL|ZP_CS|ZP_IE|ZP_PD|ZP_PDRV0|ZP_PDRV1|ZP_PU|ZP_SL
+ 76450 ppolyf_u_1k L=76.45U W=1U
R$1974 \$2144 \$46
+ VSS|XN_CS|XN_IE|XN_PD|XN_PDRV0|XN_PDRV1|XN_PU|XN_SL|XP_CS|XP_IE|XP_PD|XP_PDRV0|XP_PDRV1|XP_PU|XP_SL|YN_CS|YN_IE|YN_PD|YN_PDRV0|YN_PDRV1|YN_PU|YN_SL|YP_CS|YP_IE|YP_PD|YP_PDRV0|YP_PDRV1|YP_PU|YP_SL|ZN_CS|ZN_IE|ZN_PD|ZN_PDRV0|ZN_PDRV1|ZN_PU|ZN_SL|ZP_CS|ZP_IE|ZP_PD|ZP_PDRV0|ZP_PDRV1|ZP_PU|ZP_SL
+ 76450 ppolyf_u_1k L=76.45U W=1U
R$1975 \$2148 \$2149
+ VSS|XN_CS|XN_IE|XN_PD|XN_PDRV0|XN_PDRV1|XN_PU|XN_SL|XP_CS|XP_IE|XP_PD|XP_PDRV0|XP_PDRV1|XP_PU|XP_SL|YN_CS|YN_IE|YN_PD|YN_PDRV0|YN_PDRV1|YN_PU|YN_SL|YP_CS|YP_IE|YP_PD|YP_PDRV0|YP_PDRV1|YP_PU|YP_SL|ZN_CS|ZN_IE|ZN_PD|ZN_PDRV0|ZN_PDRV1|ZN_PU|ZN_SL|ZP_CS|ZP_IE|ZP_PD|ZP_PDRV0|ZP_PDRV1|ZP_PU|ZP_SL
+ 76450 ppolyf_u_1k L=76.45U W=1U
R$1976 \$2147 \$2149
+ VSS|XN_CS|XN_IE|XN_PD|XN_PDRV0|XN_PDRV1|XN_PU|XN_SL|XP_CS|XP_IE|XP_PD|XP_PDRV0|XP_PDRV1|XP_PU|XP_SL|YN_CS|YN_IE|YN_PD|YN_PDRV0|YN_PDRV1|YN_PU|YN_SL|YP_CS|YP_IE|YP_PD|YP_PDRV0|YP_PDRV1|YP_PU|YP_SL|ZN_CS|ZN_IE|ZN_PD|ZN_PDRV0|ZN_PDRV1|ZN_PU|ZN_SL|ZP_CS|ZP_IE|ZP_PD|ZP_PDRV0|ZP_PDRV1|ZP_PU|ZP_SL
+ 76450 ppolyf_u_1k L=76.45U W=1U
R$1977 \$2147 \$1139
+ VSS|XN_CS|XN_IE|XN_PD|XN_PDRV0|XN_PDRV1|XN_PU|XN_SL|XP_CS|XP_IE|XP_PD|XP_PDRV0|XP_PDRV1|XP_PU|XP_SL|YN_CS|YN_IE|YN_PD|YN_PDRV0|YN_PDRV1|YN_PU|YN_SL|YP_CS|YP_IE|YP_PD|YP_PDRV0|YP_PDRV1|YP_PU|YP_SL|ZN_CS|ZN_IE|ZN_PD|ZN_PDRV0|ZN_PDRV1|ZN_PU|ZN_SL|ZP_CS|ZP_IE|ZP_PD|ZP_PDRV0|ZP_PDRV1|ZP_PU|ZP_SL
+ 76450 ppolyf_u_1k L=76.45U W=1U
R$1978 \$126 \$1139
+ VSS|XN_CS|XN_IE|XN_PD|XN_PDRV0|XN_PDRV1|XN_PU|XN_SL|XP_CS|XP_IE|XP_PD|XP_PDRV0|XP_PDRV1|XP_PU|XP_SL|YN_CS|YN_IE|YN_PD|YN_PDRV0|YN_PDRV1|YN_PU|YN_SL|YP_CS|YP_IE|YP_PD|YP_PDRV0|YP_PDRV1|YP_PU|YP_SL|ZN_CS|ZN_IE|ZN_PD|ZN_PDRV0|ZN_PDRV1|ZN_PU|ZN_SL|ZP_CS|ZP_IE|ZP_PD|ZP_PDRV0|ZP_PDRV1|ZP_PU|ZP_SL
+ 76450 ppolyf_u_1k L=76.45U W=1U
R$1979 \$2148 \$54
+ VSS|XN_CS|XN_IE|XN_PD|XN_PDRV0|XN_PDRV1|XN_PU|XN_SL|XP_CS|XP_IE|XP_PD|XP_PDRV0|XP_PDRV1|XP_PU|XP_SL|YN_CS|YN_IE|YN_PD|YN_PDRV0|YN_PDRV1|YN_PU|YN_SL|YP_CS|YP_IE|YP_PD|YP_PDRV0|YP_PDRV1|YP_PU|YP_SL|ZN_CS|ZN_IE|ZN_PD|ZN_PDRV0|ZN_PDRV1|ZN_PU|ZN_SL|ZP_CS|ZP_IE|ZP_PD|ZP_PDRV0|ZP_PDRV1|ZP_PU|ZP_SL
+ 76450 ppolyf_u_1k L=76.45U W=1U
R$1980 \$4551 \$3548
+ VSS|XN_CS|XN_IE|XN_PD|XN_PDRV0|XN_PDRV1|XN_PU|XN_SL|XP_CS|XP_IE|XP_PD|XP_PDRV0|XP_PDRV1|XP_PU|XP_SL|YN_CS|YN_IE|YN_PD|YN_PDRV0|YN_PDRV1|YN_PU|YN_SL|YP_CS|YP_IE|YP_PD|YP_PDRV0|YP_PDRV1|YP_PU|YP_SL|ZN_CS|ZN_IE|ZN_PD|ZN_PDRV0|ZN_PDRV1|ZN_PU|ZN_SL|ZP_CS|ZP_IE|ZP_PD|ZP_PDRV0|ZP_PDRV1|ZP_PU|ZP_SL
+ 76450 ppolyf_u_1k L=76.45U W=1U
R$1981 \$4551 \$4552
+ VSS|XN_CS|XN_IE|XN_PD|XN_PDRV0|XN_PDRV1|XN_PU|XN_SL|XP_CS|XP_IE|XP_PD|XP_PDRV0|XP_PDRV1|XP_PU|XP_SL|YN_CS|YN_IE|YN_PD|YN_PDRV0|YN_PDRV1|YN_PU|YN_SL|YP_CS|YP_IE|YP_PD|YP_PDRV0|YP_PDRV1|YP_PU|YP_SL|ZN_CS|ZN_IE|ZN_PD|ZN_PDRV0|ZN_PDRV1|ZN_PU|ZN_SL|ZP_CS|ZP_IE|ZP_PD|ZP_PDRV0|ZP_PDRV1|ZP_PU|ZP_SL
+ 76450 ppolyf_u_1k L=76.45U W=1U
R$1982 \$2531 \$3548
+ VSS|XN_CS|XN_IE|XN_PD|XN_PDRV0|XN_PDRV1|XN_PU|XN_SL|XP_CS|XP_IE|XP_PD|XP_PDRV0|XP_PDRV1|XP_PU|XP_SL|YN_CS|YN_IE|YN_PD|YN_PDRV0|YN_PDRV1|YN_PU|YN_SL|YP_CS|YP_IE|YP_PD|YP_PDRV0|YP_PDRV1|YP_PU|YP_SL|ZN_CS|ZN_IE|ZN_PD|ZN_PDRV0|ZN_PDRV1|ZN_PU|ZN_SL|ZP_CS|ZP_IE|ZP_PD|ZP_PDRV0|ZP_PDRV1|ZP_PU|ZP_SL
+ 76450 ppolyf_u_1k L=76.45U W=1U
R$1983 \$4550 \$4552
+ VSS|XN_CS|XN_IE|XN_PD|XN_PDRV0|XN_PDRV1|XN_PU|XN_SL|XP_CS|XP_IE|XP_PD|XP_PDRV0|XP_PDRV1|XP_PU|XP_SL|YN_CS|YN_IE|YN_PD|YN_PDRV0|YN_PDRV1|YN_PU|YN_SL|YP_CS|YP_IE|YP_PD|YP_PDRV0|YP_PDRV1|YP_PU|YP_SL|ZN_CS|ZN_IE|ZN_PD|ZN_PDRV0|ZN_PDRV1|ZN_PU|ZN_SL|ZP_CS|ZP_IE|ZP_PD|ZP_PDRV0|ZP_PDRV1|ZP_PU|ZP_SL
+ 76450 ppolyf_u_1k L=76.45U W=1U
R$1984 \$4550 \$2441
+ VSS|XN_CS|XN_IE|XN_PD|XN_PDRV0|XN_PDRV1|XN_PU|XN_SL|XP_CS|XP_IE|XP_PD|XP_PDRV0|XP_PDRV1|XP_PU|XP_SL|YN_CS|YN_IE|YN_PD|YN_PDRV0|YN_PDRV1|YN_PU|YN_SL|YP_CS|YP_IE|YP_PD|YP_PDRV0|YP_PDRV1|YP_PU|YP_SL|ZN_CS|ZN_IE|ZN_PD|ZN_PDRV0|ZN_PDRV1|ZN_PU|ZN_SL|ZP_CS|ZP_IE|ZP_PD|ZP_PDRV0|ZP_PDRV1|ZP_PU|ZP_SL
+ 76450 ppolyf_u_1k L=76.45U W=1U
R$1985 \$4553 \$4555
+ VSS|XN_CS|XN_IE|XN_PD|XN_PDRV0|XN_PDRV1|XN_PU|XN_SL|XP_CS|XP_IE|XP_PD|XP_PDRV0|XP_PDRV1|XP_PU|XP_SL|YN_CS|YN_IE|YN_PD|YN_PDRV0|YN_PDRV1|YN_PU|YN_SL|YP_CS|YP_IE|YP_PD|YP_PDRV0|YP_PDRV1|YP_PU|YP_SL|ZN_CS|ZN_IE|ZN_PD|ZN_PDRV0|ZN_PDRV1|ZN_PU|ZN_SL|ZP_CS|ZP_IE|ZP_PD|ZP_PDRV0|ZP_PDRV1|ZP_PU|ZP_SL
+ 76450 ppolyf_u_1k L=76.45U W=1U
R$1986 \$4554 \$2449
+ VSS|XN_CS|XN_IE|XN_PD|XN_PDRV0|XN_PDRV1|XN_PU|XN_SL|XP_CS|XP_IE|XP_PD|XP_PDRV0|XP_PDRV1|XP_PU|XP_SL|YN_CS|YN_IE|YN_PD|YN_PDRV0|YN_PDRV1|YN_PU|YN_SL|YP_CS|YP_IE|YP_PD|YP_PDRV0|YP_PDRV1|YP_PU|YP_SL|ZN_CS|ZN_IE|ZN_PD|ZN_PDRV0|ZN_PDRV1|ZN_PU|ZN_SL|ZP_CS|ZP_IE|ZP_PD|ZP_PDRV0|ZP_PDRV1|ZP_PU|ZP_SL
+ 76450 ppolyf_u_1k L=76.45U W=1U
R$1987 \$4554 \$4555
+ VSS|XN_CS|XN_IE|XN_PD|XN_PDRV0|XN_PDRV1|XN_PU|XN_SL|XP_CS|XP_IE|XP_PD|XP_PDRV0|XP_PDRV1|XP_PU|XP_SL|YN_CS|YN_IE|YN_PD|YN_PDRV0|YN_PDRV1|YN_PU|YN_SL|YP_CS|YP_IE|YP_PD|YP_PDRV0|YP_PDRV1|YP_PU|YP_SL|ZN_CS|ZN_IE|ZN_PD|ZN_PDRV0|ZN_PDRV1|ZN_PU|ZN_SL|ZP_CS|ZP_IE|ZP_PD|ZP_PDRV0|ZP_PDRV1|ZP_PU|ZP_SL
+ 76450 ppolyf_u_1k L=76.45U W=1U
R$1988 \$4553 \$3549
+ VSS|XN_CS|XN_IE|XN_PD|XN_PDRV0|XN_PDRV1|XN_PU|XN_SL|XP_CS|XP_IE|XP_PD|XP_PDRV0|XP_PDRV1|XP_PU|XP_SL|YN_CS|YN_IE|YN_PD|YN_PDRV0|YN_PDRV1|YN_PU|YN_SL|YP_CS|YP_IE|YP_PD|YP_PDRV0|YP_PDRV1|YP_PU|YP_SL|ZN_CS|ZN_IE|ZN_PD|ZN_PDRV0|ZN_PDRV1|ZN_PU|ZN_SL|ZP_CS|ZP_IE|ZP_PD|ZP_PDRV0|ZP_PDRV1|ZP_PU|ZP_SL
+ 76450 ppolyf_u_1k L=76.45U W=1U
R$1989 \$2533 \$3549
+ VSS|XN_CS|XN_IE|XN_PD|XN_PDRV0|XN_PDRV1|XN_PU|XN_SL|XP_CS|XP_IE|XP_PD|XP_PDRV0|XP_PDRV1|XP_PU|XP_SL|YN_CS|YN_IE|YN_PD|YN_PDRV0|YN_PDRV1|YN_PU|YN_SL|YP_CS|YP_IE|YP_PD|YP_PDRV0|YP_PDRV1|YP_PU|YP_SL|ZN_CS|ZN_IE|ZN_PD|ZN_PDRV0|ZN_PDRV1|ZN_PU|ZN_SL|ZP_CS|ZP_IE|ZP_PD|ZP_PDRV0|ZP_PDRV1|ZP_PU|ZP_SL
+ 76450 ppolyf_u_1k L=76.45U W=1U
R$1990 \$2535 \$3550
+ VSS|XN_CS|XN_IE|XN_PD|XN_PDRV0|XN_PDRV1|XN_PU|XN_SL|XP_CS|XP_IE|XP_PD|XP_PDRV0|XP_PDRV1|XP_PU|XP_SL|YN_CS|YN_IE|YN_PD|YN_PDRV0|YN_PDRV1|YN_PU|YN_SL|YP_CS|YP_IE|YP_PD|YP_PDRV0|YP_PDRV1|YP_PU|YP_SL|ZN_CS|ZN_IE|ZN_PD|ZN_PDRV0|ZN_PDRV1|ZN_PU|ZN_SL|ZP_CS|ZP_IE|ZP_PD|ZP_PDRV0|ZP_PDRV1|ZP_PU|ZP_SL
+ 76450 ppolyf_u_1k L=76.45U W=1U
R$1991 \$4557 \$2457
+ VSS|XN_CS|XN_IE|XN_PD|XN_PDRV0|XN_PDRV1|XN_PU|XN_SL|XP_CS|XP_IE|XP_PD|XP_PDRV0|XP_PDRV1|XP_PU|XP_SL|YN_CS|YN_IE|YN_PD|YN_PDRV0|YN_PDRV1|YN_PU|YN_SL|YP_CS|YP_IE|YP_PD|YP_PDRV0|YP_PDRV1|YP_PU|YP_SL|ZN_CS|ZN_IE|ZN_PD|ZN_PDRV0|ZN_PDRV1|ZN_PU|ZN_SL|ZP_CS|ZP_IE|ZP_PD|ZP_PDRV0|ZP_PDRV1|ZP_PU|ZP_SL
+ 76450 ppolyf_u_1k L=76.45U W=1U
R$1992 \$4557 \$4558
+ VSS|XN_CS|XN_IE|XN_PD|XN_PDRV0|XN_PDRV1|XN_PU|XN_SL|XP_CS|XP_IE|XP_PD|XP_PDRV0|XP_PDRV1|XP_PU|XP_SL|YN_CS|YN_IE|YN_PD|YN_PDRV0|YN_PDRV1|YN_PU|YN_SL|YP_CS|YP_IE|YP_PD|YP_PDRV0|YP_PDRV1|YP_PU|YP_SL|ZN_CS|ZN_IE|ZN_PD|ZN_PDRV0|ZN_PDRV1|ZN_PU|ZN_SL|ZP_CS|ZP_IE|ZP_PD|ZP_PDRV0|ZP_PDRV1|ZP_PU|ZP_SL
+ 76450 ppolyf_u_1k L=76.45U W=1U
R$1993 \$4556 \$3550
+ VSS|XN_CS|XN_IE|XN_PD|XN_PDRV0|XN_PDRV1|XN_PU|XN_SL|XP_CS|XP_IE|XP_PD|XP_PDRV0|XP_PDRV1|XP_PU|XP_SL|YN_CS|YN_IE|YN_PD|YN_PDRV0|YN_PDRV1|YN_PU|YN_SL|YP_CS|YP_IE|YP_PD|YP_PDRV0|YP_PDRV1|YP_PU|YP_SL|ZN_CS|ZN_IE|ZN_PD|ZN_PDRV0|ZN_PDRV1|ZN_PU|ZN_SL|ZP_CS|ZP_IE|ZP_PD|ZP_PDRV0|ZP_PDRV1|ZP_PU|ZP_SL
+ 76450 ppolyf_u_1k L=76.45U W=1U
R$1994 \$4556 \$4558
+ VSS|XN_CS|XN_IE|XN_PD|XN_PDRV0|XN_PDRV1|XN_PU|XN_SL|XP_CS|XP_IE|XP_PD|XP_PDRV0|XP_PDRV1|XP_PU|XP_SL|YN_CS|YN_IE|YN_PD|YN_PDRV0|YN_PDRV1|YN_PU|YN_SL|YP_CS|YP_IE|YP_PD|YP_PDRV0|YP_PDRV1|YP_PU|YP_SL|ZN_CS|ZN_IE|ZN_PD|ZN_PDRV0|ZN_PDRV1|ZN_PU|ZN_SL|ZP_CS|ZP_IE|ZP_PD|ZP_PDRV0|ZP_PDRV1|ZP_PU|ZP_SL
+ 76450 ppolyf_u_1k L=76.45U W=1U
R$1995 \$4559 \$2465
+ VSS|XN_CS|XN_IE|XN_PD|XN_PDRV0|XN_PDRV1|XN_PU|XN_SL|XP_CS|XP_IE|XP_PD|XP_PDRV0|XP_PDRV1|XP_PU|XP_SL|YN_CS|YN_IE|YN_PD|YN_PDRV0|YN_PDRV1|YN_PU|YN_SL|YP_CS|YP_IE|YP_PD|YP_PDRV0|YP_PDRV1|YP_PU|YP_SL|ZN_CS|ZN_IE|ZN_PD|ZN_PDRV0|ZN_PDRV1|ZN_PU|ZN_SL|ZP_CS|ZP_IE|ZP_PD|ZP_PDRV0|ZP_PDRV1|ZP_PU|ZP_SL
+ 76450 ppolyf_u_1k L=76.45U W=1U
R$1996 \$4559 \$4561
+ VSS|XN_CS|XN_IE|XN_PD|XN_PDRV0|XN_PDRV1|XN_PU|XN_SL|XP_CS|XP_IE|XP_PD|XP_PDRV0|XP_PDRV1|XP_PU|XP_SL|YN_CS|YN_IE|YN_PD|YN_PDRV0|YN_PDRV1|YN_PU|YN_SL|YP_CS|YP_IE|YP_PD|YP_PDRV0|YP_PDRV1|YP_PU|YP_SL|ZN_CS|ZN_IE|ZN_PD|ZN_PDRV0|ZN_PDRV1|ZN_PU|ZN_SL|ZP_CS|ZP_IE|ZP_PD|ZP_PDRV0|ZP_PDRV1|ZP_PU|ZP_SL
+ 76450 ppolyf_u_1k L=76.45U W=1U
R$1997 \$2537 \$3551
+ VSS|XN_CS|XN_IE|XN_PD|XN_PDRV0|XN_PDRV1|XN_PU|XN_SL|XP_CS|XP_IE|XP_PD|XP_PDRV0|XP_PDRV1|XP_PU|XP_SL|YN_CS|YN_IE|YN_PD|YN_PDRV0|YN_PDRV1|YN_PU|YN_SL|YP_CS|YP_IE|YP_PD|YP_PDRV0|YP_PDRV1|YP_PU|YP_SL|ZN_CS|ZN_IE|ZN_PD|ZN_PDRV0|ZN_PDRV1|ZN_PU|ZN_SL|ZP_CS|ZP_IE|ZP_PD|ZP_PDRV0|ZP_PDRV1|ZP_PU|ZP_SL
+ 76450 ppolyf_u_1k L=76.45U W=1U
R$1998 \$4560 \$4561
+ VSS|XN_CS|XN_IE|XN_PD|XN_PDRV0|XN_PDRV1|XN_PU|XN_SL|XP_CS|XP_IE|XP_PD|XP_PDRV0|XP_PDRV1|XP_PU|XP_SL|YN_CS|YN_IE|YN_PD|YN_PDRV0|YN_PDRV1|YN_PU|YN_SL|YP_CS|YP_IE|YP_PD|YP_PDRV0|YP_PDRV1|YP_PU|YP_SL|ZN_CS|ZN_IE|ZN_PD|ZN_PDRV0|ZN_PDRV1|ZN_PU|ZN_SL|ZP_CS|ZP_IE|ZP_PD|ZP_PDRV0|ZP_PDRV1|ZP_PU|ZP_SL
+ 76450 ppolyf_u_1k L=76.45U W=1U
R$1999 \$4560 \$3551
+ VSS|XN_CS|XN_IE|XN_PD|XN_PDRV0|XN_PDRV1|XN_PU|XN_SL|XP_CS|XP_IE|XP_PD|XP_PDRV0|XP_PDRV1|XP_PU|XP_SL|YN_CS|YN_IE|YN_PD|YN_PDRV0|YN_PDRV1|YN_PU|YN_SL|YP_CS|YP_IE|YP_PD|YP_PDRV0|YP_PDRV1|YP_PU|YP_SL|ZN_CS|ZN_IE|ZN_PD|ZN_PDRV0|ZN_PDRV1|ZN_PU|ZN_SL|ZP_CS|ZP_IE|ZP_PD|ZP_PDRV0|ZP_PDRV1|ZP_PU|ZP_SL
+ 76450 ppolyf_u_1k L=76.45U W=1U
R$2000 \$6963 \$5961
+ VSS|XN_CS|XN_IE|XN_PD|XN_PDRV0|XN_PDRV1|XN_PU|XN_SL|XP_CS|XP_IE|XP_PD|XP_PDRV0|XP_PDRV1|XP_PU|XP_SL|YN_CS|YN_IE|YN_PD|YN_PDRV0|YN_PDRV1|YN_PU|YN_SL|YP_CS|YP_IE|YP_PD|YP_PDRV0|YP_PDRV1|YP_PU|YP_SL|ZN_CS|ZN_IE|ZN_PD|ZN_PDRV0|ZN_PDRV1|ZN_PU|ZN_SL|ZP_CS|ZP_IE|ZP_PD|ZP_PDRV0|ZP_PDRV1|ZP_PU|ZP_SL
+ 76450 ppolyf_u_1k L=76.45U W=1U
R$2001 \$4951 \$5961
+ VSS|XN_CS|XN_IE|XN_PD|XN_PDRV0|XN_PDRV1|XN_PU|XN_SL|XP_CS|XP_IE|XP_PD|XP_PDRV0|XP_PDRV1|XP_PU|XP_SL|YN_CS|YN_IE|YN_PD|YN_PDRV0|YN_PDRV1|YN_PU|YN_SL|YP_CS|YP_IE|YP_PD|YP_PDRV0|YP_PDRV1|YP_PU|YP_SL|ZN_CS|ZN_IE|ZN_PD|ZN_PDRV0|ZN_PDRV1|ZN_PU|ZN_SL|ZP_CS|ZP_IE|ZP_PD|ZP_PDRV0|ZP_PDRV1|ZP_PU|ZP_SL
+ 76450 ppolyf_u_1k L=76.45U W=1U
R$2002 \$6963 \$6965
+ VSS|XN_CS|XN_IE|XN_PD|XN_PDRV0|XN_PDRV1|XN_PU|XN_SL|XP_CS|XP_IE|XP_PD|XP_PDRV0|XP_PDRV1|XP_PU|XP_SL|YN_CS|YN_IE|YN_PD|YN_PDRV0|YN_PDRV1|YN_PU|YN_SL|YP_CS|YP_IE|YP_PD|YP_PDRV0|YP_PDRV1|YP_PU|YP_SL|ZN_CS|ZN_IE|ZN_PD|ZN_PDRV0|ZN_PDRV1|ZN_PU|ZN_SL|ZP_CS|ZP_IE|ZP_PD|ZP_PDRV0|ZP_PDRV1|ZP_PU|ZP_SL
+ 76450 ppolyf_u_1k L=76.45U W=1U
R$2003 \$6964 \$4856
+ VSS|XN_CS|XN_IE|XN_PD|XN_PDRV0|XN_PDRV1|XN_PU|XN_SL|XP_CS|XP_IE|XP_PD|XP_PDRV0|XP_PDRV1|XP_PU|XP_SL|YN_CS|YN_IE|YN_PD|YN_PDRV0|YN_PDRV1|YN_PU|YN_SL|YP_CS|YP_IE|YP_PD|YP_PDRV0|YP_PDRV1|YP_PU|YP_SL|ZN_CS|ZN_IE|ZN_PD|ZN_PDRV0|ZN_PDRV1|ZN_PU|ZN_SL|ZP_CS|ZP_IE|ZP_PD|ZP_PDRV0|ZP_PDRV1|ZP_PU|ZP_SL
+ 76450 ppolyf_u_1k L=76.45U W=1U
R$2004 \$6964 \$6965
+ VSS|XN_CS|XN_IE|XN_PD|XN_PDRV0|XN_PDRV1|XN_PU|XN_SL|XP_CS|XP_IE|XP_PD|XP_PDRV0|XP_PDRV1|XP_PU|XP_SL|YN_CS|YN_IE|YN_PD|YN_PDRV0|YN_PDRV1|YN_PU|YN_SL|YP_CS|YP_IE|YP_PD|YP_PDRV0|YP_PDRV1|YP_PU|YP_SL|ZN_CS|ZN_IE|ZN_PD|ZN_PDRV0|ZN_PDRV1|ZN_PU|ZN_SL|ZP_CS|ZP_IE|ZP_PD|ZP_PDRV0|ZP_PDRV1|ZP_PU|ZP_SL
+ 76450 ppolyf_u_1k L=76.45U W=1U
R$2005 \$6968 \$5962
+ VSS|XN_CS|XN_IE|XN_PD|XN_PDRV0|XN_PDRV1|XN_PU|XN_SL|XP_CS|XP_IE|XP_PD|XP_PDRV0|XP_PDRV1|XP_PU|XP_SL|YN_CS|YN_IE|YN_PD|YN_PDRV0|YN_PDRV1|YN_PU|YN_SL|YP_CS|YP_IE|YP_PD|YP_PDRV0|YP_PDRV1|YP_PU|YP_SL|ZN_CS|ZN_IE|ZN_PD|ZN_PDRV0|ZN_PDRV1|ZN_PU|ZN_SL|ZP_CS|ZP_IE|ZP_PD|ZP_PDRV0|ZP_PDRV1|ZP_PU|ZP_SL
+ 76450 ppolyf_u_1k L=76.45U W=1U
R$2006 \$4954 \$5962
+ VSS|XN_CS|XN_IE|XN_PD|XN_PDRV0|XN_PDRV1|XN_PU|XN_SL|XP_CS|XP_IE|XP_PD|XP_PDRV0|XP_PDRV1|XP_PU|XP_SL|YN_CS|YN_IE|YN_PD|YN_PDRV0|YN_PDRV1|YN_PU|YN_SL|YP_CS|YP_IE|YP_PD|YP_PDRV0|YP_PDRV1|YP_PU|YP_SL|ZN_CS|ZN_IE|ZN_PD|ZN_PDRV0|ZN_PDRV1|ZN_PU|ZN_SL|ZP_CS|ZP_IE|ZP_PD|ZP_PDRV0|ZP_PDRV1|ZP_PU|ZP_SL
+ 76450 ppolyf_u_1k L=76.45U W=1U
R$2007 \$6967 \$4864
+ VSS|XN_CS|XN_IE|XN_PD|XN_PDRV0|XN_PDRV1|XN_PU|XN_SL|XP_CS|XP_IE|XP_PD|XP_PDRV0|XP_PDRV1|XP_PU|XP_SL|YN_CS|YN_IE|YN_PD|YN_PDRV0|YN_PDRV1|YN_PU|YN_SL|YP_CS|YP_IE|YP_PD|YP_PDRV0|YP_PDRV1|YP_PU|YP_SL|ZN_CS|ZN_IE|ZN_PD|ZN_PDRV0|ZN_PDRV1|ZN_PU|ZN_SL|ZP_CS|ZP_IE|ZP_PD|ZP_PDRV0|ZP_PDRV1|ZP_PU|ZP_SL
+ 76450 ppolyf_u_1k L=76.45U W=1U
R$2008 \$6967 \$6969
+ VSS|XN_CS|XN_IE|XN_PD|XN_PDRV0|XN_PDRV1|XN_PU|XN_SL|XP_CS|XP_IE|XP_PD|XP_PDRV0|XP_PDRV1|XP_PU|XP_SL|YN_CS|YN_IE|YN_PD|YN_PDRV0|YN_PDRV1|YN_PU|YN_SL|YP_CS|YP_IE|YP_PD|YP_PDRV0|YP_PDRV1|YP_PU|YP_SL|ZN_CS|ZN_IE|ZN_PD|ZN_PDRV0|ZN_PDRV1|ZN_PU|ZN_SL|ZP_CS|ZP_IE|ZP_PD|ZP_PDRV0|ZP_PDRV1|ZP_PU|ZP_SL
+ 76450 ppolyf_u_1k L=76.45U W=1U
R$2009 \$6968 \$6969
+ VSS|XN_CS|XN_IE|XN_PD|XN_PDRV0|XN_PDRV1|XN_PU|XN_SL|XP_CS|XP_IE|XP_PD|XP_PDRV0|XP_PDRV1|XP_PU|XP_SL|YN_CS|YN_IE|YN_PD|YN_PDRV0|YN_PDRV1|YN_PU|YN_SL|YP_CS|YP_IE|YP_PD|YP_PDRV0|YP_PDRV1|YP_PU|YP_SL|ZN_CS|ZN_IE|ZN_PD|ZN_PDRV0|ZN_PDRV1|ZN_PU|ZN_SL|ZP_CS|ZP_IE|ZP_PD|ZP_PDRV0|ZP_PDRV1|ZP_PU|ZP_SL
+ 76450 ppolyf_u_1k L=76.45U W=1U
R$2010 \$6972 \$5963
+ VSS|XN_CS|XN_IE|XN_PD|XN_PDRV0|XN_PDRV1|XN_PU|XN_SL|XP_CS|XP_IE|XP_PD|XP_PDRV0|XP_PDRV1|XP_PU|XP_SL|YN_CS|YN_IE|YN_PD|YN_PDRV0|YN_PDRV1|YN_PU|YN_SL|YP_CS|YP_IE|YP_PD|YP_PDRV0|YP_PDRV1|YP_PU|YP_SL|ZN_CS|ZN_IE|ZN_PD|ZN_PDRV0|ZN_PDRV1|ZN_PU|ZN_SL|ZP_CS|ZP_IE|ZP_PD|ZP_PDRV0|ZP_PDRV1|ZP_PU|ZP_SL
+ 76450 ppolyf_u_1k L=76.45U W=1U
R$2011 \$6972 \$6973
+ VSS|XN_CS|XN_IE|XN_PD|XN_PDRV0|XN_PDRV1|XN_PU|XN_SL|XP_CS|XP_IE|XP_PD|XP_PDRV0|XP_PDRV1|XP_PU|XP_SL|YN_CS|YN_IE|YN_PD|YN_PDRV0|YN_PDRV1|YN_PU|YN_SL|YP_CS|YP_IE|YP_PD|YP_PDRV0|YP_PDRV1|YP_PU|YP_SL|ZN_CS|ZN_IE|ZN_PD|ZN_PDRV0|ZN_PDRV1|ZN_PU|ZN_SL|ZP_CS|ZP_IE|ZP_PD|ZP_PDRV0|ZP_PDRV1|ZP_PU|ZP_SL
+ 76450 ppolyf_u_1k L=76.45U W=1U
R$2012 \$6971 \$6973
+ VSS|XN_CS|XN_IE|XN_PD|XN_PDRV0|XN_PDRV1|XN_PU|XN_SL|XP_CS|XP_IE|XP_PD|XP_PDRV0|XP_PDRV1|XP_PU|XP_SL|YN_CS|YN_IE|YN_PD|YN_PDRV0|YN_PDRV1|YN_PU|YN_SL|YP_CS|YP_IE|YP_PD|YP_PDRV0|YP_PDRV1|YP_PU|YP_SL|ZN_CS|ZN_IE|ZN_PD|ZN_PDRV0|ZN_PDRV1|ZN_PU|ZN_SL|ZP_CS|ZP_IE|ZP_PD|ZP_PDRV0|ZP_PDRV1|ZP_PU|ZP_SL
+ 76450 ppolyf_u_1k L=76.45U W=1U
R$2013 \$6971 \$4872
+ VSS|XN_CS|XN_IE|XN_PD|XN_PDRV0|XN_PDRV1|XN_PU|XN_SL|XP_CS|XP_IE|XP_PD|XP_PDRV0|XP_PDRV1|XP_PU|XP_SL|YN_CS|YN_IE|YN_PD|YN_PDRV0|YN_PDRV1|YN_PU|YN_SL|YP_CS|YP_IE|YP_PD|YP_PDRV0|YP_PDRV1|YP_PU|YP_SL|ZN_CS|ZN_IE|ZN_PD|ZN_PDRV0|ZN_PDRV1|ZN_PU|ZN_SL|ZP_CS|ZP_IE|ZP_PD|ZP_PDRV0|ZP_PDRV1|ZP_PU|ZP_SL
+ 76450 ppolyf_u_1k L=76.45U W=1U
R$2014 \$4957 \$5963
+ VSS|XN_CS|XN_IE|XN_PD|XN_PDRV0|XN_PDRV1|XN_PU|XN_SL|XP_CS|XP_IE|XP_PD|XP_PDRV0|XP_PDRV1|XP_PU|XP_SL|YN_CS|YN_IE|YN_PD|YN_PDRV0|YN_PDRV1|YN_PU|YN_SL|YP_CS|YP_IE|YP_PD|YP_PDRV0|YP_PDRV1|YP_PU|YP_SL|ZN_CS|ZN_IE|ZN_PD|ZN_PDRV0|ZN_PDRV1|ZN_PU|ZN_SL|ZP_CS|ZP_IE|ZP_PD|ZP_PDRV0|ZP_PDRV1|ZP_PU|ZP_SL
+ 76450 ppolyf_u_1k L=76.45U W=1U
R$2015 \$6975 \$4880
+ VSS|XN_CS|XN_IE|XN_PD|XN_PDRV0|XN_PDRV1|XN_PU|XN_SL|XP_CS|XP_IE|XP_PD|XP_PDRV0|XP_PDRV1|XP_PU|XP_SL|YN_CS|YN_IE|YN_PD|YN_PDRV0|YN_PDRV1|YN_PU|YN_SL|YP_CS|YP_IE|YP_PD|YP_PDRV0|YP_PDRV1|YP_PU|YP_SL|ZN_CS|ZN_IE|ZN_PD|ZN_PDRV0|ZN_PDRV1|ZN_PU|ZN_SL|ZP_CS|ZP_IE|ZP_PD|ZP_PDRV0|ZP_PDRV1|ZP_PU|ZP_SL
+ 76450 ppolyf_u_1k L=76.45U W=1U
R$2016 \$6975 \$6977
+ VSS|XN_CS|XN_IE|XN_PD|XN_PDRV0|XN_PDRV1|XN_PU|XN_SL|XP_CS|XP_IE|XP_PD|XP_PDRV0|XP_PDRV1|XP_PU|XP_SL|YN_CS|YN_IE|YN_PD|YN_PDRV0|YN_PDRV1|YN_PU|YN_SL|YP_CS|YP_IE|YP_PD|YP_PDRV0|YP_PDRV1|YP_PU|YP_SL|ZN_CS|ZN_IE|ZN_PD|ZN_PDRV0|ZN_PDRV1|ZN_PU|ZN_SL|ZP_CS|ZP_IE|ZP_PD|ZP_PDRV0|ZP_PDRV1|ZP_PU|ZP_SL
+ 76450 ppolyf_u_1k L=76.45U W=1U
R$2017 \$6976 \$5964
+ VSS|XN_CS|XN_IE|XN_PD|XN_PDRV0|XN_PDRV1|XN_PU|XN_SL|XP_CS|XP_IE|XP_PD|XP_PDRV0|XP_PDRV1|XP_PU|XP_SL|YN_CS|YN_IE|YN_PD|YN_PDRV0|YN_PDRV1|YN_PU|YN_SL|YP_CS|YP_IE|YP_PD|YP_PDRV0|YP_PDRV1|YP_PU|YP_SL|ZN_CS|ZN_IE|ZN_PD|ZN_PDRV0|ZN_PDRV1|ZN_PU|ZN_SL|ZP_CS|ZP_IE|ZP_PD|ZP_PDRV0|ZP_PDRV1|ZP_PU|ZP_SL
+ 76450 ppolyf_u_1k L=76.45U W=1U
R$2018 \$6976 \$6977
+ VSS|XN_CS|XN_IE|XN_PD|XN_PDRV0|XN_PDRV1|XN_PU|XN_SL|XP_CS|XP_IE|XP_PD|XP_PDRV0|XP_PDRV1|XP_PU|XP_SL|YN_CS|YN_IE|YN_PD|YN_PDRV0|YN_PDRV1|YN_PU|YN_SL|YP_CS|YP_IE|YP_PD|YP_PDRV0|YP_PDRV1|YP_PU|YP_SL|ZN_CS|ZN_IE|ZN_PD|ZN_PDRV0|ZN_PDRV1|ZN_PU|ZN_SL|ZP_CS|ZP_IE|ZP_PD|ZP_PDRV0|ZP_PDRV1|ZP_PU|ZP_SL
+ 76450 ppolyf_u_1k L=76.45U W=1U
R$2019 \$4960 \$5964
+ VSS|XN_CS|XN_IE|XN_PD|XN_PDRV0|XN_PDRV1|XN_PU|XN_SL|XP_CS|XP_IE|XP_PD|XP_PDRV0|XP_PDRV1|XP_PU|XP_SL|YN_CS|YN_IE|YN_PD|YN_PDRV0|YN_PDRV1|YN_PU|YN_SL|YP_CS|YP_IE|YP_PD|YP_PDRV0|YP_PDRV1|YP_PU|YP_SL|ZN_CS|ZN_IE|ZN_PD|ZN_PDRV0|ZN_PDRV1|ZN_PU|ZN_SL|ZP_CS|ZP_IE|ZP_PD|ZP_PDRV0|ZP_PDRV1|ZP_PU|ZP_SL
+ 76450 ppolyf_u_1k L=76.45U W=1U
C$2020 \$12673 \$12679 4e-13 cap_mim_2f0fF A=200P P=60U
C$2021 \$12679 \$12677 4e-13 cap_mim_2f0fF A=200P P=60U
C$2022 \$10891 \$10907 4e-13 cap_mim_2f0fF A=200P P=60U
C$2023 \$10882 \$10888 4e-13 cap_mim_2f0fF A=200P P=60U
C$2024 \$10907 \$10895 4e-13 cap_mim_2f0fF A=200P P=60U
C$2025 \$9106 \$9104 4e-13 cap_mim_2f0fF A=200P P=60U
C$2026 \$12682 \$12688 4e-13 cap_mim_2f0fF A=200P P=60U
C$2027 \$9109 \$9096 4e-13 cap_mim_2f0fF A=200P P=60U
C$2028 \$10899 \$10905 4e-13 cap_mim_2f0fF A=200P P=60U
C$2029 \$7298 \$7304 4e-13 cap_mim_2f0fF A=200P P=60U
C$2030 \$12688 \$12686 4e-13 cap_mim_2f0fF A=200P P=60U
C$2031 \$2441 \$2514 4e-13 cap_mim_2f0fF A=200P P=66U
C$2032 \$46 \$111 4e-13 cap_mim_2f0fF A=200P P=66U
C$2033 \$10888 \$10886 4e-13 cap_mim_2f0fF A=200P P=60U
C$2034 \$2435 \$2441 4e-13 cap_mim_2f0fF A=200P P=66U
C$2035 \$9092 \$9109 4e-13 cap_mim_2f0fF A=200P P=60U
C$2036 \$40 \$46 4e-13 cap_mim_2f0fF A=200P P=66U
C$2037 \$38 \$107 4e-13 cap_mim_2f0fF A=200P P=66U
C$2038 \$2449 \$2518 4e-13 cap_mim_2f0fF A=200P P=66U
C$2039 \$54 \$115 4e-13 cap_mim_2f0fF A=200P P=66U
C$2040 \$48 \$54 4e-13 cap_mim_2f0fF A=200P P=66U
C$2041 \$10905 \$10903 4e-13 cap_mim_2f0fF A=200P P=60U
C$2042 \$32 \$38 4e-13 cap_mim_2f0fF A=200P P=66U
C$2043 \$7280 \$7286 4e-13 cap_mim_2f0fF A=200P P=60U
C$2044 \$30 \$103 4e-13 cap_mim_2f0fF A=200P P=66U
C$2045 \$4866 \$4872 4e-13 cap_mim_2f0fF A=200P P=66U
C$2046 \$9089 \$9087 4e-13 cap_mim_2f0fF A=200P P=60U
C$2047 \$2443 \$2449 4e-13 cap_mim_2f0fF A=200P P=66U
C$2048 \$4880 \$4941 4e-13 cap_mim_2f0fF A=200P P=66U
C$2049 \$12697 \$12695 4e-13 cap_mim_2f0fF A=200P P=60U
C$2050 \$7286 \$7284 4e-13 cap_mim_2f0fF A=200P P=60U
C$2051 \$24 \$30 4e-13 cap_mim_2f0fF A=200P P=66U
C$2052 \$2457 \$2522 4e-13 cap_mim_2f0fF A=200P P=66U
C$2053 \$4864 \$4933 4e-13 cap_mim_2f0fF A=200P P=66U
C$2054 \$2459 \$2465 4e-13 cap_mim_2f0fF A=200P P=66U
C$2055 \$12691 \$12697 4e-13 cap_mim_2f0fF A=200P P=60U
C$2056 \$2451 \$2457 4e-13 cap_mim_2f0fF A=200P P=66U
C$2057 \$4856 \$4929 4e-13 cap_mim_2f0fF A=200P P=66U
C$2058 \$9100 \$9106 4e-13 cap_mim_2f0fF A=200P P=60U
C$2059 \$2465 \$2526 4e-13 cap_mim_2f0fF A=200P P=66U
C$2060 \$4874 \$4880 4e-13 cap_mim_2f0fF A=200P P=66U
C$2061 \$4850 \$4856 4e-13 cap_mim_2f0fF A=200P P=66U
C$2062 \$7295 \$7293 4e-13 cap_mim_2f0fF A=200P P=60U
C$2063 \$4872 \$4937 4e-13 cap_mim_2f0fF A=200P P=66U
C$2064 \$4858 \$4864 4e-13 cap_mim_2f0fF A=200P P=66U
C$2065 \$7304 \$7302 4e-13 cap_mim_2f0fF A=200P P=60U
C$2066 \$9083 \$9089 4e-13 cap_mim_2f0fF A=200P P=60U
C$2067 \$7289 \$7295 4e-13 cap_mim_2f0fF A=200P P=60U
.ENDS B26_A
