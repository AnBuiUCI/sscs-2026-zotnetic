* Extracted by KLayout with GF180MCU LVS runset on : 27/08/2026 06:51

.SUBCKT GRADIENT_NAV2 VDD XN XP YP YN ZN ZP S1N S1P S2N S2P S3N S3P S4N S4P X Y
+ Z VSS
M$1 \$283731 \$300358 VDD VDD pfet_05v0 L=0.5U W=1.83U AS=0.8052P AD=0.8052P
+ PS=4.54U PD=4.54U
M$2 XP \$283731 VDD VDD pfet_05v0 L=0.5U W=1.83U AS=0.8052P AD=0.8052P PS=4.54U
+ PD=4.54U
M$3 XN XP VDD VDD pfet_05v0 L=0.5U W=1.83U AS=0.8052P AD=0.8052P PS=4.54U
+ PD=4.54U
M$4 \$344511 \$359044 VDD VDD pfet_05v0 L=0.5U W=1.83U AS=0.8052P AD=0.8052P
+ PS=4.54U PD=4.54U
M$5 YP \$344511 VDD VDD pfet_05v0 L=0.5U W=1.83U AS=0.8052P AD=0.8052P PS=4.54U
+ PD=4.54U
M$6 YN YP VDD VDD pfet_05v0 L=0.5U W=1.83U AS=0.8052P AD=0.8052P PS=4.54U
+ PD=4.54U
M$7 \$404364 \$417194 VDD VDD pfet_05v0 L=0.5U W=1.83U AS=0.8052P AD=0.8052P
+ PS=4.54U PD=4.54U
M$8 ZP \$404364 VDD VDD pfet_05v0 L=0.5U W=1.83U AS=0.8052P AD=0.8052P PS=4.54U
+ PD=4.54U
M$9 ZN ZP VDD VDD pfet_05v0 L=0.5U W=1.83U AS=0.8052P AD=0.8052P PS=4.54U
+ PD=4.54U
M$10 VDD VSS VDD VDD pfet_06v0 L=2U W=18U AS=7.92P AD=7.92P PS=36.88U PD=36.88U
M$11 VDD VSS VDD VDD pfet_06v0 L=2U W=18U AS=7.92P AD=7.92P PS=36.88U PD=36.88U
M$12 VDD VSS VDD VDD pfet_06v0 L=2U W=18U AS=7.92P AD=7.92P PS=36.88U PD=36.88U
M$13 VDD VSS VDD VDD pfet_06v0 L=2U W=18U AS=7.92P AD=7.92P PS=36.88U PD=36.88U
M$14 VDD VSS VDD VDD pfet_06v0 L=2U W=18U AS=7.92P AD=7.92P PS=36.88U PD=36.88U
M$15 VDD VSS VDD VDD pfet_06v0 L=2U W=18U AS=7.92P AD=7.92P PS=36.88U PD=36.88U
M$16 VDD VSS VDD VDD pfet_06v0 L=2U W=18U AS=7.92P AD=7.92P PS=36.88U PD=36.88U
M$17 VDD VSS VDD VDD pfet_06v0 L=2U W=18U AS=7.92P AD=7.92P PS=36.88U PD=36.88U
M$18 \$98196 \$53335 VDD VDD pfet_06v0 L=1U W=10U AS=4.4P AD=2.5P PS=20.88U
+ PD=10.5U
M$19 \$55655 \$57872 \$98196 VDD pfet_06v0 L=1U W=10U AS=2.5P AD=4.4P PS=10.5U
+ PD=20.88U
M$20 \$98237 \$53335 VDD VDD pfet_06v0 L=1U W=10U AS=4.4P AD=2.5P PS=20.88U
+ PD=10.5U
M$21 \$55655 \$57872 \$98237 VDD pfet_06v0 L=1U W=10U AS=2.5P AD=4.4P PS=10.5U
+ PD=20.88U
M$22 \$98391 \$52535 VDD VDD pfet_06v0 L=1U W=10U AS=4.4P AD=2.5P PS=20.88U
+ PD=10.5U
M$23 \$52535 \$57872 \$98391 VDD pfet_06v0 L=1U W=10U AS=2.5P AD=3.3P PS=10.5U
+ PD=10.66U
M$24 \$38252 \$38252 \$52535 VDD pfet_06v0 L=1U W=10U AS=3.3P AD=4.4P PS=10.66U
+ PD=20.88U
M$25 \$98438 \$53335 VDD VDD pfet_06v0 L=1U W=10U AS=4.4P AD=2.5P PS=20.88U
+ PD=10.5U
M$26 \$42797 \$57872 \$98438 VDD pfet_06v0 L=1U W=10U AS=2.5P AD=4.4P PS=10.5U
+ PD=20.88U
M$27 \$98554 \$53335 VDD VDD pfet_06v0 L=1U W=10U AS=4.4P AD=2.5P PS=20.88U
+ PD=10.5U
M$28 \$43659 \$57872 \$98554 VDD pfet_06v0 L=1U W=10U AS=2.5P AD=4.4P PS=10.5U
+ PD=20.88U
M$29 \$98595 \$53335 VDD VDD pfet_06v0 L=1U W=10U AS=4.4P AD=2.5P PS=20.88U
+ PD=10.5U
M$30 \$43658 \$57872 \$98595 VDD pfet_06v0 L=1U W=10U AS=2.5P AD=4.4P PS=10.5U
+ PD=20.88U
M$31 \$98647 \$53335 VDD VDD pfet_06v0 L=1U W=10U AS=4.4P AD=2.5P PS=20.88U
+ PD=10.5U
M$32 \$53335 \$57872 \$98647 VDD pfet_06v0 L=1U W=10U AS=2.5P AD=4.4P PS=10.5U
+ PD=20.88U
M$33 \$98808 \$53337 VDD VDD pfet_06v0 L=1U W=10U AS=4.4P AD=2.5P PS=20.88U
+ PD=10.5U
M$34 \$55656 \$57875 \$98808 VDD pfet_06v0 L=1U W=10U AS=2.5P AD=4.4P PS=10.5U
+ PD=20.88U
M$35 \$98820 \$53337 VDD VDD pfet_06v0 L=1U W=10U AS=4.4P AD=2.5P PS=20.88U
+ PD=10.5U
M$36 \$55656 \$57875 \$98820 VDD pfet_06v0 L=1U W=10U AS=2.5P AD=4.4P PS=10.5U
+ PD=20.88U
M$37 \$98982 \$52536 VDD VDD pfet_06v0 L=1U W=10U AS=4.4P AD=2.5P PS=20.88U
+ PD=10.5U
M$38 \$52536 \$57875 \$98982 VDD pfet_06v0 L=1U W=10U AS=2.5P AD=3.3P PS=10.5U
+ PD=10.66U
M$39 \$38263 \$38263 \$52536 VDD pfet_06v0 L=1U W=10U AS=3.3P AD=4.4P PS=10.66U
+ PD=20.88U
M$40 \$99022 \$53337 VDD VDD pfet_06v0 L=1U W=10U AS=4.4P AD=2.5P PS=20.88U
+ PD=10.5U
M$41 \$42798 \$57875 \$99022 VDD pfet_06v0 L=1U W=10U AS=2.5P AD=4.4P PS=10.5U
+ PD=20.88U
M$42 \$99136 \$53337 VDD VDD pfet_06v0 L=1U W=10U AS=4.4P AD=2.5P PS=20.88U
+ PD=10.5U
M$43 \$43661 \$57875 \$99136 VDD pfet_06v0 L=1U W=10U AS=2.5P AD=4.4P PS=10.5U
+ PD=20.88U
M$44 \$99170 \$53337 VDD VDD pfet_06v0 L=1U W=10U AS=4.4P AD=2.5P PS=20.88U
+ PD=10.5U
M$45 \$43660 \$57875 \$99170 VDD pfet_06v0 L=1U W=10U AS=2.5P AD=4.4P PS=10.5U
+ PD=20.88U
M$46 \$99227 \$53337 VDD VDD pfet_06v0 L=1U W=10U AS=4.4P AD=2.5P PS=20.88U
+ PD=10.5U
M$47 \$53337 \$57875 \$99227 VDD pfet_06v0 L=1U W=10U AS=2.5P AD=4.4P PS=10.5U
+ PD=20.88U
M$48 \$99393 \$53338 VDD VDD pfet_06v0 L=1U W=10U AS=4.4P AD=2.5P PS=20.88U
+ PD=10.5U
M$49 \$55657 \$57878 \$99393 VDD pfet_06v0 L=1U W=10U AS=2.5P AD=4.4P PS=10.5U
+ PD=20.88U
M$50 \$99423 \$53338 VDD VDD pfet_06v0 L=1U W=10U AS=4.4P AD=2.5P PS=20.88U
+ PD=10.5U
M$51 \$55657 \$57878 \$99423 VDD pfet_06v0 L=1U W=10U AS=2.5P AD=4.4P PS=10.5U
+ PD=20.88U
M$52 \$99561 \$52537 VDD VDD pfet_06v0 L=1U W=10U AS=4.4P AD=2.5P PS=20.88U
+ PD=10.5U
M$53 \$52537 \$57878 \$99561 VDD pfet_06v0 L=1U W=10U AS=2.5P AD=3.3P PS=10.5U
+ PD=10.66U
M$54 \$38274 \$38274 \$52537 VDD pfet_06v0 L=1U W=10U AS=3.3P AD=4.4P PS=10.66U
+ PD=20.88U
M$55 \$99611 \$53338 VDD VDD pfet_06v0 L=1U W=10U AS=4.4P AD=2.5P PS=20.88U
+ PD=10.5U
M$56 \$42799 \$57878 \$99611 VDD pfet_06v0 L=1U W=10U AS=2.5P AD=4.4P PS=10.5U
+ PD=20.88U
M$57 \$99731 \$53338 VDD VDD pfet_06v0 L=1U W=10U AS=4.4P AD=2.5P PS=20.88U
+ PD=10.5U
M$58 \$43663 \$57878 \$99731 VDD pfet_06v0 L=1U W=10U AS=2.5P AD=4.4P PS=10.5U
+ PD=20.88U
M$59 \$99760 \$53338 VDD VDD pfet_06v0 L=1U W=10U AS=4.4P AD=2.5P PS=20.88U
+ PD=10.5U
M$60 \$43662 \$57878 \$99760 VDD pfet_06v0 L=1U W=10U AS=2.5P AD=4.4P PS=10.5U
+ PD=20.88U
M$61 \$99812 \$53338 VDD VDD pfet_06v0 L=1U W=10U AS=4.4P AD=2.5P PS=20.88U
+ PD=10.5U
M$62 \$53338 \$57878 \$99812 VDD pfet_06v0 L=1U W=10U AS=2.5P AD=4.4P PS=10.5U
+ PD=20.88U
M$63 \$99954 \$53340 VDD VDD pfet_06v0 L=1U W=10U AS=4.4P AD=2.5P PS=20.88U
+ PD=10.5U
M$64 \$55658 \$57881 \$99954 VDD pfet_06v0 L=1U W=10U AS=2.5P AD=4.4P PS=10.5U
+ PD=20.88U
M$65 \$99981 \$53340 VDD VDD pfet_06v0 L=1U W=10U AS=4.4P AD=2.5P PS=20.88U
+ PD=10.5U
M$66 \$55658 \$57881 \$99981 VDD pfet_06v0 L=1U W=10U AS=2.5P AD=4.4P PS=10.5U
+ PD=20.88U
M$67 \$100136 \$52538 VDD VDD pfet_06v0 L=1U W=10U AS=4.4P AD=2.5P PS=20.88U
+ PD=10.5U
M$68 \$52538 \$57881 \$100136 VDD pfet_06v0 L=1U W=10U AS=2.5P AD=3.3P PS=10.5U
+ PD=10.66U
M$69 \$38285 \$38285 \$52538 VDD pfet_06v0 L=1U W=10U AS=3.3P AD=4.4P PS=10.66U
+ PD=20.88U
M$70 \$100178 \$53340 VDD VDD pfet_06v0 L=1U W=10U AS=4.4P AD=2.5P PS=20.88U
+ PD=10.5U
M$71 \$42800 \$57881 \$100178 VDD pfet_06v0 L=1U W=10U AS=2.5P AD=4.4P PS=10.5U
+ PD=20.88U
M$72 \$99276 \$53340 VDD VDD pfet_06v0 L=1U W=10U AS=4.4P AD=2.5P PS=20.88U
+ PD=10.5U
M$73 \$43665 \$57881 \$99276 VDD pfet_06v0 L=1U W=10U AS=2.5P AD=4.4P PS=10.5U
+ PD=20.88U
M$74 \$99086 \$53340 VDD VDD pfet_06v0 L=1U W=10U AS=4.4P AD=2.5P PS=20.88U
+ PD=10.5U
M$75 \$43664 \$57881 \$99086 VDD pfet_06v0 L=1U W=10U AS=2.5P AD=4.4P PS=10.5U
+ PD=20.88U
M$76 \$98551 \$53340 VDD VDD pfet_06v0 L=1U W=10U AS=4.4P AD=2.5P PS=20.88U
+ PD=10.5U
M$77 \$53340 \$57881 \$98551 VDD pfet_06v0 L=1U W=10U AS=2.5P AD=4.4P PS=10.5U
+ PD=20.88U
M$78 VDD VSS VDD VDD pfet_06v0 L=2U W=18U AS=7.92P AD=7.92P PS=36.88U PD=36.88U
M$79 \$180789 \$136653 VDD VDD pfet_06v0 L=1U W=10U AS=4.4P AD=2.5P PS=20.88U
+ PD=10.5U
M$80 \$138518 \$142180 \$180789 VDD pfet_06v0 L=1U W=10U AS=2.5P AD=4.4P
+ PS=10.5U PD=20.88U
M$81 \$180877 \$136653 VDD VDD pfet_06v0 L=1U W=10U AS=4.4P AD=2.5P PS=20.88U
+ PD=10.5U
M$82 \$138518 \$142180 \$180877 VDD pfet_06v0 L=1U W=10U AS=2.5P AD=4.4P
+ PS=10.5U PD=20.88U
M$83 \$51237 \$54333 \$55655 VDD pfet_06v0 L=1U W=1.1U AS=0.484P AD=0.484P
+ PS=3.08U PD=3.08U
M$84 \$38247 \$54334 \$55655 VDD pfet_06v0 L=1U W=1U AS=0.44P AD=0.44P PS=2.88U
+ PD=2.88U
M$85 \$38246 \$38249 VDD VDD pfet_06v0 L=1U W=5U AS=2.2P AD=1.65P PS=10.88U
+ PD=5.66U
M$86 \$38249 \$57872 \$38246 VDD pfet_06v0 L=1U W=5U AS=1.65P AD=1.65P PS=5.66U
+ PD=5.66U
M$87 \$38248 \$38252 \$38249 VDD pfet_06v0 L=1U W=5U AS=1.65P AD=2.2P PS=5.66U
+ PD=10.88U
M$88 \$38245 \$38249 VDD VDD pfet_06v0 L=1U W=5U AS=2.2P AD=1.65P PS=10.88U
+ PD=5.66U
M$89 \$38251 \$57872 \$38245 VDD pfet_06v0 L=1U W=5U AS=1.65P AD=1.65P PS=5.66U
+ PD=5.66U
M$90 \$38250 \$38252 \$38251 VDD pfet_06v0 L=1U W=5U AS=1.65P AD=2.2P PS=5.66U
+ PD=10.88U
M$91 \$181181 \$135417 VDD VDD pfet_06v0 L=1U W=10U AS=4.4P AD=2.5P PS=20.88U
+ PD=10.5U
M$92 \$135417 \$142180 \$181181 VDD pfet_06v0 L=1U W=10U AS=2.5P AD=3.3P
+ PS=10.5U PD=10.66U
M$93 \$120565 \$120565 \$135417 VDD pfet_06v0 L=1U W=10U AS=3.3P AD=4.4P
+ PS=10.66U PD=20.88U
M$94 \$181247 \$136653 VDD VDD pfet_06v0 L=1U W=10U AS=4.4P AD=2.5P PS=20.88U
+ PD=10.5U
M$95 \$123308 \$142180 \$181247 VDD pfet_06v0 L=1U W=10U AS=2.5P AD=4.4P
+ PS=10.5U PD=20.88U
M$96 \$38254 \$38251 VDD VDD pfet_06v0 L=1U W=0.5U AS=0.22P AD=0.22P PS=1.88U
+ PD=1.88U
M$97 \$38254 \$38251 VDD VDD pfet_06v0 L=1U W=0.5U AS=0.22P AD=0.22P PS=1.88U
+ PD=1.88U
M$98 \$38254 \$38251 VDD VDD pfet_06v0 L=1U W=0.5U AS=0.22P AD=0.22P PS=1.88U
+ PD=1.88U
M$99 \$38254 \$38251 VDD VDD pfet_06v0 L=1U W=0.5U AS=0.22P AD=0.22P PS=1.88U
+ PD=1.88U
M$100 \$181453 \$136653 VDD VDD pfet_06v0 L=1U W=10U AS=4.4P AD=2.5P PS=20.88U
+ PD=10.5U
M$101 \$127781 \$142180 \$181453 VDD pfet_06v0 L=1U W=10U AS=2.5P AD=4.4P
+ PS=10.5U PD=20.88U
M$102 \$181534 \$136653 VDD VDD pfet_06v0 L=1U W=10U AS=4.4P AD=2.5P PS=20.88U
+ PD=10.5U
M$103 \$127780 \$142180 \$181534 VDD pfet_06v0 L=1U W=10U AS=2.5P AD=4.4P
+ PS=10.5U PD=20.88U
M$104 \$57872 \$57872 VDD VDD pfet_06v0 L=1U W=2U AS=0.88P AD=0.88P PS=4.88U
+ PD=4.88U
M$105 \$181625 \$136653 VDD VDD pfet_06v0 L=1U W=10U AS=4.4P AD=2.5P PS=20.88U
+ PD=10.5U
M$106 \$136653 \$142180 \$181625 VDD pfet_06v0 L=1U W=10U AS=2.5P AD=4.4P
+ PS=10.5U PD=20.88U
M$107 VDD VSS VDD VDD pfet_06v0 L=2U W=18U AS=7.92P AD=7.92P PS=36.88U PD=36.88U
M$108 VDD VSS VDD VDD pfet_06v0 L=2U W=18U AS=7.92P AD=7.92P PS=36.88U PD=36.88U
M$109 \$181868 \$136655 VDD VDD pfet_06v0 L=1U W=10U AS=4.4P AD=2.5P PS=20.88U
+ PD=10.5U
M$110 \$138520 \$142183 \$181868 VDD pfet_06v0 L=1U W=10U AS=2.5P AD=4.4P
+ PS=10.5U PD=20.88U
M$111 \$181914 \$136655 VDD VDD pfet_06v0 L=1U W=10U AS=4.4P AD=2.5P PS=20.88U
+ PD=10.5U
M$112 \$138520 \$142183 \$181914 VDD pfet_06v0 L=1U W=10U AS=2.5P AD=4.4P
+ PS=10.5U PD=20.88U
M$113 \$51238 \$54335 \$55656 VDD pfet_06v0 L=1U W=1.1U AS=0.484P AD=0.484P
+ PS=3.08U PD=3.08U
M$114 \$38258 \$53336 \$55656 VDD pfet_06v0 L=1U W=1U AS=0.44P AD=0.44P
+ PS=2.88U PD=2.88U
M$115 \$38257 \$38260 VDD VDD pfet_06v0 L=1U W=5U AS=2.2P AD=1.65P PS=10.88U
+ PD=5.66U
M$116 \$38260 \$57875 \$38257 VDD pfet_06v0 L=1U W=5U AS=1.65P AD=1.65P
+ PS=5.66U PD=5.66U
M$117 \$38259 \$38263 \$38260 VDD pfet_06v0 L=1U W=5U AS=1.65P AD=2.2P PS=5.66U
+ PD=10.88U
M$118 \$38256 \$38260 VDD VDD pfet_06v0 L=1U W=5U AS=2.2P AD=1.65P PS=10.88U
+ PD=5.66U
M$119 \$38262 \$57875 \$38256 VDD pfet_06v0 L=1U W=5U AS=1.65P AD=1.65P
+ PS=5.66U PD=5.66U
M$120 \$38261 \$38263 \$38262 VDD pfet_06v0 L=1U W=5U AS=1.65P AD=2.2P PS=5.66U
+ PD=10.88U
M$121 \$182211 \$135421 VDD VDD pfet_06v0 L=1U W=10U AS=4.4P AD=2.5P PS=20.88U
+ PD=10.5U
M$122 \$135421 \$142183 \$182211 VDD pfet_06v0 L=1U W=10U AS=2.5P AD=3.3P
+ PS=10.5U PD=10.66U
M$123 \$120576 \$120576 \$135421 VDD pfet_06v0 L=1U W=10U AS=3.3P AD=4.4P
+ PS=10.66U PD=20.88U
M$124 \$182294 \$136655 VDD VDD pfet_06v0 L=1U W=10U AS=4.4P AD=2.5P PS=20.88U
+ PD=10.5U
M$125 \$123309 \$142183 \$182294 VDD pfet_06v0 L=1U W=10U AS=2.5P AD=4.4P
+ PS=10.5U PD=20.88U
M$126 \$38265 \$38262 VDD VDD pfet_06v0 L=1U W=0.5U AS=0.22P AD=0.22P PS=1.88U
+ PD=1.88U
M$127 \$38265 \$38262 VDD VDD pfet_06v0 L=1U W=0.5U AS=0.22P AD=0.22P PS=1.88U
+ PD=1.88U
M$128 \$38265 \$38262 VDD VDD pfet_06v0 L=1U W=0.5U AS=0.22P AD=0.22P PS=1.88U
+ PD=1.88U
M$129 \$38265 \$38262 VDD VDD pfet_06v0 L=1U W=0.5U AS=0.22P AD=0.22P PS=1.88U
+ PD=1.88U
M$130 \$182508 \$136655 VDD VDD pfet_06v0 L=1U W=10U AS=4.4P AD=2.5P PS=20.88U
+ PD=10.5U
M$131 \$127783 \$142183 \$182508 VDD pfet_06v0 L=1U W=10U AS=2.5P AD=4.4P
+ PS=10.5U PD=20.88U
M$132 \$182576 \$136655 VDD VDD pfet_06v0 L=1U W=10U AS=4.4P AD=2.5P PS=20.88U
+ PD=10.5U
M$133 \$127782 \$142183 \$182576 VDD pfet_06v0 L=1U W=10U AS=2.5P AD=4.4P
+ PS=10.5U PD=20.88U
M$134 \$57875 \$57875 VDD VDD pfet_06v0 L=1U W=2U AS=0.88P AD=0.88P PS=4.88U
+ PD=4.88U
M$135 \$182662 \$136655 VDD VDD pfet_06v0 L=1U W=10U AS=4.4P AD=2.5P PS=20.88U
+ PD=10.5U
M$136 \$136655 \$142183 \$182662 VDD pfet_06v0 L=1U W=10U AS=2.5P AD=4.4P
+ PS=10.5U PD=20.88U
M$137 VDD VSS VDD VDD pfet_06v0 L=2U W=18U AS=7.92P AD=7.92P PS=36.88U PD=36.88U
M$138 VDD VSS VDD VDD pfet_06v0 L=2U W=18U AS=7.92P AD=7.92P PS=36.88U PD=36.88U
M$139 \$182906 \$136656 VDD VDD pfet_06v0 L=1U W=10U AS=4.4P AD=2.5P PS=20.88U
+ PD=10.5U
M$140 \$138521 \$142186 \$182906 VDD pfet_06v0 L=1U W=10U AS=2.5P AD=4.4P
+ PS=10.5U PD=20.88U
M$141 \$182983 \$136656 VDD VDD pfet_06v0 L=1U W=10U AS=4.4P AD=2.5P PS=20.88U
+ PD=10.5U
M$142 \$138521 \$142186 \$182983 VDD pfet_06v0 L=1U W=10U AS=2.5P AD=4.4P
+ PS=10.5U PD=20.88U
M$143 \$51241 \$54336 \$55657 VDD pfet_06v0 L=1U W=1.1U AS=0.484P AD=0.484P
+ PS=3.08U PD=3.08U
M$144 \$38269 \$53339 \$55657 VDD pfet_06v0 L=1U W=1U AS=0.44P AD=0.44P
+ PS=2.88U PD=2.88U
M$145 \$38268 \$38271 VDD VDD pfet_06v0 L=1U W=5U AS=2.2P AD=1.65P PS=10.88U
+ PD=5.66U
M$146 \$38271 \$57878 \$38268 VDD pfet_06v0 L=1U W=5U AS=1.65P AD=1.65P
+ PS=5.66U PD=5.66U
M$147 \$38270 \$38274 \$38271 VDD pfet_06v0 L=1U W=5U AS=1.65P AD=2.2P PS=5.66U
+ PD=10.88U
M$148 \$38267 \$38271 VDD VDD pfet_06v0 L=1U W=5U AS=2.2P AD=1.65P PS=10.88U
+ PD=5.66U
M$149 \$38273 \$57878 \$38267 VDD pfet_06v0 L=1U W=5U AS=1.65P AD=1.65P
+ PS=5.66U PD=5.66U
M$150 \$38272 \$38274 \$38273 VDD pfet_06v0 L=1U W=5U AS=1.65P AD=2.2P PS=5.66U
+ PD=10.88U
M$151 \$183255 \$135425 VDD VDD pfet_06v0 L=1U W=10U AS=4.4P AD=2.5P PS=20.88U
+ PD=10.5U
M$152 \$135425 \$142186 \$183255 VDD pfet_06v0 L=1U W=10U AS=2.5P AD=3.3P
+ PS=10.5U PD=10.66U
M$153 \$120587 \$120587 \$135425 VDD pfet_06v0 L=1U W=10U AS=3.3P AD=4.4P
+ PS=10.66U PD=20.88U
M$154 \$183335 \$136656 VDD VDD pfet_06v0 L=1U W=10U AS=4.4P AD=2.5P PS=20.88U
+ PD=10.5U
M$155 \$123310 \$142186 \$183335 VDD pfet_06v0 L=1U W=10U AS=2.5P AD=4.4P
+ PS=10.5U PD=20.88U
M$156 \$38276 \$38273 VDD VDD pfet_06v0 L=1U W=0.5U AS=0.22P AD=0.22P PS=1.88U
+ PD=1.88U
M$157 \$38276 \$38273 VDD VDD pfet_06v0 L=1U W=0.5U AS=0.22P AD=0.22P PS=1.88U
+ PD=1.88U
M$158 \$38276 \$38273 VDD VDD pfet_06v0 L=1U W=0.5U AS=0.22P AD=0.22P PS=1.88U
+ PD=1.88U
M$159 \$38276 \$38273 VDD VDD pfet_06v0 L=1U W=0.5U AS=0.22P AD=0.22P PS=1.88U
+ PD=1.88U
M$160 \$183548 \$136656 VDD VDD pfet_06v0 L=1U W=10U AS=4.4P AD=2.5P PS=20.88U
+ PD=10.5U
M$161 \$127785 \$142186 \$183548 VDD pfet_06v0 L=1U W=10U AS=2.5P AD=4.4P
+ PS=10.5U PD=20.88U
M$162 \$183604 \$136656 VDD VDD pfet_06v0 L=1U W=10U AS=4.4P AD=2.5P PS=20.88U
+ PD=10.5U
M$163 \$127784 \$142186 \$183604 VDD pfet_06v0 L=1U W=10U AS=2.5P AD=4.4P
+ PS=10.5U PD=20.88U
M$164 \$57878 \$57878 VDD VDD pfet_06v0 L=1U W=2U AS=0.88P AD=0.88P PS=4.88U
+ PD=4.88U
M$165 \$183701 \$136656 VDD VDD pfet_06v0 L=1U W=10U AS=4.4P AD=2.5P PS=20.88U
+ PD=10.5U
M$166 \$136656 \$142186 \$183701 VDD pfet_06v0 L=1U W=10U AS=2.5P AD=4.4P
+ PS=10.5U PD=20.88U
M$167 VDD VSS VDD VDD pfet_06v0 L=2U W=18U AS=7.92P AD=7.92P PS=36.88U PD=36.88U
M$168 VDD VSS VDD VDD pfet_06v0 L=2U W=18U AS=7.92P AD=7.92P PS=36.88U PD=36.88U
M$169 \$183939 \$136657 VDD VDD pfet_06v0 L=1U W=10U AS=4.4P AD=2.5P PS=20.88U
+ PD=10.5U
M$170 \$138522 \$142189 \$183939 VDD pfet_06v0 L=1U W=10U AS=2.5P AD=4.4P
+ PS=10.5U PD=20.88U
M$171 \$183990 \$136657 VDD VDD pfet_06v0 L=1U W=10U AS=4.4P AD=2.5P PS=20.88U
+ PD=10.5U
M$172 \$138522 \$142189 \$183990 VDD pfet_06v0 L=1U W=10U AS=2.5P AD=4.4P
+ PS=10.5U PD=20.88U
M$173 \$51246 \$54333 \$55658 VDD pfet_06v0 L=1U W=1.1U AS=0.484P AD=0.484P
+ PS=3.08U PD=3.08U
M$174 \$38280 \$54334 \$55658 VDD pfet_06v0 L=1U W=1U AS=0.44P AD=0.44P
+ PS=2.88U PD=2.88U
M$175 \$38279 \$38282 VDD VDD pfet_06v0 L=1U W=5U AS=2.2P AD=1.65P PS=10.88U
+ PD=5.66U
M$176 \$38282 \$57881 \$38279 VDD pfet_06v0 L=1U W=5U AS=1.65P AD=1.65P
+ PS=5.66U PD=5.66U
M$177 \$38281 \$38285 \$38282 VDD pfet_06v0 L=1U W=5U AS=1.65P AD=2.2P PS=5.66U
+ PD=10.88U
M$178 \$38278 \$38282 VDD VDD pfet_06v0 L=1U W=5U AS=2.2P AD=1.65P PS=10.88U
+ PD=5.66U
M$179 \$38284 \$57881 \$38278 VDD pfet_06v0 L=1U W=5U AS=1.65P AD=1.65P
+ PS=5.66U PD=5.66U
M$180 \$38283 \$38285 \$38284 VDD pfet_06v0 L=1U W=5U AS=1.65P AD=2.2P PS=5.66U
+ PD=10.88U
M$181 \$184265 \$135429 VDD VDD pfet_06v0 L=1U W=10U AS=4.4P AD=2.5P PS=20.88U
+ PD=10.5U
M$182 \$135429 \$142189 \$184265 VDD pfet_06v0 L=1U W=10U AS=2.5P AD=3.3P
+ PS=10.5U PD=10.66U
M$183 \$120598 \$120598 \$135429 VDD pfet_06v0 L=1U W=10U AS=3.3P AD=4.4P
+ PS=10.66U PD=20.88U
M$184 \$184360 \$136657 VDD VDD pfet_06v0 L=1U W=10U AS=4.4P AD=2.5P PS=20.88U
+ PD=10.5U
M$185 \$123311 \$142189 \$184360 VDD pfet_06v0 L=1U W=10U AS=2.5P AD=4.4P
+ PS=10.5U PD=20.88U
M$186 \$38287 \$38284 VDD VDD pfet_06v0 L=1U W=0.5U AS=0.22P AD=0.22P PS=1.88U
+ PD=1.88U
M$187 \$38287 \$38284 VDD VDD pfet_06v0 L=1U W=0.5U AS=0.22P AD=0.22P PS=1.88U
+ PD=1.88U
M$188 \$38287 \$38284 VDD VDD pfet_06v0 L=1U W=0.5U AS=0.22P AD=0.22P PS=1.88U
+ PD=1.88U
M$189 \$38287 \$38284 VDD VDD pfet_06v0 L=1U W=0.5U AS=0.22P AD=0.22P PS=1.88U
+ PD=1.88U
M$190 \$182791 \$136657 VDD VDD pfet_06v0 L=1U W=10U AS=4.4P AD=2.5P PS=20.88U
+ PD=10.5U
M$191 \$127787 \$142189 \$182791 VDD pfet_06v0 L=1U W=10U AS=2.5P AD=4.4P
+ PS=10.5U PD=20.88U
M$192 \$182264 \$136657 VDD VDD pfet_06v0 L=1U W=10U AS=4.4P AD=2.5P PS=20.88U
+ PD=10.5U
M$193 \$127786 \$142189 \$182264 VDD pfet_06v0 L=1U W=10U AS=2.5P AD=4.4P
+ PS=10.5U PD=20.88U
M$194 \$57881 \$57881 VDD VDD pfet_06v0 L=1U W=2U AS=0.88P AD=0.88P PS=4.88U
+ PD=4.88U
M$195 \$181451 \$136657 VDD VDD pfet_06v0 L=1U W=10U AS=4.4P AD=2.5P PS=20.88U
+ PD=10.5U
M$196 \$136657 \$142189 \$181451 VDD pfet_06v0 L=1U W=10U AS=2.5P AD=4.4P
+ PS=10.5U PD=20.88U
M$197 VDD VSS VDD VDD pfet_06v0 L=2U W=18U AS=7.92P AD=7.92P PS=36.88U PD=36.88U
M$198 VDD VSS VDD VDD pfet_06v0 L=2U W=18U AS=7.92P AD=7.92P PS=36.88U PD=36.88U
M$199 \$264643 \$220426 VDD VDD pfet_06v0 L=1U W=10U AS=4.4P AD=2.5P PS=20.88U
+ PD=10.5U
M$200 \$223638 \$225734 \$264643 VDD pfet_06v0 L=1U W=10U AS=2.5P AD=4.4P
+ PS=10.5U PD=20.88U
M$201 \$264722 \$220426 VDD VDD pfet_06v0 L=1U W=10U AS=4.4P AD=2.5P PS=20.88U
+ PD=10.5U
M$202 \$223638 \$225734 \$264722 VDD pfet_06v0 L=1U W=10U AS=2.5P AD=4.4P
+ PS=10.5U PD=20.88U
M$203 \$135414 \$136654 \$138518 VDD pfet_06v0 L=1U W=1.1U AS=0.484P AD=0.484P
+ PS=3.08U PD=3.08U
M$204 \$120560 \$138519 \$138518 VDD pfet_06v0 L=1U W=1U AS=0.44P AD=0.44P
+ PS=2.88U PD=2.88U
M$205 \$120559 \$120562 VDD VDD pfet_06v0 L=1U W=5U AS=2.2P AD=1.65P PS=10.88U
+ PD=5.66U
M$206 \$120562 \$142180 \$120559 VDD pfet_06v0 L=1U W=5U AS=1.65P AD=1.65P
+ PS=5.66U PD=5.66U
M$207 \$120561 \$120565 \$120562 VDD pfet_06v0 L=1U W=5U AS=1.65P AD=2.2P
+ PS=5.66U PD=10.88U
M$208 \$120558 \$120562 VDD VDD pfet_06v0 L=1U W=5U AS=2.2P AD=1.65P PS=10.88U
+ PD=5.66U
M$209 \$120564 \$142180 \$120558 VDD pfet_06v0 L=1U W=5U AS=1.65P AD=1.65P
+ PS=5.66U PD=5.66U
M$210 \$120563 \$120565 \$120564 VDD pfet_06v0 L=1U W=5U AS=1.65P AD=2.2P
+ PS=5.66U PD=10.88U
M$211 \$265025 \$218338 VDD VDD pfet_06v0 L=1U W=10U AS=4.4P AD=2.5P PS=20.88U
+ PD=10.5U
M$212 \$218338 \$225734 \$265025 VDD pfet_06v0 L=1U W=10U AS=2.5P AD=3.3P
+ PS=10.5U PD=10.66U
M$213 \$205746 \$205746 \$218338 VDD pfet_06v0 L=1U W=10U AS=3.3P AD=4.4P
+ PS=10.66U PD=20.88U
M$214 \$265097 \$220426 VDD VDD pfet_06v0 L=1U W=10U AS=4.4P AD=2.5P PS=20.88U
+ PD=10.5U
M$215 \$210291 \$225734 \$265097 VDD pfet_06v0 L=1U W=10U AS=2.5P AD=4.4P
+ PS=10.5U PD=20.88U
M$216 \$120567 \$120564 VDD VDD pfet_06v0 L=1U W=0.5U AS=0.22P AD=0.22P
+ PS=1.88U PD=1.88U
M$217 \$120567 \$120564 VDD VDD pfet_06v0 L=1U W=0.5U AS=0.22P AD=0.22P
+ PS=1.88U PD=1.88U
M$218 \$120567 \$120564 VDD VDD pfet_06v0 L=1U W=0.5U AS=0.22P AD=0.22P
+ PS=1.88U PD=1.88U
M$219 \$120567 \$120564 VDD VDD pfet_06v0 L=1U W=0.5U AS=0.22P AD=0.22P
+ PS=1.88U PD=1.88U
M$220 \$265307 \$220426 VDD VDD pfet_06v0 L=1U W=10U AS=4.4P AD=2.5P PS=20.88U
+ PD=10.5U
M$221 \$215913 \$225734 \$265307 VDD pfet_06v0 L=1U W=10U AS=2.5P AD=4.4P
+ PS=10.5U PD=20.88U
M$222 \$265358 \$220426 VDD VDD pfet_06v0 L=1U W=10U AS=4.4P AD=2.5P PS=20.88U
+ PD=10.5U
M$223 \$213492 \$225734 \$265358 VDD pfet_06v0 L=1U W=10U AS=2.5P AD=4.4P
+ PS=10.5U PD=20.88U
M$224 \$142180 \$142180 VDD VDD pfet_06v0 L=1U W=2U AS=0.88P AD=0.88P PS=4.88U
+ PD=4.88U
M$225 \$265434 \$220426 VDD VDD pfet_06v0 L=1U W=10U AS=4.4P AD=2.5P PS=20.88U
+ PD=10.5U
M$226 \$220426 \$225734 \$265434 VDD pfet_06v0 L=1U W=10U AS=2.5P AD=4.4P
+ PS=10.5U PD=20.88U
M$227 VDD VSS VDD VDD pfet_06v0 L=2U W=18U AS=7.92P AD=7.92P PS=36.88U PD=36.88U
M$228 VDD VSS VDD VDD pfet_06v0 L=2U W=18U AS=7.92P AD=7.92P PS=36.88U PD=36.88U
M$229 \$265716 \$220427 VDD VDD pfet_06v0 L=1U W=10U AS=4.4P AD=2.5P PS=20.88U
+ PD=10.5U
M$230 \$223639 \$225735 \$265716 VDD pfet_06v0 L=1U W=10U AS=2.5P AD=4.4P
+ PS=10.5U PD=20.88U
M$231 \$265759 \$220427 VDD VDD pfet_06v0 L=1U W=10U AS=4.4P AD=2.5P PS=20.88U
+ PD=10.5U
M$232 \$223639 \$225735 \$265759 VDD pfet_06v0 L=1U W=10U AS=2.5P AD=4.4P
+ PS=10.5U PD=20.88U
M$233 \$135418 \$54336 \$138520 VDD pfet_06v0 L=1U W=1.1U AS=0.484P AD=0.484P
+ PS=3.08U PD=3.08U
M$234 \$120571 \$53339 \$138520 VDD pfet_06v0 L=1U W=1U AS=0.44P AD=0.44P
+ PS=2.88U PD=2.88U
M$235 \$120570 \$120573 VDD VDD pfet_06v0 L=1U W=5U AS=2.2P AD=1.65P PS=10.88U
+ PD=5.66U
M$236 \$120573 \$142183 \$120570 VDD pfet_06v0 L=1U W=5U AS=1.65P AD=1.65P
+ PS=5.66U PD=5.66U
M$237 \$120572 \$120576 \$120573 VDD pfet_06v0 L=1U W=5U AS=1.65P AD=2.2P
+ PS=5.66U PD=10.88U
M$238 \$120569 \$120573 VDD VDD pfet_06v0 L=1U W=5U AS=2.2P AD=1.65P PS=10.88U
+ PD=5.66U
M$239 \$120575 \$142183 \$120569 VDD pfet_06v0 L=1U W=5U AS=1.65P AD=1.65P
+ PS=5.66U PD=5.66U
M$240 \$120574 \$120576 \$120575 VDD pfet_06v0 L=1U W=5U AS=1.65P AD=2.2P
+ PS=5.66U PD=10.88U
M$241 \$266011 \$218339 VDD VDD pfet_06v0 L=1U W=10U AS=4.4P AD=2.5P PS=20.88U
+ PD=10.5U
M$242 \$218339 \$225735 \$266011 VDD pfet_06v0 L=1U W=10U AS=2.5P AD=3.3P
+ PS=10.5U PD=10.66U
M$243 \$205757 \$205757 \$218339 VDD pfet_06v0 L=1U W=10U AS=3.3P AD=4.4P
+ PS=10.66U PD=20.88U
M$244 \$266094 \$220427 VDD VDD pfet_06v0 L=1U W=10U AS=4.4P AD=2.5P PS=20.88U
+ PD=10.5U
M$245 \$210292 \$225735 \$266094 VDD pfet_06v0 L=1U W=10U AS=2.5P AD=4.4P
+ PS=10.5U PD=20.88U
M$246 \$120578 \$120575 VDD VDD pfet_06v0 L=1U W=0.5U AS=0.22P AD=0.22P
+ PS=1.88U PD=1.88U
M$247 \$120578 \$120575 VDD VDD pfet_06v0 L=1U W=0.5U AS=0.22P AD=0.22P
+ PS=1.88U PD=1.88U
M$248 \$120578 \$120575 VDD VDD pfet_06v0 L=1U W=0.5U AS=0.22P AD=0.22P
+ PS=1.88U PD=1.88U
M$249 \$120578 \$120575 VDD VDD pfet_06v0 L=1U W=0.5U AS=0.22P AD=0.22P
+ PS=1.88U PD=1.88U
M$250 \$266274 \$220427 VDD VDD pfet_06v0 L=1U W=10U AS=4.4P AD=2.5P PS=20.88U
+ PD=10.5U
M$251 \$215914 \$225735 \$266274 VDD pfet_06v0 L=1U W=10U AS=2.5P AD=4.4P
+ PS=10.5U PD=20.88U
M$252 \$266329 \$220427 VDD VDD pfet_06v0 L=1U W=10U AS=4.4P AD=2.5P PS=20.88U
+ PD=10.5U
M$253 \$213493 \$225735 \$266329 VDD pfet_06v0 L=1U W=10U AS=2.5P AD=4.4P
+ PS=10.5U PD=20.88U
M$254 \$142183 \$142183 VDD VDD pfet_06v0 L=1U W=2U AS=0.88P AD=0.88P PS=4.88U
+ PD=4.88U
M$255 \$266427 \$220427 VDD VDD pfet_06v0 L=1U W=10U AS=4.4P AD=2.5P PS=20.88U
+ PD=10.5U
M$256 \$220427 \$225735 \$266427 VDD pfet_06v0 L=1U W=10U AS=2.5P AD=4.4P
+ PS=10.5U PD=20.88U
M$257 VDD VSS VDD VDD pfet_06v0 L=2U W=18U AS=7.92P AD=7.92P PS=36.88U PD=36.88U
M$258 VDD VSS VDD VDD pfet_06v0 L=2U W=18U AS=7.92P AD=7.92P PS=36.88U PD=36.88U
M$259 \$266692 \$220428 VDD VDD pfet_06v0 L=1U W=10U AS=4.4P AD=2.5P PS=20.88U
+ PD=10.5U
M$260 \$223640 \$225736 \$266692 VDD pfet_06v0 L=1U W=10U AS=2.5P AD=4.4P
+ PS=10.5U PD=20.88U
M$261 \$266734 \$220428 VDD VDD pfet_06v0 L=1U W=10U AS=4.4P AD=2.5P PS=20.88U
+ PD=10.5U
M$262 \$223640 \$225736 \$266734 VDD pfet_06v0 L=1U W=10U AS=2.5P AD=4.4P
+ PS=10.5U PD=20.88U
M$263 \$135424 \$136654 \$138521 VDD pfet_06v0 L=1U W=1.1U AS=0.484P AD=0.484P
+ PS=3.08U PD=3.08U
M$264 \$120582 \$138519 \$138521 VDD pfet_06v0 L=1U W=1U AS=0.44P AD=0.44P
+ PS=2.88U PD=2.88U
M$265 \$120581 \$120584 VDD VDD pfet_06v0 L=1U W=5U AS=2.2P AD=1.65P PS=10.88U
+ PD=5.66U
M$266 \$120584 \$142186 \$120581 VDD pfet_06v0 L=1U W=5U AS=1.65P AD=1.65P
+ PS=5.66U PD=5.66U
M$267 \$120583 \$120587 \$120584 VDD pfet_06v0 L=1U W=5U AS=1.65P AD=2.2P
+ PS=5.66U PD=10.88U
M$268 \$120580 \$120584 VDD VDD pfet_06v0 L=1U W=5U AS=2.2P AD=1.65P PS=10.88U
+ PD=5.66U
M$269 \$120586 \$142186 \$120580 VDD pfet_06v0 L=1U W=5U AS=1.65P AD=1.65P
+ PS=5.66U PD=5.66U
M$270 \$120585 \$120587 \$120586 VDD pfet_06v0 L=1U W=5U AS=1.65P AD=2.2P
+ PS=5.66U PD=10.88U
M$271 \$266947 \$218340 VDD VDD pfet_06v0 L=1U W=10U AS=4.4P AD=2.5P PS=20.88U
+ PD=10.5U
M$272 \$218340 \$225736 \$266947 VDD pfet_06v0 L=1U W=10U AS=2.5P AD=3.3P
+ PS=10.5U PD=10.66U
M$273 \$205768 \$205768 \$218340 VDD pfet_06v0 L=1U W=10U AS=3.3P AD=4.4P
+ PS=10.66U PD=20.88U
M$274 \$267027 \$220428 VDD VDD pfet_06v0 L=1U W=10U AS=4.4P AD=2.5P PS=20.88U
+ PD=10.5U
M$275 \$210293 \$225736 \$267027 VDD pfet_06v0 L=1U W=10U AS=2.5P AD=4.4P
+ PS=10.5U PD=20.88U
M$276 \$120589 \$120586 VDD VDD pfet_06v0 L=1U W=0.5U AS=0.22P AD=0.22P
+ PS=1.88U PD=1.88U
M$277 \$120589 \$120586 VDD VDD pfet_06v0 L=1U W=0.5U AS=0.22P AD=0.22P
+ PS=1.88U PD=1.88U
M$278 \$120589 \$120586 VDD VDD pfet_06v0 L=1U W=0.5U AS=0.22P AD=0.22P
+ PS=1.88U PD=1.88U
M$279 \$120589 \$120586 VDD VDD pfet_06v0 L=1U W=0.5U AS=0.22P AD=0.22P
+ PS=1.88U PD=1.88U
M$280 \$267214 \$220428 VDD VDD pfet_06v0 L=1U W=10U AS=4.4P AD=2.5P PS=20.88U
+ PD=10.5U
M$281 \$215915 \$225736 \$267214 VDD pfet_06v0 L=1U W=10U AS=2.5P AD=4.4P
+ PS=10.5U PD=20.88U
M$282 \$267281 \$220428 VDD VDD pfet_06v0 L=1U W=10U AS=4.4P AD=2.5P PS=20.88U
+ PD=10.5U
M$283 \$213494 \$225736 \$267281 VDD pfet_06v0 L=1U W=10U AS=2.5P AD=4.4P
+ PS=10.5U PD=20.88U
M$284 \$142186 \$142186 VDD VDD pfet_06v0 L=1U W=2U AS=0.88P AD=0.88P PS=4.88U
+ PD=4.88U
M$285 \$267358 \$220428 VDD VDD pfet_06v0 L=1U W=10U AS=4.4P AD=2.5P PS=20.88U
+ PD=10.5U
M$286 \$220428 \$225736 \$267358 VDD pfet_06v0 L=1U W=10U AS=2.5P AD=4.4P
+ PS=10.5U PD=20.88U
M$287 VDD VSS VDD VDD pfet_06v0 L=2U W=18U AS=7.92P AD=7.92P PS=36.88U PD=36.88U
M$288 VDD VSS VDD VDD pfet_06v0 L=2U W=18U AS=7.92P AD=7.92P PS=36.88U PD=36.88U
M$289 \$267631 \$220429 VDD VDD pfet_06v0 L=1U W=10U AS=4.4P AD=2.5P PS=20.88U
+ PD=10.5U
M$290 \$223641 \$225737 \$267631 VDD pfet_06v0 L=1U W=10U AS=2.5P AD=4.4P
+ PS=10.5U PD=20.88U
M$291 \$267650 \$220429 VDD VDD pfet_06v0 L=1U W=10U AS=4.4P AD=2.5P PS=20.88U
+ PD=10.5U
M$292 \$223641 \$225737 \$267650 VDD pfet_06v0 L=1U W=10U AS=2.5P AD=4.4P
+ PS=10.5U PD=20.88U
M$293 \$135426 \$54336 \$138522 VDD pfet_06v0 L=1U W=1.1U AS=0.484P AD=0.484P
+ PS=3.08U PD=3.08U
M$294 \$120593 \$53339 \$138522 VDD pfet_06v0 L=1U W=1U AS=0.44P AD=0.44P
+ PS=2.88U PD=2.88U
M$295 \$120592 \$120595 VDD VDD pfet_06v0 L=1U W=5U AS=2.2P AD=1.65P PS=10.88U
+ PD=5.66U
M$296 \$120595 \$142189 \$120592 VDD pfet_06v0 L=1U W=5U AS=1.65P AD=1.65P
+ PS=5.66U PD=5.66U
M$297 \$120594 \$120598 \$120595 VDD pfet_06v0 L=1U W=5U AS=1.65P AD=2.2P
+ PS=5.66U PD=10.88U
M$298 \$120591 \$120595 VDD VDD pfet_06v0 L=1U W=5U AS=2.2P AD=1.65P PS=10.88U
+ PD=5.66U
M$299 \$120597 \$142189 \$120591 VDD pfet_06v0 L=1U W=5U AS=1.65P AD=1.65P
+ PS=5.66U PD=5.66U
M$300 \$120596 \$120598 \$120597 VDD pfet_06v0 L=1U W=5U AS=1.65P AD=2.2P
+ PS=5.66U PD=10.88U
M$301 \$267737 \$218341 VDD VDD pfet_06v0 L=1U W=10U AS=4.4P AD=2.5P PS=20.88U
+ PD=10.5U
M$302 \$218341 \$225737 \$267737 VDD pfet_06v0 L=1U W=10U AS=2.5P AD=3.3P
+ PS=10.5U PD=10.66U
M$303 \$205779 \$205779 \$218341 VDD pfet_06v0 L=1U W=10U AS=3.3P AD=4.4P
+ PS=10.66U PD=20.88U
M$304 \$267316 \$220429 VDD VDD pfet_06v0 L=1U W=10U AS=4.4P AD=2.5P PS=20.88U
+ PD=10.5U
M$305 \$210294 \$225737 \$267316 VDD pfet_06v0 L=1U W=10U AS=2.5P AD=4.4P
+ PS=10.5U PD=20.88U
M$306 \$120600 \$120597 VDD VDD pfet_06v0 L=1U W=0.5U AS=0.22P AD=0.22P
+ PS=1.88U PD=1.88U
M$307 \$120600 \$120597 VDD VDD pfet_06v0 L=1U W=0.5U AS=0.22P AD=0.22P
+ PS=1.88U PD=1.88U
M$308 \$120600 \$120597 VDD VDD pfet_06v0 L=1U W=0.5U AS=0.22P AD=0.22P
+ PS=1.88U PD=1.88U
M$309 \$120600 \$120597 VDD VDD pfet_06v0 L=1U W=0.5U AS=0.22P AD=0.22P
+ PS=1.88U PD=1.88U
M$310 \$266119 \$220429 VDD VDD pfet_06v0 L=1U W=10U AS=4.4P AD=2.5P PS=20.88U
+ PD=10.5U
M$311 \$215916 \$225737 \$266119 VDD pfet_06v0 L=1U W=10U AS=2.5P AD=4.4P
+ PS=10.5U PD=20.88U
M$312 \$265896 \$220429 VDD VDD pfet_06v0 L=1U W=10U AS=4.4P AD=2.5P PS=20.88U
+ PD=10.5U
M$313 \$213495 \$225737 \$265896 VDD pfet_06v0 L=1U W=10U AS=2.5P AD=4.4P
+ PS=10.5U PD=20.88U
M$314 \$142189 \$142189 VDD VDD pfet_06v0 L=1U W=2U AS=0.88P AD=0.88P PS=4.88U
+ PD=4.88U
M$315 \$265241 \$220429 VDD VDD pfet_06v0 L=1U W=10U AS=4.4P AD=2.5P PS=20.88U
+ PD=10.5U
M$316 \$220429 \$225737 \$265241 VDD pfet_06v0 L=1U W=10U AS=2.5P AD=4.4P
+ PS=10.5U PD=20.88U
M$317 VDD VSS VDD VDD pfet_06v0 L=2U W=18U AS=7.92P AD=7.92P PS=36.88U PD=36.88U
M$318 VDD VSS VDD VDD pfet_06v0 L=2U W=9.75U AS=4.29P AD=4.29P PS=20.38U
+ PD=20.38U
M$319 \$217300 \$54335 \$223638 VDD pfet_06v0 L=1U W=1.1U AS=0.484P AD=0.484P
+ PS=3.08U PD=3.08U
M$320 \$205741 \$53336 \$223638 VDD pfet_06v0 L=1U W=1U AS=0.44P AD=0.44P
+ PS=2.88U PD=2.88U
M$321 \$205740 \$205743 VDD VDD pfet_06v0 L=1U W=5U AS=2.2P AD=1.65P PS=10.88U
+ PD=5.66U
M$322 \$205743 \$225734 \$205740 VDD pfet_06v0 L=1U W=5U AS=1.65P AD=1.65P
+ PS=5.66U PD=5.66U
M$323 \$205742 \$205746 \$205743 VDD pfet_06v0 L=1U W=5U AS=1.65P AD=2.2P
+ PS=5.66U PD=10.88U
M$324 \$205739 \$205743 VDD VDD pfet_06v0 L=1U W=5U AS=2.2P AD=1.65P PS=10.88U
+ PD=5.66U
M$325 \$205745 \$225734 \$205739 VDD pfet_06v0 L=1U W=5U AS=1.65P AD=1.65P
+ PS=5.66U PD=5.66U
M$326 \$205744 \$205746 \$205745 VDD pfet_06v0 L=1U W=5U AS=1.65P AD=2.2P
+ PS=5.66U PD=10.88U
M$327 \$288691 \$38254 \$300870 VDD pfet_06v0 L=1U W=10U AS=4.4P AD=2.6P
+ PS=20.88U PD=10.52U
M$328 \$300870 \$38254 \$288691 VDD pfet_06v0 L=1U W=10U AS=2.6P AD=4.4P
+ PS=10.52U PD=20.88U
M$329 \$288689 \$38276 \$300870 VDD pfet_06v0 L=1U W=10U AS=4.4P AD=2.6P
+ PS=20.88U PD=10.52U
M$330 \$300870 \$38276 \$288689 VDD pfet_06v0 L=1U W=10U AS=2.6P AD=4.4P
+ PS=10.52U PD=20.88U
M$331 \$205748 \$205745 VDD VDD pfet_06v0 L=1U W=0.5U AS=0.22P AD=0.22P
+ PS=1.88U PD=1.88U
M$332 \$205748 \$205745 VDD VDD pfet_06v0 L=1U W=0.5U AS=0.22P AD=0.22P
+ PS=1.88U PD=1.88U
M$333 \$205748 \$205745 VDD VDD pfet_06v0 L=1U W=0.5U AS=0.22P AD=0.22P
+ PS=1.88U PD=1.88U
M$334 \$205748 \$205745 VDD VDD pfet_06v0 L=1U W=0.5U AS=0.22P AD=0.22P
+ PS=1.88U PD=1.88U
M$335 \$225734 \$225734 VDD VDD pfet_06v0 L=1U W=2U AS=0.88P AD=0.88P PS=4.88U
+ PD=4.88U
M$336 \$288696 \$288693 VDD VDD pfet_06v0 L=1U W=10U AS=4.4P AD=2.6P PS=20.88U
+ PD=10.52U
M$337 VDD \$288693 \$288696 VDD pfet_06v0 L=1U W=10U AS=2.6P AD=2.6P PS=10.52U
+ PD=10.52U
M$338 \$288696 \$288693 VDD VDD pfet_06v0 L=1U W=10U AS=2.6P AD=4.4P PS=10.52U
+ PD=20.88U
M$339 VDD VSS VDD VDD pfet_06v0 L=2U W=9.75U AS=4.29P AD=4.29P PS=20.38U
+ PD=20.38U
M$340 VDD VSS VDD VDD pfet_06v0 L=2U W=9.75U AS=4.29P AD=4.29P PS=20.38U
+ PD=20.38U
M$341 \$217303 \$136654 \$223639 VDD pfet_06v0 L=1U W=1.1U AS=0.484P AD=0.484P
+ PS=3.08U PD=3.08U
M$342 \$205752 \$138519 \$223639 VDD pfet_06v0 L=1U W=1U AS=0.44P AD=0.44P
+ PS=2.88U PD=2.88U
M$343 \$205751 \$205754 VDD VDD pfet_06v0 L=1U W=5U AS=2.2P AD=1.65P PS=10.88U
+ PD=5.66U
M$344 \$205754 \$225735 \$205751 VDD pfet_06v0 L=1U W=5U AS=1.65P AD=1.65P
+ PS=5.66U PD=5.66U
M$345 \$205753 \$205757 \$205754 VDD pfet_06v0 L=1U W=5U AS=1.65P AD=2.2P
+ PS=5.66U PD=10.88U
M$346 \$205750 \$205754 VDD VDD pfet_06v0 L=1U W=5U AS=2.2P AD=1.65P PS=10.88U
+ PD=5.66U
M$347 \$205756 \$225735 \$205750 VDD pfet_06v0 L=1U W=5U AS=1.65P AD=1.65P
+ PS=5.66U PD=5.66U
M$348 \$205755 \$205757 \$205756 VDD pfet_06v0 L=1U W=5U AS=1.65P AD=2.2P
+ PS=5.66U PD=10.88U
M$349 \$288703 \$38265 \$300871 VDD pfet_06v0 L=1U W=10U AS=4.4P AD=2.6P
+ PS=20.88U PD=10.52U
M$350 \$300871 \$38265 \$288703 VDD pfet_06v0 L=1U W=10U AS=2.6P AD=4.4P
+ PS=10.52U PD=20.88U
M$351 \$205759 \$205756 VDD VDD pfet_06v0 L=1U W=0.5U AS=0.22P AD=0.22P
+ PS=1.88U PD=1.88U
M$352 \$288701 \$38276 \$300871 VDD pfet_06v0 L=1U W=10U AS=4.4P AD=2.6P
+ PS=20.88U PD=10.52U
M$353 \$300871 \$38276 \$288701 VDD pfet_06v0 L=1U W=10U AS=2.6P AD=4.4P
+ PS=10.52U PD=20.88U
M$354 \$205759 \$205756 VDD VDD pfet_06v0 L=1U W=0.5U AS=0.22P AD=0.22P
+ PS=1.88U PD=1.88U
M$355 \$205759 \$205756 VDD VDD pfet_06v0 L=1U W=0.5U AS=0.22P AD=0.22P
+ PS=1.88U PD=1.88U
M$356 \$205759 \$205756 VDD VDD pfet_06v0 L=1U W=0.5U AS=0.22P AD=0.22P
+ PS=1.88U PD=1.88U
M$357 \$225735 \$225735 VDD VDD pfet_06v0 L=1U W=2U AS=0.88P AD=0.88P PS=4.88U
+ PD=4.88U
M$358 \$288708 \$288705 VDD VDD pfet_06v0 L=1U W=10U AS=4.4P AD=2.6P PS=20.88U
+ PD=10.52U
M$359 VDD \$288705 \$288708 VDD pfet_06v0 L=1U W=10U AS=2.6P AD=2.6P PS=10.52U
+ PD=10.52U
M$360 \$288708 \$288705 VDD VDD pfet_06v0 L=1U W=10U AS=2.6P AD=4.4P PS=10.52U
+ PD=20.88U
M$361 VDD VSS VDD VDD pfet_06v0 L=2U W=9.75U AS=4.29P AD=4.29P PS=20.38U
+ PD=20.38U
M$362 \$217305 \$54333 \$223640 VDD pfet_06v0 L=1U W=1.1U AS=0.484P AD=0.484P
+ PS=3.08U PD=3.08U
M$363 \$205763 \$54334 \$223640 VDD pfet_06v0 L=1U W=1U AS=0.44P AD=0.44P
+ PS=2.88U PD=2.88U
M$364 VDD VSS VDD VDD pfet_06v0 L=2U W=9.75U AS=4.29P AD=4.29P PS=20.38U
+ PD=20.38U
M$365 \$205762 \$205765 VDD VDD pfet_06v0 L=1U W=5U AS=2.2P AD=1.65P PS=10.88U
+ PD=5.66U
M$366 \$205765 \$225736 \$205762 VDD pfet_06v0 L=1U W=5U AS=1.65P AD=1.65P
+ PS=5.66U PD=5.66U
M$367 \$205764 \$205768 \$205765 VDD pfet_06v0 L=1U W=5U AS=1.65P AD=2.2P
+ PS=5.66U PD=10.88U
M$368 \$205761 \$205765 VDD VDD pfet_06v0 L=1U W=5U AS=2.2P AD=1.65P PS=10.88U
+ PD=5.66U
M$369 \$205767 \$225736 \$205761 VDD pfet_06v0 L=1U W=5U AS=1.65P AD=1.65P
+ PS=5.66U PD=5.66U
M$370 \$205766 \$205768 \$205767 VDD pfet_06v0 L=1U W=5U AS=1.65P AD=2.2P
+ PS=5.66U PD=10.88U
M$371 \$205770 \$205767 VDD VDD pfet_06v0 L=1U W=0.5U AS=0.22P AD=0.22P
+ PS=1.88U PD=1.88U
M$372 \$205770 \$205767 VDD VDD pfet_06v0 L=1U W=0.5U AS=0.22P AD=0.22P
+ PS=1.88U PD=1.88U
M$373 \$288715 \$38265 \$300872 VDD pfet_06v0 L=1U W=10U AS=4.4P AD=2.6P
+ PS=20.88U PD=10.52U
M$374 \$300872 \$38265 \$288715 VDD pfet_06v0 L=1U W=10U AS=2.6P AD=4.4P
+ PS=10.52U PD=20.88U
M$375 \$205770 \$205767 VDD VDD pfet_06v0 L=1U W=0.5U AS=0.22P AD=0.22P
+ PS=1.88U PD=1.88U
M$376 \$288713 \$38254 \$300872 VDD pfet_06v0 L=1U W=10U AS=4.4P AD=2.6P
+ PS=20.88U PD=10.52U
M$377 \$300872 \$38254 \$288713 VDD pfet_06v0 L=1U W=10U AS=2.6P AD=4.4P
+ PS=10.52U PD=20.88U
M$378 \$205770 \$205767 VDD VDD pfet_06v0 L=1U W=0.5U AS=0.22P AD=0.22P
+ PS=1.88U PD=1.88U
M$379 \$225736 \$225736 VDD VDD pfet_06v0 L=1U W=2U AS=0.88P AD=0.88P PS=4.88U
+ PD=4.88U
M$380 \$217308 \$54335 \$223641 VDD pfet_06v0 L=1U W=1.1U AS=0.484P AD=0.484P
+ PS=3.08U PD=3.08U
M$381 \$288720 \$288717 VDD VDD pfet_06v0 L=1U W=10U AS=4.4P AD=2.6P PS=20.88U
+ PD=10.52U
M$382 VDD \$288717 \$288720 VDD pfet_06v0 L=1U W=10U AS=2.6P AD=2.6P PS=10.52U
+ PD=10.52U
M$383 \$288720 \$288717 VDD VDD pfet_06v0 L=1U W=10U AS=2.6P AD=4.4P PS=10.52U
+ PD=20.88U
M$384 \$205774 \$53336 \$223641 VDD pfet_06v0 L=1U W=1U AS=0.44P AD=0.44P
+ PS=2.88U PD=2.88U
M$385 \$205773 \$205776 VDD VDD pfet_06v0 L=1U W=5U AS=2.2P AD=1.65P PS=10.88U
+ PD=5.66U
M$386 \$205776 \$225737 \$205773 VDD pfet_06v0 L=1U W=5U AS=1.65P AD=1.65P
+ PS=5.66U PD=5.66U
M$387 \$205775 \$205779 \$205776 VDD pfet_06v0 L=1U W=5U AS=1.65P AD=2.2P
+ PS=5.66U PD=10.88U
M$388 VDD VSS VDD VDD pfet_06v0 L=2U W=9.75U AS=4.29P AD=4.29P PS=20.38U
+ PD=20.38U
M$389 \$205772 \$205776 VDD VDD pfet_06v0 L=1U W=5U AS=2.2P AD=1.65P PS=10.88U
+ PD=5.66U
M$390 \$205778 \$225737 \$205772 VDD pfet_06v0 L=1U W=5U AS=1.65P AD=1.65P
+ PS=5.66U PD=5.66U
M$391 \$205777 \$205779 \$205778 VDD pfet_06v0 L=1U W=5U AS=1.65P AD=2.2P
+ PS=5.66U PD=10.88U
M$392 VDD VSS VDD VDD pfet_06v0 L=2U W=9.75U AS=4.29P AD=4.29P PS=20.38U
+ PD=20.38U
M$393 \$205781 \$205778 VDD VDD pfet_06v0 L=1U W=0.5U AS=0.22P AD=0.22P
+ PS=1.88U PD=1.88U
M$394 \$205781 \$205778 VDD VDD pfet_06v0 L=1U W=0.5U AS=0.22P AD=0.22P
+ PS=1.88U PD=1.88U
M$395 \$205781 \$205778 VDD VDD pfet_06v0 L=1U W=0.5U AS=0.22P AD=0.22P
+ PS=1.88U PD=1.88U
M$396 \$205781 \$205778 VDD VDD pfet_06v0 L=1U W=0.5U AS=0.22P AD=0.22P
+ PS=1.88U PD=1.88U
M$397 \$225737 \$225737 VDD VDD pfet_06v0 L=1U W=2U AS=0.88P AD=0.88P PS=4.88U
+ PD=4.88U
M$398 \$323585 \$306773 VDD VDD pfet_06v0 L=1U W=10U AS=4.4P AD=2.5P PS=20.88U
+ PD=10.5U
M$399 \$290937 \$306774 \$323585 VDD pfet_06v0 L=1U W=10U AS=2.5P AD=4.4P
+ PS=10.5U PD=20.88U
M$400 \$323627 \$306773 VDD VDD pfet_06v0 L=1U W=10U AS=4.4P AD=2.5P PS=20.88U
+ PD=10.5U
M$401 \$288685 \$306774 \$323627 VDD pfet_06v0 L=1U W=10U AS=2.5P AD=4.4P
+ PS=10.5U PD=20.88U
M$402 \$323673 \$306773 VDD VDD pfet_06v0 L=1U W=10U AS=4.4P AD=2.5P PS=20.88U
+ PD=10.5U
M$403 \$306773 \$306774 \$323673 VDD pfet_06v0 L=1U W=10U AS=2.5P AD=4.4P
+ PS=10.5U PD=20.88U
M$404 \$323712 \$306773 VDD VDD pfet_06v0 L=1U W=10U AS=4.4P AD=2.5P PS=20.88U
+ PD=10.5U
M$405 \$300870 \$306774 \$323712 VDD pfet_06v0 L=1U W=10U AS=2.5P AD=3.3P
+ PS=10.5U PD=10.66U
M$406 \$323734 \$306774 \$300870 VDD pfet_06v0 L=1U W=10U AS=3.3P AD=2.5P
+ PS=10.66U PD=10.5U
M$407 VDD \$306773 \$323734 VDD pfet_06v0 L=1U W=10U AS=2.5P AD=4.4P PS=10.5U
+ PD=20.88U
M$408 \$324005 \$300354 VDD VDD pfet_06v0 L=1U W=10U AS=4.4P AD=2.5P PS=20.88U
+ PD=10.5U
M$409 \$300354 \$306774 \$324005 VDD pfet_06v0 L=1U W=10U AS=2.5P AD=3.3P
+ PS=10.5U PD=10.66U
M$410 \$288694 \$288694 \$300354 VDD pfet_06v0 L=1U W=10U AS=3.3P AD=4.4P
+ PS=10.66U PD=20.88U
M$411 \$324041 \$306773 VDD VDD pfet_06v0 L=1U W=10U AS=4.4P AD=2.5P PS=20.88U
+ PD=10.5U
M$412 \$290938 \$306774 \$324041 VDD pfet_06v0 L=1U W=10U AS=2.5P AD=4.4P
+ PS=10.5U PD=20.88U
M$413 \$324228 \$306776 VDD VDD pfet_06v0 L=1U W=10U AS=4.4P AD=2.5P PS=20.88U
+ PD=10.5U
M$414 \$290939 \$306777 \$324228 VDD pfet_06v0 L=1U W=10U AS=2.5P AD=4.4P
+ PS=10.5U PD=20.88U
M$415 \$324261 \$306776 VDD VDD pfet_06v0 L=1U W=10U AS=4.4P AD=2.5P PS=20.88U
+ PD=10.5U
M$416 \$288697 \$306777 \$324261 VDD pfet_06v0 L=1U W=10U AS=2.5P AD=4.4P
+ PS=10.5U PD=20.88U
M$417 \$324319 \$306776 VDD VDD pfet_06v0 L=1U W=10U AS=4.4P AD=2.5P PS=20.88U
+ PD=10.5U
M$418 \$306776 \$306777 \$324319 VDD pfet_06v0 L=1U W=10U AS=2.5P AD=4.4P
+ PS=10.5U PD=20.88U
M$419 \$324352 \$306776 VDD VDD pfet_06v0 L=1U W=10U AS=4.4P AD=2.5P PS=20.88U
+ PD=10.5U
M$420 \$300871 \$306777 \$324352 VDD pfet_06v0 L=1U W=10U AS=2.5P AD=3.3P
+ PS=10.5U PD=10.66U
M$421 \$324378 \$306777 \$300871 VDD pfet_06v0 L=1U W=10U AS=3.3P AD=2.5P
+ PS=10.66U PD=10.5U
M$422 VDD \$306776 \$324378 VDD pfet_06v0 L=1U W=10U AS=2.5P AD=4.4P PS=10.5U
+ PD=20.88U
M$423 \$324628 \$300355 VDD VDD pfet_06v0 L=1U W=10U AS=4.4P AD=2.5P PS=20.88U
+ PD=10.5U
M$424 \$300355 \$306777 \$324628 VDD pfet_06v0 L=1U W=10U AS=2.5P AD=3.3P
+ PS=10.5U PD=10.66U
M$425 \$288706 \$288706 \$300355 VDD pfet_06v0 L=1U W=10U AS=3.3P AD=4.4P
+ PS=10.66U PD=20.88U
M$426 \$324652 \$306776 VDD VDD pfet_06v0 L=1U W=10U AS=4.4P AD=2.5P PS=20.88U
+ PD=10.5U
M$427 \$290940 \$306777 \$324652 VDD pfet_06v0 L=1U W=10U AS=2.5P AD=4.4P
+ PS=10.5U PD=20.88U
M$428 \$324821 \$306779 VDD VDD pfet_06v0 L=1U W=10U AS=4.4P AD=2.5P PS=20.88U
+ PD=10.5U
M$429 \$290941 \$306780 \$324821 VDD pfet_06v0 L=1U W=10U AS=2.5P AD=4.4P
+ PS=10.5U PD=20.88U
M$430 \$324873 \$306779 VDD VDD pfet_06v0 L=1U W=10U AS=4.4P AD=2.5P PS=20.88U
+ PD=10.5U
M$431 \$288709 \$306780 \$324873 VDD pfet_06v0 L=1U W=10U AS=2.5P AD=4.4P
+ PS=10.5U PD=20.88U
M$432 \$324917 \$306779 VDD VDD pfet_06v0 L=1U W=10U AS=4.4P AD=2.5P PS=20.88U
+ PD=10.5U
M$433 \$306779 \$306780 \$324917 VDD pfet_06v0 L=1U W=10U AS=2.5P AD=4.4P
+ PS=10.5U PD=20.88U
M$434 \$324953 \$306779 VDD VDD pfet_06v0 L=1U W=10U AS=4.4P AD=2.5P PS=20.88U
+ PD=10.5U
M$435 \$300872 \$306780 \$324953 VDD pfet_06v0 L=1U W=10U AS=2.5P AD=3.3P
+ PS=10.5U PD=10.66U
M$436 \$324969 \$306780 \$300872 VDD pfet_06v0 L=1U W=10U AS=3.3P AD=2.5P
+ PS=10.66U PD=10.5U
M$437 VDD \$306779 \$324969 VDD pfet_06v0 L=1U W=10U AS=2.5P AD=4.4P PS=10.5U
+ PD=20.88U
M$438 \$325247 \$300356 VDD VDD pfet_06v0 L=1U W=10U AS=4.4P AD=2.5P PS=20.88U
+ PD=10.5U
M$439 \$300356 \$306780 \$325247 VDD pfet_06v0 L=1U W=10U AS=2.5P AD=3.3P
+ PS=10.5U PD=10.66U
M$440 \$288718 \$288718 \$300356 VDD pfet_06v0 L=1U W=10U AS=3.3P AD=4.4P
+ PS=10.66U PD=20.88U
M$441 \$325282 \$306779 VDD VDD pfet_06v0 L=1U W=10U AS=4.4P AD=2.5P PS=20.88U
+ PD=10.5U
M$442 \$290942 \$306780 \$325282 VDD pfet_06v0 L=1U W=10U AS=2.5P AD=4.4P
+ PS=10.5U PD=20.88U
M$443 VDD VSS VDD VDD pfet_06v0 L=2U W=9.75U AS=4.29P AD=4.29P PS=20.38U
+ PD=20.38U
M$444 \$306774 \$306774 VDD VDD pfet_06v0 L=1U W=2U AS=0.88P AD=0.88P PS=4.88U
+ PD=4.88U
M$445 \$347602 \$38287 \$360255 VDD pfet_06v0 L=1U W=10U AS=4.4P AD=2.6P
+ PS=20.88U PD=10.52U
M$446 \$360255 \$38287 \$347602 VDD pfet_06v0 L=1U W=10U AS=2.6P AD=4.4P
+ PS=10.52U PD=20.88U
M$447 \$347600 \$120578 \$360255 VDD pfet_06v0 L=1U W=10U AS=4.4P AD=2.6P
+ PS=20.88U PD=10.52U
M$448 \$360255 \$120578 \$347600 VDD pfet_06v0 L=1U W=10U AS=2.6P AD=4.4P
+ PS=10.52U PD=20.88U
M$449 \$302272 \$306774 \$288688 VDD pfet_06v0 L=1U W=5U AS=2.2P AD=1.3P
+ PS=10.88U PD=5.52U
M$450 \$288688 \$306774 \$302272 VDD pfet_06v0 L=1U W=5U AS=1.3P AD=2.2P
+ PS=5.52U PD=10.88U
M$451 \$288693 \$306774 \$288687 VDD pfet_06v0 L=1U W=5U AS=2.2P AD=1.3P
+ PS=10.88U PD=5.52U
M$452 \$288687 \$306774 \$288693 VDD pfet_06v0 L=1U W=5U AS=1.3P AD=2.2P
+ PS=5.52U PD=10.88U
M$453 \$288688 \$302272 VDD VDD pfet_06v0 L=1U W=5U AS=2.2P AD=1.3P PS=10.88U
+ PD=5.52U
M$454 VDD \$302272 \$288688 VDD pfet_06v0 L=1U W=5U AS=1.3P AD=1.3P PS=5.52U
+ PD=5.52U
M$455 \$288688 \$302272 VDD VDD pfet_06v0 L=1U W=5U AS=1.3P AD=1.3P PS=5.52U
+ PD=5.52U
M$456 VDD \$302272 \$288688 VDD pfet_06v0 L=1U W=5U AS=1.3P AD=2.2P PS=5.52U
+ PD=10.88U
M$457 \$288687 \$302272 VDD VDD pfet_06v0 L=1U W=5U AS=2.2P AD=1.3P PS=10.88U
+ PD=5.52U
M$458 VDD \$302272 \$288687 VDD pfet_06v0 L=1U W=5U AS=1.3P AD=1.3P PS=5.52U
+ PD=5.52U
M$459 \$288687 \$302272 VDD VDD pfet_06v0 L=1U W=5U AS=1.3P AD=1.3P PS=5.52U
+ PD=5.52U
M$460 VDD \$302272 \$288687 VDD pfet_06v0 L=1U W=5U AS=1.3P AD=2.2P PS=5.52U
+ PD=10.88U
M$461 \$288690 \$288694 \$302272 VDD pfet_06v0 L=1U W=5U AS=2.2P AD=2.2P
+ PS=10.88U PD=10.88U
M$462 \$288692 \$288694 \$288693 VDD pfet_06v0 L=1U W=5U AS=2.2P AD=2.2P
+ PS=10.88U PD=10.88U
M$463 \$347607 \$347604 VDD VDD pfet_06v0 L=1U W=10U AS=4.4P AD=2.6P PS=20.88U
+ PD=10.52U
M$464 VDD \$347604 \$347607 VDD pfet_06v0 L=1U W=10U AS=2.6P AD=2.6P PS=10.52U
+ PD=10.52U
M$465 \$347607 \$347604 VDD VDD pfet_06v0 L=1U W=10U AS=2.6P AD=4.4P PS=10.52U
+ PD=20.88U
M$466 VDD VSS VDD VDD pfet_06v0 L=2U W=9.75U AS=4.29P AD=4.29P PS=20.38U
+ PD=20.38U
M$467 VDD VSS VDD VDD pfet_06v0 L=2U W=9.75U AS=4.29P AD=4.29P PS=20.38U
+ PD=20.38U
M$468 \$306777 \$306777 VDD VDD pfet_06v0 L=1U W=2U AS=0.88P AD=0.88P PS=4.88U
+ PD=4.88U
M$469 \$347614 \$120567 \$360256 VDD pfet_06v0 L=1U W=10U AS=4.4P AD=2.6P
+ PS=20.88U PD=10.52U
M$470 \$360256 \$120567 \$347614 VDD pfet_06v0 L=1U W=10U AS=2.6P AD=4.4P
+ PS=10.52U PD=20.88U
M$471 \$347612 \$120578 \$360256 VDD pfet_06v0 L=1U W=10U AS=4.4P AD=2.6P
+ PS=20.88U PD=10.52U
M$472 \$360256 \$120578 \$347612 VDD pfet_06v0 L=1U W=10U AS=2.6P AD=4.4P
+ PS=10.52U PD=20.88U
M$473 \$302273 \$306777 \$288700 VDD pfet_06v0 L=1U W=5U AS=2.2P AD=1.3P
+ PS=10.88U PD=5.52U
M$474 \$288700 \$306777 \$302273 VDD pfet_06v0 L=1U W=5U AS=1.3P AD=2.2P
+ PS=5.52U PD=10.88U
M$475 \$288705 \$306777 \$288699 VDD pfet_06v0 L=1U W=5U AS=2.2P AD=1.3P
+ PS=10.88U PD=5.52U
M$476 \$288699 \$306777 \$288705 VDD pfet_06v0 L=1U W=5U AS=1.3P AD=2.2P
+ PS=5.52U PD=10.88U
M$477 \$288700 \$302273 VDD VDD pfet_06v0 L=1U W=5U AS=2.2P AD=1.3P PS=10.88U
+ PD=5.52U
M$478 VDD \$302273 \$288700 VDD pfet_06v0 L=1U W=5U AS=1.3P AD=1.3P PS=5.52U
+ PD=5.52U
M$479 \$288700 \$302273 VDD VDD pfet_06v0 L=1U W=5U AS=1.3P AD=1.3P PS=5.52U
+ PD=5.52U
M$480 VDD \$302273 \$288700 VDD pfet_06v0 L=1U W=5U AS=1.3P AD=2.2P PS=5.52U
+ PD=10.88U
M$481 \$288699 \$302273 VDD VDD pfet_06v0 L=1U W=5U AS=2.2P AD=1.3P PS=10.88U
+ PD=5.52U
M$482 VDD \$302273 \$288699 VDD pfet_06v0 L=1U W=5U AS=1.3P AD=1.3P PS=5.52U
+ PD=5.52U
M$483 \$288699 \$302273 VDD VDD pfet_06v0 L=1U W=5U AS=1.3P AD=1.3P PS=5.52U
+ PD=5.52U
M$484 VDD \$302273 \$288699 VDD pfet_06v0 L=1U W=5U AS=1.3P AD=2.2P PS=5.52U
+ PD=10.88U
M$485 \$288702 \$288706 \$302273 VDD pfet_06v0 L=1U W=5U AS=2.2P AD=2.2P
+ PS=10.88U PD=10.88U
M$486 \$288704 \$288706 \$288705 VDD pfet_06v0 L=1U W=5U AS=2.2P AD=2.2P
+ PS=10.88U PD=10.88U
M$487 \$347619 \$347616 VDD VDD pfet_06v0 L=1U W=10U AS=4.4P AD=2.6P PS=20.88U
+ PD=10.52U
M$488 VDD \$347616 \$347619 VDD pfet_06v0 L=1U W=10U AS=2.6P AD=2.6P PS=10.52U
+ PD=10.52U
M$489 \$347619 \$347616 VDD VDD pfet_06v0 L=1U W=10U AS=2.6P AD=4.4P PS=10.52U
+ PD=20.88U
M$490 VDD VSS VDD VDD pfet_06v0 L=2U W=9.75U AS=4.29P AD=4.29P PS=20.38U
+ PD=20.38U
M$491 VDD VSS VDD VDD pfet_06v0 L=2U W=9.75U AS=4.29P AD=4.29P PS=20.38U
+ PD=20.38U
M$492 \$306780 \$306780 VDD VDD pfet_06v0 L=1U W=2U AS=0.88P AD=0.88P PS=4.88U
+ PD=4.88U
M$493 \$347626 \$120567 \$360257 VDD pfet_06v0 L=1U W=10U AS=4.4P AD=2.6P
+ PS=20.88U PD=10.52U
M$494 \$360257 \$120567 \$347626 VDD pfet_06v0 L=1U W=10U AS=2.6P AD=4.4P
+ PS=10.52U PD=20.88U
M$495 \$347624 \$38287 \$360257 VDD pfet_06v0 L=1U W=10U AS=4.4P AD=2.6P
+ PS=20.88U PD=10.52U
M$496 \$360257 \$38287 \$347624 VDD pfet_06v0 L=1U W=10U AS=2.6P AD=4.4P
+ PS=10.52U PD=20.88U
M$497 \$302274 \$306780 \$288712 VDD pfet_06v0 L=1U W=5U AS=2.2P AD=1.3P
+ PS=10.88U PD=5.52U
M$498 \$288712 \$306780 \$302274 VDD pfet_06v0 L=1U W=5U AS=1.3P AD=2.2P
+ PS=5.52U PD=10.88U
M$499 \$288717 \$306780 \$288711 VDD pfet_06v0 L=1U W=5U AS=2.2P AD=1.3P
+ PS=10.88U PD=5.52U
M$500 \$288711 \$306780 \$288717 VDD pfet_06v0 L=1U W=5U AS=1.3P AD=2.2P
+ PS=5.52U PD=10.88U
M$501 \$288712 \$302274 VDD VDD pfet_06v0 L=1U W=5U AS=2.2P AD=1.3P PS=10.88U
+ PD=5.52U
M$502 VDD \$302274 \$288712 VDD pfet_06v0 L=1U W=5U AS=1.3P AD=1.3P PS=5.52U
+ PD=5.52U
M$503 \$288712 \$302274 VDD VDD pfet_06v0 L=1U W=5U AS=1.3P AD=1.3P PS=5.52U
+ PD=5.52U
M$504 VDD \$302274 \$288712 VDD pfet_06v0 L=1U W=5U AS=1.3P AD=2.2P PS=5.52U
+ PD=10.88U
M$505 \$288711 \$302274 VDD VDD pfet_06v0 L=1U W=5U AS=2.2P AD=1.3P PS=10.88U
+ PD=5.52U
M$506 VDD \$302274 \$288711 VDD pfet_06v0 L=1U W=5U AS=1.3P AD=1.3P PS=5.52U
+ PD=5.52U
M$507 \$288711 \$302274 VDD VDD pfet_06v0 L=1U W=5U AS=1.3P AD=1.3P PS=5.52U
+ PD=5.52U
M$508 VDD \$302274 \$288711 VDD pfet_06v0 L=1U W=5U AS=1.3P AD=2.2P PS=5.52U
+ PD=10.88U
M$509 \$288714 \$288718 \$302274 VDD pfet_06v0 L=1U W=5U AS=2.2P AD=2.2P
+ PS=10.88U PD=10.88U
M$510 \$288716 \$288718 \$288717 VDD pfet_06v0 L=1U W=5U AS=2.2P AD=2.2P
+ PS=10.88U PD=10.88U
M$511 \$347631 \$347628 VDD VDD pfet_06v0 L=1U W=10U AS=4.4P AD=2.6P PS=20.88U
+ PD=10.52U
M$512 VDD \$347628 \$347631 VDD pfet_06v0 L=1U W=10U AS=2.6P AD=2.6P PS=10.52U
+ PD=10.52U
M$513 \$347631 \$347628 VDD VDD pfet_06v0 L=1U W=10U AS=2.6P AD=4.4P PS=10.52U
+ PD=20.88U
M$514 VDD VSS VDD VDD pfet_06v0 L=2U W=9.75U AS=4.29P AD=4.29P PS=20.38U
+ PD=20.38U
M$515 VDD VSS VDD VDD pfet_06v0 L=2U W=9.75U AS=4.29P AD=4.29P PS=20.38U
+ PD=20.38U
M$516 \$300358 \$300358 VDD VDD pfet_06v0 L=1U W=2U AS=0.88P AD=0.52P PS=4.88U
+ PD=2.52U
M$517 VDD \$300358 \$300358 VDD pfet_06v0 L=1U W=2U AS=0.52P AD=0.52P PS=2.52U
+ PD=2.52U
M$518 \$300358 \$300358 VDD VDD pfet_06v0 L=1U W=2U AS=0.52P AD=0.52P PS=2.52U
+ PD=2.52U
M$519 VDD \$300358 \$300358 VDD pfet_06v0 L=1U W=2U AS=0.52P AD=0.52P PS=2.52U
+ PD=2.52U
M$520 \$300358 \$300358 VDD VDD pfet_06v0 L=1U W=2U AS=0.52P AD=0.52P PS=2.52U
+ PD=2.52U
M$521 VDD \$300358 \$300358 VDD pfet_06v0 L=1U W=2U AS=0.52P AD=0.88P PS=2.52U
+ PD=4.88U
M$522 \$287457 \$287457 VDD VDD pfet_06v0 L=1U W=2U AS=0.88P AD=0.88P PS=4.88U
+ PD=4.88U
M$523 \$381014 \$365590 VDD VDD pfet_06v0 L=1U W=10U AS=4.4P AD=2.5P PS=20.88U
+ PD=10.5U
M$524 \$349887 \$366766 \$381014 VDD pfet_06v0 L=1U W=10U AS=2.5P AD=4.4P
+ PS=10.5U PD=20.88U
M$525 \$381048 \$365590 VDD VDD pfet_06v0 L=1U W=10U AS=4.4P AD=2.5P PS=20.88U
+ PD=10.5U
M$526 \$347596 \$366766 \$381048 VDD pfet_06v0 L=1U W=10U AS=2.5P AD=4.4P
+ PS=10.5U PD=20.88U
M$527 \$381129 \$365590 VDD VDD pfet_06v0 L=1U W=10U AS=4.4P AD=2.5P PS=20.88U
+ PD=10.5U
M$528 \$365590 \$366766 \$381129 VDD pfet_06v0 L=1U W=10U AS=2.5P AD=4.4P
+ PS=10.5U PD=20.88U
M$529 \$381161 \$365590 VDD VDD pfet_06v0 L=1U W=10U AS=4.4P AD=2.5P PS=20.88U
+ PD=10.5U
M$530 \$360255 \$366766 \$381161 VDD pfet_06v0 L=1U W=10U AS=2.5P AD=3.3P
+ PS=10.5U PD=10.66U
M$531 \$381174 \$366766 \$360255 VDD pfet_06v0 L=1U W=10U AS=3.3P AD=2.5P
+ PS=10.66U PD=10.5U
M$532 VDD \$365590 \$381174 VDD pfet_06v0 L=1U W=10U AS=2.5P AD=4.4P PS=10.5U
+ PD=20.88U
M$533 \$381602 \$359040 VDD VDD pfet_06v0 L=1U W=10U AS=4.4P AD=2.5P PS=20.88U
+ PD=10.5U
M$534 \$359040 \$366766 \$381602 VDD pfet_06v0 L=1U W=10U AS=2.5P AD=3.3P
+ PS=10.5U PD=10.66U
M$535 \$347605 \$347605 \$359040 VDD pfet_06v0 L=1U W=10U AS=3.3P AD=4.4P
+ PS=10.66U PD=20.88U
M$536 \$381670 \$365590 VDD VDD pfet_06v0 L=1U W=10U AS=4.4P AD=2.5P PS=20.88U
+ PD=10.5U
M$537 \$349888 \$366766 \$381670 VDD pfet_06v0 L=1U W=10U AS=2.5P AD=4.4P
+ PS=10.5U PD=20.88U
M$538 \$381978 \$365591 VDD VDD pfet_06v0 L=1U W=10U AS=4.4P AD=2.5P PS=20.88U
+ PD=10.5U
M$539 \$349889 \$366768 \$381978 VDD pfet_06v0 L=1U W=10U AS=2.5P AD=4.4P
+ PS=10.5U PD=20.88U
M$540 \$382049 \$365591 VDD VDD pfet_06v0 L=1U W=10U AS=4.4P AD=2.5P PS=20.88U
+ PD=10.5U
M$541 \$347608 \$366768 \$382049 VDD pfet_06v0 L=1U W=10U AS=2.5P AD=4.4P
+ PS=10.5U PD=20.88U
M$542 \$382128 \$365591 VDD VDD pfet_06v0 L=1U W=10U AS=4.4P AD=2.5P PS=20.88U
+ PD=10.5U
M$543 \$365591 \$366768 \$382128 VDD pfet_06v0 L=1U W=10U AS=2.5P AD=4.4P
+ PS=10.5U PD=20.88U
M$544 \$382146 \$365591 VDD VDD pfet_06v0 L=1U W=10U AS=4.4P AD=2.5P PS=20.88U
+ PD=10.5U
M$545 \$360256 \$366768 \$382146 VDD pfet_06v0 L=1U W=10U AS=2.5P AD=3.3P
+ PS=10.5U PD=10.66U
M$546 \$382179 \$366768 \$360256 VDD pfet_06v0 L=1U W=10U AS=3.3P AD=2.5P
+ PS=10.66U PD=10.5U
M$547 VDD \$365591 \$382179 VDD pfet_06v0 L=1U W=10U AS=2.5P AD=4.4P PS=10.5U
+ PD=20.88U
M$548 \$382605 \$359041 VDD VDD pfet_06v0 L=1U W=10U AS=4.4P AD=2.5P PS=20.88U
+ PD=10.5U
M$549 \$359041 \$366768 \$382605 VDD pfet_06v0 L=1U W=10U AS=2.5P AD=3.3P
+ PS=10.5U PD=10.66U
M$550 \$347617 \$347617 \$359041 VDD pfet_06v0 L=1U W=10U AS=3.3P AD=4.4P
+ PS=10.66U PD=20.88U
M$551 \$382692 \$365591 VDD VDD pfet_06v0 L=1U W=10U AS=4.4P AD=2.5P PS=20.88U
+ PD=10.5U
M$552 \$349890 \$366768 \$382692 VDD pfet_06v0 L=1U W=10U AS=2.5P AD=4.4P
+ PS=10.5U PD=20.88U
M$553 \$383015 \$365592 VDD VDD pfet_06v0 L=1U W=10U AS=4.4P AD=2.5P PS=20.88U
+ PD=10.5U
M$554 \$349891 \$366770 \$383015 VDD pfet_06v0 L=1U W=10U AS=2.5P AD=4.4P
+ PS=10.5U PD=20.88U
M$555 \$383077 \$365592 VDD VDD pfet_06v0 L=1U W=10U AS=4.4P AD=2.5P PS=20.88U
+ PD=10.5U
M$556 \$347620 \$366770 \$383077 VDD pfet_06v0 L=1U W=10U AS=2.5P AD=4.4P
+ PS=10.5U PD=20.88U
M$557 \$383136 \$365592 VDD VDD pfet_06v0 L=1U W=10U AS=4.4P AD=2.5P PS=20.88U
+ PD=10.5U
M$558 \$365592 \$366770 \$383136 VDD pfet_06v0 L=1U W=10U AS=2.5P AD=4.4P
+ PS=10.5U PD=20.88U
M$559 \$383153 \$365592 VDD VDD pfet_06v0 L=1U W=10U AS=4.4P AD=2.5P PS=20.88U
+ PD=10.5U
M$560 \$360257 \$366770 \$383153 VDD pfet_06v0 L=1U W=10U AS=2.5P AD=3.3P
+ PS=10.5U PD=10.66U
M$561 \$383187 \$366770 \$360257 VDD pfet_06v0 L=1U W=10U AS=3.3P AD=2.5P
+ PS=10.66U PD=10.5U
M$562 VDD \$365592 \$383187 VDD pfet_06v0 L=1U W=10U AS=2.5P AD=4.4P PS=10.5U
+ PD=20.88U
M$563 \$383594 \$359042 VDD VDD pfet_06v0 L=1U W=10U AS=4.4P AD=2.5P PS=20.88U
+ PD=10.5U
M$564 \$359042 \$366770 \$383594 VDD pfet_06v0 L=1U W=10U AS=2.5P AD=3.3P
+ PS=10.5U PD=10.66U
M$565 \$347629 \$347629 \$359042 VDD pfet_06v0 L=1U W=10U AS=3.3P AD=4.4P
+ PS=10.66U PD=20.88U
M$566 \$383687 \$365592 VDD VDD pfet_06v0 L=1U W=10U AS=4.4P AD=2.5P PS=20.88U
+ PD=10.5U
M$567 \$349892 \$366770 \$383687 VDD pfet_06v0 L=1U W=10U AS=2.5P AD=4.4P
+ PS=10.5U PD=20.88U
M$568 VDD VSS VDD VDD pfet_06v0 L=2U W=9.75U AS=4.29P AD=4.29P PS=20.38U
+ PD=20.38U
M$569 \$366766 \$366766 VDD VDD pfet_06v0 L=1U W=2U AS=0.88P AD=0.88P PS=4.88U
+ PD=4.88U
M$570 \$406859 \$120589 \$418989 VDD pfet_06v0 L=1U W=10U AS=4.4P AD=2.6P
+ PS=20.88U PD=10.52U
M$571 \$418989 \$120589 \$406859 VDD pfet_06v0 L=1U W=10U AS=2.6P AD=4.4P
+ PS=10.52U PD=20.88U
M$572 \$406857 \$205748 \$418989 VDD pfet_06v0 L=1U W=10U AS=4.4P AD=2.6P
+ PS=20.88U PD=10.52U
M$573 \$418989 \$205748 \$406857 VDD pfet_06v0 L=1U W=10U AS=2.6P AD=4.4P
+ PS=10.52U PD=20.88U
M$574 \$360996 \$366766 \$347599 VDD pfet_06v0 L=1U W=5U AS=2.2P AD=1.3P
+ PS=10.88U PD=5.52U
M$575 \$347599 \$366766 \$360996 VDD pfet_06v0 L=1U W=5U AS=1.3P AD=2.2P
+ PS=5.52U PD=10.88U
M$576 \$347604 \$366766 \$347598 VDD pfet_06v0 L=1U W=5U AS=2.2P AD=1.3P
+ PS=10.88U PD=5.52U
M$577 \$347598 \$366766 \$347604 VDD pfet_06v0 L=1U W=5U AS=1.3P AD=2.2P
+ PS=5.52U PD=10.88U
M$578 \$347599 \$360996 VDD VDD pfet_06v0 L=1U W=5U AS=2.2P AD=1.3P PS=10.88U
+ PD=5.52U
M$579 VDD \$360996 \$347599 VDD pfet_06v0 L=1U W=5U AS=1.3P AD=1.3P PS=5.52U
+ PD=5.52U
M$580 \$347599 \$360996 VDD VDD pfet_06v0 L=1U W=5U AS=1.3P AD=1.3P PS=5.52U
+ PD=5.52U
M$581 VDD \$360996 \$347599 VDD pfet_06v0 L=1U W=5U AS=1.3P AD=2.2P PS=5.52U
+ PD=10.88U
M$582 \$347598 \$360996 VDD VDD pfet_06v0 L=1U W=5U AS=2.2P AD=1.3P PS=10.88U
+ PD=5.52U
M$583 VDD \$360996 \$347598 VDD pfet_06v0 L=1U W=5U AS=1.3P AD=1.3P PS=5.52U
+ PD=5.52U
M$584 \$347598 \$360996 VDD VDD pfet_06v0 L=1U W=5U AS=1.3P AD=1.3P PS=5.52U
+ PD=5.52U
M$585 VDD \$360996 \$347598 VDD pfet_06v0 L=1U W=5U AS=1.3P AD=2.2P PS=5.52U
+ PD=10.88U
M$586 \$347601 \$347605 \$360996 VDD pfet_06v0 L=1U W=5U AS=2.2P AD=2.2P
+ PS=10.88U PD=10.88U
M$587 \$347603 \$347605 \$347604 VDD pfet_06v0 L=1U W=5U AS=2.2P AD=2.2P
+ PS=10.88U PD=10.88U
M$588 \$406861 \$405608 VDD VDD pfet_06v0 L=1U W=10U AS=4.4P AD=2.6P PS=20.88U
+ PD=10.52U
M$589 VDD \$405608 \$406861 VDD pfet_06v0 L=1U W=10U AS=2.6P AD=2.6P PS=10.52U
+ PD=10.52U
M$590 \$406861 \$405608 VDD VDD pfet_06v0 L=1U W=10U AS=2.6P AD=4.4P PS=10.52U
+ PD=20.88U
M$591 VDD VSS VDD VDD pfet_06v0 L=2U W=9.75U AS=4.29P AD=4.29P PS=20.38U
+ PD=20.38U
M$592 VDD VSS VDD VDD pfet_06v0 L=2U W=9.75U AS=4.29P AD=4.29P PS=20.38U
+ PD=20.38U
M$593 \$366768 \$366768 VDD VDD pfet_06v0 L=1U W=2U AS=0.88P AD=0.88P PS=4.88U
+ PD=4.88U
M$594 \$406867 \$120600 \$418991 VDD pfet_06v0 L=1U W=10U AS=4.4P AD=2.6P
+ PS=20.88U PD=10.52U
M$595 \$418991 \$120600 \$406867 VDD pfet_06v0 L=1U W=10U AS=2.6P AD=4.4P
+ PS=10.52U PD=20.88U
M$596 \$406865 \$205748 \$418991 VDD pfet_06v0 L=1U W=10U AS=4.4P AD=2.6P
+ PS=20.88U PD=10.52U
M$597 \$418991 \$205748 \$406865 VDD pfet_06v0 L=1U W=10U AS=2.6P AD=4.4P
+ PS=10.52U PD=20.88U
M$598 \$360997 \$366768 \$347611 VDD pfet_06v0 L=1U W=5U AS=2.2P AD=1.3P
+ PS=10.88U PD=5.52U
M$599 \$347611 \$366768 \$360997 VDD pfet_06v0 L=1U W=5U AS=1.3P AD=2.2P
+ PS=5.52U PD=10.88U
M$600 \$347616 \$366768 \$347610 VDD pfet_06v0 L=1U W=5U AS=2.2P AD=1.3P
+ PS=10.88U PD=5.52U
M$601 \$347610 \$366768 \$347616 VDD pfet_06v0 L=1U W=5U AS=1.3P AD=2.2P
+ PS=5.52U PD=10.88U
M$602 \$347611 \$360997 VDD VDD pfet_06v0 L=1U W=5U AS=2.2P AD=1.3P PS=10.88U
+ PD=5.52U
M$603 VDD \$360997 \$347611 VDD pfet_06v0 L=1U W=5U AS=1.3P AD=1.3P PS=5.52U
+ PD=5.52U
M$604 \$347611 \$360997 VDD VDD pfet_06v0 L=1U W=5U AS=1.3P AD=1.3P PS=5.52U
+ PD=5.52U
M$605 VDD \$360997 \$347611 VDD pfet_06v0 L=1U W=5U AS=1.3P AD=2.2P PS=5.52U
+ PD=10.88U
M$606 \$347610 \$360997 VDD VDD pfet_06v0 L=1U W=5U AS=2.2P AD=1.3P PS=10.88U
+ PD=5.52U
M$607 VDD \$360997 \$347610 VDD pfet_06v0 L=1U W=5U AS=1.3P AD=1.3P PS=5.52U
+ PD=5.52U
M$608 \$347610 \$360997 VDD VDD pfet_06v0 L=1U W=5U AS=1.3P AD=1.3P PS=5.52U
+ PD=5.52U
M$609 VDD \$360997 \$347610 VDD pfet_06v0 L=1U W=5U AS=1.3P AD=2.2P PS=5.52U
+ PD=10.88U
M$610 \$347613 \$347617 \$360997 VDD pfet_06v0 L=1U W=5U AS=2.2P AD=2.2P
+ PS=10.88U PD=10.88U
M$611 \$347615 \$347617 \$347616 VDD pfet_06v0 L=1U W=5U AS=2.2P AD=2.2P
+ PS=10.88U PD=10.88U
M$612 \$406869 \$405612 VDD VDD pfet_06v0 L=1U W=10U AS=4.4P AD=2.6P PS=20.88U
+ PD=10.52U
M$613 VDD \$405612 \$406869 VDD pfet_06v0 L=1U W=10U AS=2.6P AD=2.6P PS=10.52U
+ PD=10.52U
M$614 \$406869 \$405612 VDD VDD pfet_06v0 L=1U W=10U AS=2.6P AD=4.4P PS=10.52U
+ PD=20.88U
M$615 VDD VSS VDD VDD pfet_06v0 L=2U W=9.75U AS=4.29P AD=4.29P PS=20.38U
+ PD=20.38U
M$616 VDD VSS VDD VDD pfet_06v0 L=2U W=9.75U AS=4.29P AD=4.29P PS=20.38U
+ PD=20.38U
M$617 \$366770 \$366770 VDD VDD pfet_06v0 L=1U W=2U AS=0.88P AD=0.88P PS=4.88U
+ PD=4.88U
M$618 \$406875 \$120600 \$418993 VDD pfet_06v0 L=1U W=10U AS=4.4P AD=2.6P
+ PS=20.88U PD=10.52U
M$619 \$418993 \$120600 \$406875 VDD pfet_06v0 L=1U W=10U AS=2.6P AD=4.4P
+ PS=10.52U PD=20.88U
M$620 \$406873 \$120589 \$418993 VDD pfet_06v0 L=1U W=10U AS=4.4P AD=2.6P
+ PS=20.88U PD=10.52U
M$621 \$418993 \$120589 \$406873 VDD pfet_06v0 L=1U W=10U AS=2.6P AD=4.4P
+ PS=10.52U PD=20.88U
M$622 \$360998 \$366770 \$347623 VDD pfet_06v0 L=1U W=5U AS=2.2P AD=1.3P
+ PS=10.88U PD=5.52U
M$623 \$347623 \$366770 \$360998 VDD pfet_06v0 L=1U W=5U AS=1.3P AD=2.2P
+ PS=5.52U PD=10.88U
M$624 \$347628 \$366770 \$347622 VDD pfet_06v0 L=1U W=5U AS=2.2P AD=1.3P
+ PS=10.88U PD=5.52U
M$625 \$347622 \$366770 \$347628 VDD pfet_06v0 L=1U W=5U AS=1.3P AD=2.2P
+ PS=5.52U PD=10.88U
M$626 \$347623 \$360998 VDD VDD pfet_06v0 L=1U W=5U AS=2.2P AD=1.3P PS=10.88U
+ PD=5.52U
M$627 VDD \$360998 \$347623 VDD pfet_06v0 L=1U W=5U AS=1.3P AD=1.3P PS=5.52U
+ PD=5.52U
M$628 \$347623 \$360998 VDD VDD pfet_06v0 L=1U W=5U AS=1.3P AD=1.3P PS=5.52U
+ PD=5.52U
M$629 VDD \$360998 \$347623 VDD pfet_06v0 L=1U W=5U AS=1.3P AD=2.2P PS=5.52U
+ PD=10.88U
M$630 \$347622 \$360998 VDD VDD pfet_06v0 L=1U W=5U AS=2.2P AD=1.3P PS=10.88U
+ PD=5.52U
M$631 VDD \$360998 \$347622 VDD pfet_06v0 L=1U W=5U AS=1.3P AD=1.3P PS=5.52U
+ PD=5.52U
M$632 \$347622 \$360998 VDD VDD pfet_06v0 L=1U W=5U AS=1.3P AD=1.3P PS=5.52U
+ PD=5.52U
M$633 VDD \$360998 \$347622 VDD pfet_06v0 L=1U W=5U AS=1.3P AD=2.2P PS=5.52U
+ PD=10.88U
M$634 \$347625 \$347629 \$360998 VDD pfet_06v0 L=1U W=5U AS=2.2P AD=2.2P
+ PS=10.88U PD=10.88U
M$635 \$347627 \$347629 \$347628 VDD pfet_06v0 L=1U W=5U AS=2.2P AD=2.2P
+ PS=10.88U PD=10.88U
M$636 \$406877 \$405616 VDD VDD pfet_06v0 L=1U W=10U AS=4.4P AD=2.6P PS=20.88U
+ PD=10.52U
M$637 VDD \$405616 \$406877 VDD pfet_06v0 L=1U W=10U AS=2.6P AD=2.6P PS=10.52U
+ PD=10.52U
M$638 \$406877 \$405616 VDD VDD pfet_06v0 L=1U W=10U AS=2.6P AD=4.4P PS=10.52U
+ PD=20.88U
M$639 VDD VSS VDD VDD pfet_06v0 L=2U W=9.75U AS=4.29P AD=4.29P PS=20.38U
+ PD=20.38U
M$640 VDD VSS VDD VDD pfet_06v0 L=2U W=9.75U AS=4.29P AD=4.29P PS=20.38U
+ PD=20.38U
M$641 \$359044 \$359044 VDD VDD pfet_06v0 L=1U W=2U AS=0.88P AD=0.52P PS=4.88U
+ PD=2.52U
M$642 VDD \$359044 \$359044 VDD pfet_06v0 L=1U W=2U AS=0.52P AD=0.52P PS=2.52U
+ PD=2.52U
M$643 \$359044 \$359044 VDD VDD pfet_06v0 L=1U W=2U AS=0.52P AD=0.52P PS=2.52U
+ PD=2.52U
M$644 VDD \$359044 \$359044 VDD pfet_06v0 L=1U W=2U AS=0.52P AD=0.52P PS=2.52U
+ PD=2.52U
M$645 \$359044 \$359044 VDD VDD pfet_06v0 L=1U W=2U AS=0.52P AD=0.52P PS=2.52U
+ PD=2.52U
M$646 VDD \$359044 \$359044 VDD pfet_06v0 L=1U W=2U AS=0.52P AD=0.88P PS=2.52U
+ PD=4.88U
M$647 \$347632 \$347632 VDD VDD pfet_06v0 L=1U W=2U AS=0.88P AD=0.88P PS=4.88U
+ PD=4.88U
M$648 \$438587 \$423548 VDD VDD pfet_06v0 L=1U W=10U AS=4.4P AD=2.5P PS=20.88U
+ PD=10.5U
M$649 \$407607 \$424670 \$438587 VDD pfet_06v0 L=1U W=10U AS=2.5P AD=4.4P
+ PS=10.5U PD=20.88U
M$650 \$438653 \$423548 VDD VDD pfet_06v0 L=1U W=10U AS=4.4P AD=2.5P PS=20.88U
+ PD=10.5U
M$651 \$405607 \$424670 \$438653 VDD pfet_06v0 L=1U W=10U AS=2.5P AD=4.4P
+ PS=10.5U PD=20.88U
M$652 \$438762 \$423548 VDD VDD pfet_06v0 L=1U W=10U AS=4.4P AD=2.5P PS=20.88U
+ PD=10.5U
M$653 \$423548 \$424670 \$438762 VDD pfet_06v0 L=1U W=10U AS=2.5P AD=4.4P
+ PS=10.5U PD=20.88U
M$654 \$438809 \$423548 VDD VDD pfet_06v0 L=1U W=10U AS=4.4P AD=2.5P PS=20.88U
+ PD=10.5U
M$655 \$418989 \$424670 \$438809 VDD pfet_06v0 L=1U W=10U AS=2.5P AD=3.3P
+ PS=10.5U PD=10.66U
M$656 \$438819 \$424670 \$418989 VDD pfet_06v0 L=1U W=10U AS=3.3P AD=2.5P
+ PS=10.66U PD=10.5U
M$657 VDD \$423548 \$438819 VDD pfet_06v0 L=1U W=10U AS=2.5P AD=4.4P PS=10.5U
+ PD=20.88U
M$658 \$439444 \$417191 VDD VDD pfet_06v0 L=1U W=10U AS=4.4P AD=2.5P PS=20.88U
+ PD=10.5U
M$659 \$417191 \$424670 \$439444 VDD pfet_06v0 L=1U W=10U AS=2.5P AD=3.3P
+ PS=10.5U PD=10.66U
M$660 \$405609 \$405609 \$417191 VDD pfet_06v0 L=1U W=10U AS=3.3P AD=4.4P
+ PS=10.66U PD=20.88U
M$661 \$439503 \$423548 VDD VDD pfet_06v0 L=1U W=10U AS=4.4P AD=2.5P PS=20.88U
+ PD=10.5U
M$662 \$410145 \$424670 \$439503 VDD pfet_06v0 L=1U W=10U AS=2.5P AD=4.4P
+ PS=10.5U PD=20.88U
M$663 \$439881 \$423549 VDD VDD pfet_06v0 L=1U W=10U AS=4.4P AD=2.5P PS=20.88U
+ PD=10.5U
M$664 \$407608 \$424672 \$439881 VDD pfet_06v0 L=1U W=10U AS=2.5P AD=4.4P
+ PS=10.5U PD=20.88U
M$665 \$439963 \$423549 VDD VDD pfet_06v0 L=1U W=10U AS=4.4P AD=2.5P PS=20.88U
+ PD=10.5U
M$666 \$405611 \$424672 \$439963 VDD pfet_06v0 L=1U W=10U AS=2.5P AD=4.4P
+ PS=10.5U PD=20.88U
M$667 \$440052 \$423549 VDD VDD pfet_06v0 L=1U W=10U AS=4.4P AD=2.5P PS=20.88U
+ PD=10.5U
M$668 \$423549 \$424672 \$440052 VDD pfet_06v0 L=1U W=10U AS=2.5P AD=4.4P
+ PS=10.5U PD=20.88U
M$669 \$440113 \$423549 VDD VDD pfet_06v0 L=1U W=10U AS=4.4P AD=2.5P PS=20.88U
+ PD=10.5U
M$670 \$418991 \$424672 \$440113 VDD pfet_06v0 L=1U W=10U AS=2.5P AD=3.3P
+ PS=10.5U PD=10.66U
M$671 \$440143 \$424672 \$418991 VDD pfet_06v0 L=1U W=10U AS=3.3P AD=2.5P
+ PS=10.66U PD=10.5U
M$672 VDD \$423549 \$440143 VDD pfet_06v0 L=1U W=10U AS=2.5P AD=4.4P PS=10.5U
+ PD=20.88U
M$673 \$440785 \$417192 VDD VDD pfet_06v0 L=1U W=10U AS=4.4P AD=2.5P PS=20.88U
+ PD=10.5U
M$674 \$417192 \$424672 \$440785 VDD pfet_06v0 L=1U W=10U AS=2.5P AD=3.3P
+ PS=10.5U PD=10.66U
M$675 \$405613 \$405613 \$417192 VDD pfet_06v0 L=1U W=10U AS=3.3P AD=4.4P
+ PS=10.66U PD=20.88U
M$676 \$440841 \$423549 VDD VDD pfet_06v0 L=1U W=10U AS=4.4P AD=2.5P PS=20.88U
+ PD=10.5U
M$677 \$410146 \$424672 \$440841 VDD pfet_06v0 L=1U W=10U AS=2.5P AD=4.4P
+ PS=10.5U PD=20.88U
M$678 \$441223 \$423550 VDD VDD pfet_06v0 L=1U W=10U AS=4.4P AD=2.5P PS=20.88U
+ PD=10.5U
M$679 \$407609 \$424674 \$441223 VDD pfet_06v0 L=1U W=10U AS=2.5P AD=4.4P
+ PS=10.5U PD=20.88U
M$680 \$441263 \$423550 VDD VDD pfet_06v0 L=1U W=10U AS=4.4P AD=2.5P PS=20.88U
+ PD=10.5U
M$681 \$405615 \$424674 \$441263 VDD pfet_06v0 L=1U W=10U AS=2.5P AD=4.4P
+ PS=10.5U PD=20.88U
M$682 \$441365 \$423550 VDD VDD pfet_06v0 L=1U W=10U AS=4.4P AD=2.5P PS=20.88U
+ PD=10.5U
M$683 \$423550 \$424674 \$441365 VDD pfet_06v0 L=1U W=10U AS=2.5P AD=4.4P
+ PS=10.5U PD=20.88U
M$684 \$441408 \$423550 VDD VDD pfet_06v0 L=1U W=10U AS=4.4P AD=2.5P PS=20.88U
+ PD=10.5U
M$685 \$418993 \$424674 \$441408 VDD pfet_06v0 L=1U W=10U AS=2.5P AD=3.3P
+ PS=10.5U PD=10.66U
M$686 \$441435 \$424674 \$418993 VDD pfet_06v0 L=1U W=10U AS=3.3P AD=2.5P
+ PS=10.66U PD=10.5U
M$687 VDD \$423550 \$441435 VDD pfet_06v0 L=1U W=10U AS=2.5P AD=4.4P PS=10.5U
+ PD=20.88U
M$688 \$441336 \$417193 VDD VDD pfet_06v0 L=1U W=10U AS=4.4P AD=2.5P PS=20.88U
+ PD=10.5U
M$689 \$417193 \$424674 \$441336 VDD pfet_06v0 L=1U W=10U AS=2.5P AD=3.3P
+ PS=10.5U PD=10.66U
M$690 \$405617 \$405617 \$417193 VDD pfet_06v0 L=1U W=10U AS=3.3P AD=4.4P
+ PS=10.66U PD=20.88U
M$691 \$441171 \$423550 VDD VDD pfet_06v0 L=1U W=10U AS=4.4P AD=2.5P PS=20.88U
+ PD=10.5U
M$692 \$410147 \$424674 \$441171 VDD pfet_06v0 L=1U W=10U AS=2.5P AD=4.4P
+ PS=10.5U PD=20.88U
M$693 VDD VSS VDD VDD pfet_06v0 L=2U W=9.75U AS=4.29P AD=4.29P PS=20.38U
+ PD=20.38U
M$694 \$424670 \$424670 VDD VDD pfet_06v0 L=1U W=2U AS=0.88P AD=0.88P PS=4.88U
+ PD=4.88U
M$695 \$464251 \$205759 \$475861 VDD pfet_06v0 L=1U W=10U AS=4.4P AD=2.6P
+ PS=20.88U PD=10.52U
M$696 \$475861 \$205759 \$464251 VDD pfet_06v0 L=1U W=10U AS=2.6P AD=4.4P
+ PS=10.52U PD=20.88U
M$697 \$464249 \$205781 \$475861 VDD pfet_06v0 L=1U W=10U AS=4.4P AD=2.6P
+ PS=20.88U PD=10.52U
M$698 \$475861 \$205781 \$464249 VDD pfet_06v0 L=1U W=10U AS=2.6P AD=4.4P
+ PS=10.52U PD=20.88U
M$699 \$418990 \$424670 \$406856 VDD pfet_06v0 L=1U W=5U AS=2.2P AD=1.3P
+ PS=10.88U PD=5.52U
M$700 \$406856 \$424670 \$418990 VDD pfet_06v0 L=1U W=5U AS=1.3P AD=2.2P
+ PS=5.52U PD=10.88U
M$701 \$405608 \$424670 \$406855 VDD pfet_06v0 L=1U W=5U AS=2.2P AD=1.3P
+ PS=10.88U PD=5.52U
M$702 \$406855 \$424670 \$405608 VDD pfet_06v0 L=1U W=5U AS=1.3P AD=2.2P
+ PS=5.52U PD=10.88U
M$703 \$406856 \$418990 VDD VDD pfet_06v0 L=1U W=5U AS=2.2P AD=1.3P PS=10.88U
+ PD=5.52U
M$704 VDD \$418990 \$406856 VDD pfet_06v0 L=1U W=5U AS=1.3P AD=1.3P PS=5.52U
+ PD=5.52U
M$705 \$406856 \$418990 VDD VDD pfet_06v0 L=1U W=5U AS=1.3P AD=1.3P PS=5.52U
+ PD=5.52U
M$706 VDD \$418990 \$406856 VDD pfet_06v0 L=1U W=5U AS=1.3P AD=2.2P PS=5.52U
+ PD=10.88U
M$707 \$406855 \$418990 VDD VDD pfet_06v0 L=1U W=5U AS=2.2P AD=1.3P PS=10.88U
+ PD=5.52U
M$708 VDD \$418990 \$406855 VDD pfet_06v0 L=1U W=5U AS=1.3P AD=1.3P PS=5.52U
+ PD=5.52U
M$709 \$406855 \$418990 VDD VDD pfet_06v0 L=1U W=5U AS=1.3P AD=1.3P PS=5.52U
+ PD=5.52U
M$710 VDD \$418990 \$406855 VDD pfet_06v0 L=1U W=5U AS=1.3P AD=2.2P PS=5.52U
+ PD=10.88U
M$711 \$406858 \$405609 \$418990 VDD pfet_06v0 L=1U W=5U AS=2.2P AD=2.2P
+ PS=10.88U PD=10.88U
M$712 \$406860 \$405609 \$405608 VDD pfet_06v0 L=1U W=5U AS=2.2P AD=2.2P
+ PS=10.88U PD=10.88U
M$713 \$464253 \$464234 VDD VDD pfet_06v0 L=1U W=10U AS=4.4P AD=2.6P PS=20.88U
+ PD=10.52U
M$714 VDD \$464234 \$464253 VDD pfet_06v0 L=1U W=10U AS=2.6P AD=2.6P PS=10.52U
+ PD=10.52U
M$715 \$464253 \$464234 VDD VDD pfet_06v0 L=1U W=10U AS=2.6P AD=4.4P PS=10.52U
+ PD=20.88U
M$716 VDD VSS VDD VDD pfet_06v0 L=2U W=9.75U AS=4.29P AD=4.29P PS=20.38U
+ PD=20.38U
M$717 VDD VSS VDD VDD pfet_06v0 L=2U W=9.75U AS=4.29P AD=4.29P PS=20.38U
+ PD=20.38U
M$718 \$424672 \$424672 VDD VDD pfet_06v0 L=1U W=2U AS=0.88P AD=0.88P PS=4.88U
+ PD=4.88U
M$719 \$464260 \$205770 \$475863 VDD pfet_06v0 L=1U W=10U AS=4.4P AD=2.6P
+ PS=20.88U PD=10.52U
M$720 \$475863 \$205770 \$464260 VDD pfet_06v0 L=1U W=10U AS=2.6P AD=4.4P
+ PS=10.52U PD=20.88U
M$721 \$464258 \$205781 \$475863 VDD pfet_06v0 L=1U W=10U AS=4.4P AD=2.6P
+ PS=20.88U PD=10.52U
M$722 \$475863 \$205781 \$464258 VDD pfet_06v0 L=1U W=10U AS=2.6P AD=4.4P
+ PS=10.52U PD=20.88U
M$723 \$418992 \$424672 \$406864 VDD pfet_06v0 L=1U W=5U AS=2.2P AD=1.3P
+ PS=10.88U PD=5.52U
M$724 \$406864 \$424672 \$418992 VDD pfet_06v0 L=1U W=5U AS=1.3P AD=2.2P
+ PS=5.52U PD=10.88U
M$725 \$405612 \$424672 \$406863 VDD pfet_06v0 L=1U W=5U AS=2.2P AD=1.3P
+ PS=10.88U PD=5.52U
M$726 \$406863 \$424672 \$405612 VDD pfet_06v0 L=1U W=5U AS=1.3P AD=2.2P
+ PS=5.52U PD=10.88U
M$727 \$406864 \$418992 VDD VDD pfet_06v0 L=1U W=5U AS=2.2P AD=1.3P PS=10.88U
+ PD=5.52U
M$728 VDD \$418992 \$406864 VDD pfet_06v0 L=1U W=5U AS=1.3P AD=1.3P PS=5.52U
+ PD=5.52U
M$729 \$406864 \$418992 VDD VDD pfet_06v0 L=1U W=5U AS=1.3P AD=1.3P PS=5.52U
+ PD=5.52U
M$730 VDD \$418992 \$406864 VDD pfet_06v0 L=1U W=5U AS=1.3P AD=2.2P PS=5.52U
+ PD=10.88U
M$731 \$406863 \$418992 VDD VDD pfet_06v0 L=1U W=5U AS=2.2P AD=1.3P PS=10.88U
+ PD=5.52U
M$732 VDD \$418992 \$406863 VDD pfet_06v0 L=1U W=5U AS=1.3P AD=1.3P PS=5.52U
+ PD=5.52U
M$733 \$406863 \$418992 VDD VDD pfet_06v0 L=1U W=5U AS=1.3P AD=1.3P PS=5.52U
+ PD=5.52U
M$734 VDD \$418992 \$406863 VDD pfet_06v0 L=1U W=5U AS=1.3P AD=2.2P PS=5.52U
+ PD=10.88U
M$735 \$406866 \$405613 \$418992 VDD pfet_06v0 L=1U W=5U AS=2.2P AD=2.2P
+ PS=10.88U PD=10.88U
M$736 \$406868 \$405613 \$405612 VDD pfet_06v0 L=1U W=5U AS=2.2P AD=2.2P
+ PS=10.88U PD=10.88U
M$737 \$464262 \$464238 VDD VDD pfet_06v0 L=1U W=10U AS=4.4P AD=2.6P PS=20.88U
+ PD=10.52U
M$738 VDD \$464238 \$464262 VDD pfet_06v0 L=1U W=10U AS=2.6P AD=2.6P PS=10.52U
+ PD=10.52U
M$739 \$464262 \$464238 VDD VDD pfet_06v0 L=1U W=10U AS=2.6P AD=4.4P PS=10.52U
+ PD=20.88U
M$740 VDD VSS VDD VDD pfet_06v0 L=2U W=9.75U AS=4.29P AD=4.29P PS=20.38U
+ PD=20.38U
M$741 VDD VSS VDD VDD pfet_06v0 L=2U W=9.75U AS=4.29P AD=4.29P PS=20.38U
+ PD=20.38U
M$742 \$424674 \$424674 VDD VDD pfet_06v0 L=1U W=2U AS=0.88P AD=0.88P PS=4.88U
+ PD=4.88U
M$743 \$464269 \$205770 \$475865 VDD pfet_06v0 L=1U W=10U AS=4.4P AD=2.6P
+ PS=20.88U PD=10.52U
M$744 \$475865 \$205770 \$464269 VDD pfet_06v0 L=1U W=10U AS=2.6P AD=4.4P
+ PS=10.52U PD=20.88U
M$745 \$464267 \$205759 \$475865 VDD pfet_06v0 L=1U W=10U AS=4.4P AD=2.6P
+ PS=20.88U PD=10.52U
M$746 \$475865 \$205759 \$464267 VDD pfet_06v0 L=1U W=10U AS=2.6P AD=4.4P
+ PS=10.52U PD=20.88U
M$747 \$418994 \$424674 \$406872 VDD pfet_06v0 L=1U W=5U AS=2.2P AD=1.3P
+ PS=10.88U PD=5.52U
M$748 \$406872 \$424674 \$418994 VDD pfet_06v0 L=1U W=5U AS=1.3P AD=2.2P
+ PS=5.52U PD=10.88U
M$749 \$405616 \$424674 \$406871 VDD pfet_06v0 L=1U W=5U AS=2.2P AD=1.3P
+ PS=10.88U PD=5.52U
M$750 \$406871 \$424674 \$405616 VDD pfet_06v0 L=1U W=5U AS=1.3P AD=2.2P
+ PS=5.52U PD=10.88U
M$751 \$406872 \$418994 VDD VDD pfet_06v0 L=1U W=5U AS=2.2P AD=1.3P PS=10.88U
+ PD=5.52U
M$752 VDD \$418994 \$406872 VDD pfet_06v0 L=1U W=5U AS=1.3P AD=1.3P PS=5.52U
+ PD=5.52U
M$753 \$406872 \$418994 VDD VDD pfet_06v0 L=1U W=5U AS=1.3P AD=1.3P PS=5.52U
+ PD=5.52U
M$754 VDD \$418994 \$406872 VDD pfet_06v0 L=1U W=5U AS=1.3P AD=2.2P PS=5.52U
+ PD=10.88U
M$755 \$406871 \$418994 VDD VDD pfet_06v0 L=1U W=5U AS=2.2P AD=1.3P PS=10.88U
+ PD=5.52U
M$756 VDD \$418994 \$406871 VDD pfet_06v0 L=1U W=5U AS=1.3P AD=1.3P PS=5.52U
+ PD=5.52U
M$757 \$406871 \$418994 VDD VDD pfet_06v0 L=1U W=5U AS=1.3P AD=1.3P PS=5.52U
+ PD=5.52U
M$758 VDD \$418994 \$406871 VDD pfet_06v0 L=1U W=5U AS=1.3P AD=2.2P PS=5.52U
+ PD=10.88U
M$759 \$406874 \$405617 \$418994 VDD pfet_06v0 L=1U W=5U AS=2.2P AD=2.2P
+ PS=10.88U PD=10.88U
M$760 \$406876 \$405617 \$405616 VDD pfet_06v0 L=1U W=5U AS=2.2P AD=2.2P
+ PS=10.88U PD=10.88U
M$761 \$464271 \$464242 VDD VDD pfet_06v0 L=1U W=10U AS=4.4P AD=2.6P PS=20.88U
+ PD=10.52U
M$762 VDD \$464242 \$464271 VDD pfet_06v0 L=1U W=10U AS=2.6P AD=2.6P PS=10.52U
+ PD=10.52U
M$763 \$464271 \$464242 VDD VDD pfet_06v0 L=1U W=10U AS=2.6P AD=4.4P PS=10.52U
+ PD=20.88U
M$764 VDD VSS VDD VDD pfet_06v0 L=2U W=9.75U AS=4.29P AD=4.29P PS=20.38U
+ PD=20.38U
M$765 VDD VSS VDD VDD pfet_06v0 L=2U W=9.75U AS=4.29P AD=4.29P PS=20.38U
+ PD=20.38U
M$766 \$417194 \$417194 VDD VDD pfet_06v0 L=1U W=2U AS=0.88P AD=0.52P PS=4.88U
+ PD=2.52U
M$767 VDD \$417194 \$417194 VDD pfet_06v0 L=1U W=2U AS=0.52P AD=0.52P PS=2.52U
+ PD=2.52U
M$768 \$417194 \$417194 VDD VDD pfet_06v0 L=1U W=2U AS=0.52P AD=0.52P PS=2.52U
+ PD=2.52U
M$769 VDD \$417194 \$417194 VDD pfet_06v0 L=1U W=2U AS=0.52P AD=0.52P PS=2.52U
+ PD=2.52U
M$770 \$417194 \$417194 VDD VDD pfet_06v0 L=1U W=2U AS=0.52P AD=0.52P PS=2.52U
+ PD=2.52U
M$771 VDD \$417194 \$417194 VDD pfet_06v0 L=1U W=2U AS=0.52P AD=0.88P PS=2.52U
+ PD=4.88U
M$772 \$405619 \$405619 VDD VDD pfet_06v0 L=1U W=2U AS=0.88P AD=0.88P PS=4.88U
+ PD=4.88U
M$773 VDD VSS VDD VDD pfet_06v0 L=2U W=2U AS=0.88P AD=0.88P PS=4.88U PD=4.88U
M$774 VDD VSS VDD VDD pfet_06v0 L=2U W=2U AS=0.88P AD=0.88P PS=4.88U PD=4.88U
M$775 VDD VSS VDD VDD pfet_06v0 L=2U W=2U AS=0.88P AD=0.88P PS=4.88U PD=4.88U
M$776 VDD VSS VDD VDD pfet_06v0 L=2U W=2U AS=0.88P AD=0.88P PS=4.88U PD=4.88U
M$777 \$496998 \$480564 VDD VDD pfet_06v0 L=1U W=10U AS=4.4P AD=2.5P PS=20.88U
+ PD=10.5U
M$778 \$464245 \$482221 \$496998 VDD pfet_06v0 L=1U W=10U AS=2.5P AD=4.4P
+ PS=10.5U PD=20.88U
M$779 \$497104 \$480564 VDD VDD pfet_06v0 L=1U W=10U AS=4.4P AD=2.5P PS=20.88U
+ PD=10.5U
M$780 \$464233 \$482221 \$497104 VDD pfet_06v0 L=1U W=10U AS=2.5P AD=4.4P
+ PS=10.5U PD=20.88U
M$781 \$497174 \$480564 VDD VDD pfet_06v0 L=1U W=10U AS=4.4P AD=2.5P PS=20.88U
+ PD=10.5U
M$782 \$480564 \$482221 \$497174 VDD pfet_06v0 L=1U W=10U AS=2.5P AD=4.4P
+ PS=10.5U PD=20.88U
M$783 \$497206 \$480564 VDD VDD pfet_06v0 L=1U W=10U AS=4.4P AD=2.5P PS=20.88U
+ PD=10.5U
M$784 \$475861 \$482221 \$497206 VDD pfet_06v0 L=1U W=10U AS=2.5P AD=3.3P
+ PS=10.5U PD=10.66U
M$785 \$497213 \$482221 \$475861 VDD pfet_06v0 L=1U W=10U AS=3.3P AD=2.5P
+ PS=10.66U PD=10.5U
M$786 VDD \$480564 \$497213 VDD pfet_06v0 L=1U W=10U AS=2.5P AD=4.4P PS=10.5U
+ PD=20.88U
M$787 \$497816 \$474639 VDD VDD pfet_06v0 L=1U W=10U AS=4.4P AD=2.5P PS=20.88U
+ PD=10.5U
M$788 \$474639 \$482221 \$497816 VDD pfet_06v0 L=1U W=10U AS=2.5P AD=3.3P
+ PS=10.5U PD=10.66U
M$789 \$464235 \$464235 \$474639 VDD pfet_06v0 L=1U W=10U AS=3.3P AD=4.4P
+ PS=10.66U PD=20.88U
M$790 \$497879 \$480564 VDD VDD pfet_06v0 L=1U W=10U AS=4.4P AD=2.5P PS=20.88U
+ PD=10.5U
M$791 \$468243 \$482221 \$497879 VDD pfet_06v0 L=1U W=10U AS=2.5P AD=4.4P
+ PS=10.5U PD=20.88U
M$792 \$498255 \$480565 VDD VDD pfet_06v0 L=1U W=10U AS=4.4P AD=2.5P PS=20.88U
+ PD=10.5U
M$793 \$464254 \$482223 \$498255 VDD pfet_06v0 L=1U W=10U AS=2.5P AD=4.4P
+ PS=10.5U PD=20.88U
M$794 \$498337 \$480565 VDD VDD pfet_06v0 L=1U W=10U AS=4.4P AD=2.5P PS=20.88U
+ PD=10.5U
M$795 \$464237 \$482223 \$498337 VDD pfet_06v0 L=1U W=10U AS=2.5P AD=4.4P
+ PS=10.5U PD=20.88U
M$796 \$498430 \$480565 VDD VDD pfet_06v0 L=1U W=10U AS=4.4P AD=2.5P PS=20.88U
+ PD=10.5U
M$797 \$480565 \$482223 \$498430 VDD pfet_06v0 L=1U W=10U AS=2.5P AD=4.4P
+ PS=10.5U PD=20.88U
M$798 \$498463 \$480565 VDD VDD pfet_06v0 L=1U W=10U AS=4.4P AD=2.5P PS=20.88U
+ PD=10.5U
M$799 \$475863 \$482223 \$498463 VDD pfet_06v0 L=1U W=10U AS=2.5P AD=3.3P
+ PS=10.5U PD=10.66U
M$800 \$498475 \$482223 \$475863 VDD pfet_06v0 L=1U W=10U AS=3.3P AD=2.5P
+ PS=10.66U PD=10.5U
M$801 VDD \$480565 \$498475 VDD pfet_06v0 L=1U W=10U AS=2.5P AD=4.4P PS=10.5U
+ PD=20.88U
M$802 \$499092 \$474642 VDD VDD pfet_06v0 L=1U W=10U AS=4.4P AD=2.5P PS=20.88U
+ PD=10.5U
M$803 \$474642 \$482223 \$499092 VDD pfet_06v0 L=1U W=10U AS=2.5P AD=3.3P
+ PS=10.5U PD=10.66U
M$804 \$464239 \$464239 \$474642 VDD pfet_06v0 L=1U W=10U AS=3.3P AD=4.4P
+ PS=10.66U PD=20.88U
M$805 \$499168 \$480565 VDD VDD pfet_06v0 L=1U W=10U AS=4.4P AD=2.5P PS=20.88U
+ PD=10.5U
M$806 \$468244 \$482223 \$499168 VDD pfet_06v0 L=1U W=10U AS=2.5P AD=4.4P
+ PS=10.5U PD=20.88U
M$807 \$499514 \$480566 VDD VDD pfet_06v0 L=1U W=10U AS=4.4P AD=2.5P PS=20.88U
+ PD=10.5U
M$808 \$464263 \$482225 \$499514 VDD pfet_06v0 L=1U W=10U AS=2.5P AD=4.4P
+ PS=10.5U PD=20.88U
M$809 \$499579 \$480566 VDD VDD pfet_06v0 L=1U W=10U AS=4.4P AD=2.5P PS=20.88U
+ PD=10.5U
M$810 \$464241 \$482225 \$499579 VDD pfet_06v0 L=1U W=10U AS=2.5P AD=4.4P
+ PS=10.5U PD=20.88U
M$811 \$499659 \$480566 VDD VDD pfet_06v0 L=1U W=10U AS=4.4P AD=2.5P PS=20.88U
+ PD=10.5U
M$812 \$480566 \$482225 \$499659 VDD pfet_06v0 L=1U W=10U AS=2.5P AD=4.4P
+ PS=10.5U PD=20.88U
M$813 \$499690 \$480566 VDD VDD pfet_06v0 L=1U W=10U AS=4.4P AD=2.5P PS=20.88U
+ PD=10.5U
M$814 \$475865 \$482225 \$499690 VDD pfet_06v0 L=1U W=10U AS=2.5P AD=3.3P
+ PS=10.5U PD=10.66U
M$815 \$499701 \$482225 \$475865 VDD pfet_06v0 L=1U W=10U AS=3.3P AD=2.5P
+ PS=10.66U PD=10.5U
M$816 VDD \$480566 \$499701 VDD pfet_06v0 L=1U W=10U AS=2.5P AD=4.4P PS=10.5U
+ PD=20.88U
M$817 \$499692 \$474645 VDD VDD pfet_06v0 L=1U W=10U AS=4.4P AD=2.5P PS=20.88U
+ PD=10.5U
M$818 \$474645 \$482225 \$499692 VDD pfet_06v0 L=1U W=10U AS=2.5P AD=3.3P
+ PS=10.5U PD=10.66U
M$819 \$464243 \$464243 \$474645 VDD pfet_06v0 L=1U W=10U AS=3.3P AD=4.4P
+ PS=10.66U PD=20.88U
M$820 \$499541 \$480566 VDD VDD pfet_06v0 L=1U W=10U AS=4.4P AD=2.5P PS=20.88U
+ PD=10.5U
M$821 \$468245 \$482225 \$499541 VDD pfet_06v0 L=1U W=10U AS=2.5P AD=4.4P
+ PS=10.5U PD=20.88U
M$822 VDD VSS VDD VDD pfet_06v0 L=2U W=2U AS=0.88P AD=0.88P PS=4.88U PD=4.88U
M$823 \$482221 \$482221 VDD VDD pfet_06v0 L=1U W=2U AS=0.88P AD=0.88P PS=4.88U
+ PD=4.88U
M$824 VDD VSS VDD VDD pfet_06v0 L=2U W=2U AS=0.88P AD=0.88P PS=4.88U PD=4.88U
M$825 VDD VSS VDD VDD pfet_06v0 L=2U W=2U AS=0.88P AD=0.88P PS=4.88U PD=4.88U
M$826 \$475862 \$482221 \$464248 VDD pfet_06v0 L=1U W=5U AS=2.2P AD=1.3P
+ PS=10.88U PD=5.52U
M$827 \$464248 \$482221 \$475862 VDD pfet_06v0 L=1U W=5U AS=1.3P AD=2.2P
+ PS=5.52U PD=10.88U
M$828 \$464234 \$482221 \$464247 VDD pfet_06v0 L=1U W=5U AS=2.2P AD=1.3P
+ PS=10.88U PD=5.52U
M$829 \$464247 \$482221 \$464234 VDD pfet_06v0 L=1U W=5U AS=1.3P AD=2.2P
+ PS=5.52U PD=10.88U
M$830 \$464248 \$475862 VDD VDD pfet_06v0 L=1U W=5U AS=2.2P AD=1.3P PS=10.88U
+ PD=5.52U
M$831 VDD \$475862 \$464248 VDD pfet_06v0 L=1U W=5U AS=1.3P AD=1.3P PS=5.52U
+ PD=5.52U
M$832 \$464248 \$475862 VDD VDD pfet_06v0 L=1U W=5U AS=1.3P AD=1.3P PS=5.52U
+ PD=5.52U
M$833 VDD \$475862 \$464248 VDD pfet_06v0 L=1U W=5U AS=1.3P AD=2.2P PS=5.52U
+ PD=10.88U
M$834 \$464247 \$475862 VDD VDD pfet_06v0 L=1U W=5U AS=2.2P AD=1.3P PS=10.88U
+ PD=5.52U
M$835 VDD \$475862 \$464247 VDD pfet_06v0 L=1U W=5U AS=1.3P AD=1.3P PS=5.52U
+ PD=5.52U
M$836 \$464247 \$475862 VDD VDD pfet_06v0 L=1U W=5U AS=1.3P AD=1.3P PS=5.52U
+ PD=5.52U
M$837 VDD \$475862 \$464247 VDD pfet_06v0 L=1U W=5U AS=1.3P AD=2.2P PS=5.52U
+ PD=10.88U
M$838 \$464250 \$464235 \$475862 VDD pfet_06v0 L=1U W=5U AS=2.2P AD=2.2P
+ PS=10.88U PD=10.88U
M$839 \$464252 \$464235 \$464234 VDD pfet_06v0 L=1U W=5U AS=2.2P AD=2.2P
+ PS=10.88U PD=10.88U
M$840 VDD VSS VDD VDD pfet_06v0 L=2U W=2U AS=0.88P AD=0.88P PS=4.88U PD=4.88U
M$841 VDD VSS VDD VDD pfet_06v0 L=2U W=2U AS=0.88P AD=0.88P PS=4.88U PD=4.88U
M$842 \$482223 \$482223 VDD VDD pfet_06v0 L=1U W=2U AS=0.88P AD=0.88P PS=4.88U
+ PD=4.88U
M$843 VDD VSS VDD VDD pfet_06v0 L=2U W=2U AS=0.88P AD=0.88P PS=4.88U PD=4.88U
M$844 VDD VSS VDD VDD pfet_06v0 L=2U W=1.5U AS=0.66P AD=0.66P PS=3.88U PD=3.88U
M$845 VDD VSS VDD VDD pfet_06v0 L=2U W=2U AS=0.88P AD=0.88P PS=4.88U PD=4.88U
M$846 VDD VSS VDD VDD pfet_06v0 L=2U W=1.5U AS=0.66P AD=0.66P PS=3.88U PD=3.88U
M$847 \$475864 \$482223 \$464257 VDD pfet_06v0 L=1U W=5U AS=2.2P AD=1.3P
+ PS=10.88U PD=5.52U
M$848 \$464257 \$482223 \$475864 VDD pfet_06v0 L=1U W=5U AS=1.3P AD=2.2P
+ PS=5.52U PD=10.88U
M$849 \$464238 \$482223 \$464256 VDD pfet_06v0 L=1U W=5U AS=2.2P AD=1.3P
+ PS=10.88U PD=5.52U
M$850 \$464256 \$482223 \$464238 VDD pfet_06v0 L=1U W=5U AS=1.3P AD=2.2P
+ PS=5.52U PD=10.88U
M$851 \$464257 \$475864 VDD VDD pfet_06v0 L=1U W=5U AS=2.2P AD=1.3P PS=10.88U
+ PD=5.52U
M$852 VDD \$475864 \$464257 VDD pfet_06v0 L=1U W=5U AS=1.3P AD=1.3P PS=5.52U
+ PD=5.52U
M$853 \$464257 \$475864 VDD VDD pfet_06v0 L=1U W=5U AS=1.3P AD=1.3P PS=5.52U
+ PD=5.52U
M$854 VDD \$475864 \$464257 VDD pfet_06v0 L=1U W=5U AS=1.3P AD=2.2P PS=5.52U
+ PD=10.88U
M$855 VDD VSS VDD VDD pfet_06v0 L=2U W=2U AS=0.88P AD=0.88P PS=4.88U PD=4.88U
M$856 \$464256 \$475864 VDD VDD pfet_06v0 L=1U W=5U AS=2.2P AD=1.3P PS=10.88U
+ PD=5.52U
M$857 VDD \$475864 \$464256 VDD pfet_06v0 L=1U W=5U AS=1.3P AD=1.3P PS=5.52U
+ PD=5.52U
M$858 \$464256 \$475864 VDD VDD pfet_06v0 L=1U W=5U AS=1.3P AD=1.3P PS=5.52U
+ PD=5.52U
M$859 VDD \$475864 \$464256 VDD pfet_06v0 L=1U W=5U AS=1.3P AD=2.2P PS=5.52U
+ PD=10.88U
M$860 VDD VSS VDD VDD pfet_06v0 L=2U W=1.5U AS=0.66P AD=0.66P PS=3.88U PD=3.88U
M$861 VDD VSS VDD VDD pfet_06v0 L=2U W=2U AS=0.88P AD=0.88P PS=4.88U PD=4.88U
M$862 VDD VSS VDD VDD pfet_06v0 L=2U W=1.5U AS=0.66P AD=0.66P PS=3.88U PD=3.88U
M$863 \$464259 \$464239 \$475864 VDD pfet_06v0 L=1U W=5U AS=2.2P AD=2.2P
+ PS=10.88U PD=10.88U
M$864 \$464261 \$464239 \$464238 VDD pfet_06v0 L=1U W=5U AS=2.2P AD=2.2P
+ PS=10.88U PD=10.88U
M$865 VDD VSS VDD VDD pfet_06v0 L=2U W=2U AS=0.88P AD=0.88P PS=4.88U PD=4.88U
M$866 VDD VSS VDD VDD pfet_06v0 L=2U W=1.5U AS=0.66P AD=0.66P PS=3.88U PD=3.88U
M$867 VDD VSS VDD VDD pfet_06v0 L=2U W=2U AS=0.88P AD=0.88P PS=4.88U PD=4.88U
M$868 VDD VSS VDD VDD pfet_06v0 L=2U W=1.5U AS=0.66P AD=0.66P PS=3.88U PD=3.88U
M$869 \$482225 \$482225 VDD VDD pfet_06v0 L=1U W=2U AS=0.88P AD=0.88P PS=4.88U
+ PD=4.88U
M$870 VDD VSS VDD VDD pfet_06v0 L=2U W=2U AS=0.88P AD=0.88P PS=4.88U PD=4.88U
M$871 \$475866 \$482225 \$464266 VDD pfet_06v0 L=1U W=5U AS=2.2P AD=1.3P
+ PS=10.88U PD=5.52U
M$872 \$464266 \$482225 \$475866 VDD pfet_06v0 L=1U W=5U AS=1.3P AD=2.2P
+ PS=5.52U PD=10.88U
M$873 VDD VSS VDD VDD pfet_06v0 L=2U W=2U AS=0.88P AD=0.88P PS=4.88U PD=4.88U
M$874 VDD VSS VDD VDD pfet_06v0 L=2U W=1.5U AS=0.66P AD=0.66P PS=3.88U PD=3.88U
M$875 \$464242 \$482225 \$464265 VDD pfet_06v0 L=1U W=5U AS=2.2P AD=1.3P
+ PS=10.88U PD=5.52U
M$876 \$464265 \$482225 \$464242 VDD pfet_06v0 L=1U W=5U AS=1.3P AD=2.2P
+ PS=5.52U PD=10.88U
M$877 VDD VSS VDD VDD pfet_06v0 L=2U W=1.5U AS=0.66P AD=0.66P PS=3.88U PD=3.88U
M$878 \$464266 \$475866 VDD VDD pfet_06v0 L=1U W=5U AS=2.2P AD=1.3P PS=10.88U
+ PD=5.52U
M$879 VDD \$475866 \$464266 VDD pfet_06v0 L=1U W=5U AS=1.3P AD=1.3P PS=5.52U
+ PD=5.52U
M$880 \$464266 \$475866 VDD VDD pfet_06v0 L=1U W=5U AS=1.3P AD=1.3P PS=5.52U
+ PD=5.52U
M$881 VDD \$475866 \$464266 VDD pfet_06v0 L=1U W=5U AS=1.3P AD=2.2P PS=5.52U
+ PD=10.88U
M$882 VDD VSS VDD VDD pfet_06v0 L=2U W=1.5U AS=0.66P AD=0.66P PS=3.88U PD=3.88U
M$883 \$464265 \$475866 VDD VDD pfet_06v0 L=1U W=5U AS=2.2P AD=1.3P PS=10.88U
+ PD=5.52U
M$884 VDD \$475866 \$464265 VDD pfet_06v0 L=1U W=5U AS=1.3P AD=1.3P PS=5.52U
+ PD=5.52U
M$885 \$464265 \$475866 VDD VDD pfet_06v0 L=1U W=5U AS=1.3P AD=1.3P PS=5.52U
+ PD=5.52U
M$886 VDD \$475866 \$464265 VDD pfet_06v0 L=1U W=5U AS=1.3P AD=2.2P PS=5.52U
+ PD=10.88U
M$887 VDD VSS VDD VDD pfet_06v0 L=2U W=1.5U AS=0.66P AD=0.66P PS=3.88U PD=3.88U
M$888 VDD VSS VDD VDD pfet_06v0 L=2U W=1.5U AS=0.66P AD=0.66P PS=3.88U PD=3.88U
M$889 \$464268 \$464243 \$475866 VDD pfet_06v0 L=1U W=5U AS=2.2P AD=2.2P
+ PS=10.88U PD=10.88U
M$890 VDD VSS VDD VDD pfet_06v0 L=2U W=1.5U AS=0.66P AD=0.66P PS=3.88U PD=3.88U
M$891 \$464270 \$464243 \$464242 VDD pfet_06v0 L=1U W=5U AS=2.2P AD=2.2P
+ PS=10.88U PD=10.88U
M$892 VDD VSS VDD VDD pfet_06v0 L=2U W=1.5U AS=0.66P AD=0.66P PS=3.88U PD=3.88U
M$893 VDD VSS VDD VDD pfet_06v0 L=2U W=1.5U AS=0.66P AD=0.66P PS=3.88U PD=3.88U
M$894 VDD VSS VDD VDD pfet_06v0 L=2U W=2U AS=0.88P AD=0.88P PS=4.88U PD=4.88U
M$895 VDD VSS VDD VDD pfet_06v0 L=2U W=1.5U AS=0.66P AD=0.66P PS=3.88U PD=3.88U
M$896 VDD VSS VDD VDD pfet_06v0 L=2U W=2U AS=0.88P AD=0.88P PS=4.88U PD=4.88U
M$897 VDD VSS VDD VDD pfet_06v0 L=2U W=1.5U AS=0.66P AD=0.66P PS=3.88U PD=3.88U
M$898 VDD VSS VDD VDD pfet_06v0 L=2U W=1.5U AS=0.66P AD=0.66P PS=3.88U PD=3.88U
M$899 VDD VSS VDD VDD pfet_06v0 L=2U W=1.5U AS=0.66P AD=0.66P PS=3.88U PD=3.88U
M$900 VDD VSS VDD VDD pfet_06v0 L=2U W=1.5U AS=0.66P AD=0.66P PS=3.88U PD=3.88U
M$901 VDD VSS VDD VDD pfet_06v0 L=2U W=1.5U AS=0.66P AD=0.66P PS=3.88U PD=3.88U
M$902 VDD VSS VDD VDD pfet_06v0 L=2U W=1.5U AS=0.66P AD=0.66P PS=3.88U PD=3.88U
M$903 VDD VSS VDD VDD pfet_06v0 L=2U W=1.5U AS=0.66P AD=0.66P PS=3.88U PD=3.88U
M$904 VDD VSS VDD VDD pfet_06v0 L=2U W=1.5U AS=0.66P AD=0.66P PS=3.88U PD=3.88U
M$905 VDD VSS VDD VDD pfet_06v0 L=2U W=2U AS=0.88P AD=0.88P PS=4.88U PD=4.88U
M$906 VDD VSS VDD VDD pfet_06v0 L=2U W=1.5U AS=0.66P AD=0.66P PS=3.88U PD=3.88U
M$907 VDD VSS VDD VDD pfet_06v0 L=2U W=2U AS=0.88P AD=0.88P PS=4.88U PD=4.88U
M$908 VDD VSS VDD VDD pfet_06v0 L=2U W=1.5U AS=0.66P AD=0.66P PS=3.88U PD=3.88U
M$909 VDD VSS VDD VDD pfet_06v0 L=2U W=2U AS=0.88P AD=0.88P PS=4.88U PD=4.88U
M$910 VDD VSS VDD VDD pfet_06v0 L=2U W=1.5U AS=0.66P AD=0.66P PS=3.88U PD=3.88U
M$911 VDD VSS VDD VDD pfet_06v0 L=2U W=2U AS=0.88P AD=0.88P PS=4.88U PD=4.88U
M$912 VDD VSS VDD VDD pfet_06v0 L=2U W=1.5U AS=0.66P AD=0.66P PS=3.88U PD=3.88U
M$913 VDD VSS VDD VDD pfet_06v0 L=2U W=2U AS=0.88P AD=0.88P PS=4.88U PD=4.88U
M$914 VDD VSS VDD VDD pfet_06v0 L=2U W=1.5U AS=0.66P AD=0.66P PS=3.88U PD=3.88U
M$915 VDD VSS VDD VDD pfet_06v0 L=2U W=2U AS=0.88P AD=0.88P PS=4.88U PD=4.88U
M$916 VDD VSS VDD VDD pfet_06v0 L=2U W=1.5U AS=0.66P AD=0.66P PS=3.88U PD=3.88U
M$917 VDD VSS VDD VDD pfet_06v0 L=2U W=2U AS=0.88P AD=0.88P PS=4.88U PD=4.88U
M$918 VDD VSS VDD VDD pfet_06v0 L=2U W=2U AS=0.88P AD=0.88P PS=4.88U PD=4.88U
M$919 VDD VSS VDD VDD pfet_06v0 L=2U W=2U AS=0.88P AD=0.88P PS=4.88U PD=4.88U
M$920 VDD VSS VDD VDD pfet_06v0 L=2U W=2U AS=0.88P AD=0.88P PS=4.88U PD=4.88U
M$921 VDD VSS VDD VDD pfet_06v0 L=2U W=2U AS=0.88P AD=0.88P PS=4.88U PD=4.88U
M$922 VDD VSS VDD VDD pfet_06v0 L=2U W=2U AS=0.88P AD=0.88P PS=4.88U PD=4.88U
M$923 \$579615 \$288720 \$416195 VDD pfet_06v0 L=1U W=3U AS=1.32P AD=0.75P
+ PS=6.88U PD=3.5U
M$924 VDD \$288708 \$579615 VDD pfet_06v0 L=1U W=3U AS=0.75P AD=1.32P PS=3.5U
+ PD=6.88U
M$925 \$562732 \$288696 VDD VDD pfet_06v0 L=1U W=3U AS=1.32P AD=1.32P PS=6.88U
+ PD=6.88U
M$926 \$357645 \$565111 VDD VDD pfet_06v0 L=1U W=3U AS=1.32P AD=1.32P PS=6.88U
+ PD=6.88U
M$927 \$565111 \$288720 VDD VDD pfet_06v0 L=1U W=3U AS=1.32P AD=0.99P PS=6.88U
+ PD=3.66U
M$928 VDD \$562732 \$565111 VDD pfet_06v0 L=1U W=3U AS=0.99P AD=1.32P PS=3.66U
+ PD=6.88U
M$929 \$299174 \$565112 VDD VDD pfet_06v0 L=1U W=3U AS=1.32P AD=1.32P PS=6.88U
+ PD=6.88U
M$930 \$565112 \$288696 VDD VDD pfet_06v0 L=1U W=3U AS=1.32P AD=0.99P PS=6.88U
+ PD=3.66U
M$931 VDD \$288708 \$565112 VDD pfet_06v0 L=1U W=3U AS=0.99P AD=1.32P PS=3.66U
+ PD=6.88U
M$932 \$580135 \$347631 \$416192 VDD pfet_06v0 L=1U W=3U AS=1.32P AD=0.75P
+ PS=6.88U PD=3.5U
M$933 VDD \$347619 \$580135 VDD pfet_06v0 L=1U W=3U AS=0.75P AD=1.32P PS=3.5U
+ PD=6.88U
M$934 \$562733 \$347607 VDD VDD pfet_06v0 L=1U W=3U AS=1.32P AD=1.32P PS=6.88U
+ PD=6.88U
M$935 \$357644 \$565113 VDD VDD pfet_06v0 L=1U W=3U AS=1.32P AD=1.32P PS=6.88U
+ PD=6.88U
M$936 \$565113 \$347631 VDD VDD pfet_06v0 L=1U W=3U AS=1.32P AD=0.99P PS=6.88U
+ PD=3.66U
M$937 VDD \$562733 \$565113 VDD pfet_06v0 L=1U W=3U AS=0.99P AD=1.32P PS=3.66U
+ PD=6.88U
M$938 \$299173 \$565114 VDD VDD pfet_06v0 L=1U W=3U AS=1.32P AD=1.32P PS=6.88U
+ PD=6.88U
M$939 \$565114 \$347607 VDD VDD pfet_06v0 L=1U W=3U AS=1.32P AD=0.99P PS=6.88U
+ PD=3.66U
M$940 VDD \$347619 \$565114 VDD pfet_06v0 L=1U W=3U AS=0.99P AD=1.32P PS=3.66U
+ PD=6.88U
M$941 \$580644 \$406877 \$404362 VDD pfet_06v0 L=1U W=3U AS=1.32P AD=0.75P
+ PS=6.88U PD=3.5U
M$942 VDD \$406869 \$580644 VDD pfet_06v0 L=1U W=3U AS=0.75P AD=1.32P PS=3.5U
+ PD=6.88U
M$943 \$562734 \$406861 VDD VDD pfet_06v0 L=1U W=3U AS=1.32P AD=1.32P PS=6.88U
+ PD=6.88U
M$944 \$344509 \$565115 VDD VDD pfet_06v0 L=1U W=3U AS=1.32P AD=1.32P PS=6.88U
+ PD=6.88U
M$945 \$565115 \$406877 VDD VDD pfet_06v0 L=1U W=3U AS=1.32P AD=0.99P PS=6.88U
+ PD=3.66U
M$946 VDD \$562734 \$565115 VDD pfet_06v0 L=1U W=3U AS=0.99P AD=1.32P PS=3.66U
+ PD=6.88U
M$947 \$287456 \$565116 VDD VDD pfet_06v0 L=1U W=3U AS=1.32P AD=1.32P PS=6.88U
+ PD=6.88U
M$948 \$565116 \$406861 VDD VDD pfet_06v0 L=1U W=3U AS=1.32P AD=0.99P PS=6.88U
+ PD=3.66U
M$949 VDD \$406869 \$565116 VDD pfet_06v0 L=1U W=3U AS=0.99P AD=1.32P PS=3.66U
+ PD=6.88U
M$950 \$581164 \$464271 \$416190 VDD pfet_06v0 L=1U W=3U AS=1.32P AD=0.75P
+ PS=6.88U PD=3.5U
M$951 VDD \$464262 \$581164 VDD pfet_06v0 L=1U W=3U AS=0.75P AD=1.32P PS=3.5U
+ PD=6.88U
M$952 \$562735 \$464253 VDD VDD pfet_06v0 L=1U W=3U AS=1.32P AD=1.32P PS=6.88U
+ PD=6.88U
M$953 \$357643 \$565117 VDD VDD pfet_06v0 L=1U W=3U AS=1.32P AD=1.32P PS=6.88U
+ PD=6.88U
M$954 \$565117 \$464271 VDD VDD pfet_06v0 L=1U W=3U AS=1.32P AD=0.99P PS=6.88U
+ PD=3.66U
M$955 VDD \$562735 \$565117 VDD pfet_06v0 L=1U W=3U AS=0.99P AD=1.32P PS=3.66U
+ PD=6.88U
M$956 \$299172 \$565118 VDD VDD pfet_06v0 L=1U W=3U AS=1.32P AD=1.32P PS=6.88U
+ PD=6.88U
M$957 \$565118 \$464253 VDD VDD pfet_06v0 L=1U W=3U AS=1.32P AD=0.99P PS=6.88U
+ PD=3.66U
M$958 VDD \$464262 \$565118 VDD pfet_06v0 L=1U W=3U AS=0.99P AD=1.32P PS=3.66U
+ PD=6.88U
M$959 \$283731 \$300358 VSS VSS nfet_05v0 L=0.6U W=1.32U AS=0.5808P AD=0.5808P
+ PS=3.52U PD=3.52U
M$960 XP \$283731 VSS VSS nfet_05v0 L=0.6U W=1.32U AS=0.5808P AD=0.5808P
+ PS=3.52U PD=3.52U
M$961 XN XP VSS VSS nfet_05v0 L=0.6U W=1.32U AS=0.5808P AD=0.5808P PS=3.52U
+ PD=3.52U
M$962 \$344511 \$359044 VSS VSS nfet_05v0 L=0.6U W=1.32U AS=0.5808P AD=0.5808P
+ PS=3.52U PD=3.52U
M$963 YP \$344511 VSS VSS nfet_05v0 L=0.6U W=1.32U AS=0.5808P AD=0.5808P
+ PS=3.52U PD=3.52U
M$964 YN YP VSS VSS nfet_05v0 L=0.6U W=1.32U AS=0.5808P AD=0.5808P PS=3.52U
+ PD=3.52U
M$965 \$404364 \$417194 VSS VSS nfet_05v0 L=0.6U W=1.32U AS=0.5808P AD=0.5808P
+ PS=3.52U PD=3.52U
M$966 ZP \$404364 VSS VSS nfet_05v0 L=0.6U W=1.32U AS=0.5808P AD=0.5808P
+ PS=3.52U PD=3.52U
M$967 ZN ZP VSS VSS nfet_05v0 L=0.6U W=1.32U AS=0.5808P AD=0.5808P PS=3.52U
+ PD=3.52U
M$968 \$43789 \$43658 VSS VSS nfet_06v0 L=1U W=5U AS=2.2P AD=1.25P PS=10.88U
+ PD=5.5U
M$969 \$38244 \$43659 \$43789 VSS nfet_06v0 L=1U W=5U AS=1.25P AD=2.2P PS=5.5U
+ PD=10.88U
M$970 \$43850 \$43658 VSS VSS nfet_06v0 L=1U W=5U AS=2.2P AD=1.25P PS=10.88U
+ PD=5.5U
M$971 \$38244 \$43659 \$43850 VSS nfet_06v0 L=1U W=5U AS=1.25P AD=2.2P PS=5.5U
+ PD=10.88U
M$972 \$38245 \$54333 \$38244 VSS nfet_06v0 L=1U W=1U AS=0.44P AD=0.44P
+ PS=2.88U PD=2.88U
M$973 \$38246 \$54334 \$38244 VSS nfet_06v0 L=1U W=1U AS=0.44P AD=0.44P
+ PS=2.88U PD=2.88U
M$974 \$38247 \$38248 VSS VSS nfet_06v0 L=1U W=2.5U AS=1.1P AD=0.825P PS=5.88U
+ PD=3.16U
M$975 \$38248 \$43659 \$38247 VSS nfet_06v0 L=1U W=2.5U AS=0.825P AD=0.825P
+ PS=3.16U PD=3.16U
M$976 \$38249 \$42797 \$38248 VSS nfet_06v0 L=1U W=2.5U AS=0.825P AD=1.1P
+ PS=3.16U PD=5.88U
M$977 \$51237 \$38248 VSS VSS nfet_06v0 L=1U W=2.5U AS=1.1P AD=0.825P PS=5.88U
+ PD=3.16U
M$978 \$38250 \$43659 \$51237 VSS nfet_06v0 L=1U W=2.5U AS=0.825P AD=0.825P
+ PS=3.16U PD=3.16U
M$979 \$38251 \$42797 \$38250 VSS nfet_06v0 L=1U W=2.5U AS=0.825P AD=1.1P
+ PS=3.16U PD=5.88U
M$980 \$44163 \$43658 VSS VSS nfet_06v0 L=1U W=5U AS=2.2P AD=1.25P PS=10.88U
+ PD=5.5U
M$981 \$38252 \$43659 \$44163 VSS nfet_06v0 L=1U W=5U AS=1.25P AD=2.2P PS=5.5U
+ PD=10.88U
M$982 \$44233 \$38253 VSS VSS nfet_06v0 L=1U W=5U AS=2.2P AD=1.25P PS=10.88U
+ PD=5.5U
M$983 \$38253 \$43659 \$44233 VSS nfet_06v0 L=1U W=5U AS=1.25P AD=1.65P PS=5.5U
+ PD=5.66U
M$984 \$42797 \$42797 \$38253 VSS nfet_06v0 L=1U W=5U AS=1.65P AD=2.2P PS=5.66U
+ PD=10.88U
M$985 \$38254 \$38250 VSS VSS nfet_06v0 L=1U W=1U AS=0.44P AD=0.44P PS=2.88U
+ PD=2.88U
M$986 \$43659 \$43659 VSS VSS nfet_06v0 L=1U W=1U AS=0.44P AD=0.44P PS=2.88U
+ PD=2.88U
M$987 \$44402 \$43658 VSS VSS nfet_06v0 L=1U W=5U AS=2.2P AD=1.25P PS=10.88U
+ PD=5.5U
M$988 \$43658 \$43659 \$44402 VSS nfet_06v0 L=1U W=5U AS=1.25P AD=2.2P PS=5.5U
+ PD=10.88U
M$989 \$39957 \$57872 VSS VSS nfet_06v0 L=1U W=1U AS=0.44P AD=0.25P PS=2.88U
+ PD=1.5U
M$990 \$53335 \$57872 \$39957 VSS nfet_06v0 L=1U W=1U AS=0.25P AD=0.44P PS=1.5U
+ PD=2.88U
M$991 \$40021 \$57872 VSS VSS nfet_06v0 L=1U W=1U AS=0.44P AD=0.25P PS=2.88U
+ PD=1.5U
M$992 \$57872 \$57872 \$40021 VSS nfet_06v0 L=1U W=1U AS=0.25P AD=0.44P PS=1.5U
+ PD=2.88U
M$993 \$45014 \$43660 VSS VSS nfet_06v0 L=1U W=5U AS=2.2P AD=1.25P PS=10.88U
+ PD=5.5U
M$994 \$38255 \$43661 \$45014 VSS nfet_06v0 L=1U W=5U AS=1.25P AD=2.2P PS=5.5U
+ PD=10.88U
M$995 \$45076 \$43660 VSS VSS nfet_06v0 L=1U W=5U AS=2.2P AD=1.25P PS=10.88U
+ PD=5.5U
M$996 \$38255 \$43661 \$45076 VSS nfet_06v0 L=1U W=5U AS=1.25P AD=2.2P PS=5.5U
+ PD=10.88U
M$997 \$38256 \$54335 \$38255 VSS nfet_06v0 L=1U W=1U AS=0.44P AD=0.44P
+ PS=2.88U PD=2.88U
M$998 \$38257 \$53336 \$38255 VSS nfet_06v0 L=1U W=1U AS=0.44P AD=0.44P
+ PS=2.88U PD=2.88U
M$999 \$38258 \$38259 VSS VSS nfet_06v0 L=1U W=2.5U AS=1.1P AD=0.825P PS=5.88U
+ PD=3.16U
M$1000 \$38259 \$43661 \$38258 VSS nfet_06v0 L=1U W=2.5U AS=0.825P AD=0.825P
+ PS=3.16U PD=3.16U
M$1001 \$38260 \$42798 \$38259 VSS nfet_06v0 L=1U W=2.5U AS=0.825P AD=1.1P
+ PS=3.16U PD=5.88U
M$1002 \$51238 \$38259 VSS VSS nfet_06v0 L=1U W=2.5U AS=1.1P AD=0.825P PS=5.88U
+ PD=3.16U
M$1003 \$38261 \$43661 \$51238 VSS nfet_06v0 L=1U W=2.5U AS=0.825P AD=0.825P
+ PS=3.16U PD=3.16U
M$1004 \$38262 \$42798 \$38261 VSS nfet_06v0 L=1U W=2.5U AS=0.825P AD=1.1P
+ PS=3.16U PD=5.88U
M$1005 \$45385 \$43660 VSS VSS nfet_06v0 L=1U W=5U AS=2.2P AD=1.25P PS=10.88U
+ PD=5.5U
M$1006 \$38263 \$43661 \$45385 VSS nfet_06v0 L=1U W=5U AS=1.25P AD=2.2P PS=5.5U
+ PD=10.88U
M$1007 \$45449 \$38264 VSS VSS nfet_06v0 L=1U W=5U AS=2.2P AD=1.25P PS=10.88U
+ PD=5.5U
M$1008 \$38264 \$43661 \$45449 VSS nfet_06v0 L=1U W=5U AS=1.25P AD=1.65P
+ PS=5.5U PD=5.66U
M$1009 \$42798 \$42798 \$38264 VSS nfet_06v0 L=1U W=5U AS=1.65P AD=2.2P
+ PS=5.66U PD=10.88U
M$1010 \$38265 \$38261 VSS VSS nfet_06v0 L=1U W=1U AS=0.44P AD=0.44P PS=2.88U
+ PD=2.88U
M$1011 \$43661 \$43661 VSS VSS nfet_06v0 L=1U W=1U AS=0.44P AD=0.44P PS=2.88U
+ PD=2.88U
M$1012 \$45616 \$43660 VSS VSS nfet_06v0 L=1U W=5U AS=2.2P AD=1.25P PS=10.88U
+ PD=5.5U
M$1013 \$43660 \$43661 \$45616 VSS nfet_06v0 L=1U W=5U AS=1.25P AD=2.2P PS=5.5U
+ PD=10.88U
M$1014 \$41114 \$57875 VSS VSS nfet_06v0 L=1U W=1U AS=0.44P AD=0.25P PS=2.88U
+ PD=1.5U
M$1015 \$53337 \$57875 \$41114 VSS nfet_06v0 L=1U W=1U AS=0.25P AD=0.44P
+ PS=1.5U PD=2.88U
M$1016 \$41178 \$57875 VSS VSS nfet_06v0 L=1U W=1U AS=0.44P AD=0.25P PS=2.88U
+ PD=1.5U
M$1017 \$57875 \$57875 \$41178 VSS nfet_06v0 L=1U W=1U AS=0.25P AD=0.44P
+ PS=1.5U PD=2.88U
M$1018 \$46211 \$43662 VSS VSS nfet_06v0 L=1U W=5U AS=2.2P AD=1.25P PS=10.88U
+ PD=5.5U
M$1019 \$38266 \$43663 \$46211 VSS nfet_06v0 L=1U W=5U AS=1.25P AD=2.2P PS=5.5U
+ PD=10.88U
M$1020 \$46277 \$43662 VSS VSS nfet_06v0 L=1U W=5U AS=2.2P AD=1.25P PS=10.88U
+ PD=5.5U
M$1021 \$38266 \$43663 \$46277 VSS nfet_06v0 L=1U W=5U AS=1.25P AD=2.2P PS=5.5U
+ PD=10.88U
M$1022 \$38267 \$54336 \$38266 VSS nfet_06v0 L=1U W=1U AS=0.44P AD=0.44P
+ PS=2.88U PD=2.88U
M$1023 \$38268 \$53339 \$38266 VSS nfet_06v0 L=1U W=1U AS=0.44P AD=0.44P
+ PS=2.88U PD=2.88U
M$1024 \$38269 \$38270 VSS VSS nfet_06v0 L=1U W=2.5U AS=1.1P AD=0.825P PS=5.88U
+ PD=3.16U
M$1025 \$38270 \$43663 \$38269 VSS nfet_06v0 L=1U W=2.5U AS=0.825P AD=0.825P
+ PS=3.16U PD=3.16U
M$1026 \$38271 \$42799 \$38270 VSS nfet_06v0 L=1U W=2.5U AS=0.825P AD=1.1P
+ PS=3.16U PD=5.88U
M$1027 \$51241 \$38270 VSS VSS nfet_06v0 L=1U W=2.5U AS=1.1P AD=0.825P PS=5.88U
+ PD=3.16U
M$1028 \$38272 \$43663 \$51241 VSS nfet_06v0 L=1U W=2.5U AS=0.825P AD=0.825P
+ PS=3.16U PD=3.16U
M$1029 \$38273 \$42799 \$38272 VSS nfet_06v0 L=1U W=2.5U AS=0.825P AD=1.1P
+ PS=3.16U PD=5.88U
M$1030 \$46586 \$43662 VSS VSS nfet_06v0 L=1U W=5U AS=2.2P AD=1.25P PS=10.88U
+ PD=5.5U
M$1031 \$38274 \$43663 \$46586 VSS nfet_06v0 L=1U W=5U AS=1.25P AD=2.2P PS=5.5U
+ PD=10.88U
M$1032 \$46656 \$38275 VSS VSS nfet_06v0 L=1U W=5U AS=2.2P AD=1.25P PS=10.88U
+ PD=5.5U
M$1033 \$38275 \$43663 \$46656 VSS nfet_06v0 L=1U W=5U AS=1.25P AD=1.65P
+ PS=5.5U PD=5.66U
M$1034 \$42799 \$42799 \$38275 VSS nfet_06v0 L=1U W=5U AS=1.65P AD=2.2P
+ PS=5.66U PD=10.88U
M$1035 \$38276 \$38272 VSS VSS nfet_06v0 L=1U W=1U AS=0.44P AD=0.44P PS=2.88U
+ PD=2.88U
M$1036 \$43663 \$43663 VSS VSS nfet_06v0 L=1U W=1U AS=0.44P AD=0.44P PS=2.88U
+ PD=2.88U
M$1037 \$46822 \$43662 VSS VSS nfet_06v0 L=1U W=5U AS=2.2P AD=1.25P PS=10.88U
+ PD=5.5U
M$1038 \$43662 \$43663 \$46822 VSS nfet_06v0 L=1U W=5U AS=1.25P AD=2.2P PS=5.5U
+ PD=10.88U
M$1039 \$42252 \$57878 VSS VSS nfet_06v0 L=1U W=1U AS=0.44P AD=0.25P PS=2.88U
+ PD=1.5U
M$1040 \$53338 \$57878 \$42252 VSS nfet_06v0 L=1U W=1U AS=0.25P AD=0.44P
+ PS=1.5U PD=2.88U
M$1041 \$42307 \$57878 VSS VSS nfet_06v0 L=1U W=1U AS=0.44P AD=0.25P PS=2.88U
+ PD=1.5U
M$1042 \$57878 \$57878 \$42307 VSS nfet_06v0 L=1U W=1U AS=0.25P AD=0.44P
+ PS=1.5U PD=2.88U
M$1043 \$46983 \$43664 VSS VSS nfet_06v0 L=1U W=5U AS=2.2P AD=1.25P PS=10.88U
+ PD=5.5U
M$1044 \$38277 \$43665 \$46983 VSS nfet_06v0 L=1U W=5U AS=1.25P AD=2.2P PS=5.5U
+ PD=10.88U
M$1045 \$46777 \$43664 VSS VSS nfet_06v0 L=1U W=5U AS=2.2P AD=1.25P PS=10.88U
+ PD=5.5U
M$1046 \$38277 \$43665 \$46777 VSS nfet_06v0 L=1U W=5U AS=1.25P AD=2.2P PS=5.5U
+ PD=10.88U
M$1047 \$38278 \$54333 \$38277 VSS nfet_06v0 L=1U W=1U AS=0.44P AD=0.44P
+ PS=2.88U PD=2.88U
M$1048 \$38279 \$54334 \$38277 VSS nfet_06v0 L=1U W=1U AS=0.44P AD=0.44P
+ PS=2.88U PD=2.88U
M$1049 \$38280 \$38281 VSS VSS nfet_06v0 L=1U W=2.5U AS=1.1P AD=0.825P PS=5.88U
+ PD=3.16U
M$1050 \$38281 \$43665 \$38280 VSS nfet_06v0 L=1U W=2.5U AS=0.825P AD=0.825P
+ PS=3.16U PD=3.16U
M$1051 \$38282 \$42800 \$38281 VSS nfet_06v0 L=1U W=2.5U AS=0.825P AD=1.1P
+ PS=3.16U PD=5.88U
M$1052 \$51246 \$38281 VSS VSS nfet_06v0 L=1U W=2.5U AS=1.1P AD=0.825P PS=5.88U
+ PD=3.16U
M$1053 \$38283 \$43665 \$51246 VSS nfet_06v0 L=1U W=2.5U AS=0.825P AD=0.825P
+ PS=3.16U PD=3.16U
M$1054 \$38284 \$42800 \$38283 VSS nfet_06v0 L=1U W=2.5U AS=0.825P AD=1.1P
+ PS=3.16U PD=5.88U
M$1055 \$45834 \$43664 VSS VSS nfet_06v0 L=1U W=5U AS=2.2P AD=1.25P PS=10.88U
+ PD=5.5U
M$1056 \$38285 \$43665 \$45834 VSS nfet_06v0 L=1U W=5U AS=1.25P AD=2.2P PS=5.5U
+ PD=10.88U
M$1057 \$45601 \$38286 VSS VSS nfet_06v0 L=1U W=5U AS=2.2P AD=1.25P PS=10.88U
+ PD=5.5U
M$1058 \$38286 \$43665 \$45601 VSS nfet_06v0 L=1U W=5U AS=1.25P AD=1.65P
+ PS=5.5U PD=5.66U
M$1059 \$42800 \$42800 \$38286 VSS nfet_06v0 L=1U W=5U AS=1.65P AD=2.2P
+ PS=5.66U PD=10.88U
M$1060 \$38287 \$38283 VSS VSS nfet_06v0 L=1U W=1U AS=0.44P AD=0.44P PS=2.88U
+ PD=2.88U
M$1061 \$43665 \$43665 VSS VSS nfet_06v0 L=1U W=1U AS=0.44P AD=0.44P PS=2.88U
+ PD=2.88U
M$1062 \$45113 \$43664 VSS VSS nfet_06v0 L=1U W=5U AS=2.2P AD=1.25P PS=10.88U
+ PD=5.5U
M$1063 \$43664 \$43665 \$45113 VSS nfet_06v0 L=1U W=5U AS=1.25P AD=2.2P PS=5.5U
+ PD=10.88U
M$1064 \$40541 \$57881 VSS VSS nfet_06v0 L=1U W=1U AS=0.44P AD=0.25P PS=2.88U
+ PD=1.5U
M$1065 \$53340 \$57881 \$40541 VSS nfet_06v0 L=1U W=1U AS=0.25P AD=0.44P
+ PS=1.5U PD=2.88U
M$1066 \$40346 \$57881 VSS VSS nfet_06v0 L=1U W=1U AS=0.44P AD=0.25P PS=2.88U
+ PD=1.5U
M$1067 \$57881 \$57881 \$40346 VSS nfet_06v0 L=1U W=1U AS=0.25P AD=0.44P
+ PS=1.5U PD=2.88U
M$1068 VSS VDD VSS VSS nfet_06v0 L=2U W=18U AS=7.92P AD=7.92P PS=36.88U
+ PD=36.88U
M$1069 \$127909 \$127780 VSS VSS nfet_06v0 L=1U W=5U AS=2.2P AD=1.25P PS=10.88U
+ PD=5.5U
M$1070 \$120557 \$127781 \$127909 VSS nfet_06v0 L=1U W=5U AS=1.25P AD=2.2P
+ PS=5.5U PD=10.88U
M$1071 \$127966 \$127780 VSS VSS nfet_06v0 L=1U W=5U AS=2.2P AD=1.25P PS=10.88U
+ PD=5.5U
M$1072 \$120557 \$127781 \$127966 VSS nfet_06v0 L=1U W=5U AS=1.25P AD=2.2P
+ PS=5.5U PD=10.88U
M$1073 \$120558 \$136654 \$120557 VSS nfet_06v0 L=1U W=1U AS=0.44P AD=0.44P
+ PS=2.88U PD=2.88U
M$1074 \$120559 \$138519 \$120557 VSS nfet_06v0 L=1U W=1U AS=0.44P AD=0.44P
+ PS=2.88U PD=2.88U
M$1075 \$120560 \$120561 VSS VSS nfet_06v0 L=1U W=2.5U AS=1.1P AD=0.825P
+ PS=5.88U PD=3.16U
M$1076 \$120561 \$127781 \$120560 VSS nfet_06v0 L=1U W=2.5U AS=0.825P AD=0.825P
+ PS=3.16U PD=3.16U
M$1077 \$120562 \$123308 \$120561 VSS nfet_06v0 L=1U W=2.5U AS=0.825P AD=1.1P
+ PS=3.16U PD=5.88U
M$1078 \$135414 \$120561 VSS VSS nfet_06v0 L=1U W=2.5U AS=1.1P AD=0.825P
+ PS=5.88U PD=3.16U
M$1079 \$120563 \$127781 \$135414 VSS nfet_06v0 L=1U W=2.5U AS=0.825P AD=0.825P
+ PS=3.16U PD=3.16U
M$1080 \$120564 \$123308 \$120563 VSS nfet_06v0 L=1U W=2.5U AS=0.825P AD=1.1P
+ PS=3.16U PD=5.88U
M$1081 \$128281 \$127780 VSS VSS nfet_06v0 L=1U W=5U AS=2.2P AD=1.25P PS=10.88U
+ PD=5.5U
M$1082 \$120565 \$127781 \$128281 VSS nfet_06v0 L=1U W=5U AS=1.25P AD=2.2P
+ PS=5.5U PD=10.88U
M$1083 \$128345 \$120566 VSS VSS nfet_06v0 L=1U W=5U AS=2.2P AD=1.25P PS=10.88U
+ PD=5.5U
M$1084 \$120566 \$127781 \$128345 VSS nfet_06v0 L=1U W=5U AS=1.25P AD=1.65P
+ PS=5.5U PD=5.66U
M$1085 \$123308 \$123308 \$120566 VSS nfet_06v0 L=1U W=5U AS=1.65P AD=2.2P
+ PS=5.66U PD=10.88U
M$1086 \$120567 \$120563 VSS VSS nfet_06v0 L=1U W=1U AS=0.44P AD=0.44P PS=2.88U
+ PD=2.88U
M$1087 \$127781 \$127781 VSS VSS nfet_06v0 L=1U W=1U AS=0.44P AD=0.44P PS=2.88U
+ PD=2.88U
M$1088 \$128513 \$127780 VSS VSS nfet_06v0 L=1U W=5U AS=2.2P AD=1.25P PS=10.88U
+ PD=5.5U
M$1089 \$127780 \$127781 \$128513 VSS nfet_06v0 L=1U W=5U AS=1.25P AD=2.2P
+ PS=5.5U PD=10.88U
M$1090 \$121393 \$142180 VSS VSS nfet_06v0 L=1U W=1U AS=0.44P AD=0.25P PS=2.88U
+ PD=1.5U
M$1091 \$136653 \$142180 \$121393 VSS nfet_06v0 L=1U W=1U AS=0.25P AD=0.44P
+ PS=1.5U PD=2.88U
M$1092 \$121455 \$142180 VSS VSS nfet_06v0 L=1U W=1U AS=0.44P AD=0.25P PS=2.88U
+ PD=1.5U
M$1093 \$142180 \$142180 \$121455 VSS nfet_06v0 L=1U W=1U AS=0.25P AD=0.44P
+ PS=1.5U PD=2.88U
M$1094 VSS VDD VSS VSS nfet_06v0 L=2U W=18U AS=7.92P AD=7.92P PS=36.88U
+ PD=36.88U
M$1095 VSS VDD VSS VSS nfet_06v0 L=2U W=18U AS=7.92P AD=7.92P PS=36.88U
+ PD=36.88U
M$1096 \$129133 \$127782 VSS VSS nfet_06v0 L=1U W=5U AS=2.2P AD=1.25P PS=10.88U
+ PD=5.5U
M$1097 \$120568 \$127783 \$129133 VSS nfet_06v0 L=1U W=5U AS=1.25P AD=2.2P
+ PS=5.5U PD=10.88U
M$1098 \$129195 \$127782 VSS VSS nfet_06v0 L=1U W=5U AS=2.2P AD=1.25P PS=10.88U
+ PD=5.5U
M$1099 \$120568 \$127783 \$129195 VSS nfet_06v0 L=1U W=5U AS=1.25P AD=2.2P
+ PS=5.5U PD=10.88U
M$1100 \$120569 \$54336 \$120568 VSS nfet_06v0 L=1U W=1U AS=0.44P AD=0.44P
+ PS=2.88U PD=2.88U
M$1101 \$120570 \$53339 \$120568 VSS nfet_06v0 L=1U W=1U AS=0.44P AD=0.44P
+ PS=2.88U PD=2.88U
M$1102 \$120571 \$120572 VSS VSS nfet_06v0 L=1U W=2.5U AS=1.1P AD=0.825P
+ PS=5.88U PD=3.16U
M$1103 \$120572 \$127783 \$120571 VSS nfet_06v0 L=1U W=2.5U AS=0.825P AD=0.825P
+ PS=3.16U PD=3.16U
M$1104 \$120573 \$123309 \$120572 VSS nfet_06v0 L=1U W=2.5U AS=0.825P AD=1.1P
+ PS=3.16U PD=5.88U
M$1105 \$135418 \$120572 VSS VSS nfet_06v0 L=1U W=2.5U AS=1.1P AD=0.825P
+ PS=5.88U PD=3.16U
M$1106 \$120574 \$127783 \$135418 VSS nfet_06v0 L=1U W=2.5U AS=0.825P AD=0.825P
+ PS=3.16U PD=3.16U
M$1107 \$120575 \$123309 \$120574 VSS nfet_06v0 L=1U W=2.5U AS=0.825P AD=1.1P
+ PS=3.16U PD=5.88U
M$1108 \$129497 \$127782 VSS VSS nfet_06v0 L=1U W=5U AS=2.2P AD=1.25P PS=10.88U
+ PD=5.5U
M$1109 \$120576 \$127783 \$129497 VSS nfet_06v0 L=1U W=5U AS=1.25P AD=2.2P
+ PS=5.5U PD=10.88U
M$1110 \$129557 \$120577 VSS VSS nfet_06v0 L=1U W=5U AS=2.2P AD=1.25P PS=10.88U
+ PD=5.5U
M$1111 \$120577 \$127783 \$129557 VSS nfet_06v0 L=1U W=5U AS=1.25P AD=1.65P
+ PS=5.5U PD=5.66U
M$1112 \$123309 \$123309 \$120577 VSS nfet_06v0 L=1U W=5U AS=1.65P AD=2.2P
+ PS=5.66U PD=10.88U
M$1113 \$120578 \$120574 VSS VSS nfet_06v0 L=1U W=1U AS=0.44P AD=0.44P PS=2.88U
+ PD=2.88U
M$1114 \$127783 \$127783 VSS VSS nfet_06v0 L=1U W=1U AS=0.44P AD=0.44P PS=2.88U
+ PD=2.88U
M$1115 \$129728 \$127782 VSS VSS nfet_06v0 L=1U W=5U AS=2.2P AD=1.25P PS=10.88U
+ PD=5.5U
M$1116 \$127782 \$127783 \$129728 VSS nfet_06v0 L=1U W=5U AS=1.25P AD=2.2P
+ PS=5.5U PD=10.88U
M$1117 \$122604 \$142183 VSS VSS nfet_06v0 L=1U W=1U AS=0.44P AD=0.25P PS=2.88U
+ PD=1.5U
M$1118 \$136655 \$142183 \$122604 VSS nfet_06v0 L=1U W=1U AS=0.25P AD=0.44P
+ PS=1.5U PD=2.88U
M$1119 \$122666 \$142183 VSS VSS nfet_06v0 L=1U W=1U AS=0.44P AD=0.25P PS=2.88U
+ PD=1.5U
M$1120 \$142183 \$142183 \$122666 VSS nfet_06v0 L=1U W=1U AS=0.25P AD=0.44P
+ PS=1.5U PD=2.88U
M$1121 VSS VDD VSS VSS nfet_06v0 L=2U W=18U AS=7.92P AD=7.92P PS=36.88U
+ PD=36.88U
M$1122 VSS VDD VSS VSS nfet_06v0 L=2U W=18U AS=7.92P AD=7.92P PS=36.88U
+ PD=36.88U
M$1123 \$130319 \$127784 VSS VSS nfet_06v0 L=1U W=5U AS=2.2P AD=1.25P PS=10.88U
+ PD=5.5U
M$1124 \$120579 \$127785 \$130319 VSS nfet_06v0 L=1U W=5U AS=1.25P AD=2.2P
+ PS=5.5U PD=10.88U
M$1125 \$130381 \$127784 VSS VSS nfet_06v0 L=1U W=5U AS=2.2P AD=1.25P PS=10.88U
+ PD=5.5U
M$1126 \$120579 \$127785 \$130381 VSS nfet_06v0 L=1U W=5U AS=1.25P AD=2.2P
+ PS=5.5U PD=10.88U
M$1127 \$120580 \$136654 \$120579 VSS nfet_06v0 L=1U W=1U AS=0.44P AD=0.44P
+ PS=2.88U PD=2.88U
M$1128 \$120581 \$138519 \$120579 VSS nfet_06v0 L=1U W=1U AS=0.44P AD=0.44P
+ PS=2.88U PD=2.88U
M$1129 \$120582 \$120583 VSS VSS nfet_06v0 L=1U W=2.5U AS=1.1P AD=0.825P
+ PS=5.88U PD=3.16U
M$1130 \$120583 \$127785 \$120582 VSS nfet_06v0 L=1U W=2.5U AS=0.825P AD=0.825P
+ PS=3.16U PD=3.16U
M$1131 \$120584 \$123310 \$120583 VSS nfet_06v0 L=1U W=2.5U AS=0.825P AD=1.1P
+ PS=3.16U PD=5.88U
M$1132 \$135424 \$120583 VSS VSS nfet_06v0 L=1U W=2.5U AS=1.1P AD=0.825P
+ PS=5.88U PD=3.16U
M$1133 \$120585 \$127785 \$135424 VSS nfet_06v0 L=1U W=2.5U AS=0.825P AD=0.825P
+ PS=3.16U PD=3.16U
M$1134 \$120586 \$123310 \$120585 VSS nfet_06v0 L=1U W=2.5U AS=0.825P AD=1.1P
+ PS=3.16U PD=5.88U
M$1135 \$130699 \$127784 VSS VSS nfet_06v0 L=1U W=5U AS=2.2P AD=1.25P PS=10.88U
+ PD=5.5U
M$1136 \$120587 \$127785 \$130699 VSS nfet_06v0 L=1U W=5U AS=1.25P AD=2.2P
+ PS=5.5U PD=10.88U
M$1137 \$130763 \$120588 VSS VSS nfet_06v0 L=1U W=5U AS=2.2P AD=1.25P PS=10.88U
+ PD=5.5U
M$1138 \$120588 \$127785 \$130763 VSS nfet_06v0 L=1U W=5U AS=1.25P AD=1.65P
+ PS=5.5U PD=5.66U
M$1139 \$123310 \$123310 \$120588 VSS nfet_06v0 L=1U W=5U AS=1.65P AD=2.2P
+ PS=5.66U PD=10.88U
M$1140 \$120589 \$120585 VSS VSS nfet_06v0 L=1U W=1U AS=0.44P AD=0.44P PS=2.88U
+ PD=2.88U
M$1141 \$127785 \$127785 VSS VSS nfet_06v0 L=1U W=1U AS=0.44P AD=0.44P PS=2.88U
+ PD=2.88U
M$1142 \$130919 \$127784 VSS VSS nfet_06v0 L=1U W=5U AS=2.2P AD=1.25P PS=10.88U
+ PD=5.5U
M$1143 \$127784 \$127785 \$130919 VSS nfet_06v0 L=1U W=5U AS=1.25P AD=2.2P
+ PS=5.5U PD=10.88U
M$1144 \$122663 \$142186 VSS VSS nfet_06v0 L=1U W=1U AS=0.44P AD=0.25P PS=2.88U
+ PD=1.5U
M$1145 \$136656 \$142186 \$122663 VSS nfet_06v0 L=1U W=1U AS=0.25P AD=0.44P
+ PS=1.5U PD=2.88U
M$1146 \$122580 \$142186 VSS VSS nfet_06v0 L=1U W=1U AS=0.44P AD=0.25P PS=2.88U
+ PD=1.5U
M$1147 \$142186 \$142186 \$122580 VSS nfet_06v0 L=1U W=1U AS=0.25P AD=0.44P
+ PS=1.5U PD=2.88U
M$1148 VSS VDD VSS VSS nfet_06v0 L=2U W=18U AS=7.92P AD=7.92P PS=36.88U
+ PD=36.88U
M$1149 VSS VDD VSS VSS nfet_06v0 L=2U W=18U AS=7.92P AD=7.92P PS=36.88U
+ PD=36.88U
M$1150 \$131319 \$127786 VSS VSS nfet_06v0 L=1U W=5U AS=2.2P AD=1.25P PS=10.88U
+ PD=5.5U
M$1151 \$120590 \$127787 \$131319 VSS nfet_06v0 L=1U W=5U AS=1.25P AD=2.2P
+ PS=5.5U PD=10.88U
M$1152 \$131056 \$127786 VSS VSS nfet_06v0 L=1U W=5U AS=2.2P AD=1.25P PS=10.88U
+ PD=5.5U
M$1153 \$120590 \$127787 \$131056 VSS nfet_06v0 L=1U W=5U AS=1.25P AD=2.2P
+ PS=5.5U PD=10.88U
M$1154 \$120591 \$54336 \$120590 VSS nfet_06v0 L=1U W=1U AS=0.44P AD=0.44P
+ PS=2.88U PD=2.88U
M$1155 \$120592 \$53339 \$120590 VSS nfet_06v0 L=1U W=1U AS=0.44P AD=0.44P
+ PS=2.88U PD=2.88U
M$1156 \$120593 \$120594 VSS VSS nfet_06v0 L=1U W=2.5U AS=1.1P AD=0.825P
+ PS=5.88U PD=3.16U
M$1157 \$120594 \$127787 \$120593 VSS nfet_06v0 L=1U W=2.5U AS=0.825P AD=0.825P
+ PS=3.16U PD=3.16U
M$1158 \$120595 \$123311 \$120594 VSS nfet_06v0 L=1U W=2.5U AS=0.825P AD=1.1P
+ PS=3.16U PD=5.88U
M$1159 \$135426 \$120594 VSS VSS nfet_06v0 L=1U W=2.5U AS=1.1P AD=0.825P
+ PS=5.88U PD=3.16U
M$1160 \$120596 \$127787 \$135426 VSS nfet_06v0 L=1U W=2.5U AS=0.825P AD=0.825P
+ PS=3.16U PD=3.16U
M$1161 \$120597 \$123311 \$120596 VSS nfet_06v0 L=1U W=2.5U AS=0.825P AD=1.1P
+ PS=3.16U PD=5.88U
M$1162 \$130110 \$127786 VSS VSS nfet_06v0 L=1U W=5U AS=2.2P AD=1.25P PS=10.88U
+ PD=5.5U
M$1163 \$120598 \$127787 \$130110 VSS nfet_06v0 L=1U W=5U AS=1.25P AD=2.2P
+ PS=5.5U PD=10.88U
M$1164 \$129829 \$120599 VSS VSS nfet_06v0 L=1U W=5U AS=2.2P AD=1.25P PS=10.88U
+ PD=5.5U
M$1165 \$120599 \$127787 \$129829 VSS nfet_06v0 L=1U W=5U AS=1.25P AD=1.65P
+ PS=5.5U PD=5.66U
M$1166 \$123311 \$123311 \$120599 VSS nfet_06v0 L=1U W=5U AS=1.65P AD=2.2P
+ PS=5.66U PD=10.88U
M$1167 \$120600 \$120596 VSS VSS nfet_06v0 L=1U W=1U AS=0.44P AD=0.44P PS=2.88U
+ PD=2.88U
M$1168 \$127787 \$127787 VSS VSS nfet_06v0 L=1U W=1U AS=0.44P AD=0.44P PS=2.88U
+ PD=2.88U
M$1169 \$129295 \$127786 VSS VSS nfet_06v0 L=1U W=5U AS=2.2P AD=1.25P PS=10.88U
+ PD=5.5U
M$1170 \$127786 \$127787 \$129295 VSS nfet_06v0 L=1U W=5U AS=1.25P AD=2.2P
+ PS=5.5U PD=10.88U
M$1171 \$121120 \$142189 VSS VSS nfet_06v0 L=1U W=1U AS=0.44P AD=0.25P PS=2.88U
+ PD=1.5U
M$1172 \$136657 \$142189 \$121120 VSS nfet_06v0 L=1U W=1U AS=0.25P AD=0.44P
+ PS=1.5U PD=2.88U
M$1173 \$121045 \$142189 VSS VSS nfet_06v0 L=1U W=1U AS=0.44P AD=0.25P PS=2.88U
+ PD=1.5U
M$1174 \$142189 \$142189 \$121045 VSS nfet_06v0 L=1U W=1U AS=0.25P AD=0.44P
+ PS=1.5U PD=2.88U
M$1175 VSS VDD VSS VSS nfet_06v0 L=2U W=18U AS=7.92P AD=7.92P PS=36.88U
+ PD=36.88U
M$1176 VSS VDD VSS VSS nfet_06v0 L=2U W=18U AS=7.92P AD=7.92P PS=36.88U
+ PD=36.88U
M$1177 \$213547 \$213492 VSS VSS nfet_06v0 L=1U W=5U AS=2.2P AD=1.25P PS=10.88U
+ PD=5.5U
M$1178 \$205738 \$215913 \$213547 VSS nfet_06v0 L=1U W=5U AS=1.25P AD=2.2P
+ PS=5.5U PD=10.88U
M$1179 \$213574 \$213492 VSS VSS nfet_06v0 L=1U W=5U AS=2.2P AD=1.25P PS=10.88U
+ PD=5.5U
M$1180 \$205738 \$215913 \$213574 VSS nfet_06v0 L=1U W=5U AS=1.25P AD=2.2P
+ PS=5.5U PD=10.88U
M$1181 \$205739 \$54335 \$205738 VSS nfet_06v0 L=1U W=1U AS=0.44P AD=0.44P
+ PS=2.88U PD=2.88U
M$1182 \$205740 \$53336 \$205738 VSS nfet_06v0 L=1U W=1U AS=0.44P AD=0.44P
+ PS=2.88U PD=2.88U
M$1183 \$205741 \$205742 VSS VSS nfet_06v0 L=1U W=2.5U AS=1.1P AD=0.825P
+ PS=5.88U PD=3.16U
M$1184 \$205742 \$215913 \$205741 VSS nfet_06v0 L=1U W=2.5U AS=0.825P AD=0.825P
+ PS=3.16U PD=3.16U
M$1185 \$205743 \$210291 \$205742 VSS nfet_06v0 L=1U W=2.5U AS=0.825P AD=1.1P
+ PS=3.16U PD=5.88U
M$1186 \$217300 \$205742 VSS VSS nfet_06v0 L=1U W=2.5U AS=1.1P AD=0.825P
+ PS=5.88U PD=3.16U
M$1187 \$205744 \$215913 \$217300 VSS nfet_06v0 L=1U W=2.5U AS=0.825P AD=0.825P
+ PS=3.16U PD=3.16U
M$1188 \$205745 \$210291 \$205744 VSS nfet_06v0 L=1U W=2.5U AS=0.825P AD=1.1P
+ PS=3.16U PD=5.88U
M$1189 \$213676 \$213492 VSS VSS nfet_06v0 L=1U W=5U AS=2.2P AD=1.25P PS=10.88U
+ PD=5.5U
M$1190 \$205746 \$215913 \$213676 VSS nfet_06v0 L=1U W=5U AS=1.25P AD=2.2P
+ PS=5.5U PD=10.88U
M$1191 \$213698 \$205747 VSS VSS nfet_06v0 L=1U W=5U AS=2.2P AD=1.25P PS=10.88U
+ PD=5.5U
M$1192 \$205747 \$215913 \$213698 VSS nfet_06v0 L=1U W=5U AS=1.25P AD=1.65P
+ PS=5.5U PD=5.66U
M$1193 \$210291 \$210291 \$205747 VSS nfet_06v0 L=1U W=5U AS=1.65P AD=2.2P
+ PS=5.66U PD=10.88U
M$1194 \$205748 \$205744 VSS VSS nfet_06v0 L=1U W=1U AS=0.44P AD=0.44P PS=2.88U
+ PD=2.88U
M$1195 \$215913 \$215913 VSS VSS nfet_06v0 L=1U W=1U AS=0.44P AD=0.44P PS=2.88U
+ PD=2.88U
M$1196 \$213760 \$213492 VSS VSS nfet_06v0 L=1U W=5U AS=2.2P AD=1.25P PS=10.88U
+ PD=5.5U
M$1197 \$213492 \$215913 \$213760 VSS nfet_06v0 L=1U W=5U AS=1.25P AD=2.2P
+ PS=5.5U PD=10.88U
M$1198 \$206401 \$225734 VSS VSS nfet_06v0 L=1U W=1U AS=0.44P AD=0.25P PS=2.88U
+ PD=1.5U
M$1199 \$220426 \$225734 \$206401 VSS nfet_06v0 L=1U W=1U AS=0.25P AD=0.44P
+ PS=1.5U PD=2.88U
M$1200 \$206449 \$225734 VSS VSS nfet_06v0 L=1U W=1U AS=0.44P AD=0.25P PS=2.88U
+ PD=1.5U
M$1201 \$225734 \$225734 \$206449 VSS nfet_06v0 L=1U W=1U AS=0.25P AD=0.44P
+ PS=1.5U PD=2.88U
M$1202 VSS VDD VSS VSS nfet_06v0 L=2U W=18U AS=7.92P AD=7.92P PS=36.88U
+ PD=36.88U
M$1203 VSS VDD VSS VSS nfet_06v0 L=2U W=18U AS=7.92P AD=7.92P PS=36.88U
+ PD=36.88U
M$1204 \$213968 \$213493 VSS VSS nfet_06v0 L=1U W=5U AS=2.2P AD=1.25P PS=10.88U
+ PD=5.5U
M$1205 \$205749 \$215914 \$213968 VSS nfet_06v0 L=1U W=5U AS=1.25P AD=2.2P
+ PS=5.5U PD=10.88U
M$1206 \$213993 \$213493 VSS VSS nfet_06v0 L=1U W=5U AS=2.2P AD=1.25P PS=10.88U
+ PD=5.5U
M$1207 \$205749 \$215914 \$213993 VSS nfet_06v0 L=1U W=5U AS=1.25P AD=2.2P
+ PS=5.5U PD=10.88U
M$1208 \$205750 \$136654 \$205749 VSS nfet_06v0 L=1U W=1U AS=0.44P AD=0.44P
+ PS=2.88U PD=2.88U
M$1209 \$205751 \$138519 \$205749 VSS nfet_06v0 L=1U W=1U AS=0.44P AD=0.44P
+ PS=2.88U PD=2.88U
M$1210 \$205752 \$205753 VSS VSS nfet_06v0 L=1U W=2.5U AS=1.1P AD=0.825P
+ PS=5.88U PD=3.16U
M$1211 \$205753 \$215914 \$205752 VSS nfet_06v0 L=1U W=2.5U AS=0.825P AD=0.825P
+ PS=3.16U PD=3.16U
M$1212 \$205754 \$210292 \$205753 VSS nfet_06v0 L=1U W=2.5U AS=0.825P AD=1.1P
+ PS=3.16U PD=5.88U
M$1213 \$217303 \$205753 VSS VSS nfet_06v0 L=1U W=2.5U AS=1.1P AD=0.825P
+ PS=5.88U PD=3.16U
M$1214 \$205755 \$215914 \$217303 VSS nfet_06v0 L=1U W=2.5U AS=0.825P AD=0.825P
+ PS=3.16U PD=3.16U
M$1215 \$205756 \$210292 \$205755 VSS nfet_06v0 L=1U W=2.5U AS=0.825P AD=1.1P
+ PS=3.16U PD=5.88U
M$1216 \$214099 \$213493 VSS VSS nfet_06v0 L=1U W=5U AS=2.2P AD=1.25P PS=10.88U
+ PD=5.5U
M$1217 \$205757 \$215914 \$214099 VSS nfet_06v0 L=1U W=5U AS=1.25P AD=2.2P
+ PS=5.5U PD=10.88U
M$1218 \$214122 \$205758 VSS VSS nfet_06v0 L=1U W=5U AS=2.2P AD=1.25P PS=10.88U
+ PD=5.5U
M$1219 \$205758 \$215914 \$214122 VSS nfet_06v0 L=1U W=5U AS=1.25P AD=1.65P
+ PS=5.5U PD=5.66U
M$1220 \$210292 \$210292 \$205758 VSS nfet_06v0 L=1U W=5U AS=1.65P AD=2.2P
+ PS=5.66U PD=10.88U
M$1221 \$205759 \$205755 VSS VSS nfet_06v0 L=1U W=1U AS=0.44P AD=0.44P PS=2.88U
+ PD=2.88U
M$1222 \$215914 \$215914 VSS VSS nfet_06v0 L=1U W=1U AS=0.44P AD=0.44P PS=2.88U
+ PD=2.88U
M$1223 \$214190 \$213493 VSS VSS nfet_06v0 L=1U W=5U AS=2.2P AD=1.25P PS=10.88U
+ PD=5.5U
M$1224 \$213493 \$215914 \$214190 VSS nfet_06v0 L=1U W=5U AS=1.25P AD=2.2P
+ PS=5.5U PD=10.88U
M$1225 \$207340 \$225735 VSS VSS nfet_06v0 L=1U W=1U AS=0.44P AD=0.25P PS=2.88U
+ PD=1.5U
M$1226 \$220427 \$225735 \$207340 VSS nfet_06v0 L=1U W=1U AS=0.25P AD=0.44P
+ PS=1.5U PD=2.88U
M$1227 \$207388 \$225735 VSS VSS nfet_06v0 L=1U W=1U AS=0.44P AD=0.25P PS=2.88U
+ PD=1.5U
M$1228 \$225735 \$225735 \$207388 VSS nfet_06v0 L=1U W=1U AS=0.25P AD=0.44P
+ PS=1.5U PD=2.88U
M$1229 VSS VDD VSS VSS nfet_06v0 L=2U W=18U AS=7.92P AD=7.92P PS=36.88U
+ PD=36.88U
M$1230 VSS VDD VSS VSS nfet_06v0 L=2U W=18U AS=7.92P AD=7.92P PS=36.88U
+ PD=36.88U
M$1231 \$214105 \$213494 VSS VSS nfet_06v0 L=1U W=5U AS=2.2P AD=1.25P PS=10.88U
+ PD=5.5U
M$1232 \$205760 \$215915 \$214105 VSS nfet_06v0 L=1U W=5U AS=1.25P AD=2.2P
+ PS=5.5U PD=10.88U
M$1233 \$214089 \$213494 VSS VSS nfet_06v0 L=1U W=5U AS=2.2P AD=1.25P PS=10.88U
+ PD=5.5U
M$1234 \$205760 \$215915 \$214089 VSS nfet_06v0 L=1U W=5U AS=1.25P AD=2.2P
+ PS=5.5U PD=10.88U
M$1235 \$205761 \$54333 \$205760 VSS nfet_06v0 L=1U W=1U AS=0.44P AD=0.44P
+ PS=2.88U PD=2.88U
M$1236 \$205762 \$54334 \$205760 VSS nfet_06v0 L=1U W=1U AS=0.44P AD=0.44P
+ PS=2.88U PD=2.88U
M$1237 \$205763 \$205764 VSS VSS nfet_06v0 L=1U W=2.5U AS=1.1P AD=0.825P
+ PS=5.88U PD=3.16U
M$1238 \$205764 \$215915 \$205763 VSS nfet_06v0 L=1U W=2.5U AS=0.825P AD=0.825P
+ PS=3.16U PD=3.16U
M$1239 \$205765 \$210293 \$205764 VSS nfet_06v0 L=1U W=2.5U AS=0.825P AD=1.1P
+ PS=3.16U PD=5.88U
M$1240 \$217305 \$205764 VSS VSS nfet_06v0 L=1U W=2.5U AS=1.1P AD=0.825P
+ PS=5.88U PD=3.16U
M$1241 \$205766 \$215915 \$217305 VSS nfet_06v0 L=1U W=2.5U AS=0.825P AD=0.825P
+ PS=3.16U PD=3.16U
M$1242 \$205767 \$210293 \$205766 VSS nfet_06v0 L=1U W=2.5U AS=0.825P AD=1.1P
+ PS=3.16U PD=5.88U
M$1243 \$214006 \$213494 VSS VSS nfet_06v0 L=1U W=5U AS=2.2P AD=1.25P PS=10.88U
+ PD=5.5U
M$1244 \$205768 \$215915 \$214006 VSS nfet_06v0 L=1U W=5U AS=1.25P AD=2.2P
+ PS=5.5U PD=10.88U
M$1245 \$213982 \$205769 VSS VSS nfet_06v0 L=1U W=5U AS=2.2P AD=1.25P PS=10.88U
+ PD=5.5U
M$1246 \$205769 \$215915 \$213982 VSS nfet_06v0 L=1U W=5U AS=1.25P AD=1.65P
+ PS=5.5U PD=5.66U
M$1247 \$210293 \$210293 \$205769 VSS nfet_06v0 L=1U W=5U AS=1.65P AD=2.2P
+ PS=5.66U PD=10.88U
M$1248 \$205770 \$205766 VSS VSS nfet_06v0 L=1U W=1U AS=0.44P AD=0.44P PS=2.88U
+ PD=2.88U
M$1249 \$215915 \$215915 VSS VSS nfet_06v0 L=1U W=1U AS=0.44P AD=0.44P PS=2.88U
+ PD=2.88U
M$1250 \$213936 \$213494 VSS VSS nfet_06v0 L=1U W=5U AS=2.2P AD=1.25P PS=10.88U
+ PD=5.5U
M$1251 \$213494 \$215915 \$213936 VSS nfet_06v0 L=1U W=5U AS=1.25P AD=2.2P
+ PS=5.5U PD=10.88U
M$1252 \$206989 \$225736 VSS VSS nfet_06v0 L=1U W=1U AS=0.44P AD=0.25P PS=2.88U
+ PD=1.5U
M$1253 \$220428 \$225736 \$206989 VSS nfet_06v0 L=1U W=1U AS=0.25P AD=0.44P
+ PS=1.5U PD=2.88U
M$1254 \$206945 \$225736 VSS VSS nfet_06v0 L=1U W=1U AS=0.44P AD=0.25P PS=2.88U
+ PD=1.5U
M$1255 \$225736 \$225736 \$206945 VSS nfet_06v0 L=1U W=1U AS=0.25P AD=0.44P
+ PS=1.5U PD=2.88U
M$1256 VSS VDD VSS VSS nfet_06v0 L=2U W=18U AS=7.92P AD=7.92P PS=36.88U
+ PD=36.88U
M$1257 VSS VDD VSS VSS nfet_06v0 L=2U W=18U AS=7.92P AD=7.92P PS=36.88U
+ PD=36.88U
M$1258 \$213779 \$213495 VSS VSS nfet_06v0 L=1U W=5U AS=2.2P AD=1.25P PS=10.88U
+ PD=5.5U
M$1259 \$205771 \$215916 \$213779 VSS nfet_06v0 L=1U W=5U AS=1.25P AD=2.2P
+ PS=5.5U PD=10.88U
M$1260 \$213762 \$213495 VSS VSS nfet_06v0 L=1U W=5U AS=2.2P AD=1.25P PS=10.88U
+ PD=5.5U
M$1261 \$205771 \$215916 \$213762 VSS nfet_06v0 L=1U W=5U AS=1.25P AD=2.2P
+ PS=5.5U PD=10.88U
M$1262 \$205772 \$54335 \$205771 VSS nfet_06v0 L=1U W=1U AS=0.44P AD=0.44P
+ PS=2.88U PD=2.88U
M$1263 \$205773 \$53336 \$205771 VSS nfet_06v0 L=1U W=1U AS=0.44P AD=0.44P
+ PS=2.88U PD=2.88U
M$1264 \$205774 \$205775 VSS VSS nfet_06v0 L=1U W=2.5U AS=1.1P AD=0.825P
+ PS=5.88U PD=3.16U
M$1265 \$205775 \$215916 \$205774 VSS nfet_06v0 L=1U W=2.5U AS=0.825P AD=0.825P
+ PS=3.16U PD=3.16U
M$1266 \$205776 \$210294 \$205775 VSS nfet_06v0 L=1U W=2.5U AS=0.825P AD=1.1P
+ PS=3.16U PD=5.88U
M$1267 \$217308 \$205775 VSS VSS nfet_06v0 L=1U W=2.5U AS=1.1P AD=0.825P
+ PS=5.88U PD=3.16U
M$1268 \$205777 \$215916 \$217308 VSS nfet_06v0 L=1U W=2.5U AS=0.825P AD=0.825P
+ PS=3.16U PD=3.16U
M$1269 \$205778 \$210294 \$205777 VSS nfet_06v0 L=1U W=2.5U AS=0.825P AD=1.1P
+ PS=3.16U PD=5.88U
M$1270 \$213684 \$213495 VSS VSS nfet_06v0 L=1U W=5U AS=2.2P AD=1.25P PS=10.88U
+ PD=5.5U
M$1271 \$205779 \$215916 \$213684 VSS nfet_06v0 L=1U W=5U AS=1.25P AD=2.2P
+ PS=5.5U PD=10.88U
M$1272 \$213664 \$205780 VSS VSS nfet_06v0 L=1U W=5U AS=2.2P AD=1.25P PS=10.88U
+ PD=5.5U
M$1273 \$205780 \$215916 \$213664 VSS nfet_06v0 L=1U W=5U AS=1.25P AD=1.65P
+ PS=5.5U PD=5.66U
M$1274 \$210294 \$210294 \$205780 VSS nfet_06v0 L=1U W=5U AS=1.65P AD=2.2P
+ PS=5.66U PD=10.88U
M$1275 \$205781 \$205777 VSS VSS nfet_06v0 L=1U W=1U AS=0.44P AD=0.44P PS=2.88U
+ PD=2.88U
M$1276 \$215916 \$215916 VSS VSS nfet_06v0 L=1U W=1U AS=0.44P AD=0.44P PS=2.88U
+ PD=2.88U
M$1277 \$213623 \$213495 VSS VSS nfet_06v0 L=1U W=5U AS=2.2P AD=1.25P PS=10.88U
+ PD=5.5U
M$1278 \$213495 \$215916 \$213623 VSS nfet_06v0 L=1U W=5U AS=1.25P AD=2.2P
+ PS=5.5U PD=10.88U
M$1279 \$206087 \$225737 VSS VSS nfet_06v0 L=1U W=1U AS=0.44P AD=0.25P PS=2.88U
+ PD=1.5U
M$1280 \$220429 \$225737 \$206087 VSS nfet_06v0 L=1U W=1U AS=0.25P AD=0.44P
+ PS=1.5U PD=2.88U
M$1281 \$206040 \$225737 VSS VSS nfet_06v0 L=1U W=1U AS=0.44P AD=0.25P PS=2.88U
+ PD=1.5U
M$1282 \$225737 \$225737 \$206040 VSS nfet_06v0 L=1U W=1U AS=0.25P AD=0.44P
+ PS=1.5U PD=2.88U
M$1283 VSS VDD VSS VSS nfet_06v0 L=2U W=18U AS=7.92P AD=7.92P PS=36.88U
+ PD=36.88U
M$1284 VSS VDD VSS VSS nfet_06v0 L=2U W=18U AS=7.92P AD=7.92P PS=36.88U
+ PD=36.88U
M$1285 \$290937 \$290937 VSS VSS nfet_06v0 L=1U W=1U AS=0.44P AD=0.44P PS=2.88U
+ PD=2.88U
M$1286 \$296889 \$288685 VSS VSS nfet_06v0 L=1U W=5U AS=2.2P AD=1.25P PS=10.88U
+ PD=5.5U
M$1287 \$288685 \$290937 \$296889 VSS nfet_06v0 L=1U W=5U AS=1.25P AD=2.2P
+ PS=5.5U PD=10.88U
M$1288 \$290330 \$306774 VSS VSS nfet_06v0 L=1U W=1U AS=0.44P AD=0.25P PS=2.88U
+ PD=1.5U
M$1289 \$306773 \$306774 \$290330 VSS nfet_06v0 L=1U W=1U AS=0.25P AD=0.44P
+ PS=1.5U PD=2.88U
M$1290 \$290370 \$306774 VSS VSS nfet_06v0 L=1U W=1U AS=0.44P AD=0.25P PS=2.88U
+ PD=1.5U
M$1291 \$306774 \$306774 \$290370 VSS nfet_06v0 L=1U W=1U AS=0.25P AD=0.44P
+ PS=1.5U PD=2.88U
M$1292 \$296966 \$288685 VSS VSS nfet_06v0 L=1U W=5U AS=2.2P AD=1.25P PS=10.88U
+ PD=5.5U
M$1293 \$288686 \$290937 \$296966 VSS nfet_06v0 L=1U W=5U AS=1.25P AD=1.65P
+ PS=5.5U PD=5.66U
M$1294 \$296977 \$290937 \$288686 VSS nfet_06v0 L=1U W=5U AS=1.65P AD=1.25P
+ PS=5.66U PD=5.5U
M$1295 VSS \$288685 \$296977 VSS nfet_06v0 L=1U W=5U AS=1.25P AD=2.2P PS=5.5U
+ PD=10.88U
M$1296 \$288687 \$38254 \$288686 VSS nfet_06v0 L=1U W=5U AS=2.2P AD=1.3P
+ PS=10.88U PD=5.52U
M$1297 \$288686 \$38254 \$288687 VSS nfet_06v0 L=1U W=5U AS=1.3P AD=2.2P
+ PS=5.52U PD=10.88U
M$1298 \$288688 \$38276 \$288686 VSS nfet_06v0 L=1U W=5U AS=2.2P AD=1.3P
+ PS=10.88U PD=5.52U
M$1299 \$288686 \$38276 \$288688 VSS nfet_06v0 L=1U W=5U AS=1.3P AD=2.2P
+ PS=5.52U PD=10.88U
M$1300 \$288690 \$290937 \$288689 VSS nfet_06v0 L=1U W=2.5U AS=1.1P AD=0.65P
+ PS=5.88U PD=3.02U
M$1301 \$288689 \$290937 \$288690 VSS nfet_06v0 L=1U W=2.5U AS=0.65P AD=1.1P
+ PS=3.02U PD=5.88U
M$1302 \$288692 \$290937 \$288691 VSS nfet_06v0 L=1U W=2.5U AS=1.1P AD=0.65P
+ PS=5.88U PD=3.02U
M$1303 \$288691 \$290937 \$288692 VSS nfet_06v0 L=1U W=2.5U AS=0.65P AD=1.1P
+ PS=3.02U PD=5.88U
M$1304 \$288689 \$288690 VSS VSS nfet_06v0 L=1U W=2.5U AS=1.1P AD=0.65P
+ PS=5.88U PD=3.02U
M$1305 VSS \$288690 \$288689 VSS nfet_06v0 L=1U W=2.5U AS=0.65P AD=0.65P
+ PS=3.02U PD=3.02U
M$1306 \$288689 \$288690 VSS VSS nfet_06v0 L=1U W=2.5U AS=0.65P AD=0.65P
+ PS=3.02U PD=3.02U
M$1307 VSS \$288690 \$288689 VSS nfet_06v0 L=1U W=2.5U AS=0.65P AD=1.1P
+ PS=3.02U PD=5.88U
M$1308 \$288691 \$288690 VSS VSS nfet_06v0 L=1U W=2.5U AS=1.1P AD=0.65P
+ PS=5.88U PD=3.02U
M$1309 VSS \$288690 \$288691 VSS nfet_06v0 L=1U W=2.5U AS=0.65P AD=0.65P
+ PS=3.02U PD=3.02U
M$1310 \$288691 \$288690 VSS VSS nfet_06v0 L=1U W=2.5U AS=0.65P AD=0.65P
+ PS=3.02U PD=3.02U
M$1311 VSS \$288690 \$288691 VSS nfet_06v0 L=1U W=2.5U AS=0.65P AD=1.1P
+ PS=3.02U PD=5.88U
M$1312 \$302272 \$290938 \$288690 VSS nfet_06v0 L=1U W=2.5U AS=1.1P AD=1.1P
+ PS=5.88U PD=5.88U
M$1313 \$288693 \$290938 \$288692 VSS nfet_06v0 L=1U W=2.5U AS=1.1P AD=1.1P
+ PS=5.88U PD=5.88U
M$1314 \$297101 \$288685 VSS VSS nfet_06v0 L=1U W=5U AS=2.2P AD=1.25P PS=10.88U
+ PD=5.5U
M$1315 \$288694 \$290937 \$297101 VSS nfet_06v0 L=1U W=5U AS=1.25P AD=2.2P
+ PS=5.5U PD=10.88U
M$1316 \$297109 \$288695 VSS VSS nfet_06v0 L=1U W=5U AS=2.2P AD=1.25P PS=10.88U
+ PD=5.5U
M$1317 \$288695 \$290937 \$297109 VSS nfet_06v0 L=1U W=5U AS=1.25P AD=1.65P
+ PS=5.5U PD=5.66U
M$1318 \$290938 \$290938 \$288695 VSS nfet_06v0 L=1U W=5U AS=1.65P AD=2.2P
+ PS=5.66U PD=10.88U
M$1319 \$288696 \$288692 VSS VSS nfet_06v0 L=1U W=5U AS=2.2P AD=1.3P PS=10.88U
+ PD=5.52U
M$1320 VSS \$288692 \$288696 VSS nfet_06v0 L=1U W=5U AS=1.3P AD=1.3P PS=5.52U
+ PD=5.52U
M$1321 \$288696 \$288692 VSS VSS nfet_06v0 L=1U W=5U AS=1.3P AD=2.2P PS=5.52U
+ PD=10.88U
M$1322 VSS VDD VSS VSS nfet_06v0 L=2U W=18U AS=7.92P AD=7.92P PS=36.88U
+ PD=36.88U
M$1323 VSS VDD VSS VSS nfet_06v0 L=2U W=18U AS=7.92P AD=7.92P PS=36.88U
+ PD=36.88U
M$1324 \$290939 \$290939 VSS VSS nfet_06v0 L=1U W=1U AS=0.44P AD=0.44P PS=2.88U
+ PD=2.88U
M$1325 \$297245 \$288697 VSS VSS nfet_06v0 L=1U W=5U AS=2.2P AD=1.25P PS=10.88U
+ PD=5.5U
M$1326 \$288697 \$290939 \$297245 VSS nfet_06v0 L=1U W=5U AS=1.25P AD=2.2P
+ PS=5.5U PD=10.88U
M$1327 \$290912 \$306777 VSS VSS nfet_06v0 L=1U W=1U AS=0.44P AD=0.25P PS=2.88U
+ PD=1.5U
M$1328 \$306776 \$306777 \$290912 VSS nfet_06v0 L=1U W=1U AS=0.25P AD=0.44P
+ PS=1.5U PD=2.88U
M$1329 \$290890 \$306777 VSS VSS nfet_06v0 L=1U W=1U AS=0.44P AD=0.25P PS=2.88U
+ PD=1.5U
M$1330 \$306777 \$306777 \$290890 VSS nfet_06v0 L=1U W=1U AS=0.25P AD=0.44P
+ PS=1.5U PD=2.88U
M$1331 \$297280 \$288697 VSS VSS nfet_06v0 L=1U W=5U AS=2.2P AD=1.25P PS=10.88U
+ PD=5.5U
M$1332 \$288698 \$290939 \$297280 VSS nfet_06v0 L=1U W=5U AS=1.25P AD=1.65P
+ PS=5.5U PD=5.66U
M$1333 \$297283 \$290939 \$288698 VSS nfet_06v0 L=1U W=5U AS=1.65P AD=1.25P
+ PS=5.66U PD=5.5U
M$1334 VSS \$288697 \$297283 VSS nfet_06v0 L=1U W=5U AS=1.25P AD=2.2P PS=5.5U
+ PD=10.88U
M$1335 \$288699 \$38265 \$288698 VSS nfet_06v0 L=1U W=5U AS=2.2P AD=1.3P
+ PS=10.88U PD=5.52U
M$1336 \$288698 \$38265 \$288699 VSS nfet_06v0 L=1U W=5U AS=1.3P AD=2.2P
+ PS=5.52U PD=10.88U
M$1337 \$288700 \$38276 \$288698 VSS nfet_06v0 L=1U W=5U AS=2.2P AD=1.3P
+ PS=10.88U PD=5.52U
M$1338 \$288698 \$38276 \$288700 VSS nfet_06v0 L=1U W=5U AS=1.3P AD=2.2P
+ PS=5.52U PD=10.88U
M$1339 \$288702 \$290939 \$288701 VSS nfet_06v0 L=1U W=2.5U AS=1.1P AD=0.65P
+ PS=5.88U PD=3.02U
M$1340 \$288701 \$290939 \$288702 VSS nfet_06v0 L=1U W=2.5U AS=0.65P AD=1.1P
+ PS=3.02U PD=5.88U
M$1341 \$288704 \$290939 \$288703 VSS nfet_06v0 L=1U W=2.5U AS=1.1P AD=0.65P
+ PS=5.88U PD=3.02U
M$1342 \$288703 \$290939 \$288704 VSS nfet_06v0 L=1U W=2.5U AS=0.65P AD=1.1P
+ PS=3.02U PD=5.88U
M$1343 \$288701 \$288702 VSS VSS nfet_06v0 L=1U W=2.5U AS=1.1P AD=0.65P
+ PS=5.88U PD=3.02U
M$1344 VSS \$288702 \$288701 VSS nfet_06v0 L=1U W=2.5U AS=0.65P AD=0.65P
+ PS=3.02U PD=3.02U
M$1345 \$288701 \$288702 VSS VSS nfet_06v0 L=1U W=2.5U AS=0.65P AD=0.65P
+ PS=3.02U PD=3.02U
M$1346 VSS \$288702 \$288701 VSS nfet_06v0 L=1U W=2.5U AS=0.65P AD=1.1P
+ PS=3.02U PD=5.88U
M$1347 \$288703 \$288702 VSS VSS nfet_06v0 L=1U W=2.5U AS=1.1P AD=0.65P
+ PS=5.88U PD=3.02U
M$1348 VSS \$288702 \$288703 VSS nfet_06v0 L=1U W=2.5U AS=0.65P AD=0.65P
+ PS=3.02U PD=3.02U
M$1349 \$288703 \$288702 VSS VSS nfet_06v0 L=1U W=2.5U AS=0.65P AD=0.65P
+ PS=3.02U PD=3.02U
M$1350 VSS \$288702 \$288703 VSS nfet_06v0 L=1U W=2.5U AS=0.65P AD=1.1P
+ PS=3.02U PD=5.88U
M$1351 \$302273 \$290940 \$288702 VSS nfet_06v0 L=1U W=2.5U AS=1.1P AD=1.1P
+ PS=5.88U PD=5.88U
M$1352 \$288705 \$290940 \$288704 VSS nfet_06v0 L=1U W=2.5U AS=1.1P AD=1.1P
+ PS=5.88U PD=5.88U
M$1353 \$297481 \$288697 VSS VSS nfet_06v0 L=1U W=5U AS=2.2P AD=1.25P PS=10.88U
+ PD=5.5U
M$1354 \$288706 \$290939 \$297481 VSS nfet_06v0 L=1U W=5U AS=1.25P AD=2.2P
+ PS=5.5U PD=10.88U
M$1355 VSS VDD VSS VSS nfet_06v0 L=2U W=18U AS=7.92P AD=7.92P PS=36.88U
+ PD=36.88U
M$1356 \$297492 \$288707 VSS VSS nfet_06v0 L=1U W=5U AS=2.2P AD=1.25P PS=10.88U
+ PD=5.5U
M$1357 \$288707 \$290939 \$297492 VSS nfet_06v0 L=1U W=5U AS=1.25P AD=1.65P
+ PS=5.5U PD=5.66U
M$1358 \$290940 \$290940 \$288707 VSS nfet_06v0 L=1U W=5U AS=1.65P AD=2.2P
+ PS=5.66U PD=10.88U
M$1359 VSS VDD VSS VSS nfet_06v0 L=2U W=18U AS=7.92P AD=7.92P PS=36.88U
+ PD=36.88U
M$1360 \$288708 \$288704 VSS VSS nfet_06v0 L=1U W=5U AS=2.2P AD=1.3P PS=10.88U
+ PD=5.52U
M$1361 VSS \$288704 \$288708 VSS nfet_06v0 L=1U W=5U AS=1.3P AD=1.3P PS=5.52U
+ PD=5.52U
M$1362 \$288708 \$288704 VSS VSS nfet_06v0 L=1U W=5U AS=1.3P AD=2.2P PS=5.52U
+ PD=10.88U
M$1363 \$290941 \$290941 VSS VSS nfet_06v0 L=1U W=1U AS=0.44P AD=0.44P PS=2.88U
+ PD=2.88U
M$1364 \$297332 \$288709 VSS VSS nfet_06v0 L=1U W=5U AS=2.2P AD=1.25P PS=10.88U
+ PD=5.5U
M$1365 \$288709 \$290941 \$297332 VSS nfet_06v0 L=1U W=5U AS=1.25P AD=2.2P
+ PS=5.5U PD=10.88U
M$1366 \$290592 \$306780 VSS VSS nfet_06v0 L=1U W=1U AS=0.44P AD=0.25P PS=2.88U
+ PD=1.5U
M$1367 \$306779 \$306780 \$290592 VSS nfet_06v0 L=1U W=1U AS=0.25P AD=0.44P
+ PS=1.5U PD=2.88U
M$1368 \$290578 \$306780 VSS VSS nfet_06v0 L=1U W=1U AS=0.44P AD=0.25P PS=2.88U
+ PD=1.5U
M$1369 \$306780 \$306780 \$290578 VSS nfet_06v0 L=1U W=1U AS=0.25P AD=0.44P
+ PS=1.5U PD=2.88U
M$1370 \$297287 \$288709 VSS VSS nfet_06v0 L=1U W=5U AS=2.2P AD=1.25P PS=10.88U
+ PD=5.5U
M$1371 \$288710 \$290941 \$297287 VSS nfet_06v0 L=1U W=5U AS=1.25P AD=1.65P
+ PS=5.5U PD=5.66U
M$1372 \$297272 \$290941 \$288710 VSS nfet_06v0 L=1U W=5U AS=1.65P AD=1.25P
+ PS=5.66U PD=5.5U
M$1373 VSS \$288709 \$297272 VSS nfet_06v0 L=1U W=5U AS=1.25P AD=2.2P PS=5.5U
+ PD=10.88U
M$1374 \$288711 \$38265 \$288710 VSS nfet_06v0 L=1U W=5U AS=2.2P AD=1.3P
+ PS=10.88U PD=5.52U
M$1375 \$288710 \$38265 \$288711 VSS nfet_06v0 L=1U W=5U AS=1.3P AD=2.2P
+ PS=5.52U PD=10.88U
M$1376 \$288712 \$38254 \$288710 VSS nfet_06v0 L=1U W=5U AS=2.2P AD=1.3P
+ PS=10.88U PD=5.52U
M$1377 \$288710 \$38254 \$288712 VSS nfet_06v0 L=1U W=5U AS=1.3P AD=2.2P
+ PS=5.52U PD=10.88U
M$1378 \$288714 \$290941 \$288713 VSS nfet_06v0 L=1U W=2.5U AS=1.1P AD=0.65P
+ PS=5.88U PD=3.02U
M$1379 \$288713 \$290941 \$288714 VSS nfet_06v0 L=1U W=2.5U AS=0.65P AD=1.1P
+ PS=3.02U PD=5.88U
M$1380 \$288716 \$290941 \$288715 VSS nfet_06v0 L=1U W=2.5U AS=1.1P AD=0.65P
+ PS=5.88U PD=3.02U
M$1381 \$288715 \$290941 \$288716 VSS nfet_06v0 L=1U W=2.5U AS=0.65P AD=1.1P
+ PS=3.02U PD=5.88U
M$1382 \$288713 \$288714 VSS VSS nfet_06v0 L=1U W=2.5U AS=1.1P AD=0.65P
+ PS=5.88U PD=3.02U
M$1383 VSS \$288714 \$288713 VSS nfet_06v0 L=1U W=2.5U AS=0.65P AD=0.65P
+ PS=3.02U PD=3.02U
M$1384 \$288713 \$288714 VSS VSS nfet_06v0 L=1U W=2.5U AS=0.65P AD=0.65P
+ PS=3.02U PD=3.02U
M$1385 VSS \$288714 \$288713 VSS nfet_06v0 L=1U W=2.5U AS=0.65P AD=1.1P
+ PS=3.02U PD=5.88U
M$1386 \$288715 \$288714 VSS VSS nfet_06v0 L=1U W=2.5U AS=1.1P AD=0.65P
+ PS=5.88U PD=3.02U
M$1387 VSS \$288714 \$288715 VSS nfet_06v0 L=1U W=2.5U AS=0.65P AD=0.65P
+ PS=3.02U PD=3.02U
M$1388 \$288715 \$288714 VSS VSS nfet_06v0 L=1U W=2.5U AS=0.65P AD=0.65P
+ PS=3.02U PD=3.02U
M$1389 VSS \$288714 \$288715 VSS nfet_06v0 L=1U W=2.5U AS=0.65P AD=1.1P
+ PS=3.02U PD=5.88U
M$1390 VSS VDD VSS VSS nfet_06v0 L=2U W=18U AS=7.92P AD=7.92P PS=36.88U
+ PD=36.88U
M$1391 \$302274 \$290942 \$288714 VSS nfet_06v0 L=1U W=2.5U AS=1.1P AD=1.1P
+ PS=5.88U PD=5.88U
M$1392 VSS VDD VSS VSS nfet_06v0 L=2U W=18U AS=7.92P AD=7.92P PS=36.88U
+ PD=36.88U
M$1393 \$288717 \$290942 \$288716 VSS nfet_06v0 L=1U W=2.5U AS=1.1P AD=1.1P
+ PS=5.88U PD=5.88U
M$1394 \$297124 \$288709 VSS VSS nfet_06v0 L=1U W=5U AS=2.2P AD=1.25P PS=10.88U
+ PD=5.5U
M$1395 \$288718 \$290941 \$297124 VSS nfet_06v0 L=1U W=5U AS=1.25P AD=2.2P
+ PS=5.5U PD=10.88U
M$1396 \$297087 \$288719 VSS VSS nfet_06v0 L=1U W=5U AS=2.2P AD=1.25P PS=10.88U
+ PD=5.5U
M$1397 \$288719 \$290941 \$297087 VSS nfet_06v0 L=1U W=5U AS=1.25P AD=1.65P
+ PS=5.5U PD=5.66U
M$1398 \$290942 \$290942 \$288719 VSS nfet_06v0 L=1U W=5U AS=1.65P AD=2.2P
+ PS=5.66U PD=10.88U
M$1399 \$288720 \$288716 VSS VSS nfet_06v0 L=1U W=5U AS=2.2P AD=1.3P PS=10.88U
+ PD=5.52U
M$1400 VSS \$288716 \$288720 VSS nfet_06v0 L=1U W=5U AS=1.3P AD=1.3P PS=5.52U
+ PD=5.52U
M$1401 \$288720 \$288716 VSS VSS nfet_06v0 L=1U W=5U AS=1.3P AD=2.2P PS=5.52U
+ PD=10.88U
M$1402 VSS VDD VSS VSS nfet_06v0 L=2U W=18U AS=7.92P AD=7.92P PS=36.88U
+ PD=36.88U
M$1403 VSS VDD VSS VSS nfet_06v0 L=2U W=9.75U AS=4.29P AD=4.29P PS=20.38U
+ PD=20.38U
M$1404 \$349887 \$349887 VSS VSS nfet_06v0 L=1U W=1U AS=0.44P AD=0.44P PS=2.88U
+ PD=2.88U
M$1405 \$354073 \$347596 VSS VSS nfet_06v0 L=1U W=5U AS=2.2P AD=1.25P PS=10.88U
+ PD=5.5U
M$1406 \$347596 \$349887 \$354073 VSS nfet_06v0 L=1U W=5U AS=1.25P AD=2.2P
+ PS=5.5U PD=10.88U
M$1407 \$349235 \$366766 VSS VSS nfet_06v0 L=1U W=1U AS=0.44P AD=0.25P PS=2.88U
+ PD=1.5U
M$1408 \$365590 \$366766 \$349235 VSS nfet_06v0 L=1U W=1U AS=0.25P AD=0.44P
+ PS=1.5U PD=2.88U
M$1409 \$349275 \$366766 VSS VSS nfet_06v0 L=1U W=1U AS=0.44P AD=0.25P PS=2.88U
+ PD=1.5U
M$1410 \$366766 \$366766 \$349275 VSS nfet_06v0 L=1U W=1U AS=0.25P AD=0.44P
+ PS=1.5U PD=2.88U
M$1411 \$354230 \$347596 VSS VSS nfet_06v0 L=1U W=5U AS=2.2P AD=1.25P PS=10.88U
+ PD=5.5U
M$1412 \$347597 \$349887 \$354230 VSS nfet_06v0 L=1U W=5U AS=1.25P AD=1.65P
+ PS=5.5U PD=5.66U
M$1413 \$354256 \$349887 \$347597 VSS nfet_06v0 L=1U W=5U AS=1.65P AD=1.25P
+ PS=5.66U PD=5.5U
M$1414 VSS \$347596 \$354256 VSS nfet_06v0 L=1U W=5U AS=1.25P AD=2.2P PS=5.5U
+ PD=10.88U
M$1415 \$347598 \$38287 \$347597 VSS nfet_06v0 L=1U W=5U AS=2.2P AD=1.3P
+ PS=10.88U PD=5.52U
M$1416 \$347597 \$38287 \$347598 VSS nfet_06v0 L=1U W=5U AS=1.3P AD=2.2P
+ PS=5.52U PD=10.88U
M$1417 \$347599 \$120578 \$347597 VSS nfet_06v0 L=1U W=5U AS=2.2P AD=1.3P
+ PS=10.88U PD=5.52U
M$1418 \$347597 \$120578 \$347599 VSS nfet_06v0 L=1U W=5U AS=1.3P AD=2.2P
+ PS=5.52U PD=10.88U
M$1419 \$347601 \$349887 \$347600 VSS nfet_06v0 L=1U W=2.5U AS=1.1P AD=0.65P
+ PS=5.88U PD=3.02U
M$1420 \$347600 \$349887 \$347601 VSS nfet_06v0 L=1U W=2.5U AS=0.65P AD=1.1P
+ PS=3.02U PD=5.88U
M$1421 \$347603 \$349887 \$347602 VSS nfet_06v0 L=1U W=2.5U AS=1.1P AD=0.65P
+ PS=5.88U PD=3.02U
M$1422 \$347602 \$349887 \$347603 VSS nfet_06v0 L=1U W=2.5U AS=0.65P AD=1.1P
+ PS=3.02U PD=5.88U
M$1423 \$347600 \$347601 VSS VSS nfet_06v0 L=1U W=2.5U AS=1.1P AD=0.65P
+ PS=5.88U PD=3.02U
M$1424 VSS \$347601 \$347600 VSS nfet_06v0 L=1U W=2.5U AS=0.65P AD=0.65P
+ PS=3.02U PD=3.02U
M$1425 \$347600 \$347601 VSS VSS nfet_06v0 L=1U W=2.5U AS=0.65P AD=0.65P
+ PS=3.02U PD=3.02U
M$1426 VSS \$347601 \$347600 VSS nfet_06v0 L=1U W=2.5U AS=0.65P AD=1.1P
+ PS=3.02U PD=5.88U
M$1427 \$347602 \$347601 VSS VSS nfet_06v0 L=1U W=2.5U AS=1.1P AD=0.65P
+ PS=5.88U PD=3.02U
M$1428 VSS \$347601 \$347602 VSS nfet_06v0 L=1U W=2.5U AS=0.65P AD=0.65P
+ PS=3.02U PD=3.02U
M$1429 \$347602 \$347601 VSS VSS nfet_06v0 L=1U W=2.5U AS=0.65P AD=0.65P
+ PS=3.02U PD=3.02U
M$1430 VSS \$347601 \$347602 VSS nfet_06v0 L=1U W=2.5U AS=0.65P AD=1.1P
+ PS=3.02U PD=5.88U
M$1431 \$360996 \$349888 \$347601 VSS nfet_06v0 L=1U W=2.5U AS=1.1P AD=1.1P
+ PS=5.88U PD=5.88U
M$1432 \$347604 \$349888 \$347603 VSS nfet_06v0 L=1U W=2.5U AS=1.1P AD=1.1P
+ PS=5.88U PD=5.88U
M$1433 \$354676 \$347596 VSS VSS nfet_06v0 L=1U W=5U AS=2.2P AD=1.25P PS=10.88U
+ PD=5.5U
M$1434 \$347605 \$349887 \$354676 VSS nfet_06v0 L=1U W=5U AS=1.25P AD=2.2P
+ PS=5.5U PD=10.88U
M$1435 \$354697 \$347606 VSS VSS nfet_06v0 L=1U W=5U AS=2.2P AD=1.25P PS=10.88U
+ PD=5.5U
M$1436 \$347606 \$349887 \$354697 VSS nfet_06v0 L=1U W=5U AS=1.25P AD=1.65P
+ PS=5.5U PD=5.66U
M$1437 \$349888 \$349888 \$347606 VSS nfet_06v0 L=1U W=5U AS=1.65P AD=2.2P
+ PS=5.66U PD=10.88U
M$1438 \$347607 \$347603 VSS VSS nfet_06v0 L=1U W=5U AS=2.2P AD=1.3P PS=10.88U
+ PD=5.52U
M$1439 VSS \$347603 \$347607 VSS nfet_06v0 L=1U W=5U AS=1.3P AD=1.3P PS=5.52U
+ PD=5.52U
M$1440 \$347607 \$347603 VSS VSS nfet_06v0 L=1U W=5U AS=1.3P AD=2.2P PS=5.52U
+ PD=10.88U
M$1441 VSS VDD VSS VSS nfet_06v0 L=2U W=9.75U AS=4.29P AD=4.29P PS=20.38U
+ PD=20.38U
M$1442 VSS VDD VSS VSS nfet_06v0 L=2U W=9.75U AS=4.29P AD=4.29P PS=20.38U
+ PD=20.38U
M$1443 \$349889 \$349889 VSS VSS nfet_06v0 L=1U W=1U AS=0.44P AD=0.44P PS=2.88U
+ PD=2.88U
M$1444 \$355044 \$347608 VSS VSS nfet_06v0 L=1U W=5U AS=2.2P AD=1.25P PS=10.88U
+ PD=5.5U
M$1445 \$347608 \$349889 \$355044 VSS nfet_06v0 L=1U W=5U AS=1.25P AD=2.2P
+ PS=5.5U PD=10.88U
M$1446 \$349844 \$366768 VSS VSS nfet_06v0 L=1U W=1U AS=0.44P AD=0.25P PS=2.88U
+ PD=1.5U
M$1447 \$365591 \$366768 \$349844 VSS nfet_06v0 L=1U W=1U AS=0.25P AD=0.44P
+ PS=1.5U PD=2.88U
M$1448 \$349827 \$366768 VSS VSS nfet_06v0 L=1U W=1U AS=0.44P AD=0.25P PS=2.88U
+ PD=1.5U
M$1449 \$366768 \$366768 \$349827 VSS nfet_06v0 L=1U W=1U AS=0.25P AD=0.44P
+ PS=1.5U PD=2.88U
M$1450 \$355192 \$347608 VSS VSS nfet_06v0 L=1U W=5U AS=2.2P AD=1.25P PS=10.88U
+ PD=5.5U
M$1451 \$347609 \$349889 \$355192 VSS nfet_06v0 L=1U W=5U AS=1.25P AD=1.65P
+ PS=5.5U PD=5.66U
M$1452 \$355217 \$349889 \$347609 VSS nfet_06v0 L=1U W=5U AS=1.65P AD=1.25P
+ PS=5.66U PD=5.5U
M$1453 VSS \$347608 \$355217 VSS nfet_06v0 L=1U W=5U AS=1.25P AD=2.2P PS=5.5U
+ PD=10.88U
M$1454 \$347610 \$120567 \$347609 VSS nfet_06v0 L=1U W=5U AS=2.2P AD=1.3P
+ PS=10.88U PD=5.52U
M$1455 \$347609 \$120567 \$347610 VSS nfet_06v0 L=1U W=5U AS=1.3P AD=2.2P
+ PS=5.52U PD=10.88U
M$1456 \$347611 \$120578 \$347609 VSS nfet_06v0 L=1U W=5U AS=2.2P AD=1.3P
+ PS=10.88U PD=5.52U
M$1457 \$347609 \$120578 \$347611 VSS nfet_06v0 L=1U W=5U AS=1.3P AD=2.2P
+ PS=5.52U PD=10.88U
M$1458 \$347613 \$349889 \$347612 VSS nfet_06v0 L=1U W=2.5U AS=1.1P AD=0.65P
+ PS=5.88U PD=3.02U
M$1459 \$347612 \$349889 \$347613 VSS nfet_06v0 L=1U W=2.5U AS=0.65P AD=1.1P
+ PS=3.02U PD=5.88U
M$1460 \$347615 \$349889 \$347614 VSS nfet_06v0 L=1U W=2.5U AS=1.1P AD=0.65P
+ PS=5.88U PD=3.02U
M$1461 \$347614 \$349889 \$347615 VSS nfet_06v0 L=1U W=2.5U AS=0.65P AD=1.1P
+ PS=3.02U PD=5.88U
M$1462 \$347612 \$347613 VSS VSS nfet_06v0 L=1U W=2.5U AS=1.1P AD=0.65P
+ PS=5.88U PD=3.02U
M$1463 VSS \$347613 \$347612 VSS nfet_06v0 L=1U W=2.5U AS=0.65P AD=0.65P
+ PS=3.02U PD=3.02U
M$1464 \$347612 \$347613 VSS VSS nfet_06v0 L=1U W=2.5U AS=0.65P AD=0.65P
+ PS=3.02U PD=3.02U
M$1465 VSS \$347613 \$347612 VSS nfet_06v0 L=1U W=2.5U AS=0.65P AD=1.1P
+ PS=3.02U PD=5.88U
M$1466 \$347614 \$347613 VSS VSS nfet_06v0 L=1U W=2.5U AS=1.1P AD=0.65P
+ PS=5.88U PD=3.02U
M$1467 VSS \$347613 \$347614 VSS nfet_06v0 L=1U W=2.5U AS=0.65P AD=0.65P
+ PS=3.02U PD=3.02U
M$1468 \$347614 \$347613 VSS VSS nfet_06v0 L=1U W=2.5U AS=0.65P AD=0.65P
+ PS=3.02U PD=3.02U
M$1469 VSS \$347613 \$347614 VSS nfet_06v0 L=1U W=2.5U AS=0.65P AD=1.1P
+ PS=3.02U PD=5.88U
M$1470 \$360997 \$349890 \$347613 VSS nfet_06v0 L=1U W=2.5U AS=1.1P AD=1.1P
+ PS=5.88U PD=5.88U
M$1471 \$347616 \$349890 \$347615 VSS nfet_06v0 L=1U W=2.5U AS=1.1P AD=1.1P
+ PS=5.88U PD=5.88U
M$1472 \$355620 \$347608 VSS VSS nfet_06v0 L=1U W=5U AS=2.2P AD=1.25P PS=10.88U
+ PD=5.5U
M$1473 \$347617 \$349889 \$355620 VSS nfet_06v0 L=1U W=5U AS=1.25P AD=2.2P
+ PS=5.5U PD=10.88U
M$1474 \$355642 \$347618 VSS VSS nfet_06v0 L=1U W=5U AS=2.2P AD=1.25P PS=10.88U
+ PD=5.5U
M$1475 \$347618 \$349889 \$355642 VSS nfet_06v0 L=1U W=5U AS=1.25P AD=1.65P
+ PS=5.5U PD=5.66U
M$1476 \$349890 \$349890 \$347618 VSS nfet_06v0 L=1U W=5U AS=1.65P AD=2.2P
+ PS=5.66U PD=10.88U
M$1477 \$347619 \$347615 VSS VSS nfet_06v0 L=1U W=5U AS=2.2P AD=1.3P PS=10.88U
+ PD=5.52U
M$1478 VSS \$347615 \$347619 VSS nfet_06v0 L=1U W=5U AS=1.3P AD=1.3P PS=5.52U
+ PD=5.52U
M$1479 \$347619 \$347615 VSS VSS nfet_06v0 L=1U W=5U AS=1.3P AD=2.2P PS=5.52U
+ PD=10.88U
M$1480 VSS VDD VSS VSS nfet_06v0 L=2U W=9.75U AS=4.29P AD=4.29P PS=20.38U
+ PD=20.38U
M$1481 VSS VDD VSS VSS nfet_06v0 L=2U W=9.75U AS=4.29P AD=4.29P PS=20.38U
+ PD=20.38U
M$1482 \$349891 \$349891 VSS VSS nfet_06v0 L=1U W=1U AS=0.44P AD=0.44P PS=2.88U
+ PD=2.88U
M$1483 \$355969 \$347620 VSS VSS nfet_06v0 L=1U W=5U AS=2.2P AD=1.25P PS=10.88U
+ PD=5.5U
M$1484 \$347620 \$349891 \$355969 VSS nfet_06v0 L=1U W=5U AS=1.25P AD=2.2P
+ PS=5.5U PD=10.88U
M$1485 \$349546 \$366770 VSS VSS nfet_06v0 L=1U W=1U AS=0.44P AD=0.25P PS=2.88U
+ PD=1.5U
M$1486 \$365592 \$366770 \$349546 VSS nfet_06v0 L=1U W=1U AS=0.25P AD=0.44P
+ PS=1.5U PD=2.88U
M$1487 \$349532 \$366770 VSS VSS nfet_06v0 L=1U W=1U AS=0.44P AD=0.25P PS=2.88U
+ PD=1.5U
M$1488 \$366770 \$366770 \$349532 VSS nfet_06v0 L=1U W=1U AS=0.25P AD=0.44P
+ PS=1.5U PD=2.88U
M$1489 \$356116 \$347620 VSS VSS nfet_06v0 L=1U W=5U AS=2.2P AD=1.25P PS=10.88U
+ PD=5.5U
M$1490 \$347621 \$349891 \$356116 VSS nfet_06v0 L=1U W=5U AS=1.25P AD=1.65P
+ PS=5.5U PD=5.66U
M$1491 \$356132 \$349891 \$347621 VSS nfet_06v0 L=1U W=5U AS=1.65P AD=1.25P
+ PS=5.66U PD=5.5U
M$1492 VSS \$347620 \$356132 VSS nfet_06v0 L=1U W=5U AS=1.25P AD=2.2P PS=5.5U
+ PD=10.88U
M$1493 \$347622 \$120567 \$347621 VSS nfet_06v0 L=1U W=5U AS=2.2P AD=1.3P
+ PS=10.88U PD=5.52U
M$1494 \$347621 \$120567 \$347622 VSS nfet_06v0 L=1U W=5U AS=1.3P AD=2.2P
+ PS=5.52U PD=10.88U
M$1495 \$347623 \$38287 \$347621 VSS nfet_06v0 L=1U W=5U AS=2.2P AD=1.3P
+ PS=10.88U PD=5.52U
M$1496 \$347621 \$38287 \$347623 VSS nfet_06v0 L=1U W=5U AS=1.3P AD=2.2P
+ PS=5.52U PD=10.88U
M$1497 \$347625 \$349891 \$347624 VSS nfet_06v0 L=1U W=2.5U AS=1.1P AD=0.65P
+ PS=5.88U PD=3.02U
M$1498 \$347624 \$349891 \$347625 VSS nfet_06v0 L=1U W=2.5U AS=0.65P AD=1.1P
+ PS=3.02U PD=5.88U
M$1499 \$347627 \$349891 \$347626 VSS nfet_06v0 L=1U W=2.5U AS=1.1P AD=0.65P
+ PS=5.88U PD=3.02U
M$1500 \$347626 \$349891 \$347627 VSS nfet_06v0 L=1U W=2.5U AS=0.65P AD=1.1P
+ PS=3.02U PD=5.88U
M$1501 \$347624 \$347625 VSS VSS nfet_06v0 L=1U W=2.5U AS=1.1P AD=0.65P
+ PS=5.88U PD=3.02U
M$1502 VSS \$347625 \$347624 VSS nfet_06v0 L=1U W=2.5U AS=0.65P AD=0.65P
+ PS=3.02U PD=3.02U
M$1503 \$347624 \$347625 VSS VSS nfet_06v0 L=1U W=2.5U AS=0.65P AD=0.65P
+ PS=3.02U PD=3.02U
M$1504 VSS \$347625 \$347624 VSS nfet_06v0 L=1U W=2.5U AS=0.65P AD=1.1P
+ PS=3.02U PD=5.88U
M$1505 \$347626 \$347625 VSS VSS nfet_06v0 L=1U W=2.5U AS=1.1P AD=0.65P
+ PS=5.88U PD=3.02U
M$1506 VSS \$347625 \$347626 VSS nfet_06v0 L=1U W=2.5U AS=0.65P AD=0.65P
+ PS=3.02U PD=3.02U
M$1507 \$347626 \$347625 VSS VSS nfet_06v0 L=1U W=2.5U AS=0.65P AD=0.65P
+ PS=3.02U PD=3.02U
M$1508 VSS \$347625 \$347626 VSS nfet_06v0 L=1U W=2.5U AS=0.65P AD=1.1P
+ PS=3.02U PD=5.88U
M$1509 \$360998 \$349892 \$347625 VSS nfet_06v0 L=1U W=2.5U AS=1.1P AD=1.1P
+ PS=5.88U PD=5.88U
M$1510 \$347628 \$349892 \$347627 VSS nfet_06v0 L=1U W=2.5U AS=1.1P AD=1.1P
+ PS=5.88U PD=5.88U
M$1511 \$356556 \$347620 VSS VSS nfet_06v0 L=1U W=5U AS=2.2P AD=1.25P PS=10.88U
+ PD=5.5U
M$1512 \$347629 \$349891 \$356556 VSS nfet_06v0 L=1U W=5U AS=1.25P AD=2.2P
+ PS=5.5U PD=10.88U
M$1513 \$356583 \$347630 VSS VSS nfet_06v0 L=1U W=5U AS=2.2P AD=1.25P PS=10.88U
+ PD=5.5U
M$1514 \$347630 \$349891 \$356583 VSS nfet_06v0 L=1U W=5U AS=1.25P AD=1.65P
+ PS=5.5U PD=5.66U
M$1515 \$349892 \$349892 \$347630 VSS nfet_06v0 L=1U W=5U AS=1.65P AD=2.2P
+ PS=5.66U PD=10.88U
M$1516 \$347631 \$347627 VSS VSS nfet_06v0 L=1U W=5U AS=2.2P AD=1.3P PS=10.88U
+ PD=5.52U
M$1517 VSS \$347627 \$347631 VSS nfet_06v0 L=1U W=5U AS=1.3P AD=1.3P PS=5.52U
+ PD=5.52U
M$1518 \$347631 \$347627 VSS VSS nfet_06v0 L=1U W=5U AS=1.3P AD=2.2P PS=5.52U
+ PD=10.88U
M$1519 VSS VDD VSS VSS nfet_06v0 L=2U W=9.75U AS=4.29P AD=4.29P PS=20.38U
+ PD=20.38U
M$1520 VSS VDD VSS VSS nfet_06v0 L=2U W=9.75U AS=4.29P AD=4.29P PS=20.38U
+ PD=20.38U
M$1521 \$300358 \$299172 \$300357 VSS nfet_06v0 L=1U W=2.48U AS=1.0912P
+ AD=0.6448P PS=5.84U PD=3U
M$1522 \$300357 \$299172 \$300358 VSS nfet_06v0 L=1U W=2.48U AS=0.6448P
+ AD=1.0912P PS=3U PD=5.84U
M$1523 \$300358 \$287456 \$283730 VSS nfet_06v0 L=1U W=2.48U AS=1.0912P
+ AD=0.6448P PS=5.84U PD=3U
M$1524 \$283730 \$287456 \$300358 VSS nfet_06v0 L=1U W=2.48U AS=0.6448P
+ AD=1.0912P PS=3U PD=5.84U
M$1525 \$300358 \$299173 \$300359 VSS nfet_06v0 L=1U W=2.48U AS=1.0912P
+ AD=0.6448P PS=5.84U PD=3U
M$1526 \$300359 \$299173 \$300358 VSS nfet_06v0 L=1U W=2.48U AS=0.6448P
+ AD=1.0912P PS=3U PD=5.84U
M$1527 \$283730 \$287457 VSS VSS nfet_06v0 L=1U W=1.24U AS=0.5456P AD=0.5456P
+ PS=3.36U PD=3.36U
M$1528 \$300357 \$287457 VSS VSS nfet_06v0 L=1U W=1.24U AS=0.5456P AD=0.5456P
+ PS=3.36U PD=3.36U
M$1529 \$300359 \$287457 VSS VSS nfet_06v0 L=1U W=1.24U AS=0.5456P AD=0.5456P
+ PS=3.36U PD=3.36U
M$1530 \$293664 \$287457 VSS VSS nfet_06v0 L=1U W=0.7U AS=0.308P AD=0.175P
+ PS=2.28U PD=1.2U
M$1531 \$293643 \$287457 \$293664 VSS nfet_06v0 L=1U W=0.7U AS=0.175P AD=0.175P
+ PS=1.2U PD=1.2U
M$1532 \$293619 \$287457 \$293643 VSS nfet_06v0 L=1U W=0.7U AS=0.175P AD=0.175P
+ PS=1.2U PD=1.2U
M$1533 \$287457 \$287457 \$293619 VSS nfet_06v0 L=1U W=0.7U AS=0.175P AD=0.308P
+ PS=1.2U PD=2.28U
M$1534 \$300358 \$300358 \$300360 VSS nfet_06v0 L=1U W=2U AS=0.88P AD=0.52P
+ PS=4.88U PD=2.52U
M$1535 \$300360 \$300358 \$300358 VSS nfet_06v0 L=1U W=2U AS=0.52P AD=0.88P
+ PS=2.52U PD=4.88U
M$1536 \$301589 \$300358 VSS VSS nfet_06v0 L=1U W=2U AS=0.88P AD=0.5P PS=4.88U
+ PD=2.5U
M$1537 \$300360 \$300358 \$301589 VSS nfet_06v0 L=1U W=2U AS=0.5P AD=0.88P
+ PS=2.5U PD=4.88U
M$1538 \$300358 \$299174 \$300361 VSS nfet_06v0 L=1U W=2.48U AS=1.0912P
+ AD=0.6448P PS=5.84U PD=3U
M$1539 \$300361 \$299174 \$300358 VSS nfet_06v0 L=1U W=2.48U AS=0.6448P
+ AD=1.0912P PS=3U PD=5.84U
M$1540 \$300361 \$287457 VSS VSS nfet_06v0 L=1U W=1.24U AS=0.5456P AD=0.5456P
+ PS=3.36U PD=3.36U
M$1541 VSS VDD VSS VSS nfet_06v0 L=2U W=9.75U AS=4.29P AD=4.29P PS=20.38U
+ PD=20.38U
M$1542 \$407607 \$407607 VSS VSS nfet_06v0 L=1U W=1U AS=0.44P AD=0.44P PS=2.88U
+ PD=2.88U
M$1543 \$413653 \$405607 VSS VSS nfet_06v0 L=1U W=5U AS=2.2P AD=1.25P PS=10.88U
+ PD=5.5U
M$1544 \$405607 \$407607 \$413653 VSS nfet_06v0 L=1U W=5U AS=1.25P AD=2.2P
+ PS=5.5U PD=10.88U
M$1545 \$407801 \$424670 VSS VSS nfet_06v0 L=1U W=1U AS=0.44P AD=0.25P PS=2.88U
+ PD=1.5U
M$1546 \$423548 \$424670 \$407801 VSS nfet_06v0 L=1U W=1U AS=0.25P AD=0.44P
+ PS=1.5U PD=2.88U
M$1547 \$407851 \$424670 VSS VSS nfet_06v0 L=1U W=1U AS=0.44P AD=0.25P PS=2.88U
+ PD=1.5U
M$1548 \$424670 \$424670 \$407851 VSS nfet_06v0 L=1U W=1U AS=0.25P AD=0.44P
+ PS=1.5U PD=2.88U
M$1549 \$413736 \$405607 VSS VSS nfet_06v0 L=1U W=5U AS=2.2P AD=1.25P PS=10.88U
+ PD=5.5U
M$1550 \$406854 \$407607 \$413736 VSS nfet_06v0 L=1U W=5U AS=1.25P AD=1.65P
+ PS=5.5U PD=5.66U
M$1551 \$413747 \$407607 \$406854 VSS nfet_06v0 L=1U W=5U AS=1.65P AD=1.25P
+ PS=5.66U PD=5.5U
M$1552 VSS \$405607 \$413747 VSS nfet_06v0 L=1U W=5U AS=1.25P AD=2.2P PS=5.5U
+ PD=10.88U
M$1553 \$406855 \$120589 \$406854 VSS nfet_06v0 L=1U W=5U AS=2.2P AD=1.3P
+ PS=10.88U PD=5.52U
M$1554 \$406854 \$120589 \$406855 VSS nfet_06v0 L=1U W=5U AS=1.3P AD=2.2P
+ PS=5.52U PD=10.88U
M$1555 \$406856 \$205748 \$406854 VSS nfet_06v0 L=1U W=5U AS=2.2P AD=1.3P
+ PS=10.88U PD=5.52U
M$1556 \$406854 \$205748 \$406856 VSS nfet_06v0 L=1U W=5U AS=1.3P AD=2.2P
+ PS=5.52U PD=10.88U
M$1557 \$406858 \$407607 \$406857 VSS nfet_06v0 L=1U W=2.5U AS=1.1P AD=0.65P
+ PS=5.88U PD=3.02U
M$1558 \$406857 \$407607 \$406858 VSS nfet_06v0 L=1U W=2.5U AS=0.65P AD=1.1P
+ PS=3.02U PD=5.88U
M$1559 \$406860 \$407607 \$406859 VSS nfet_06v0 L=1U W=2.5U AS=1.1P AD=0.65P
+ PS=5.88U PD=3.02U
M$1560 \$406859 \$407607 \$406860 VSS nfet_06v0 L=1U W=2.5U AS=0.65P AD=1.1P
+ PS=3.02U PD=5.88U
M$1561 \$406857 \$406858 VSS VSS nfet_06v0 L=1U W=2.5U AS=1.1P AD=0.65P
+ PS=5.88U PD=3.02U
M$1562 VSS \$406858 \$406857 VSS nfet_06v0 L=1U W=2.5U AS=0.65P AD=0.65P
+ PS=3.02U PD=3.02U
M$1563 \$406857 \$406858 VSS VSS nfet_06v0 L=1U W=2.5U AS=0.65P AD=0.65P
+ PS=3.02U PD=3.02U
M$1564 VSS \$406858 \$406857 VSS nfet_06v0 L=1U W=2.5U AS=0.65P AD=1.1P
+ PS=3.02U PD=5.88U
M$1565 \$406859 \$406858 VSS VSS nfet_06v0 L=1U W=2.5U AS=1.1P AD=0.65P
+ PS=5.88U PD=3.02U
M$1566 VSS \$406858 \$406859 VSS nfet_06v0 L=1U W=2.5U AS=0.65P AD=0.65P
+ PS=3.02U PD=3.02U
M$1567 \$406859 \$406858 VSS VSS nfet_06v0 L=1U W=2.5U AS=0.65P AD=0.65P
+ PS=3.02U PD=3.02U
M$1568 VSS \$406858 \$406859 VSS nfet_06v0 L=1U W=2.5U AS=0.65P AD=1.1P
+ PS=3.02U PD=5.88U
M$1569 \$418990 \$410145 \$406858 VSS nfet_06v0 L=1U W=2.5U AS=1.1P AD=1.1P
+ PS=5.88U PD=5.88U
M$1570 \$405608 \$410145 \$406860 VSS nfet_06v0 L=1U W=2.5U AS=1.1P AD=1.1P
+ PS=5.88U PD=5.88U
M$1571 \$413943 \$405607 VSS VSS nfet_06v0 L=1U W=5U AS=2.2P AD=1.25P PS=10.88U
+ PD=5.5U
M$1572 \$405609 \$407607 \$413943 VSS nfet_06v0 L=1U W=5U AS=1.25P AD=2.2P
+ PS=5.5U PD=10.88U
M$1573 \$413957 \$405610 VSS VSS nfet_06v0 L=1U W=5U AS=2.2P AD=1.25P PS=10.88U
+ PD=5.5U
M$1574 \$405610 \$407607 \$413957 VSS nfet_06v0 L=1U W=5U AS=1.25P AD=1.65P
+ PS=5.5U PD=5.66U
M$1575 \$410145 \$410145 \$405610 VSS nfet_06v0 L=1U W=5U AS=1.65P AD=2.2P
+ PS=5.66U PD=10.88U
M$1576 \$406861 \$406860 VSS VSS nfet_06v0 L=1U W=5U AS=2.2P AD=1.3P PS=10.88U
+ PD=5.52U
M$1577 VSS \$406860 \$406861 VSS nfet_06v0 L=1U W=5U AS=1.3P AD=1.3P PS=5.52U
+ PD=5.52U
M$1578 \$406861 \$406860 VSS VSS nfet_06v0 L=1U W=5U AS=1.3P AD=2.2P PS=5.52U
+ PD=10.88U
M$1579 VSS VDD VSS VSS nfet_06v0 L=2U W=9.75U AS=4.29P AD=4.29P PS=20.38U
+ PD=20.38U
M$1580 VSS VDD VSS VSS nfet_06v0 L=2U W=9.75U AS=4.29P AD=4.29P PS=20.38U
+ PD=20.38U
M$1581 \$407608 \$407608 VSS VSS nfet_06v0 L=1U W=1U AS=0.44P AD=0.44P PS=2.88U
+ PD=2.88U
M$1582 \$414180 \$405611 VSS VSS nfet_06v0 L=1U W=5U AS=2.2P AD=1.25P PS=10.88U
+ PD=5.5U
M$1583 \$405611 \$407608 \$414180 VSS nfet_06v0 L=1U W=5U AS=1.25P AD=2.2P
+ PS=5.5U PD=10.88U
M$1584 \$408902 \$424672 VSS VSS nfet_06v0 L=1U W=1U AS=0.44P AD=0.25P PS=2.88U
+ PD=1.5U
M$1585 \$423549 \$424672 \$408902 VSS nfet_06v0 L=1U W=1U AS=0.25P AD=0.44P
+ PS=1.5U PD=2.88U
M$1586 \$408949 \$424672 VSS VSS nfet_06v0 L=1U W=1U AS=0.44P AD=0.25P PS=2.88U
+ PD=1.5U
M$1587 \$424672 \$424672 \$408949 VSS nfet_06v0 L=1U W=1U AS=0.25P AD=0.44P
+ PS=1.5U PD=2.88U
M$1588 \$414273 \$405611 VSS VSS nfet_06v0 L=1U W=5U AS=2.2P AD=1.25P PS=10.88U
+ PD=5.5U
M$1589 \$406862 \$407608 \$414273 VSS nfet_06v0 L=1U W=5U AS=1.25P AD=1.65P
+ PS=5.5U PD=5.66U
M$1590 \$414285 \$407608 \$406862 VSS nfet_06v0 L=1U W=5U AS=1.65P AD=1.25P
+ PS=5.66U PD=5.5U
M$1591 VSS \$405611 \$414285 VSS nfet_06v0 L=1U W=5U AS=1.25P AD=2.2P PS=5.5U
+ PD=10.88U
M$1592 \$406863 \$120600 \$406862 VSS nfet_06v0 L=1U W=5U AS=2.2P AD=1.3P
+ PS=10.88U PD=5.52U
M$1593 \$406862 \$120600 \$406863 VSS nfet_06v0 L=1U W=5U AS=1.3P AD=2.2P
+ PS=5.52U PD=10.88U
M$1594 \$406864 \$205748 \$406862 VSS nfet_06v0 L=1U W=5U AS=2.2P AD=1.3P
+ PS=10.88U PD=5.52U
M$1595 \$406862 \$205748 \$406864 VSS nfet_06v0 L=1U W=5U AS=1.3P AD=2.2P
+ PS=5.52U PD=10.88U
M$1596 \$406866 \$407608 \$406865 VSS nfet_06v0 L=1U W=2.5U AS=1.1P AD=0.65P
+ PS=5.88U PD=3.02U
M$1597 \$406865 \$407608 \$406866 VSS nfet_06v0 L=1U W=2.5U AS=0.65P AD=1.1P
+ PS=3.02U PD=5.88U
M$1598 \$406868 \$407608 \$406867 VSS nfet_06v0 L=1U W=2.5U AS=1.1P AD=0.65P
+ PS=5.88U PD=3.02U
M$1599 \$406867 \$407608 \$406868 VSS nfet_06v0 L=1U W=2.5U AS=0.65P AD=1.1P
+ PS=3.02U PD=5.88U
M$1600 \$406865 \$406866 VSS VSS nfet_06v0 L=1U W=2.5U AS=1.1P AD=0.65P
+ PS=5.88U PD=3.02U
M$1601 VSS \$406866 \$406865 VSS nfet_06v0 L=1U W=2.5U AS=0.65P AD=0.65P
+ PS=3.02U PD=3.02U
M$1602 \$406865 \$406866 VSS VSS nfet_06v0 L=1U W=2.5U AS=0.65P AD=0.65P
+ PS=3.02U PD=3.02U
M$1603 VSS \$406866 \$406865 VSS nfet_06v0 L=1U W=2.5U AS=0.65P AD=1.1P
+ PS=3.02U PD=5.88U
M$1604 \$406867 \$406866 VSS VSS nfet_06v0 L=1U W=2.5U AS=1.1P AD=0.65P
+ PS=5.88U PD=3.02U
M$1605 VSS \$406866 \$406867 VSS nfet_06v0 L=1U W=2.5U AS=0.65P AD=0.65P
+ PS=3.02U PD=3.02U
M$1606 \$406867 \$406866 VSS VSS nfet_06v0 L=1U W=2.5U AS=0.65P AD=0.65P
+ PS=3.02U PD=3.02U
M$1607 VSS \$406866 \$406867 VSS nfet_06v0 L=1U W=2.5U AS=0.65P AD=1.1P
+ PS=3.02U PD=5.88U
M$1608 \$418992 \$410146 \$406866 VSS nfet_06v0 L=1U W=2.5U AS=1.1P AD=1.1P
+ PS=5.88U PD=5.88U
M$1609 \$405612 \$410146 \$406868 VSS nfet_06v0 L=1U W=2.5U AS=1.1P AD=1.1P
+ PS=5.88U PD=5.88U
M$1610 \$414469 \$405611 VSS VSS nfet_06v0 L=1U W=5U AS=2.2P AD=1.25P PS=10.88U
+ PD=5.5U
M$1611 \$405613 \$407608 \$414469 VSS nfet_06v0 L=1U W=5U AS=1.25P AD=2.2P
+ PS=5.5U PD=10.88U
M$1612 \$414479 \$405614 VSS VSS nfet_06v0 L=1U W=5U AS=2.2P AD=1.25P PS=10.88U
+ PD=5.5U
M$1613 \$405614 \$407608 \$414479 VSS nfet_06v0 L=1U W=5U AS=1.25P AD=1.65P
+ PS=5.5U PD=5.66U
M$1614 \$410146 \$410146 \$405614 VSS nfet_06v0 L=1U W=5U AS=1.65P AD=2.2P
+ PS=5.66U PD=10.88U
M$1615 \$406869 \$406868 VSS VSS nfet_06v0 L=1U W=5U AS=2.2P AD=1.3P PS=10.88U
+ PD=5.52U
M$1616 VSS \$406868 \$406869 VSS nfet_06v0 L=1U W=5U AS=1.3P AD=1.3P PS=5.52U
+ PD=5.52U
M$1617 \$406869 \$406868 VSS VSS nfet_06v0 L=1U W=5U AS=1.3P AD=2.2P PS=5.52U
+ PD=10.88U
M$1618 VSS VDD VSS VSS nfet_06v0 L=2U W=9.75U AS=4.29P AD=4.29P PS=20.38U
+ PD=20.38U
M$1619 VSS VDD VSS VSS nfet_06v0 L=2U W=9.75U AS=4.29P AD=4.29P PS=20.38U
+ PD=20.38U
M$1620 \$407609 \$407609 VSS VSS nfet_06v0 L=1U W=1U AS=0.44P AD=0.44P PS=2.88U
+ PD=2.88U
M$1621 \$414698 \$405615 VSS VSS nfet_06v0 L=1U W=5U AS=2.2P AD=1.25P PS=10.88U
+ PD=5.5U
M$1622 \$405615 \$407609 \$414698 VSS nfet_06v0 L=1U W=5U AS=1.25P AD=2.2P
+ PS=5.5U PD=10.88U
M$1623 \$409979 \$424674 VSS VSS nfet_06v0 L=1U W=1U AS=0.44P AD=0.25P PS=2.88U
+ PD=1.5U
M$1624 \$423550 \$424674 \$409979 VSS nfet_06v0 L=1U W=1U AS=0.25P AD=0.44P
+ PS=1.5U PD=2.88U
M$1625 \$410024 \$424674 VSS VSS nfet_06v0 L=1U W=1U AS=0.44P AD=0.25P PS=2.88U
+ PD=1.5U
M$1626 \$424674 \$424674 \$410024 VSS nfet_06v0 L=1U W=1U AS=0.25P AD=0.44P
+ PS=1.5U PD=2.88U
M$1627 \$414768 \$405615 VSS VSS nfet_06v0 L=1U W=5U AS=2.2P AD=1.25P PS=10.88U
+ PD=5.5U
M$1628 \$406870 \$407609 \$414768 VSS nfet_06v0 L=1U W=5U AS=1.25P AD=1.65P
+ PS=5.5U PD=5.66U
M$1629 \$414767 \$407609 \$406870 VSS nfet_06v0 L=1U W=5U AS=1.65P AD=1.25P
+ PS=5.66U PD=5.5U
M$1630 VSS \$405615 \$414767 VSS nfet_06v0 L=1U W=5U AS=1.25P AD=2.2P PS=5.5U
+ PD=10.88U
M$1631 \$406871 \$120600 \$406870 VSS nfet_06v0 L=1U W=5U AS=2.2P AD=1.3P
+ PS=10.88U PD=5.52U
M$1632 \$406870 \$120600 \$406871 VSS nfet_06v0 L=1U W=5U AS=1.3P AD=2.2P
+ PS=5.52U PD=10.88U
M$1633 \$406872 \$120589 \$406870 VSS nfet_06v0 L=1U W=5U AS=2.2P AD=1.3P
+ PS=10.88U PD=5.52U
M$1634 \$406870 \$120589 \$406872 VSS nfet_06v0 L=1U W=5U AS=1.3P AD=2.2P
+ PS=5.52U PD=10.88U
M$1635 \$406874 \$407609 \$406873 VSS nfet_06v0 L=1U W=2.5U AS=1.1P AD=0.65P
+ PS=5.88U PD=3.02U
M$1636 \$406873 \$407609 \$406874 VSS nfet_06v0 L=1U W=2.5U AS=0.65P AD=1.1P
+ PS=3.02U PD=5.88U
M$1637 \$406876 \$407609 \$406875 VSS nfet_06v0 L=1U W=2.5U AS=1.1P AD=0.65P
+ PS=5.88U PD=3.02U
M$1638 \$406875 \$407609 \$406876 VSS nfet_06v0 L=1U W=2.5U AS=0.65P AD=1.1P
+ PS=3.02U PD=5.88U
M$1639 \$406873 \$406874 VSS VSS nfet_06v0 L=1U W=2.5U AS=1.1P AD=0.65P
+ PS=5.88U PD=3.02U
M$1640 VSS \$406874 \$406873 VSS nfet_06v0 L=1U W=2.5U AS=0.65P AD=0.65P
+ PS=3.02U PD=3.02U
M$1641 \$406873 \$406874 VSS VSS nfet_06v0 L=1U W=2.5U AS=0.65P AD=0.65P
+ PS=3.02U PD=3.02U
M$1642 VSS \$406874 \$406873 VSS nfet_06v0 L=1U W=2.5U AS=0.65P AD=1.1P
+ PS=3.02U PD=5.88U
M$1643 \$406875 \$406874 VSS VSS nfet_06v0 L=1U W=2.5U AS=1.1P AD=0.65P
+ PS=5.88U PD=3.02U
M$1644 VSS \$406874 \$406875 VSS nfet_06v0 L=1U W=2.5U AS=0.65P AD=0.65P
+ PS=3.02U PD=3.02U
M$1645 \$406875 \$406874 VSS VSS nfet_06v0 L=1U W=2.5U AS=0.65P AD=0.65P
+ PS=3.02U PD=3.02U
M$1646 VSS \$406874 \$406875 VSS nfet_06v0 L=1U W=2.5U AS=0.65P AD=1.1P
+ PS=3.02U PD=5.88U
M$1647 \$418994 \$410147 \$406874 VSS nfet_06v0 L=1U W=2.5U AS=1.1P AD=1.1P
+ PS=5.88U PD=5.88U
M$1648 \$405616 \$410147 \$406876 VSS nfet_06v0 L=1U W=2.5U AS=1.1P AD=1.1P
+ PS=5.88U PD=5.88U
M$1649 \$414459 \$405615 VSS VSS nfet_06v0 L=1U W=5U AS=2.2P AD=1.25P PS=10.88U
+ PD=5.5U
M$1650 \$405617 \$407609 \$414459 VSS nfet_06v0 L=1U W=5U AS=1.25P AD=2.2P
+ PS=5.5U PD=10.88U
M$1651 \$414420 \$405618 VSS VSS nfet_06v0 L=1U W=5U AS=2.2P AD=1.25P PS=10.88U
+ PD=5.5U
M$1652 \$405618 \$407609 \$414420 VSS nfet_06v0 L=1U W=5U AS=1.25P AD=1.65P
+ PS=5.5U PD=5.66U
M$1653 \$410147 \$410147 \$405618 VSS nfet_06v0 L=1U W=5U AS=1.65P AD=2.2P
+ PS=5.66U PD=10.88U
M$1654 \$406877 \$406876 VSS VSS nfet_06v0 L=1U W=5U AS=2.2P AD=1.3P PS=10.88U
+ PD=5.52U
M$1655 VSS \$406876 \$406877 VSS nfet_06v0 L=1U W=5U AS=1.3P AD=1.3P PS=5.52U
+ PD=5.52U
M$1656 \$406877 \$406876 VSS VSS nfet_06v0 L=1U W=5U AS=1.3P AD=2.2P PS=5.52U
+ PD=10.88U
M$1657 VSS VDD VSS VSS nfet_06v0 L=2U W=9.75U AS=4.29P AD=4.29P PS=20.38U
+ PD=20.38U
M$1658 VSS VDD VSS VSS nfet_06v0 L=2U W=9.75U AS=4.29P AD=4.29P PS=20.38U
+ PD=20.38U
M$1659 \$359044 \$357643 \$359043 VSS nfet_06v0 L=1U W=2.48U AS=1.0912P
+ AD=0.6448P PS=5.84U PD=3U
M$1660 \$359043 \$357643 \$359044 VSS nfet_06v0 L=1U W=2.48U AS=0.6448P
+ AD=1.0912P PS=3U PD=5.84U
M$1661 \$359044 \$344509 \$344510 VSS nfet_06v0 L=1U W=2.48U AS=1.0912P
+ AD=0.6448P PS=5.84U PD=3U
M$1662 \$344510 \$344509 \$359044 VSS nfet_06v0 L=1U W=2.48U AS=0.6448P
+ AD=1.0912P PS=3U PD=5.84U
M$1663 \$359044 \$357644 \$359045 VSS nfet_06v0 L=1U W=2.48U AS=1.0912P
+ AD=0.6448P PS=5.84U PD=3U
M$1664 \$359045 \$357644 \$359044 VSS nfet_06v0 L=1U W=2.48U AS=0.6448P
+ AD=1.0912P PS=3U PD=5.84U
M$1665 \$344510 \$347632 VSS VSS nfet_06v0 L=1U W=1.24U AS=0.5456P AD=0.5456P
+ PS=3.36U PD=3.36U
M$1666 \$359043 \$347632 VSS VSS nfet_06v0 L=1U W=1.24U AS=0.5456P AD=0.5456P
+ PS=3.36U PD=3.36U
M$1667 \$359045 \$347632 VSS VSS nfet_06v0 L=1U W=1.24U AS=0.5456P AD=0.5456P
+ PS=3.36U PD=3.36U
M$1668 \$353238 \$347632 VSS VSS nfet_06v0 L=1U W=0.7U AS=0.308P AD=0.175P
+ PS=2.28U PD=1.2U
M$1669 \$353237 \$347632 \$353238 VSS nfet_06v0 L=1U W=0.7U AS=0.175P AD=0.175P
+ PS=1.2U PD=1.2U
M$1670 \$353236 \$347632 \$353237 VSS nfet_06v0 L=1U W=0.7U AS=0.175P AD=0.175P
+ PS=1.2U PD=1.2U
M$1671 \$347632 \$347632 \$353236 VSS nfet_06v0 L=1U W=0.7U AS=0.175P AD=0.308P
+ PS=1.2U PD=2.28U
M$1672 \$359044 \$359044 \$359046 VSS nfet_06v0 L=1U W=2U AS=0.88P AD=0.52P
+ PS=4.88U PD=2.52U
M$1673 \$359046 \$359044 \$359044 VSS nfet_06v0 L=1U W=2U AS=0.52P AD=0.88P
+ PS=2.52U PD=4.88U
M$1674 \$360417 \$359044 VSS VSS nfet_06v0 L=1U W=2U AS=0.88P AD=0.5P PS=4.88U
+ PD=2.5U
M$1675 \$359046 \$359044 \$360417 VSS nfet_06v0 L=1U W=2U AS=0.5P AD=0.88P
+ PS=2.5U PD=4.88U
M$1676 \$359044 \$357645 \$359047 VSS nfet_06v0 L=1U W=2.48U AS=1.0912P
+ AD=0.6448P PS=5.84U PD=3U
M$1677 \$359047 \$357645 \$359044 VSS nfet_06v0 L=1U W=2.48U AS=0.6448P
+ AD=1.0912P PS=3U PD=5.84U
M$1678 \$359047 \$347632 VSS VSS nfet_06v0 L=1U W=1.24U AS=0.5456P AD=0.5456P
+ PS=3.36U PD=3.36U
M$1679 VSS VDD VSS VSS nfet_06v0 L=2U W=9.75U AS=4.29P AD=4.29P PS=20.38U
+ PD=20.38U
M$1680 \$464245 \$464245 VSS VSS nfet_06v0 L=1U W=1U AS=0.44P AD=0.44P PS=2.88U
+ PD=2.88U
M$1681 \$469157 \$464233 VSS VSS nfet_06v0 L=1U W=5U AS=2.2P AD=1.25P PS=10.88U
+ PD=5.5U
M$1682 \$464233 \$464245 \$469157 VSS nfet_06v0 L=1U W=5U AS=1.25P AD=2.2P
+ PS=5.5U PD=10.88U
M$1683 \$464455 \$482221 VSS VSS nfet_06v0 L=1U W=1U AS=0.44P AD=0.25P PS=2.88U
+ PD=1.5U
M$1684 \$480564 \$482221 \$464455 VSS nfet_06v0 L=1U W=1U AS=0.25P AD=0.44P
+ PS=1.5U PD=2.88U
M$1685 \$464509 \$482221 VSS VSS nfet_06v0 L=1U W=1U AS=0.44P AD=0.25P PS=2.88U
+ PD=1.5U
M$1686 \$482221 \$482221 \$464509 VSS nfet_06v0 L=1U W=1U AS=0.25P AD=0.44P
+ PS=1.5U PD=2.88U
M$1687 \$469334 \$464233 VSS VSS nfet_06v0 L=1U W=5U AS=2.2P AD=1.25P PS=10.88U
+ PD=5.5U
M$1688 \$464246 \$464245 \$469334 VSS nfet_06v0 L=1U W=5U AS=1.25P AD=1.65P
+ PS=5.5U PD=5.66U
M$1689 \$469376 \$464245 \$464246 VSS nfet_06v0 L=1U W=5U AS=1.65P AD=1.25P
+ PS=5.66U PD=5.5U
M$1690 VSS \$464233 \$469376 VSS nfet_06v0 L=1U W=5U AS=1.25P AD=2.2P PS=5.5U
+ PD=10.88U
M$1691 \$464247 \$205759 \$464246 VSS nfet_06v0 L=1U W=5U AS=2.2P AD=1.3P
+ PS=10.88U PD=5.52U
M$1692 \$464246 \$205759 \$464247 VSS nfet_06v0 L=1U W=5U AS=1.3P AD=2.2P
+ PS=5.52U PD=10.88U
M$1693 \$464248 \$205781 \$464246 VSS nfet_06v0 L=1U W=5U AS=2.2P AD=1.3P
+ PS=10.88U PD=5.52U
M$1694 \$464246 \$205781 \$464248 VSS nfet_06v0 L=1U W=5U AS=1.3P AD=2.2P
+ PS=5.52U PD=10.88U
M$1695 \$464250 \$464245 \$464249 VSS nfet_06v0 L=1U W=2.5U AS=1.1P AD=0.65P
+ PS=5.88U PD=3.02U
M$1696 \$464249 \$464245 \$464250 VSS nfet_06v0 L=1U W=2.5U AS=0.65P AD=1.1P
+ PS=3.02U PD=5.88U
M$1697 \$464252 \$464245 \$464251 VSS nfet_06v0 L=1U W=2.5U AS=1.1P AD=0.65P
+ PS=5.88U PD=3.02U
M$1698 \$464251 \$464245 \$464252 VSS nfet_06v0 L=1U W=2.5U AS=0.65P AD=1.1P
+ PS=3.02U PD=5.88U
M$1699 \$464249 \$464250 VSS VSS nfet_06v0 L=1U W=2.5U AS=1.1P AD=0.65P
+ PS=5.88U PD=3.02U
M$1700 VSS \$464250 \$464249 VSS nfet_06v0 L=1U W=2.5U AS=0.65P AD=0.65P
+ PS=3.02U PD=3.02U
M$1701 \$464249 \$464250 VSS VSS nfet_06v0 L=1U W=2.5U AS=0.65P AD=0.65P
+ PS=3.02U PD=3.02U
M$1702 VSS \$464250 \$464249 VSS nfet_06v0 L=1U W=2.5U AS=0.65P AD=1.1P
+ PS=3.02U PD=5.88U
M$1703 \$464251 \$464250 VSS VSS nfet_06v0 L=1U W=2.5U AS=1.1P AD=0.65P
+ PS=5.88U PD=3.02U
M$1704 VSS \$464250 \$464251 VSS nfet_06v0 L=1U W=2.5U AS=0.65P AD=0.65P
+ PS=3.02U PD=3.02U
M$1705 \$464251 \$464250 VSS VSS nfet_06v0 L=1U W=2.5U AS=0.65P AD=0.65P
+ PS=3.02U PD=3.02U
M$1706 VSS \$464250 \$464251 VSS nfet_06v0 L=1U W=2.5U AS=0.65P AD=1.1P
+ PS=3.02U PD=5.88U
M$1707 \$475862 \$468243 \$464250 VSS nfet_06v0 L=1U W=2.5U AS=1.1P AD=1.1P
+ PS=5.88U PD=5.88U
M$1708 \$464234 \$468243 \$464252 VSS nfet_06v0 L=1U W=2.5U AS=1.1P AD=1.1P
+ PS=5.88U PD=5.88U
M$1709 \$469866 \$464233 VSS VSS nfet_06v0 L=1U W=5U AS=2.2P AD=1.25P PS=10.88U
+ PD=5.5U
M$1710 \$464235 \$464245 \$469866 VSS nfet_06v0 L=1U W=5U AS=1.25P AD=2.2P
+ PS=5.5U PD=10.88U
M$1711 \$469914 \$464236 VSS VSS nfet_06v0 L=1U W=5U AS=2.2P AD=1.25P PS=10.88U
+ PD=5.5U
M$1712 \$464236 \$464245 \$469914 VSS nfet_06v0 L=1U W=5U AS=1.25P AD=1.65P
+ PS=5.5U PD=5.66U
M$1713 \$468243 \$468243 \$464236 VSS nfet_06v0 L=1U W=5U AS=1.65P AD=2.2P
+ PS=5.66U PD=10.88U
M$1714 \$464253 \$464252 VSS VSS nfet_06v0 L=1U W=5U AS=2.2P AD=1.3P PS=10.88U
+ PD=5.52U
M$1715 VSS \$464252 \$464253 VSS nfet_06v0 L=1U W=5U AS=1.3P AD=1.3P PS=5.52U
+ PD=5.52U
M$1716 \$464253 \$464252 VSS VSS nfet_06v0 L=1U W=5U AS=1.3P AD=2.2P PS=5.52U
+ PD=10.88U
M$1717 VSS VDD VSS VSS nfet_06v0 L=2U W=9.75U AS=4.29P AD=4.29P PS=20.38U
+ PD=20.38U
M$1718 VSS VDD VSS VSS nfet_06v0 L=2U W=9.75U AS=4.29P AD=4.29P PS=20.38U
+ PD=20.38U
M$1719 \$464254 \$464254 VSS VSS nfet_06v0 L=1U W=1U AS=0.44P AD=0.44P PS=2.88U
+ PD=2.88U
M$1720 \$470251 \$464237 VSS VSS nfet_06v0 L=1U W=5U AS=2.2P AD=1.25P PS=10.88U
+ PD=5.5U
M$1721 \$464237 \$464254 \$470251 VSS nfet_06v0 L=1U W=5U AS=1.25P AD=2.2P
+ PS=5.5U PD=10.88U
M$1722 \$465513 \$482223 VSS VSS nfet_06v0 L=1U W=1U AS=0.44P AD=0.25P PS=2.88U
+ PD=1.5U
M$1723 \$480565 \$482223 \$465513 VSS nfet_06v0 L=1U W=1U AS=0.25P AD=0.44P
+ PS=1.5U PD=2.88U
M$1724 \$465563 \$482223 VSS VSS nfet_06v0 L=1U W=1U AS=0.44P AD=0.25P PS=2.88U
+ PD=1.5U
M$1725 \$482223 \$482223 \$465563 VSS nfet_06v0 L=1U W=1U AS=0.25P AD=0.44P
+ PS=1.5U PD=2.88U
M$1726 \$470379 \$464237 VSS VSS nfet_06v0 L=1U W=5U AS=2.2P AD=1.25P PS=10.88U
+ PD=5.5U
M$1727 \$464255 \$464254 \$470379 VSS nfet_06v0 L=1U W=5U AS=1.25P AD=1.65P
+ PS=5.5U PD=5.66U
M$1728 \$470408 \$464254 \$464255 VSS nfet_06v0 L=1U W=5U AS=1.65P AD=1.25P
+ PS=5.66U PD=5.5U
M$1729 VSS \$464237 \$470408 VSS nfet_06v0 L=1U W=5U AS=1.25P AD=2.2P PS=5.5U
+ PD=10.88U
M$1730 \$464256 \$205770 \$464255 VSS nfet_06v0 L=1U W=5U AS=2.2P AD=1.3P
+ PS=10.88U PD=5.52U
M$1731 \$464255 \$205770 \$464256 VSS nfet_06v0 L=1U W=5U AS=1.3P AD=2.2P
+ PS=5.52U PD=10.88U
M$1732 \$464257 \$205781 \$464255 VSS nfet_06v0 L=1U W=5U AS=2.2P AD=1.3P
+ PS=10.88U PD=5.52U
M$1733 \$464255 \$205781 \$464257 VSS nfet_06v0 L=1U W=5U AS=1.3P AD=2.2P
+ PS=5.52U PD=10.88U
M$1734 \$464259 \$464254 \$464258 VSS nfet_06v0 L=1U W=2.5U AS=1.1P AD=0.65P
+ PS=5.88U PD=3.02U
M$1735 \$464258 \$464254 \$464259 VSS nfet_06v0 L=1U W=2.5U AS=0.65P AD=1.1P
+ PS=3.02U PD=5.88U
M$1736 \$464261 \$464254 \$464260 VSS nfet_06v0 L=1U W=2.5U AS=1.1P AD=0.65P
+ PS=5.88U PD=3.02U
M$1737 \$464260 \$464254 \$464261 VSS nfet_06v0 L=1U W=2.5U AS=0.65P AD=1.1P
+ PS=3.02U PD=5.88U
M$1738 \$464258 \$464259 VSS VSS nfet_06v0 L=1U W=2.5U AS=1.1P AD=0.65P
+ PS=5.88U PD=3.02U
M$1739 VSS \$464259 \$464258 VSS nfet_06v0 L=1U W=2.5U AS=0.65P AD=0.65P
+ PS=3.02U PD=3.02U
M$1740 \$464258 \$464259 VSS VSS nfet_06v0 L=1U W=2.5U AS=0.65P AD=0.65P
+ PS=3.02U PD=3.02U
M$1741 VSS \$464259 \$464258 VSS nfet_06v0 L=1U W=2.5U AS=0.65P AD=1.1P
+ PS=3.02U PD=5.88U
M$1742 \$464260 \$464259 VSS VSS nfet_06v0 L=1U W=2.5U AS=1.1P AD=0.65P
+ PS=5.88U PD=3.02U
M$1743 VSS \$464259 \$464260 VSS nfet_06v0 L=1U W=2.5U AS=0.65P AD=0.65P
+ PS=3.02U PD=3.02U
M$1744 \$464260 \$464259 VSS VSS nfet_06v0 L=1U W=2.5U AS=0.65P AD=0.65P
+ PS=3.02U PD=3.02U
M$1745 VSS \$464259 \$464260 VSS nfet_06v0 L=1U W=2.5U AS=0.65P AD=1.1P
+ PS=3.02U PD=5.88U
M$1746 \$475864 \$468244 \$464259 VSS nfet_06v0 L=1U W=2.5U AS=1.1P AD=1.1P
+ PS=5.88U PD=5.88U
M$1747 \$464238 \$468244 \$464261 VSS nfet_06v0 L=1U W=2.5U AS=1.1P AD=1.1P
+ PS=5.88U PD=5.88U
M$1748 \$470840 \$464237 VSS VSS nfet_06v0 L=1U W=5U AS=2.2P AD=1.25P PS=10.88U
+ PD=5.5U
M$1749 \$464239 \$464254 \$470840 VSS nfet_06v0 L=1U W=5U AS=1.25P AD=2.2P
+ PS=5.5U PD=10.88U
M$1750 \$470892 \$464240 VSS VSS nfet_06v0 L=1U W=5U AS=2.2P AD=1.25P PS=10.88U
+ PD=5.5U
M$1751 \$464240 \$464254 \$470892 VSS nfet_06v0 L=1U W=5U AS=1.25P AD=1.65P
+ PS=5.5U PD=5.66U
M$1752 \$468244 \$468244 \$464240 VSS nfet_06v0 L=1U W=5U AS=1.65P AD=2.2P
+ PS=5.66U PD=10.88U
M$1753 \$464262 \$464261 VSS VSS nfet_06v0 L=1U W=5U AS=2.2P AD=1.3P PS=10.88U
+ PD=5.52U
M$1754 VSS \$464261 \$464262 VSS nfet_06v0 L=1U W=5U AS=1.3P AD=1.3P PS=5.52U
+ PD=5.52U
M$1755 \$464262 \$464261 VSS VSS nfet_06v0 L=1U W=5U AS=1.3P AD=2.2P PS=5.52U
+ PD=10.88U
M$1756 VSS VDD VSS VSS nfet_06v0 L=2U W=9.75U AS=4.29P AD=4.29P PS=20.38U
+ PD=20.38U
M$1757 VSS VDD VSS VSS nfet_06v0 L=2U W=9.75U AS=4.29P AD=4.29P PS=20.38U
+ PD=20.38U
M$1758 \$464263 \$464263 VSS VSS nfet_06v0 L=1U W=1U AS=0.44P AD=0.44P PS=2.88U
+ PD=2.88U
M$1759 \$471242 \$464241 VSS VSS nfet_06v0 L=1U W=5U AS=2.2P AD=1.25P PS=10.88U
+ PD=5.5U
M$1760 \$464241 \$464263 \$471242 VSS nfet_06v0 L=1U W=5U AS=1.25P AD=2.2P
+ PS=5.5U PD=10.88U
M$1761 \$466479 \$482225 VSS VSS nfet_06v0 L=1U W=1U AS=0.44P AD=0.25P PS=2.88U
+ PD=1.5U
M$1762 \$480566 \$482225 \$466479 VSS nfet_06v0 L=1U W=1U AS=0.25P AD=0.44P
+ PS=1.5U PD=2.88U
M$1763 \$466420 \$482225 VSS VSS nfet_06v0 L=1U W=1U AS=0.44P AD=0.25P PS=2.88U
+ PD=1.5U
M$1764 \$482225 \$482225 \$466420 VSS nfet_06v0 L=1U W=1U AS=0.25P AD=0.44P
+ PS=1.5U PD=2.88U
M$1765 \$471391 \$464241 VSS VSS nfet_06v0 L=1U W=5U AS=2.2P AD=1.25P PS=10.88U
+ PD=5.5U
M$1766 \$464264 \$464263 \$471391 VSS nfet_06v0 L=1U W=5U AS=1.25P AD=1.65P
+ PS=5.5U PD=5.66U
M$1767 \$471425 \$464263 \$464264 VSS nfet_06v0 L=1U W=5U AS=1.65P AD=1.25P
+ PS=5.66U PD=5.5U
M$1768 VSS \$464241 \$471425 VSS nfet_06v0 L=1U W=5U AS=1.25P AD=2.2P PS=5.5U
+ PD=10.88U
M$1769 \$464265 \$205770 \$464264 VSS nfet_06v0 L=1U W=5U AS=2.2P AD=1.3P
+ PS=10.88U PD=5.52U
M$1770 \$464264 \$205770 \$464265 VSS nfet_06v0 L=1U W=5U AS=1.3P AD=2.2P
+ PS=5.52U PD=10.88U
M$1771 \$464266 \$205759 \$464264 VSS nfet_06v0 L=1U W=5U AS=2.2P AD=1.3P
+ PS=10.88U PD=5.52U
M$1772 \$464264 \$205759 \$464266 VSS nfet_06v0 L=1U W=5U AS=1.3P AD=2.2P
+ PS=5.52U PD=10.88U
M$1773 \$464268 \$464263 \$464267 VSS nfet_06v0 L=1U W=2.5U AS=1.1P AD=0.65P
+ PS=5.88U PD=3.02U
M$1774 \$464267 \$464263 \$464268 VSS nfet_06v0 L=1U W=2.5U AS=0.65P AD=1.1P
+ PS=3.02U PD=5.88U
M$1775 \$464270 \$464263 \$464269 VSS nfet_06v0 L=1U W=2.5U AS=1.1P AD=0.65P
+ PS=5.88U PD=3.02U
M$1776 \$464269 \$464263 \$464270 VSS nfet_06v0 L=1U W=2.5U AS=0.65P AD=1.1P
+ PS=3.02U PD=5.88U
M$1777 \$464267 \$464268 VSS VSS nfet_06v0 L=1U W=2.5U AS=1.1P AD=0.65P
+ PS=5.88U PD=3.02U
M$1778 VSS \$464268 \$464267 VSS nfet_06v0 L=1U W=2.5U AS=0.65P AD=0.65P
+ PS=3.02U PD=3.02U
M$1779 \$464267 \$464268 VSS VSS nfet_06v0 L=1U W=2.5U AS=0.65P AD=0.65P
+ PS=3.02U PD=3.02U
M$1780 VSS \$464268 \$464267 VSS nfet_06v0 L=1U W=2.5U AS=0.65P AD=1.1P
+ PS=3.02U PD=5.88U
M$1781 \$464269 \$464268 VSS VSS nfet_06v0 L=1U W=2.5U AS=1.1P AD=0.65P
+ PS=5.88U PD=3.02U
M$1782 VSS \$464268 \$464269 VSS nfet_06v0 L=1U W=2.5U AS=0.65P AD=0.65P
+ PS=3.02U PD=3.02U
M$1783 \$464269 \$464268 VSS VSS nfet_06v0 L=1U W=2.5U AS=0.65P AD=0.65P
+ PS=3.02U PD=3.02U
M$1784 VSS \$464268 \$464269 VSS nfet_06v0 L=1U W=2.5U AS=0.65P AD=1.1P
+ PS=3.02U PD=5.88U
M$1785 \$475866 \$468245 \$464268 VSS nfet_06v0 L=1U W=2.5U AS=1.1P AD=1.1P
+ PS=5.88U PD=5.88U
M$1786 \$464242 \$468245 \$464270 VSS nfet_06v0 L=1U W=2.5U AS=1.1P AD=1.1P
+ PS=5.88U PD=5.88U
M$1787 \$471974 \$464241 VSS VSS nfet_06v0 L=1U W=5U AS=2.2P AD=1.25P PS=10.88U
+ PD=5.5U
M$1788 \$464243 \$464263 \$471974 VSS nfet_06v0 L=1U W=5U AS=1.25P AD=2.2P
+ PS=5.5U PD=10.88U
M$1789 \$472034 \$464244 VSS VSS nfet_06v0 L=1U W=5U AS=2.2P AD=1.25P PS=10.88U
+ PD=5.5U
M$1790 \$464244 \$464263 \$472034 VSS nfet_06v0 L=1U W=5U AS=1.25P AD=1.65P
+ PS=5.5U PD=5.66U
M$1791 \$468245 \$468245 \$464244 VSS nfet_06v0 L=1U W=5U AS=1.65P AD=2.2P
+ PS=5.66U PD=10.88U
M$1792 \$464271 \$464270 VSS VSS nfet_06v0 L=1U W=5U AS=2.2P AD=1.3P PS=10.88U
+ PD=5.52U
M$1793 VSS \$464270 \$464271 VSS nfet_06v0 L=1U W=5U AS=1.3P AD=1.3P PS=5.52U
+ PD=5.52U
M$1794 \$464271 \$464270 VSS VSS nfet_06v0 L=1U W=5U AS=1.3P AD=2.2P PS=5.52U
+ PD=10.88U
M$1795 VSS VDD VSS VSS nfet_06v0 L=2U W=9.75U AS=4.29P AD=4.29P PS=20.38U
+ PD=20.38U
M$1796 VSS VDD VSS VSS nfet_06v0 L=2U W=9.75U AS=4.29P AD=4.29P PS=20.38U
+ PD=20.38U
M$1797 \$417194 \$404362 \$404363 VSS nfet_06v0 L=1U W=2.48U AS=1.0912P
+ AD=0.6448P PS=5.84U PD=3U
M$1798 \$404363 \$404362 \$417194 VSS nfet_06v0 L=1U W=2.48U AS=0.6448P
+ AD=1.0912P PS=3U PD=5.84U
M$1799 \$417194 \$416190 \$416189 VSS nfet_06v0 L=1U W=2.48U AS=1.0912P
+ AD=0.6448P PS=5.84U PD=3U
M$1800 \$416189 \$416190 \$417194 VSS nfet_06v0 L=1U W=2.48U AS=0.6448P
+ AD=1.0912P PS=3U PD=5.84U
M$1801 \$417194 \$416192 \$416191 VSS nfet_06v0 L=1U W=2.48U AS=1.0912P
+ AD=0.6448P PS=5.84U PD=3U
M$1802 \$416191 \$416192 \$417194 VSS nfet_06v0 L=1U W=2.48U AS=0.6448P
+ AD=1.0912P PS=3U PD=5.84U
M$1803 \$404363 \$405619 VSS VSS nfet_06v0 L=1U W=1.24U AS=0.5456P AD=0.5456P
+ PS=3.36U PD=3.36U
M$1804 \$416189 \$405619 VSS VSS nfet_06v0 L=1U W=1.24U AS=0.5456P AD=0.5456P
+ PS=3.36U PD=3.36U
M$1805 \$416191 \$405619 VSS VSS nfet_06v0 L=1U W=1.24U AS=0.5456P AD=0.5456P
+ PS=3.36U PD=3.36U
M$1806 \$410592 \$405619 VSS VSS nfet_06v0 L=1U W=0.7U AS=0.308P AD=0.175P
+ PS=2.28U PD=1.2U
M$1807 \$410576 \$405619 \$410592 VSS nfet_06v0 L=1U W=0.7U AS=0.175P AD=0.175P
+ PS=1.2U PD=1.2U
M$1808 \$410556 \$405619 \$410576 VSS nfet_06v0 L=1U W=0.7U AS=0.175P AD=0.175P
+ PS=1.2U PD=1.2U
M$1809 \$405619 \$405619 \$410556 VSS nfet_06v0 L=1U W=0.7U AS=0.175P AD=0.308P
+ PS=1.2U PD=2.28U
M$1810 \$417194 \$417194 \$416193 VSS nfet_06v0 L=1U W=2U AS=0.88P AD=0.52P
+ PS=4.88U PD=2.52U
M$1811 \$416193 \$417194 \$417194 VSS nfet_06v0 L=1U W=2U AS=0.52P AD=0.88P
+ PS=2.52U PD=4.88U
M$1812 \$419451 \$417194 VSS VSS nfet_06v0 L=1U W=2U AS=0.88P AD=0.5P PS=4.88U
+ PD=2.5U
M$1813 \$416193 \$417194 \$419451 VSS nfet_06v0 L=1U W=2U AS=0.5P AD=0.88P
+ PS=2.5U PD=4.88U
M$1814 \$417194 \$416195 \$416194 VSS nfet_06v0 L=1U W=2.48U AS=1.0912P
+ AD=0.6448P PS=5.84U PD=3U
M$1815 \$416194 \$416195 \$417194 VSS nfet_06v0 L=1U W=2.48U AS=0.6448P
+ AD=1.0912P PS=3U PD=5.84U
M$1816 \$416194 \$405619 VSS VSS nfet_06v0 L=1U W=1.24U AS=0.5456P AD=0.5456P
+ PS=3.36U PD=3.36U
M$1817 VSS VDD VSS VSS nfet_06v0 L=2U W=2U AS=0.88P AD=0.88P PS=4.88U PD=4.88U
M$1818 VSS VDD VSS VSS nfet_06v0 L=2U W=9.75U AS=4.29P AD=4.29P PS=20.38U
+ PD=20.38U
M$1819 VSS VDD VSS VSS nfet_06v0 L=2U W=2U AS=0.88P AD=0.88P PS=4.88U PD=4.88U
M$1820 VSS VDD VSS VSS nfet_06v0 L=2U W=2U AS=0.88P AD=0.88P PS=4.88U PD=4.88U
M$1821 VSS VDD VSS VSS nfet_06v0 L=2U W=2U AS=0.88P AD=0.88P PS=4.88U PD=4.88U
M$1822 VSS VDD VSS VSS nfet_06v0 L=2U W=2U AS=0.88P AD=0.88P PS=4.88U PD=4.88U
M$1823 VSS VDD VSS VSS nfet_06v0 L=2U W=2U AS=0.88P AD=0.88P PS=4.88U PD=4.88U
M$1824 VSS VDD VSS VSS nfet_06v0 L=2U W=2U AS=0.88P AD=0.88P PS=4.88U PD=4.88U
M$1825 VSS VDD VSS VSS nfet_06v0 L=2U W=2U AS=0.88P AD=0.88P PS=4.88U PD=4.88U
M$1826 VSS VDD VSS VSS nfet_06v0 L=2U W=2U AS=0.88P AD=0.88P PS=4.88U PD=4.88U
M$1827 VSS VDD VSS VSS nfet_06v0 L=2U W=2U AS=0.88P AD=0.88P PS=4.88U PD=4.88U
M$1828 \$416195 \$288720 VSS VSS nfet_06v0 L=1U W=1U AS=0.44P AD=0.33P PS=2.88U
+ PD=1.66U
M$1829 VSS \$288708 \$416195 VSS nfet_06v0 L=1U W=1U AS=0.33P AD=0.44P PS=1.66U
+ PD=2.88U
M$1830 VSS \$288696 \$562732 VSS nfet_06v0 L=1U W=1U AS=0.44P AD=0.44P PS=2.88U
+ PD=2.88U
M$1831 VSS VDD VSS VSS nfet_06v0 L=2U W=9.75U AS=4.29P AD=4.29P PS=20.38U
+ PD=20.38U
M$1832 VSS \$565111 \$357645 VSS nfet_06v0 L=1U W=1U AS=0.44P AD=0.44P PS=2.88U
+ PD=2.88U
M$1833 VSS VDD VSS VSS nfet_06v0 L=2U W=9.75U AS=4.29P AD=4.29P PS=20.38U
+ PD=20.38U
M$1834 \$563917 \$562732 \$565111 VSS nfet_06v0 L=1U W=1U AS=0.44P AD=0.25P
+ PS=2.88U PD=1.5U
M$1835 VSS \$288720 \$563917 VSS nfet_06v0 L=1U W=1U AS=0.25P AD=0.44P PS=1.5U
+ PD=2.88U
M$1836 VSS \$565112 \$299174 VSS nfet_06v0 L=1U W=1U AS=0.44P AD=0.44P PS=2.88U
+ PD=2.88U
M$1837 \$563999 \$288708 \$565112 VSS nfet_06v0 L=1U W=1U AS=0.44P AD=0.25P
+ PS=2.88U PD=1.5U
M$1838 VSS \$288696 \$563999 VSS nfet_06v0 L=1U W=1U AS=0.25P AD=0.44P PS=1.5U
+ PD=2.88U
M$1839 VSS VDD VSS VSS nfet_06v0 L=2U W=2U AS=0.88P AD=0.88P PS=4.88U PD=4.88U
M$1840 VSS VDD VSS VSS nfet_06v0 L=2U W=1.5U AS=0.66P AD=0.66P PS=3.88U PD=3.88U
M$1841 VSS VDD VSS VSS nfet_06v0 L=2U W=2U AS=0.88P AD=0.88P PS=4.88U PD=4.88U
M$1842 VSS VDD VSS VSS nfet_06v0 L=2U W=1.5U AS=0.66P AD=0.66P PS=3.88U PD=3.88U
M$1843 \$416192 \$347631 VSS VSS nfet_06v0 L=1U W=1U AS=0.44P AD=0.33P PS=2.88U
+ PD=1.66U
M$1844 VSS \$347619 \$416192 VSS nfet_06v0 L=1U W=1U AS=0.33P AD=0.44P PS=1.66U
+ PD=2.88U
M$1845 VSS \$347607 \$562733 VSS nfet_06v0 L=1U W=1U AS=0.44P AD=0.44P PS=2.88U
+ PD=2.88U
M$1846 VSS \$565113 \$357644 VSS nfet_06v0 L=1U W=1U AS=0.44P AD=0.44P PS=2.88U
+ PD=2.88U
M$1847 \$564314 \$562733 \$565113 VSS nfet_06v0 L=1U W=1U AS=0.44P AD=0.25P
+ PS=2.88U PD=1.5U
M$1848 VSS \$347631 \$564314 VSS nfet_06v0 L=1U W=1U AS=0.25P AD=0.44P PS=1.5U
+ PD=2.88U
M$1849 VSS \$565114 \$299173 VSS nfet_06v0 L=1U W=1U AS=0.44P AD=0.44P PS=2.88U
+ PD=2.88U
M$1850 \$564382 \$347619 \$565114 VSS nfet_06v0 L=1U W=1U AS=0.44P AD=0.25P
+ PS=2.88U PD=1.5U
M$1851 VSS \$347607 \$564382 VSS nfet_06v0 L=1U W=1U AS=0.25P AD=0.44P PS=1.5U
+ PD=2.88U
M$1852 VSS VDD VSS VSS nfet_06v0 L=2U W=2U AS=0.88P AD=0.88P PS=4.88U PD=4.88U
M$1853 VSS VDD VSS VSS nfet_06v0 L=2U W=1.5U AS=0.66P AD=0.66P PS=3.88U PD=3.88U
M$1854 VSS VDD VSS VSS nfet_06v0 L=2U W=2U AS=0.88P AD=0.88P PS=4.88U PD=4.88U
M$1855 VSS VDD VSS VSS nfet_06v0 L=2U W=1.5U AS=0.66P AD=0.66P PS=3.88U PD=3.88U
M$1856 \$404362 \$406877 VSS VSS nfet_06v0 L=1U W=1U AS=0.44P AD=0.33P PS=2.88U
+ PD=1.66U
M$1857 VSS \$406869 \$404362 VSS nfet_06v0 L=1U W=1U AS=0.33P AD=0.44P PS=1.66U
+ PD=2.88U
M$1858 VSS \$406861 \$562734 VSS nfet_06v0 L=1U W=1U AS=0.44P AD=0.44P PS=2.88U
+ PD=2.88U
M$1859 VSS \$565115 \$344509 VSS nfet_06v0 L=1U W=1U AS=0.44P AD=0.44P PS=2.88U
+ PD=2.88U
M$1860 \$564682 \$562734 \$565115 VSS nfet_06v0 L=1U W=1U AS=0.44P AD=0.25P
+ PS=2.88U PD=1.5U
M$1861 VSS \$406877 \$564682 VSS nfet_06v0 L=1U W=1U AS=0.25P AD=0.44P PS=1.5U
+ PD=2.88U
M$1862 VSS \$565116 \$287456 VSS nfet_06v0 L=1U W=1U AS=0.44P AD=0.44P PS=2.88U
+ PD=2.88U
M$1863 \$564758 \$406869 \$565116 VSS nfet_06v0 L=1U W=1U AS=0.44P AD=0.25P
+ PS=2.88U PD=1.5U
M$1864 VSS \$406861 \$564758 VSS nfet_06v0 L=1U W=1U AS=0.25P AD=0.44P PS=1.5U
+ PD=2.88U
M$1865 VSS VDD VSS VSS nfet_06v0 L=2U W=9.75U AS=4.29P AD=4.29P PS=20.38U
+ PD=20.38U
M$1866 VSS VDD VSS VSS nfet_06v0 L=2U W=9.75U AS=4.29P AD=4.29P PS=20.38U
+ PD=20.38U
M$1867 VSS VDD VSS VSS nfet_06v0 L=2U W=2U AS=0.88P AD=0.88P PS=4.88U PD=4.88U
M$1868 VSS VDD VSS VSS nfet_06v0 L=2U W=1.5U AS=0.66P AD=0.66P PS=3.88U PD=3.88U
M$1869 VSS VDD VSS VSS nfet_06v0 L=2U W=2U AS=0.88P AD=0.88P PS=4.88U PD=4.88U
M$1870 VSS VDD VSS VSS nfet_06v0 L=2U W=1.5U AS=0.66P AD=0.66P PS=3.88U PD=3.88U
M$1871 \$416190 \$464271 VSS VSS nfet_06v0 L=1U W=1U AS=0.44P AD=0.33P PS=2.88U
+ PD=1.66U
M$1872 VSS \$464262 \$416190 VSS nfet_06v0 L=1U W=1U AS=0.33P AD=0.44P PS=1.66U
+ PD=2.88U
M$1873 VSS \$464253 \$562735 VSS nfet_06v0 L=1U W=1U AS=0.44P AD=0.44P PS=2.88U
+ PD=2.88U
M$1874 VSS \$565117 \$357643 VSS nfet_06v0 L=1U W=1U AS=0.44P AD=0.44P PS=2.88U
+ PD=2.88U
M$1875 \$565076 \$562735 \$565117 VSS nfet_06v0 L=1U W=1U AS=0.44P AD=0.25P
+ PS=2.88U PD=1.5U
M$1876 VSS \$464271 \$565076 VSS nfet_06v0 L=1U W=1U AS=0.25P AD=0.44P PS=1.5U
+ PD=2.88U
M$1877 VSS \$565118 \$299172 VSS nfet_06v0 L=1U W=1U AS=0.44P AD=0.44P PS=2.88U
+ PD=2.88U
M$1878 \$565075 \$464262 \$565118 VSS nfet_06v0 L=1U W=1U AS=0.44P AD=0.25P
+ PS=2.88U PD=1.5U
M$1879 VSS \$464253 \$565075 VSS nfet_06v0 L=1U W=1U AS=0.25P AD=0.44P PS=1.5U
+ PD=2.88U
M$1880 VSS VDD VSS VSS nfet_06v0 L=2U W=2U AS=0.88P AD=0.88P PS=4.88U PD=4.88U
M$1881 VSS VDD VSS VSS nfet_06v0 L=2U W=2U AS=0.88P AD=0.88P PS=4.88U PD=4.88U
M$1882 VSS VDD VSS VSS nfet_06v0 L=2U W=1.5U AS=0.66P AD=0.66P PS=3.88U PD=3.88U
M$1883 VSS VDD VSS VSS nfet_06v0 L=2U W=1.5U AS=0.66P AD=0.66P PS=3.88U PD=3.88U
M$1884 VSS VDD VSS VSS nfet_06v0 L=2U W=1.5U AS=0.66P AD=0.66P PS=3.88U PD=3.88U
M$1885 VSS VDD VSS VSS nfet_06v0 L=2U W=1.5U AS=0.66P AD=0.66P PS=3.88U PD=3.88U
M$1886 VSS VDD VSS VSS nfet_06v0 L=2U W=1.5U AS=0.66P AD=0.66P PS=3.88U PD=3.88U
M$1887 VSS VDD VSS VSS nfet_06v0 L=2U W=1.5U AS=0.66P AD=0.66P PS=3.88U PD=3.88U
M$1888 VSS VDD VSS VSS nfet_06v0 L=2U W=1.5U AS=0.66P AD=0.66P PS=3.88U PD=3.88U
M$1889 VSS VDD VSS VSS nfet_06v0 L=2U W=1.5U AS=0.66P AD=0.66P PS=3.88U PD=3.88U
M$1890 VSS VDD VSS VSS nfet_06v0 L=2U W=1.5U AS=0.66P AD=0.66P PS=3.88U PD=3.88U
M$1891 VSS VDD VSS VSS nfet_06v0 L=2U W=2U AS=0.88P AD=0.88P PS=4.88U PD=4.88U
M$1892 VSS VDD VSS VSS nfet_06v0 L=2U W=1.5U AS=0.66P AD=0.66P PS=3.88U PD=3.88U
M$1893 VSS VDD VSS VSS nfet_06v0 L=2U W=2U AS=0.88P AD=0.88P PS=4.88U PD=4.88U
M$1894 VSS VDD VSS VSS nfet_06v0 L=2U W=1.5U AS=0.66P AD=0.66P PS=3.88U PD=3.88U
M$1895 VSS VDD VSS VSS nfet_06v0 L=2U W=1.5U AS=0.66P AD=0.66P PS=3.88U PD=3.88U
M$1896 VSS VDD VSS VSS nfet_06v0 L=2U W=9.75U AS=4.29P AD=4.29P PS=20.38U
+ PD=20.38U
M$1897 VSS VDD VSS VSS nfet_06v0 L=2U W=1.5U AS=0.66P AD=0.66P PS=3.88U PD=3.88U
M$1898 VSS VDD VSS VSS nfet_06v0 L=2U W=9.75U AS=4.29P AD=4.29P PS=20.38U
+ PD=20.38U
M$1899 VSS VDD VSS VSS nfet_06v0 L=2U W=1.5U AS=0.66P AD=0.66P PS=3.88U PD=3.88U
M$1900 VSS VDD VSS VSS nfet_06v0 L=2U W=1.5U AS=0.66P AD=0.66P PS=3.88U PD=3.88U
M$1901 VSS VDD VSS VSS nfet_06v0 L=2U W=1.5U AS=0.66P AD=0.66P PS=3.88U PD=3.88U
M$1902 VSS VDD VSS VSS nfet_06v0 L=2U W=1.5U AS=0.66P AD=0.66P PS=3.88U PD=3.88U
M$1903 VSS VDD VSS VSS nfet_06v0 L=2U W=1.5U AS=0.66P AD=0.66P PS=3.88U PD=3.88U
M$1904 VSS VDD VSS VSS nfet_06v0 L=2U W=2U AS=0.88P AD=0.88P PS=4.88U PD=4.88U
M$1905 VSS VDD VSS VSS nfet_06v0 L=2U W=1.5U AS=0.66P AD=0.66P PS=3.88U PD=3.88U
M$1906 VSS VDD VSS VSS nfet_06v0 L=2U W=2U AS=0.88P AD=0.88P PS=4.88U PD=4.88U
M$1907 VSS VDD VSS VSS nfet_06v0 L=2U W=1.5U AS=0.66P AD=0.66P PS=3.88U PD=3.88U
M$1908 VSS VDD VSS VSS nfet_06v0 L=2U W=2U AS=0.88P AD=0.88P PS=4.88U PD=4.88U
M$1909 VSS VDD VSS VSS nfet_06v0 L=2U W=1.5U AS=0.66P AD=0.66P PS=3.88U PD=3.88U
M$1910 VSS VDD VSS VSS nfet_06v0 L=2U W=2U AS=0.88P AD=0.88P PS=4.88U PD=4.88U
M$1911 VSS VDD VSS VSS nfet_06v0 L=2U W=2U AS=0.88P AD=0.88P PS=4.88U PD=4.88U
M$1912 VSS VDD VSS VSS nfet_06v0 L=2U W=1.5U AS=0.66P AD=0.66P PS=3.88U PD=3.88U
M$1913 VSS VDD VSS VSS nfet_06v0 L=2U W=2U AS=0.88P AD=0.88P PS=4.88U PD=4.88U
M$1914 VSS VDD VSS VSS nfet_06v0 L=2U W=2U AS=0.88P AD=0.88P PS=4.88U PD=4.88U
M$1915 VSS VDD VSS VSS nfet_06v0 L=2U W=1.5U AS=0.66P AD=0.66P PS=3.88U PD=3.88U
M$1916 VSS VDD VSS VSS nfet_06v0 L=2U W=2U AS=0.88P AD=0.88P PS=4.88U PD=4.88U
M$1917 VSS VDD VSS VSS nfet_06v0 L=2U W=2U AS=0.88P AD=0.88P PS=4.88U PD=4.88U
M$1918 VSS VDD VSS VSS nfet_06v0 L=2U W=1.5U AS=0.66P AD=0.66P PS=3.88U PD=3.88U
M$1919 VSS VDD VSS VSS nfet_06v0 L=2U W=2U AS=0.88P AD=0.88P PS=4.88U PD=4.88U
M$1920 VSS VDD VSS VSS nfet_06v0 L=2U W=2U AS=0.88P AD=0.88P PS=4.88U PD=4.88U
M$1921 VSS VDD VSS VSS nfet_06v0 L=2U W=1.5U AS=0.66P AD=0.66P PS=3.88U PD=3.88U
M$1922 VSS VDD VSS VSS nfet_06v0 L=2U W=2U AS=0.88P AD=0.88P PS=4.88U PD=4.88U
M$1923 VSS VDD VSS VSS nfet_06v0 L=2U W=2U AS=0.88P AD=0.88P PS=4.88U PD=4.88U
D$1924 VSS S3P diode_nd2ps_06v0 A=50P P=30U
D$1925 VSS S2P diode_nd2ps_06v0 A=50P P=30U
D$1926 VSS S2P diode_nd2ps_06v0 A=50P P=30U
D$1927 VSS S2N diode_nd2ps_06v0 A=50P P=30U
D$1928 VSS Z diode_nd2ps_06v0 A=50P P=30U
D$1929 VSS Z diode_nd2ps_06v0 A=50P P=30U
D$1930 VSS Y diode_nd2ps_06v0 A=50P P=30U
D$1931 VSS X diode_nd2ps_06v0 A=50P P=30U
D$1932 VSS Y diode_nd2ps_06v0 A=50P P=30U
D$1933 VSS S4N diode_nd2ps_06v0 A=50P P=30U
D$1934 VSS S3P diode_nd2ps_06v0 A=50P P=30U
D$1935 VSS S1N diode_nd2ps_06v0 A=50P P=30U
D$1936 VSS X diode_nd2ps_06v0 A=50P P=30U
D$1937 VSS S4P diode_nd2ps_06v0 A=50P P=30U
D$1938 VSS S4P diode_nd2ps_06v0 A=50P P=30U
D$1939 VSS S3N diode_nd2ps_06v0 A=50P P=30U
D$1940 VSS S2N diode_nd2ps_06v0 A=50P P=30U
D$1941 VSS S1N diode_nd2ps_06v0 A=50P P=30U
D$1942 VSS S1P diode_nd2ps_06v0 A=50P P=30U
D$1943 VSS S4N diode_nd2ps_06v0 A=50P P=30U
D$1944 VSS S3N diode_nd2ps_06v0 A=50P P=30U
D$1945 VSS S1P diode_nd2ps_06v0 A=50P P=30U
D$1946 S1N VDD diode_pd2nw_06v0 A=50P P=30U
D$1947 S1N VDD diode_pd2nw_06v0 A=50P P=30U
D$1948 Y VDD diode_pd2nw_06v0 A=50P P=30U
D$1949 S1P VDD diode_pd2nw_06v0 A=50P P=30U
D$1950 S1P VDD diode_pd2nw_06v0 A=50P P=30U
D$1951 Y VDD diode_pd2nw_06v0 A=50P P=30U
D$1952 Z VDD diode_pd2nw_06v0 A=50P P=30U
D$1953 S2N VDD diode_pd2nw_06v0 A=50P P=30U
D$1954 S2N VDD diode_pd2nw_06v0 A=50P P=30U
D$1955 Z VDD diode_pd2nw_06v0 A=50P P=30U
D$1956 S2P VDD diode_pd2nw_06v0 A=50P P=30U
D$1957 S2P VDD diode_pd2nw_06v0 A=50P P=30U
D$1958 S3N VDD diode_pd2nw_06v0 A=50P P=30U
D$1959 S3N VDD diode_pd2nw_06v0 A=50P P=30U
D$1960 S3P VDD diode_pd2nw_06v0 A=50P P=30U
D$1961 S3P VDD diode_pd2nw_06v0 A=50P P=30U
D$1962 S4N VDD diode_pd2nw_06v0 A=50P P=30U
D$1963 S4N VDD diode_pd2nw_06v0 A=50P P=30U
D$1964 S4P VDD diode_pd2nw_06v0 A=50P P=30U
D$1965 S4P VDD diode_pd2nw_06v0 A=50P P=30U
D$1966 X VDD diode_pd2nw_06v0 A=50P P=30U
D$1967 X VDD diode_pd2nw_06v0 A=50P P=30U
R$1968 \$66449 \$64141 VSS 76450 ppolyf_u_1k L=76.45U W=1U
R$1969 \$66449 \$67752 VSS 76450 ppolyf_u_1k L=76.45U W=1U
R$1970 \$73178 \$67752 VSS 76450 ppolyf_u_1k L=76.45U W=1U
R$1971 \$38251 \$64141 VSS 76450 ppolyf_u_1k L=76.45U W=1U
R$1972 \$73178 \$38254 VSS 76450 ppolyf_u_1k L=76.45U W=1U
R$1973 \$38262 \$64142 VSS 76450 ppolyf_u_1k L=76.45U W=1U
R$1974 \$73179 \$38265 VSS 76450 ppolyf_u_1k L=76.45U W=1U
R$1975 \$73179 \$67753 VSS 76450 ppolyf_u_1k L=76.45U W=1U
R$1976 \$66450 \$64142 VSS 76450 ppolyf_u_1k L=76.45U W=1U
R$1977 \$66450 \$67753 VSS 76450 ppolyf_u_1k L=76.45U W=1U
R$1978 \$73180 \$67754 VSS 76450 ppolyf_u_1k L=76.45U W=1U
R$1979 \$38273 \$64143 VSS 76450 ppolyf_u_1k L=76.45U W=1U
R$1980 \$66451 \$67754 VSS 76450 ppolyf_u_1k L=76.45U W=1U
R$1981 \$66451 \$64143 VSS 76450 ppolyf_u_1k L=76.45U W=1U
R$1982 \$73180 \$38276 VSS 76450 ppolyf_u_1k L=76.45U W=1U
R$1983 \$66452 \$67755 VSS 76450 ppolyf_u_1k L=76.45U W=1U
R$1984 \$73181 \$38287 VSS 76450 ppolyf_u_1k L=76.45U W=1U
R$1985 \$38284 \$64144 VSS 76450 ppolyf_u_1k L=76.45U W=1U
R$1986 \$73181 \$67755 VSS 76450 ppolyf_u_1k L=76.45U W=1U
R$1987 \$66452 \$64144 VSS 76450 ppolyf_u_1k L=76.45U W=1U
R$1988 \$149233 \$153652 VSS 76450 ppolyf_u_1k L=76.45U W=1U
R$1989 \$149233 \$147198 VSS 76450 ppolyf_u_1k L=76.45U W=1U
R$1990 \$120564 \$147198 VSS 76450 ppolyf_u_1k L=76.45U W=1U
R$1991 \$154539 \$153652 VSS 76450 ppolyf_u_1k L=76.45U W=1U
R$1992 \$154539 \$120567 VSS 76450 ppolyf_u_1k L=76.45U W=1U
R$1993 \$149234 \$147199 VSS 76450 ppolyf_u_1k L=76.45U W=1U
R$1994 \$154540 \$153653 VSS 76450 ppolyf_u_1k L=76.45U W=1U
R$1995 \$149234 \$153653 VSS 76450 ppolyf_u_1k L=76.45U W=1U
R$1996 \$154540 \$120578 VSS 76450 ppolyf_u_1k L=76.45U W=1U
R$1997 \$120575 \$147199 VSS 76450 ppolyf_u_1k L=76.45U W=1U
R$1998 \$154541 \$153654 VSS 76450 ppolyf_u_1k L=76.45U W=1U
R$1999 \$149235 \$153654 VSS 76450 ppolyf_u_1k L=76.45U W=1U
R$2000 \$149235 \$147200 VSS 76450 ppolyf_u_1k L=76.45U W=1U
R$2001 \$154541 \$120589 VSS 76450 ppolyf_u_1k L=76.45U W=1U
R$2002 \$120586 \$147200 VSS 76450 ppolyf_u_1k L=76.45U W=1U
R$2003 \$149236 \$153655 VSS 76450 ppolyf_u_1k L=76.45U W=1U
R$2004 \$154542 \$120600 VSS 76450 ppolyf_u_1k L=76.45U W=1U
R$2005 \$154542 \$153655 VSS 76450 ppolyf_u_1k L=76.45U W=1U
R$2006 \$149236 \$147201 VSS 76450 ppolyf_u_1k L=76.45U W=1U
R$2007 \$120597 \$147201 VSS 76450 ppolyf_u_1k L=76.45U W=1U
R$2008 \$205745 \$230970 VSS 76450 ppolyf_u_1k L=76.45U W=1U
R$2009 \$239094 \$236379 VSS 76450 ppolyf_u_1k L=76.45U W=1U
R$2010 \$233920 \$230970 VSS 76450 ppolyf_u_1k L=76.45U W=1U
R$2011 \$239094 \$205748 VSS 76450 ppolyf_u_1k L=76.45U W=1U
R$2012 \$233920 \$236379 VSS 76450 ppolyf_u_1k L=76.45U W=1U
R$2013 \$205756 \$230971 VSS 76450 ppolyf_u_1k L=76.45U W=1U
R$2014 \$233921 \$230971 VSS 76450 ppolyf_u_1k L=76.45U W=1U
R$2015 \$239095 \$205759 VSS 76450 ppolyf_u_1k L=76.45U W=1U
R$2016 \$233921 \$236380 VSS 76450 ppolyf_u_1k L=76.45U W=1U
R$2017 \$239095 \$236380 VSS 76450 ppolyf_u_1k L=76.45U W=1U
R$2018 \$239096 \$205770 VSS 76450 ppolyf_u_1k L=76.45U W=1U
R$2019 \$239096 \$236381 VSS 76450 ppolyf_u_1k L=76.45U W=1U
R$2020 \$233922 \$236381 VSS 76450 ppolyf_u_1k L=76.45U W=1U
R$2021 \$233922 \$230972 VSS 76450 ppolyf_u_1k L=76.45U W=1U
R$2022 \$205767 \$230972 VSS 76450 ppolyf_u_1k L=76.45U W=1U
R$2023 \$233923 \$236382 VSS 76450 ppolyf_u_1k L=76.45U W=1U
R$2024 \$239097 \$205781 VSS 76450 ppolyf_u_1k L=76.45U W=1U
R$2025 \$233923 \$230973 VSS 76450 ppolyf_u_1k L=76.45U W=1U
R$2026 \$205778 \$230973 VSS 76450 ppolyf_u_1k L=76.45U W=1U
R$2027 \$239097 \$236382 VSS 76450 ppolyf_u_1k L=76.45U W=1U
R$2028 S1N \$53339 VSS 2000 ppolyf_u_1k L=2U W=1U
R$2029 S1N \$53339 VSS 2000 ppolyf_u_1k L=2U W=1U
R$2030 S1N \$53339 VSS 2000 ppolyf_u_1k L=2U W=1U
R$2031 S1N \$53339 VSS 2000 ppolyf_u_1k L=2U W=1U
R$2032 S1N \$53339 VSS 2000 ppolyf_u_1k L=2U W=1U
R$2033 S1P \$54336 VSS 2000 ppolyf_u_1k L=2U W=1U
R$2034 S1P \$54336 VSS 2000 ppolyf_u_1k L=2U W=1U
R$2035 S2N \$54334 VSS 2000 ppolyf_u_1k L=2U W=1U
R$2036 S2N \$54334 VSS 2000 ppolyf_u_1k L=2U W=1U
R$2037 S2P \$54333 VSS 2000 ppolyf_u_1k L=2U W=1U
R$2038 S2P \$54333 VSS 2000 ppolyf_u_1k L=2U W=1U
R$2039 S3N \$53336 VSS 2000 ppolyf_u_1k L=2U W=1U
R$2040 S3N \$53336 VSS 2000 ppolyf_u_1k L=2U W=1U
R$2041 S3P \$54335 VSS 2000 ppolyf_u_1k L=2U W=1U
R$2042 S3P \$54335 VSS 2000 ppolyf_u_1k L=2U W=1U
R$2043 S4N \$138519 VSS 2000 ppolyf_u_1k L=2U W=1U
R$2044 S4N \$138519 VSS 2000 ppolyf_u_1k L=2U W=1U
R$2045 S4P \$136654 VSS 2000 ppolyf_u_1k L=2U W=1U
R$2046 S4P \$136654 VSS 2000 ppolyf_u_1k L=2U W=1U
R$2047 X \$300358 VSS 2000 ppolyf_u_1k L=2U W=1U
R$2048 X \$300358 VSS 2000 ppolyf_u_1k L=2U W=1U
R$2049 S1P \$54336 VSS 2000 ppolyf_u_1k L=2U W=1U
R$2050 S2N \$54334 VSS 2000 ppolyf_u_1k L=2U W=1U
R$2051 S2P \$54333 VSS 2000 ppolyf_u_1k L=2U W=1U
R$2052 S3N \$53336 VSS 2000 ppolyf_u_1k L=2U W=1U
R$2053 S3P \$54335 VSS 2000 ppolyf_u_1k L=2U W=1U
R$2054 S4N \$138519 VSS 2000 ppolyf_u_1k L=2U W=1U
R$2055 S4P \$136654 VSS 2000 ppolyf_u_1k L=2U W=1U
R$2056 X \$300358 VSS 2000 ppolyf_u_1k L=2U W=1U
R$2057 S1P \$54336 VSS 2000 ppolyf_u_1k L=2U W=1U
R$2058 S2N \$54334 VSS 2000 ppolyf_u_1k L=2U W=1U
R$2059 S2P \$54333 VSS 2000 ppolyf_u_1k L=2U W=1U
R$2060 S3N \$53336 VSS 2000 ppolyf_u_1k L=2U W=1U
R$2061 S3P \$54335 VSS 2000 ppolyf_u_1k L=2U W=1U
R$2062 S4N \$138519 VSS 2000 ppolyf_u_1k L=2U W=1U
R$2063 S4P \$136654 VSS 2000 ppolyf_u_1k L=2U W=1U
R$2064 X \$300358 VSS 2000 ppolyf_u_1k L=2U W=1U
R$2065 S1P \$54336 VSS 2000 ppolyf_u_1k L=2U W=1U
R$2066 S2N \$54334 VSS 2000 ppolyf_u_1k L=2U W=1U
R$2067 S2P \$54333 VSS 2000 ppolyf_u_1k L=2U W=1U
R$2068 S3N \$53336 VSS 2000 ppolyf_u_1k L=2U W=1U
R$2069 S3P \$54335 VSS 2000 ppolyf_u_1k L=2U W=1U
R$2070 S4N \$138519 VSS 2000 ppolyf_u_1k L=2U W=1U
R$2071 S4P \$136654 VSS 2000 ppolyf_u_1k L=2U W=1U
R$2072 X \$300358 VSS 2000 ppolyf_u_1k L=2U W=1U
R$2073 Y \$359044 VSS 2000 ppolyf_u_1k L=2U W=1U
R$2074 Z \$417194 VSS 2000 ppolyf_u_1k L=2U W=1U
R$2075 Y \$359044 VSS 2000 ppolyf_u_1k L=2U W=1U
R$2076 Z \$417194 VSS 2000 ppolyf_u_1k L=2U W=1U
R$2077 Y \$359044 VSS 2000 ppolyf_u_1k L=2U W=1U
R$2078 Y \$359044 VSS 2000 ppolyf_u_1k L=2U W=1U
R$2079 Z \$417194 VSS 2000 ppolyf_u_1k L=2U W=1U
R$2080 Z \$417194 VSS 2000 ppolyf_u_1k L=2U W=1U
R$2081 Y \$359044 VSS 2000 ppolyf_u_1k L=2U W=1U
R$2082 Z \$417194 VSS 2000 ppolyf_u_1k L=2U W=1U
C$2083 \$464256 \$464262 4e-13 cap_mim_2f0fF A=200P P=60U
C$2084 \$464265 \$464271 4e-13 cap_mim_2f0fF A=200P P=60U
C$2085 \$464247 \$464253 4e-13 cap_mim_2f0fF A=200P P=60U
C$2086 \$464271 \$464269 4e-13 cap_mim_2f0fF A=200P P=60U
C$2087 \$464253 \$464251 4e-13 cap_mim_2f0fF A=200P P=60U
C$2088 \$406871 \$406877 4e-13 cap_mim_2f0fF A=200P P=60U
C$2089 \$406869 \$406867 4e-13 cap_mim_2f0fF A=200P P=60U
C$2090 \$406861 \$406859 4e-13 cap_mim_2f0fF A=200P P=60U
C$2091 \$347622 \$347631 4e-13 cap_mim_2f0fF A=200P P=60U
C$2092 \$347610 \$347619 4e-13 cap_mim_2f0fF A=200P P=60U
C$2093 \$347598 \$347607 4e-13 cap_mim_2f0fF A=200P P=60U
C$2094 \$347631 \$347626 4e-13 cap_mim_2f0fF A=200P P=60U
C$2095 \$347619 \$347614 4e-13 cap_mim_2f0fF A=200P P=60U
C$2096 \$347607 \$347602 4e-13 cap_mim_2f0fF A=200P P=60U
C$2097 \$120600 \$135426 2e-13 cap_mim_2f0fF A=100P P=58U
C$2098 \$120578 \$135418 2e-13 cap_mim_2f0fF A=100P P=58U
C$2099 \$288711 \$288720 4e-13 cap_mim_2f0fF A=200P P=60U
C$2100 \$120580 \$120589 2e-13 cap_mim_2f0fF A=100P P=58U
C$2101 \$205739 \$205748 2e-13 cap_mim_2f0fF A=100P P=58U
C$2102 \$205761 \$205770 2e-13 cap_mim_2f0fF A=100P P=58U
C$2103 \$288720 \$288715 4e-13 cap_mim_2f0fF A=200P P=60U
C$2104 \$120567 \$135414 2e-13 cap_mim_2f0fF A=100P P=58U
C$2105 \$38278 \$38287 2e-13 cap_mim_2f0fF A=100P P=58U
C$2106 \$38256 \$38265 2e-13 cap_mim_2f0fF A=100P P=58U
C$2107 \$406855 \$406861 4e-13 cap_mim_2f0fF A=200P P=60U
C$2108 \$38265 \$51238 2e-13 cap_mim_2f0fF A=100P P=58U
C$2109 \$38287 \$51246 2e-13 cap_mim_2f0fF A=100P P=58U
C$2110 \$205759 \$217303 2e-13 cap_mim_2f0fF A=100P P=58U
C$2111 \$120558 \$120567 2e-13 cap_mim_2f0fF A=100P P=58U
C$2112 \$38267 \$38276 2e-13 cap_mim_2f0fF A=100P P=58U
C$2113 \$120589 \$135424 2e-13 cap_mim_2f0fF A=100P P=58U
C$2114 \$38254 \$51237 2e-13 cap_mim_2f0fF A=100P P=58U
C$2115 \$288699 \$288708 4e-13 cap_mim_2f0fF A=200P P=60U
C$2116 \$205770 \$217305 2e-13 cap_mim_2f0fF A=100P P=58U
C$2117 \$38276 \$51241 2e-13 cap_mim_2f0fF A=100P P=58U
C$2118 \$205748 \$217300 2e-13 cap_mim_2f0fF A=100P P=58U
C$2119 \$406877 \$406875 4e-13 cap_mim_2f0fF A=200P P=60U
C$2120 \$120569 \$120578 2e-13 cap_mim_2f0fF A=100P P=58U
C$2121 \$288687 \$288696 4e-13 cap_mim_2f0fF A=200P P=60U
C$2122 \$205750 \$205759 2e-13 cap_mim_2f0fF A=100P P=58U
C$2123 \$38245 \$38254 2e-13 cap_mim_2f0fF A=100P P=58U
C$2124 \$120591 \$120600 2e-13 cap_mim_2f0fF A=100P P=58U
C$2125 \$205772 \$205781 2e-13 cap_mim_2f0fF A=100P P=58U
C$2126 \$288696 \$288691 4e-13 cap_mim_2f0fF A=200P P=60U
C$2127 \$464262 \$464260 4e-13 cap_mim_2f0fF A=200P P=60U
C$2128 \$406863 \$406869 4e-13 cap_mim_2f0fF A=200P P=60U
C$2129 \$205781 \$217308 2e-13 cap_mim_2f0fF A=100P P=58U
C$2130 \$288708 \$288703 4e-13 cap_mim_2f0fF A=200P P=60U
.ENDS GRADIENT_NAV2
