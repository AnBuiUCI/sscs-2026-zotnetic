* Extracted by KLayout with GF180MCU LVS runset on : 21/08/2026 08:15

.SUBCKT GRADIENT_NAV2 S2N S3P S1P S1N S2P S3N VDD S4P S4N XN X XP YP YN Y ZN Z
+ ZP VSS
M$1 \$2779 X VDD VDD pfet_05v0 L=0.5U W=1.83U AS=0.8052P AD=0.8052P PS=4.54U
+ PD=4.54U
M$2 XP \$2779 VDD VDD pfet_05v0 L=0.5U W=1.83U AS=0.8052P AD=0.8052P PS=4.54U
+ PD=4.54U
M$3 XN XP VDD VDD pfet_05v0 L=0.5U W=1.83U AS=0.8052P AD=0.8052P PS=4.54U
+ PD=4.54U
M$4 \$4570 Y VDD VDD pfet_05v0 L=0.5U W=1.83U AS=0.8052P AD=0.8052P PS=4.54U
+ PD=4.54U
M$5 YP \$4570 VDD VDD pfet_05v0 L=0.5U W=1.83U AS=0.8052P AD=0.8052P PS=4.54U
+ PD=4.54U
M$6 YN YP VDD VDD pfet_05v0 L=0.5U W=1.83U AS=0.8052P AD=0.8052P PS=4.54U
+ PD=4.54U
M$7 \$6361 Z VDD VDD pfet_05v0 L=0.5U W=1.83U AS=0.8052P AD=0.8052P PS=4.54U
+ PD=4.54U
M$8 ZP \$6361 VDD VDD pfet_05v0 L=0.5U W=1.83U AS=0.8052P AD=0.8052P PS=4.54U
+ PD=4.54U
M$9 ZN ZP VDD VDD pfet_05v0 L=0.5U W=1.83U AS=0.8052P AD=0.8052P PS=4.54U
+ PD=4.54U
M$10 VDD VSS VDD VDD pfet_06v0 L=2U W=18U AS=7.92P AD=7.92P PS=36.88U PD=36.88U
M$11 VDD VSS VDD VDD pfet_06v0 L=2U W=18U AS=7.92P AD=7.92P PS=36.88U PD=36.88U
M$12 VDD VSS VDD VDD pfet_06v0 L=2U W=18U AS=7.92P AD=7.92P PS=36.88U PD=36.88U
M$13 VDD VSS VDD VDD pfet_06v0 L=2U W=18U AS=7.92P AD=7.92P PS=36.88U PD=36.88U
M$14 VDD VSS VDD VDD pfet_06v0 L=2U W=18U AS=7.92P AD=7.92P PS=36.88U PD=36.88U
M$15 VDD VSS VDD VDD pfet_06v0 L=2U W=18U AS=7.92P AD=7.92P PS=36.88U PD=36.88U
M$16 VDD VSS VDD VDD pfet_06v0 L=2U W=18U AS=7.92P AD=7.92P PS=36.88U PD=36.88U
M$17 VDD VSS VDD VDD pfet_06v0 L=2U W=18U AS=7.92P AD=7.92P PS=36.88U PD=36.88U
M$18 \$902 \$111 VDD VDD pfet_06v0 L=1U W=10U AS=4.4P AD=2.5P PS=20.88U PD=10.5U
M$19 \$115 \$120 \$902 VDD pfet_06v0 L=1U W=10U AS=2.5P AD=4.4P PS=10.5U
+ PD=20.88U
M$20 \$904 \$111 VDD VDD pfet_06v0 L=1U W=10U AS=4.4P AD=2.5P PS=20.88U PD=10.5U
M$21 \$115 \$120 \$904 VDD pfet_06v0 L=1U W=10U AS=2.5P AD=4.4P PS=10.5U
+ PD=20.88U
M$22 \$907 \$105 VDD VDD pfet_06v0 L=1U W=10U AS=4.4P AD=2.5P PS=20.88U PD=10.5U
M$23 \$105 \$120 \$907 VDD pfet_06v0 L=1U W=10U AS=2.5P AD=3.3P PS=10.5U
+ PD=10.66U
M$24 \$19 \$19 \$105 VDD pfet_06v0 L=1U W=10U AS=3.3P AD=4.4P PS=10.66U
+ PD=20.88U
M$25 \$908 \$111 VDD VDD pfet_06v0 L=1U W=10U AS=4.4P AD=2.5P PS=20.88U PD=10.5U
M$26 \$63 \$120 \$908 VDD pfet_06v0 L=1U W=10U AS=2.5P AD=4.4P PS=10.5U
+ PD=20.88U
M$27 \$910 \$111 VDD VDD pfet_06v0 L=1U W=10U AS=4.4P AD=2.5P PS=20.88U PD=10.5U
M$28 \$88 \$120 \$910 VDD pfet_06v0 L=1U W=10U AS=2.5P AD=4.4P PS=10.5U
+ PD=20.88U
M$29 \$912 \$111 VDD VDD pfet_06v0 L=1U W=10U AS=4.4P AD=2.5P PS=20.88U PD=10.5U
M$30 \$87 \$120 \$912 VDD pfet_06v0 L=1U W=10U AS=2.5P AD=4.4P PS=10.5U
+ PD=20.88U
M$31 \$913 \$111 VDD VDD pfet_06v0 L=1U W=10U AS=4.4P AD=2.5P PS=20.88U PD=10.5U
M$32 \$111 \$120 \$913 VDD pfet_06v0 L=1U W=10U AS=2.5P AD=4.4P PS=10.5U
+ PD=20.88U
M$33 \$914 \$112 VDD VDD pfet_06v0 L=1U W=10U AS=4.4P AD=2.5P PS=20.88U PD=10.5U
M$34 \$116 \$121 \$914 VDD pfet_06v0 L=1U W=10U AS=2.5P AD=4.4P PS=10.5U
+ PD=20.88U
M$35 \$915 \$112 VDD VDD pfet_06v0 L=1U W=10U AS=4.4P AD=2.5P PS=20.88U PD=10.5U
M$36 \$116 \$121 \$915 VDD pfet_06v0 L=1U W=10U AS=2.5P AD=4.4P PS=10.5U
+ PD=20.88U
M$37 \$918 \$106 VDD VDD pfet_06v0 L=1U W=10U AS=4.4P AD=2.5P PS=20.88U PD=10.5U
M$38 \$106 \$121 \$918 VDD pfet_06v0 L=1U W=10U AS=2.5P AD=3.3P PS=10.5U
+ PD=10.66U
M$39 \$30 \$30 \$106 VDD pfet_06v0 L=1U W=10U AS=3.3P AD=4.4P PS=10.66U
+ PD=20.88U
M$40 \$920 \$112 VDD VDD pfet_06v0 L=1U W=10U AS=4.4P AD=2.5P PS=20.88U PD=10.5U
M$41 \$64 \$121 \$920 VDD pfet_06v0 L=1U W=10U AS=2.5P AD=4.4P PS=10.5U
+ PD=20.88U
M$42 \$923 \$112 VDD VDD pfet_06v0 L=1U W=10U AS=4.4P AD=2.5P PS=20.88U PD=10.5U
M$43 \$90 \$121 \$923 VDD pfet_06v0 L=1U W=10U AS=2.5P AD=4.4P PS=10.5U
+ PD=20.88U
M$44 \$924 \$112 VDD VDD pfet_06v0 L=1U W=10U AS=4.4P AD=2.5P PS=20.88U PD=10.5U
M$45 \$89 \$121 \$924 VDD pfet_06v0 L=1U W=10U AS=2.5P AD=4.4P PS=10.5U
+ PD=20.88U
M$46 \$925 \$112 VDD VDD pfet_06v0 L=1U W=10U AS=4.4P AD=2.5P PS=20.88U PD=10.5U
M$47 \$112 \$121 \$925 VDD pfet_06v0 L=1U W=10U AS=2.5P AD=4.4P PS=10.5U
+ PD=20.88U
M$48 \$927 \$113 VDD VDD pfet_06v0 L=1U W=10U AS=4.4P AD=2.5P PS=20.88U PD=10.5U
M$49 \$118 \$122 \$927 VDD pfet_06v0 L=1U W=10U AS=2.5P AD=4.4P PS=10.5U
+ PD=20.88U
M$50 \$928 \$113 VDD VDD pfet_06v0 L=1U W=10U AS=4.4P AD=2.5P PS=20.88U PD=10.5U
M$51 \$118 \$122 \$928 VDD pfet_06v0 L=1U W=10U AS=2.5P AD=4.4P PS=10.5U
+ PD=20.88U
M$52 \$929 \$108 VDD VDD pfet_06v0 L=1U W=10U AS=4.4P AD=2.5P PS=20.88U PD=10.5U
M$53 \$108 \$122 \$929 VDD pfet_06v0 L=1U W=10U AS=2.5P AD=3.3P PS=10.5U
+ PD=10.66U
M$54 \$41 \$41 \$108 VDD pfet_06v0 L=1U W=10U AS=3.3P AD=4.4P PS=10.66U
+ PD=20.88U
M$55 \$926 \$113 VDD VDD pfet_06v0 L=1U W=10U AS=4.4P AD=2.5P PS=20.88U PD=10.5U
M$56 \$65 \$122 \$926 VDD pfet_06v0 L=1U W=10U AS=2.5P AD=4.4P PS=10.5U
+ PD=20.88U
M$57 \$922 \$113 VDD VDD pfet_06v0 L=1U W=10U AS=4.4P AD=2.5P PS=20.88U PD=10.5U
M$58 \$92 \$122 \$922 VDD pfet_06v0 L=1U W=10U AS=2.5P AD=4.4P PS=10.5U
+ PD=20.88U
M$59 \$921 \$113 VDD VDD pfet_06v0 L=1U W=10U AS=4.4P AD=2.5P PS=20.88U PD=10.5U
M$60 \$91 \$122 \$921 VDD pfet_06v0 L=1U W=10U AS=2.5P AD=4.4P PS=10.5U
+ PD=20.88U
M$61 \$919 \$113 VDD VDD pfet_06v0 L=1U W=10U AS=4.4P AD=2.5P PS=20.88U PD=10.5U
M$62 \$113 \$122 \$919 VDD pfet_06v0 L=1U W=10U AS=2.5P AD=4.4P PS=10.5U
+ PD=20.88U
M$63 \$917 \$114 VDD VDD pfet_06v0 L=1U W=10U AS=4.4P AD=2.5P PS=20.88U PD=10.5U
M$64 \$119 \$123 \$917 VDD pfet_06v0 L=1U W=10U AS=2.5P AD=4.4P PS=10.5U
+ PD=20.88U
M$65 \$916 \$114 VDD VDD pfet_06v0 L=1U W=10U AS=4.4P AD=2.5P PS=20.88U PD=10.5U
M$66 \$119 \$123 \$916 VDD pfet_06v0 L=1U W=10U AS=2.5P AD=4.4P PS=10.5U
+ PD=20.88U
M$67 \$911 \$110 VDD VDD pfet_06v0 L=1U W=10U AS=4.4P AD=2.5P PS=20.88U PD=10.5U
M$68 \$110 \$123 \$911 VDD pfet_06v0 L=1U W=10U AS=2.5P AD=3.3P PS=10.5U
+ PD=10.66U
M$69 \$52 \$52 \$110 VDD pfet_06v0 L=1U W=10U AS=3.3P AD=4.4P PS=10.66U
+ PD=20.88U
M$70 \$909 \$114 VDD VDD pfet_06v0 L=1U W=10U AS=4.4P AD=2.5P PS=20.88U PD=10.5U
M$71 \$66 \$123 \$909 VDD pfet_06v0 L=1U W=10U AS=2.5P AD=4.4P PS=10.5U
+ PD=20.88U
M$72 \$906 \$114 VDD VDD pfet_06v0 L=1U W=10U AS=4.4P AD=2.5P PS=20.88U PD=10.5U
M$73 \$94 \$123 \$906 VDD pfet_06v0 L=1U W=10U AS=2.5P AD=4.4P PS=10.5U
+ PD=20.88U
M$74 \$905 \$114 VDD VDD pfet_06v0 L=1U W=10U AS=4.4P AD=2.5P PS=20.88U PD=10.5U
M$75 \$93 \$123 \$905 VDD pfet_06v0 L=1U W=10U AS=2.5P AD=4.4P PS=10.5U
+ PD=20.88U
M$76 \$903 \$114 VDD VDD pfet_06v0 L=1U W=10U AS=4.4P AD=2.5P PS=20.88U PD=10.5U
M$77 \$114 \$123 \$903 VDD pfet_06v0 L=1U W=10U AS=2.5P AD=4.4P PS=10.5U
+ PD=20.88U
M$78 VDD VSS VDD VDD pfet_06v0 L=2U W=18U AS=7.92P AD=7.92P PS=36.88U PD=36.88U
M$79 \$1825 \$1034 VDD VDD pfet_06v0 L=1U W=10U AS=4.4P AD=2.5P PS=20.88U
+ PD=10.5U
M$80 \$1038 \$1044 \$1825 VDD pfet_06v0 L=1U W=10U AS=2.5P AD=4.4P PS=10.5U
+ PD=20.88U
M$81 \$1827 \$1034 VDD VDD pfet_06v0 L=1U W=10U AS=4.4P AD=2.5P PS=20.88U
+ PD=10.5U
M$82 \$1038 \$1044 \$1827 VDD pfet_06v0 L=1U W=10U AS=2.5P AD=4.4P PS=10.5U
+ PD=20.88U
M$83 \$104 S2P \$115 VDD pfet_06v0 L=1U W=1.1U AS=0.484P AD=0.484P PS=3.08U
+ PD=3.08U
M$84 \$14 S2N \$115 VDD pfet_06v0 L=1U W=1U AS=0.44P AD=0.44P PS=2.88U PD=2.88U
M$85 \$13 \$16 VDD VDD pfet_06v0 L=1U W=5U AS=2.2P AD=1.65P PS=10.88U PD=5.66U
M$86 \$16 \$120 \$13 VDD pfet_06v0 L=1U W=5U AS=1.65P AD=1.65P PS=5.66U PD=5.66U
M$87 \$15 \$19 \$16 VDD pfet_06v0 L=1U W=5U AS=1.65P AD=2.2P PS=5.66U PD=10.88U
M$88 \$12 \$16 VDD VDD pfet_06v0 L=1U W=5U AS=2.2P AD=1.65P PS=10.88U PD=5.66U
M$89 \$18 \$120 \$12 VDD pfet_06v0 L=1U W=5U AS=1.65P AD=1.65P PS=5.66U PD=5.66U
M$90 \$17 \$19 \$18 VDD pfet_06v0 L=1U W=5U AS=1.65P AD=2.2P PS=5.66U PD=10.88U
M$91 \$1830 \$1028 VDD VDD pfet_06v0 L=1U W=10U AS=4.4P AD=2.5P PS=20.88U
+ PD=10.5U
M$92 \$1028 \$1044 \$1830 VDD pfet_06v0 L=1U W=10U AS=2.5P AD=3.3P PS=10.5U
+ PD=10.66U
M$93 \$942 \$942 \$1028 VDD pfet_06v0 L=1U W=10U AS=3.3P AD=4.4P PS=10.66U
+ PD=20.88U
M$94 \$1831 \$1034 VDD VDD pfet_06v0 L=1U W=10U AS=4.4P AD=2.5P PS=20.88U
+ PD=10.5U
M$95 \$986 \$1044 \$1831 VDD pfet_06v0 L=1U W=10U AS=2.5P AD=4.4P PS=10.5U
+ PD=20.88U
M$96 \$21 \$18 VDD VDD pfet_06v0 L=1U W=0.5U AS=0.22P AD=0.22P PS=1.88U PD=1.88U
M$97 \$21 \$18 VDD VDD pfet_06v0 L=1U W=0.5U AS=0.22P AD=0.22P PS=1.88U PD=1.88U
M$98 \$21 \$18 VDD VDD pfet_06v0 L=1U W=0.5U AS=0.22P AD=0.22P PS=1.88U PD=1.88U
M$99 \$21 \$18 VDD VDD pfet_06v0 L=1U W=0.5U AS=0.22P AD=0.22P PS=1.88U PD=1.88U
M$100 \$1833 \$1034 VDD VDD pfet_06v0 L=1U W=10U AS=4.4P AD=2.5P PS=20.88U
+ PD=10.5U
M$101 \$991 \$1044 \$1833 VDD pfet_06v0 L=1U W=10U AS=2.5P AD=4.4P PS=10.5U
+ PD=20.88U
M$102 \$1835 \$1034 VDD VDD pfet_06v0 L=1U W=10U AS=4.4P AD=2.5P PS=20.88U
+ PD=10.5U
M$103 \$990 \$1044 \$1835 VDD pfet_06v0 L=1U W=10U AS=2.5P AD=4.4P PS=10.5U
+ PD=20.88U
M$104 \$120 \$120 VDD VDD pfet_06v0 L=1U W=2U AS=0.88P AD=0.88P PS=4.88U
+ PD=4.88U
M$105 \$1836 \$1034 VDD VDD pfet_06v0 L=1U W=10U AS=4.4P AD=2.5P PS=20.88U
+ PD=10.5U
M$106 \$1034 \$1044 \$1836 VDD pfet_06v0 L=1U W=10U AS=2.5P AD=4.4P PS=10.5U
+ PD=20.88U
M$107 VDD VSS VDD VDD pfet_06v0 L=2U W=18U AS=7.92P AD=7.92P PS=36.88U PD=36.88U
M$108 VDD VSS VDD VDD pfet_06v0 L=2U W=18U AS=7.92P AD=7.92P PS=36.88U PD=36.88U
M$109 \$1837 \$1035 VDD VDD pfet_06v0 L=1U W=10U AS=4.4P AD=2.5P PS=20.88U
+ PD=10.5U
M$110 \$1041 \$1045 \$1837 VDD pfet_06v0 L=1U W=10U AS=2.5P AD=4.4P PS=10.5U
+ PD=20.88U
M$111 \$1838 \$1035 VDD VDD pfet_06v0 L=1U W=10U AS=4.4P AD=2.5P PS=20.88U
+ PD=10.5U
M$112 \$1041 \$1045 \$1838 VDD pfet_06v0 L=1U W=10U AS=2.5P AD=4.4P PS=10.5U
+ PD=20.88U
M$113 \$98 S3P \$116 VDD pfet_06v0 L=1U W=1.1U AS=0.484P AD=0.484P PS=3.08U
+ PD=3.08U
M$114 \$25 S3N \$116 VDD pfet_06v0 L=1U W=1U AS=0.44P AD=0.44P PS=2.88U PD=2.88U
M$115 \$24 \$27 VDD VDD pfet_06v0 L=1U W=5U AS=2.2P AD=1.65P PS=10.88U PD=5.66U
M$116 \$27 \$121 \$24 VDD pfet_06v0 L=1U W=5U AS=1.65P AD=1.65P PS=5.66U
+ PD=5.66U
M$117 \$26 \$30 \$27 VDD pfet_06v0 L=1U W=5U AS=1.65P AD=2.2P PS=5.66U PD=10.88U
M$118 \$23 \$27 VDD VDD pfet_06v0 L=1U W=5U AS=2.2P AD=1.65P PS=10.88U PD=5.66U
M$119 \$29 \$121 \$23 VDD pfet_06v0 L=1U W=5U AS=1.65P AD=1.65P PS=5.66U
+ PD=5.66U
M$120 \$28 \$30 \$29 VDD pfet_06v0 L=1U W=5U AS=1.65P AD=2.2P PS=5.66U PD=10.88U
M$121 \$1841 \$1030 VDD VDD pfet_06v0 L=1U W=10U AS=4.4P AD=2.5P PS=20.88U
+ PD=10.5U
M$122 \$1030 \$1045 \$1841 VDD pfet_06v0 L=1U W=10U AS=2.5P AD=3.3P PS=10.5U
+ PD=10.66U
M$123 \$953 \$953 \$1030 VDD pfet_06v0 L=1U W=10U AS=3.3P AD=4.4P PS=10.66U
+ PD=20.88U
M$124 \$1843 \$1035 VDD VDD pfet_06v0 L=1U W=10U AS=4.4P AD=2.5P PS=20.88U
+ PD=10.5U
M$125 \$987 \$1045 \$1843 VDD pfet_06v0 L=1U W=10U AS=2.5P AD=4.4P PS=10.5U
+ PD=20.88U
M$126 \$32 \$29 VDD VDD pfet_06v0 L=1U W=0.5U AS=0.22P AD=0.22P PS=1.88U
+ PD=1.88U
M$127 \$32 \$29 VDD VDD pfet_06v0 L=1U W=0.5U AS=0.22P AD=0.22P PS=1.88U
+ PD=1.88U
M$128 \$32 \$29 VDD VDD pfet_06v0 L=1U W=0.5U AS=0.22P AD=0.22P PS=1.88U
+ PD=1.88U
M$129 \$32 \$29 VDD VDD pfet_06v0 L=1U W=0.5U AS=0.22P AD=0.22P PS=1.88U
+ PD=1.88U
M$130 \$1846 \$1035 VDD VDD pfet_06v0 L=1U W=10U AS=4.4P AD=2.5P PS=20.88U
+ PD=10.5U
M$131 \$993 \$1045 \$1846 VDD pfet_06v0 L=1U W=10U AS=2.5P AD=4.4P PS=10.5U
+ PD=20.88U
M$132 \$1847 \$1035 VDD VDD pfet_06v0 L=1U W=10U AS=4.4P AD=2.5P PS=20.88U
+ PD=10.5U
M$133 \$992 \$1045 \$1847 VDD pfet_06v0 L=1U W=10U AS=2.5P AD=4.4P PS=10.5U
+ PD=20.88U
M$134 \$121 \$121 VDD VDD pfet_06v0 L=1U W=2U AS=0.88P AD=0.88P PS=4.88U
+ PD=4.88U
M$135 \$1848 \$1035 VDD VDD pfet_06v0 L=1U W=10U AS=4.4P AD=2.5P PS=20.88U
+ PD=10.5U
M$136 \$1035 \$1045 \$1848 VDD pfet_06v0 L=1U W=10U AS=2.5P AD=4.4P PS=10.5U
+ PD=20.88U
M$137 VDD VSS VDD VDD pfet_06v0 L=2U W=18U AS=7.92P AD=7.92P PS=36.88U PD=36.88U
M$138 VDD VSS VDD VDD pfet_06v0 L=2U W=18U AS=7.92P AD=7.92P PS=36.88U PD=36.88U
M$139 \$1850 \$1036 VDD VDD pfet_06v0 L=1U W=10U AS=4.4P AD=2.5P PS=20.88U
+ PD=10.5U
M$140 \$1042 \$1046 \$1850 VDD pfet_06v0 L=1U W=10U AS=2.5P AD=4.4P PS=10.5U
+ PD=20.88U
M$141 \$1851 \$1036 VDD VDD pfet_06v0 L=1U W=10U AS=4.4P AD=2.5P PS=20.88U
+ PD=10.5U
M$142 \$1042 \$1046 \$1851 VDD pfet_06v0 L=1U W=10U AS=2.5P AD=4.4P PS=10.5U
+ PD=20.88U
M$143 \$107 S1P \$118 VDD pfet_06v0 L=1U W=1.1U AS=0.484P AD=0.484P PS=3.08U
+ PD=3.08U
M$144 \$36 S1N \$118 VDD pfet_06v0 L=1U W=1U AS=0.44P AD=0.44P PS=2.88U PD=2.88U
M$145 \$35 \$38 VDD VDD pfet_06v0 L=1U W=5U AS=2.2P AD=1.65P PS=10.88U PD=5.66U
M$146 \$38 \$122 \$35 VDD pfet_06v0 L=1U W=5U AS=1.65P AD=1.65P PS=5.66U
+ PD=5.66U
M$147 \$37 \$41 \$38 VDD pfet_06v0 L=1U W=5U AS=1.65P AD=2.2P PS=5.66U PD=10.88U
M$148 \$34 \$38 VDD VDD pfet_06v0 L=1U W=5U AS=2.2P AD=1.65P PS=10.88U PD=5.66U
M$149 \$40 \$122 \$34 VDD pfet_06v0 L=1U W=5U AS=1.65P AD=1.65P PS=5.66U
+ PD=5.66U
M$150 \$39 \$41 \$40 VDD pfet_06v0 L=1U W=5U AS=1.65P AD=2.2P PS=5.66U PD=10.88U
M$151 \$1852 \$1031 VDD VDD pfet_06v0 L=1U W=10U AS=4.4P AD=2.5P PS=20.88U
+ PD=10.5U
M$152 \$1031 \$1046 \$1852 VDD pfet_06v0 L=1U W=10U AS=2.5P AD=3.3P PS=10.5U
+ PD=10.66U
M$153 \$964 \$964 \$1031 VDD pfet_06v0 L=1U W=10U AS=3.3P AD=4.4P PS=10.66U
+ PD=20.88U
M$154 \$1849 \$1036 VDD VDD pfet_06v0 L=1U W=10U AS=4.4P AD=2.5P PS=20.88U
+ PD=10.5U
M$155 \$988 \$1046 \$1849 VDD pfet_06v0 L=1U W=10U AS=2.5P AD=4.4P PS=10.5U
+ PD=20.88U
M$156 \$43 \$40 VDD VDD pfet_06v0 L=1U W=0.5U AS=0.22P AD=0.22P PS=1.88U
+ PD=1.88U
M$157 \$43 \$40 VDD VDD pfet_06v0 L=1U W=0.5U AS=0.22P AD=0.22P PS=1.88U
+ PD=1.88U
M$158 \$43 \$40 VDD VDD pfet_06v0 L=1U W=0.5U AS=0.22P AD=0.22P PS=1.88U
+ PD=1.88U
M$159 \$43 \$40 VDD VDD pfet_06v0 L=1U W=0.5U AS=0.22P AD=0.22P PS=1.88U
+ PD=1.88U
M$160 \$1845 \$1036 VDD VDD pfet_06v0 L=1U W=10U AS=4.4P AD=2.5P PS=20.88U
+ PD=10.5U
M$161 \$995 \$1046 \$1845 VDD pfet_06v0 L=1U W=10U AS=2.5P AD=4.4P PS=10.5U
+ PD=20.88U
M$162 \$1844 \$1036 VDD VDD pfet_06v0 L=1U W=10U AS=4.4P AD=2.5P PS=20.88U
+ PD=10.5U
M$163 \$994 \$1046 \$1844 VDD pfet_06v0 L=1U W=10U AS=2.5P AD=4.4P PS=10.5U
+ PD=20.88U
M$164 \$122 \$122 VDD VDD pfet_06v0 L=1U W=2U AS=0.88P AD=0.88P PS=4.88U
+ PD=4.88U
M$165 \$1842 \$1036 VDD VDD pfet_06v0 L=1U W=10U AS=4.4P AD=2.5P PS=20.88U
+ PD=10.5U
M$166 \$1036 \$1046 \$1842 VDD pfet_06v0 L=1U W=10U AS=2.5P AD=4.4P PS=10.5U
+ PD=20.88U
M$167 VDD VSS VDD VDD pfet_06v0 L=2U W=18U AS=7.92P AD=7.92P PS=36.88U PD=36.88U
M$168 VDD VSS VDD VDD pfet_06v0 L=2U W=18U AS=7.92P AD=7.92P PS=36.88U PD=36.88U
M$169 \$1840 \$1037 VDD VDD pfet_06v0 L=1U W=10U AS=4.4P AD=2.5P PS=20.88U
+ PD=10.5U
M$170 \$1043 \$1047 \$1840 VDD pfet_06v0 L=1U W=10U AS=2.5P AD=4.4P PS=10.5U
+ PD=20.88U
M$171 \$1839 \$1037 VDD VDD pfet_06v0 L=1U W=10U AS=4.4P AD=2.5P PS=20.88U
+ PD=10.5U
M$172 \$1043 \$1047 \$1839 VDD pfet_06v0 L=1U W=10U AS=2.5P AD=4.4P PS=10.5U
+ PD=20.88U
M$173 \$109 S2P \$119 VDD pfet_06v0 L=1U W=1.1U AS=0.484P AD=0.484P PS=3.08U
+ PD=3.08U
M$174 \$47 S2N \$119 VDD pfet_06v0 L=1U W=1U AS=0.44P AD=0.44P PS=2.88U PD=2.88U
M$175 \$46 \$49 VDD VDD pfet_06v0 L=1U W=5U AS=2.2P AD=1.65P PS=10.88U PD=5.66U
M$176 \$49 \$123 \$46 VDD pfet_06v0 L=1U W=5U AS=1.65P AD=1.65P PS=5.66U
+ PD=5.66U
M$177 \$48 \$52 \$49 VDD pfet_06v0 L=1U W=5U AS=1.65P AD=2.2P PS=5.66U PD=10.88U
M$178 \$45 \$49 VDD VDD pfet_06v0 L=1U W=5U AS=2.2P AD=1.65P PS=10.88U PD=5.66U
M$179 \$51 \$123 \$45 VDD pfet_06v0 L=1U W=5U AS=1.65P AD=1.65P PS=5.66U
+ PD=5.66U
M$180 \$50 \$52 \$51 VDD pfet_06v0 L=1U W=5U AS=1.65P AD=2.2P PS=5.66U PD=10.88U
M$181 \$1834 \$1033 VDD VDD pfet_06v0 L=1U W=10U AS=4.4P AD=2.5P PS=20.88U
+ PD=10.5U
M$182 \$1033 \$1047 \$1834 VDD pfet_06v0 L=1U W=10U AS=2.5P AD=3.3P PS=10.5U
+ PD=10.66U
M$183 \$975 \$975 \$1033 VDD pfet_06v0 L=1U W=10U AS=3.3P AD=4.4P PS=10.66U
+ PD=20.88U
M$184 \$1832 \$1037 VDD VDD pfet_06v0 L=1U W=10U AS=4.4P AD=2.5P PS=20.88U
+ PD=10.5U
M$185 \$989 \$1047 \$1832 VDD pfet_06v0 L=1U W=10U AS=2.5P AD=4.4P PS=10.5U
+ PD=20.88U
M$186 \$54 \$51 VDD VDD pfet_06v0 L=1U W=0.5U AS=0.22P AD=0.22P PS=1.88U
+ PD=1.88U
M$187 \$54 \$51 VDD VDD pfet_06v0 L=1U W=0.5U AS=0.22P AD=0.22P PS=1.88U
+ PD=1.88U
M$188 \$54 \$51 VDD VDD pfet_06v0 L=1U W=0.5U AS=0.22P AD=0.22P PS=1.88U
+ PD=1.88U
M$189 \$54 \$51 VDD VDD pfet_06v0 L=1U W=0.5U AS=0.22P AD=0.22P PS=1.88U
+ PD=1.88U
M$190 \$1829 \$1037 VDD VDD pfet_06v0 L=1U W=10U AS=4.4P AD=2.5P PS=20.88U
+ PD=10.5U
M$191 \$997 \$1047 \$1829 VDD pfet_06v0 L=1U W=10U AS=2.5P AD=4.4P PS=10.5U
+ PD=20.88U
M$192 \$1828 \$1037 VDD VDD pfet_06v0 L=1U W=10U AS=4.4P AD=2.5P PS=20.88U
+ PD=10.5U
M$193 \$996 \$1047 \$1828 VDD pfet_06v0 L=1U W=10U AS=2.5P AD=4.4P PS=10.5U
+ PD=20.88U
M$194 \$123 \$123 VDD VDD pfet_06v0 L=1U W=2U AS=0.88P AD=0.88P PS=4.88U
+ PD=4.88U
M$195 \$1826 \$1037 VDD VDD pfet_06v0 L=1U W=10U AS=4.4P AD=2.5P PS=20.88U
+ PD=10.5U
M$196 \$1037 \$1047 \$1826 VDD pfet_06v0 L=1U W=10U AS=2.5P AD=4.4P PS=10.5U
+ PD=20.88U
M$197 VDD VSS VDD VDD pfet_06v0 L=2U W=18U AS=7.92P AD=7.92P PS=36.88U PD=36.88U
M$198 VDD VSS VDD VDD pfet_06v0 L=2U W=18U AS=7.92P AD=7.92P PS=36.88U PD=36.88U
M$199 \$2746 \$1953 VDD VDD pfet_06v0 L=1U W=10U AS=4.4P AD=2.5P PS=20.88U
+ PD=10.5U
M$200 \$1957 \$1961 \$2746 VDD pfet_06v0 L=1U W=10U AS=2.5P AD=4.4P PS=10.5U
+ PD=20.88U
M$201 \$2748 \$1953 VDD VDD pfet_06v0 L=1U W=10U AS=4.4P AD=2.5P PS=20.88U
+ PD=10.5U
M$202 \$1957 \$1961 \$2748 VDD pfet_06v0 L=1U W=10U AS=2.5P AD=4.4P PS=10.5U
+ PD=20.88U
M$203 \$1020 S4P \$1038 VDD pfet_06v0 L=1U W=1.1U AS=0.484P AD=0.484P PS=3.08U
+ PD=3.08U
M$204 \$937 S4N \$1038 VDD pfet_06v0 L=1U W=1U AS=0.44P AD=0.44P PS=2.88U
+ PD=2.88U
M$205 \$936 \$939 VDD VDD pfet_06v0 L=1U W=5U AS=2.2P AD=1.65P PS=10.88U
+ PD=5.66U
M$206 \$939 \$1044 \$936 VDD pfet_06v0 L=1U W=5U AS=1.65P AD=1.65P PS=5.66U
+ PD=5.66U
M$207 \$938 \$942 \$939 VDD pfet_06v0 L=1U W=5U AS=1.65P AD=2.2P PS=5.66U
+ PD=10.88U
M$208 \$935 \$939 VDD VDD pfet_06v0 L=1U W=5U AS=2.2P AD=1.65P PS=10.88U
+ PD=5.66U
M$209 \$941 \$1044 \$935 VDD pfet_06v0 L=1U W=5U AS=1.65P AD=1.65P PS=5.66U
+ PD=5.66U
M$210 \$940 \$942 \$941 VDD pfet_06v0 L=1U W=5U AS=1.65P AD=2.2P PS=5.66U
+ PD=10.88U
M$211 \$2751 \$1940 VDD VDD pfet_06v0 L=1U W=10U AS=4.4P AD=2.5P PS=20.88U
+ PD=10.5U
M$212 \$1940 \$1961 \$2751 VDD pfet_06v0 L=1U W=10U AS=2.5P AD=3.3P PS=10.5U
+ PD=10.66U
M$213 \$1864 \$1864 \$1940 VDD pfet_06v0 L=1U W=10U AS=3.3P AD=4.4P PS=10.66U
+ PD=20.88U
M$214 \$2752 \$1953 VDD VDD pfet_06v0 L=1U W=10U AS=4.4P AD=2.5P PS=20.88U
+ PD=10.5U
M$215 \$1905 \$1961 \$2752 VDD pfet_06v0 L=1U W=10U AS=2.5P AD=4.4P PS=10.5U
+ PD=20.88U
M$216 \$944 \$941 VDD VDD pfet_06v0 L=1U W=0.5U AS=0.22P AD=0.22P PS=1.88U
+ PD=1.88U
M$217 \$944 \$941 VDD VDD pfet_06v0 L=1U W=0.5U AS=0.22P AD=0.22P PS=1.88U
+ PD=1.88U
M$218 \$944 \$941 VDD VDD pfet_06v0 L=1U W=0.5U AS=0.22P AD=0.22P PS=1.88U
+ PD=1.88U
M$219 \$944 \$941 VDD VDD pfet_06v0 L=1U W=0.5U AS=0.22P AD=0.22P PS=1.88U
+ PD=1.88U
M$220 \$2754 \$1953 VDD VDD pfet_06v0 L=1U W=10U AS=4.4P AD=2.5P PS=20.88U
+ PD=10.5U
M$221 \$1910 \$1961 \$2754 VDD pfet_06v0 L=1U W=10U AS=2.5P AD=4.4P PS=10.5U
+ PD=20.88U
M$222 \$2756 \$1953 VDD VDD pfet_06v0 L=1U W=10U AS=4.4P AD=2.5P PS=20.88U
+ PD=10.5U
M$223 \$1909 \$1961 \$2756 VDD pfet_06v0 L=1U W=10U AS=2.5P AD=4.4P PS=10.5U
+ PD=20.88U
M$224 \$1044 \$1044 VDD VDD pfet_06v0 L=1U W=2U AS=0.88P AD=0.88P PS=4.88U
+ PD=4.88U
M$225 \$2757 \$1953 VDD VDD pfet_06v0 L=1U W=10U AS=4.4P AD=2.5P PS=20.88U
+ PD=10.5U
M$226 \$1953 \$1961 \$2757 VDD pfet_06v0 L=1U W=10U AS=2.5P AD=4.4P PS=10.5U
+ PD=20.88U
M$227 VDD VSS VDD VDD pfet_06v0 L=2U W=18U AS=7.92P AD=7.92P PS=36.88U PD=36.88U
M$228 VDD VSS VDD VDD pfet_06v0 L=2U W=18U AS=7.92P AD=7.92P PS=36.88U PD=36.88U
M$229 \$2758 \$1954 VDD VDD pfet_06v0 L=1U W=10U AS=4.4P AD=2.5P PS=20.88U
+ PD=10.5U
M$230 \$1958 \$1963 \$2758 VDD pfet_06v0 L=1U W=10U AS=2.5P AD=4.4P PS=10.5U
+ PD=20.88U
M$231 \$2759 \$1954 VDD VDD pfet_06v0 L=1U W=10U AS=4.4P AD=2.5P PS=20.88U
+ PD=10.5U
M$232 \$1958 \$1963 \$2759 VDD pfet_06v0 L=1U W=10U AS=2.5P AD=4.4P PS=10.5U
+ PD=20.88U
M$233 \$1029 S1P \$1041 VDD pfet_06v0 L=1U W=1.1U AS=0.484P AD=0.484P PS=3.08U
+ PD=3.08U
M$234 \$948 S1N \$1041 VDD pfet_06v0 L=1U W=1U AS=0.44P AD=0.44P PS=2.88U
+ PD=2.88U
M$235 \$947 \$950 VDD VDD pfet_06v0 L=1U W=5U AS=2.2P AD=1.65P PS=10.88U
+ PD=5.66U
M$236 \$950 \$1045 \$947 VDD pfet_06v0 L=1U W=5U AS=1.65P AD=1.65P PS=5.66U
+ PD=5.66U
M$237 \$949 \$953 \$950 VDD pfet_06v0 L=1U W=5U AS=1.65P AD=2.2P PS=5.66U
+ PD=10.88U
M$238 \$946 \$950 VDD VDD pfet_06v0 L=1U W=5U AS=2.2P AD=1.65P PS=10.88U
+ PD=5.66U
M$239 \$952 \$1045 \$946 VDD pfet_06v0 L=1U W=5U AS=1.65P AD=1.65P PS=5.66U
+ PD=5.66U
M$240 \$951 \$953 \$952 VDD pfet_06v0 L=1U W=5U AS=1.65P AD=2.2P PS=5.66U
+ PD=10.88U
M$241 \$2762 \$1944 VDD VDD pfet_06v0 L=1U W=10U AS=4.4P AD=2.5P PS=20.88U
+ PD=10.5U
M$242 \$1944 \$1963 \$2762 VDD pfet_06v0 L=1U W=10U AS=2.5P AD=3.3P PS=10.5U
+ PD=10.66U
M$243 \$1874 \$1874 \$1944 VDD pfet_06v0 L=1U W=10U AS=3.3P AD=4.4P PS=10.66U
+ PD=20.88U
M$244 \$2764 \$1954 VDD VDD pfet_06v0 L=1U W=10U AS=4.4P AD=2.5P PS=20.88U
+ PD=10.5U
M$245 \$1906 \$1963 \$2764 VDD pfet_06v0 L=1U W=10U AS=2.5P AD=4.4P PS=10.5U
+ PD=20.88U
M$246 \$955 \$952 VDD VDD pfet_06v0 L=1U W=0.5U AS=0.22P AD=0.22P PS=1.88U
+ PD=1.88U
M$247 \$955 \$952 VDD VDD pfet_06v0 L=1U W=0.5U AS=0.22P AD=0.22P PS=1.88U
+ PD=1.88U
M$248 \$955 \$952 VDD VDD pfet_06v0 L=1U W=0.5U AS=0.22P AD=0.22P PS=1.88U
+ PD=1.88U
M$249 \$955 \$952 VDD VDD pfet_06v0 L=1U W=0.5U AS=0.22P AD=0.22P PS=1.88U
+ PD=1.88U
M$250 \$2767 \$1954 VDD VDD pfet_06v0 L=1U W=10U AS=4.4P AD=2.5P PS=20.88U
+ PD=10.5U
M$251 \$1912 \$1963 \$2767 VDD pfet_06v0 L=1U W=10U AS=2.5P AD=4.4P PS=10.5U
+ PD=20.88U
M$252 \$2768 \$1954 VDD VDD pfet_06v0 L=1U W=10U AS=4.4P AD=2.5P PS=20.88U
+ PD=10.5U
M$253 \$1911 \$1963 \$2768 VDD pfet_06v0 L=1U W=10U AS=2.5P AD=4.4P PS=10.5U
+ PD=20.88U
M$254 \$1045 \$1045 VDD VDD pfet_06v0 L=1U W=2U AS=0.88P AD=0.88P PS=4.88U
+ PD=4.88U
M$255 \$2769 \$1954 VDD VDD pfet_06v0 L=1U W=10U AS=4.4P AD=2.5P PS=20.88U
+ PD=10.5U
M$256 \$1954 \$1963 \$2769 VDD pfet_06v0 L=1U W=10U AS=2.5P AD=4.4P PS=10.5U
+ PD=20.88U
M$257 VDD VSS VDD VDD pfet_06v0 L=2U W=18U AS=7.92P AD=7.92P PS=36.88U PD=36.88U
M$258 VDD VSS VDD VDD pfet_06v0 L=2U W=18U AS=7.92P AD=7.92P PS=36.88U PD=36.88U
M$259 \$2771 \$1955 VDD VDD pfet_06v0 L=1U W=10U AS=4.4P AD=2.5P PS=20.88U
+ PD=10.5U
M$260 \$1959 \$1965 \$2771 VDD pfet_06v0 L=1U W=10U AS=2.5P AD=4.4P PS=10.5U
+ PD=20.88U
M$261 \$2772 \$1955 VDD VDD pfet_06v0 L=1U W=10U AS=4.4P AD=2.5P PS=20.88U
+ PD=10.5U
M$262 \$1959 \$1965 \$2772 VDD pfet_06v0 L=1U W=10U AS=2.5P AD=4.4P PS=10.5U
+ PD=20.88U
M$263 \$1023 S4P \$1042 VDD pfet_06v0 L=1U W=1.1U AS=0.484P AD=0.484P PS=3.08U
+ PD=3.08U
M$264 \$959 S4N \$1042 VDD pfet_06v0 L=1U W=1U AS=0.44P AD=0.44P PS=2.88U
+ PD=2.88U
M$265 \$958 \$961 VDD VDD pfet_06v0 L=1U W=5U AS=2.2P AD=1.65P PS=10.88U
+ PD=5.66U
M$266 \$961 \$1046 \$958 VDD pfet_06v0 L=1U W=5U AS=1.65P AD=1.65P PS=5.66U
+ PD=5.66U
M$267 \$960 \$964 \$961 VDD pfet_06v0 L=1U W=5U AS=1.65P AD=2.2P PS=5.66U
+ PD=10.88U
M$268 \$957 \$961 VDD VDD pfet_06v0 L=1U W=5U AS=2.2P AD=1.65P PS=10.88U
+ PD=5.66U
M$269 \$963 \$1046 \$957 VDD pfet_06v0 L=1U W=5U AS=1.65P AD=1.65P PS=5.66U
+ PD=5.66U
M$270 \$962 \$964 \$963 VDD pfet_06v0 L=1U W=5U AS=1.65P AD=2.2P PS=5.66U
+ PD=10.88U
M$271 \$2773 \$1948 VDD VDD pfet_06v0 L=1U W=10U AS=4.4P AD=2.5P PS=20.88U
+ PD=10.5U
M$272 \$1948 \$1965 \$2773 VDD pfet_06v0 L=1U W=10U AS=2.5P AD=3.3P PS=10.5U
+ PD=10.66U
M$273 \$1884 \$1884 \$1948 VDD pfet_06v0 L=1U W=10U AS=3.3P AD=4.4P PS=10.66U
+ PD=20.88U
M$274 \$2770 \$1955 VDD VDD pfet_06v0 L=1U W=10U AS=4.4P AD=2.5P PS=20.88U
+ PD=10.5U
M$275 \$1907 \$1965 \$2770 VDD pfet_06v0 L=1U W=10U AS=2.5P AD=4.4P PS=10.5U
+ PD=20.88U
M$276 \$966 \$963 VDD VDD pfet_06v0 L=1U W=0.5U AS=0.22P AD=0.22P PS=1.88U
+ PD=1.88U
M$277 \$966 \$963 VDD VDD pfet_06v0 L=1U W=0.5U AS=0.22P AD=0.22P PS=1.88U
+ PD=1.88U
M$278 \$966 \$963 VDD VDD pfet_06v0 L=1U W=0.5U AS=0.22P AD=0.22P PS=1.88U
+ PD=1.88U
M$279 \$966 \$963 VDD VDD pfet_06v0 L=1U W=0.5U AS=0.22P AD=0.22P PS=1.88U
+ PD=1.88U
M$280 \$2766 \$1955 VDD VDD pfet_06v0 L=1U W=10U AS=4.4P AD=2.5P PS=20.88U
+ PD=10.5U
M$281 \$1914 \$1965 \$2766 VDD pfet_06v0 L=1U W=10U AS=2.5P AD=4.4P PS=10.5U
+ PD=20.88U
M$282 \$2765 \$1955 VDD VDD pfet_06v0 L=1U W=10U AS=4.4P AD=2.5P PS=20.88U
+ PD=10.5U
M$283 \$1913 \$1965 \$2765 VDD pfet_06v0 L=1U W=10U AS=2.5P AD=4.4P PS=10.5U
+ PD=20.88U
M$284 \$1046 \$1046 VDD VDD pfet_06v0 L=1U W=2U AS=0.88P AD=0.88P PS=4.88U
+ PD=4.88U
M$285 \$2763 \$1955 VDD VDD pfet_06v0 L=1U W=10U AS=4.4P AD=2.5P PS=20.88U
+ PD=10.5U
M$286 \$1955 \$1965 \$2763 VDD pfet_06v0 L=1U W=10U AS=2.5P AD=4.4P PS=10.5U
+ PD=20.88U
M$287 VDD VSS VDD VDD pfet_06v0 L=2U W=18U AS=7.92P AD=7.92P PS=36.88U PD=36.88U
M$288 VDD VSS VDD VDD pfet_06v0 L=2U W=18U AS=7.92P AD=7.92P PS=36.88U PD=36.88U
M$289 \$2761 \$1956 VDD VDD pfet_06v0 L=1U W=10U AS=4.4P AD=2.5P PS=20.88U
+ PD=10.5U
M$290 \$1960 \$1967 \$2761 VDD pfet_06v0 L=1U W=10U AS=2.5P AD=4.4P PS=10.5U
+ PD=20.88U
M$291 \$2760 \$1956 VDD VDD pfet_06v0 L=1U W=10U AS=4.4P AD=2.5P PS=20.88U
+ PD=10.5U
M$292 \$1960 \$1967 \$2760 VDD pfet_06v0 L=1U W=10U AS=2.5P AD=4.4P PS=10.5U
+ PD=20.88U
M$293 \$1032 S1P \$1043 VDD pfet_06v0 L=1U W=1.1U AS=0.484P AD=0.484P PS=3.08U
+ PD=3.08U
M$294 \$970 S1N \$1043 VDD pfet_06v0 L=1U W=1U AS=0.44P AD=0.44P PS=2.88U
+ PD=2.88U
M$295 \$969 \$972 VDD VDD pfet_06v0 L=1U W=5U AS=2.2P AD=1.65P PS=10.88U
+ PD=5.66U
M$296 \$972 \$1047 \$969 VDD pfet_06v0 L=1U W=5U AS=1.65P AD=1.65P PS=5.66U
+ PD=5.66U
M$297 \$971 \$975 \$972 VDD pfet_06v0 L=1U W=5U AS=1.65P AD=2.2P PS=5.66U
+ PD=10.88U
M$298 \$968 \$972 VDD VDD pfet_06v0 L=1U W=5U AS=2.2P AD=1.65P PS=10.88U
+ PD=5.66U
M$299 \$974 \$1047 \$968 VDD pfet_06v0 L=1U W=5U AS=1.65P AD=1.65P PS=5.66U
+ PD=5.66U
M$300 \$973 \$975 \$974 VDD pfet_06v0 L=1U W=5U AS=1.65P AD=2.2P PS=5.66U
+ PD=10.88U
M$301 \$2755 \$1952 VDD VDD pfet_06v0 L=1U W=10U AS=4.4P AD=2.5P PS=20.88U
+ PD=10.5U
M$302 \$1952 \$1967 \$2755 VDD pfet_06v0 L=1U W=10U AS=2.5P AD=3.3P PS=10.5U
+ PD=10.66U
M$303 \$1894 \$1894 \$1952 VDD pfet_06v0 L=1U W=10U AS=3.3P AD=4.4P PS=10.66U
+ PD=20.88U
M$304 \$2753 \$1956 VDD VDD pfet_06v0 L=1U W=10U AS=4.4P AD=2.5P PS=20.88U
+ PD=10.5U
M$305 \$1908 \$1967 \$2753 VDD pfet_06v0 L=1U W=10U AS=2.5P AD=4.4P PS=10.5U
+ PD=20.88U
M$306 \$977 \$974 VDD VDD pfet_06v0 L=1U W=0.5U AS=0.22P AD=0.22P PS=1.88U
+ PD=1.88U
M$307 \$977 \$974 VDD VDD pfet_06v0 L=1U W=0.5U AS=0.22P AD=0.22P PS=1.88U
+ PD=1.88U
M$308 \$977 \$974 VDD VDD pfet_06v0 L=1U W=0.5U AS=0.22P AD=0.22P PS=1.88U
+ PD=1.88U
M$309 \$977 \$974 VDD VDD pfet_06v0 L=1U W=0.5U AS=0.22P AD=0.22P PS=1.88U
+ PD=1.88U
M$310 \$2750 \$1956 VDD VDD pfet_06v0 L=1U W=10U AS=4.4P AD=2.5P PS=20.88U
+ PD=10.5U
M$311 \$1916 \$1967 \$2750 VDD pfet_06v0 L=1U W=10U AS=2.5P AD=4.4P PS=10.5U
+ PD=20.88U
M$312 \$2749 \$1956 VDD VDD pfet_06v0 L=1U W=10U AS=4.4P AD=2.5P PS=20.88U
+ PD=10.5U
M$313 \$1915 \$1967 \$2749 VDD pfet_06v0 L=1U W=10U AS=2.5P AD=4.4P PS=10.5U
+ PD=20.88U
M$314 \$1047 \$1047 VDD VDD pfet_06v0 L=1U W=2U AS=0.88P AD=0.88P PS=4.88U
+ PD=4.88U
M$315 \$2747 \$1956 VDD VDD pfet_06v0 L=1U W=10U AS=4.4P AD=2.5P PS=20.88U
+ PD=10.5U
M$316 \$1956 \$1967 \$2747 VDD pfet_06v0 L=1U W=10U AS=2.5P AD=4.4P PS=10.5U
+ PD=20.88U
M$317 VDD VSS VDD VDD pfet_06v0 L=2U W=18U AS=7.92P AD=7.92P PS=36.88U PD=36.88U
M$318 VDD VSS VDD VDD pfet_06v0 L=2U W=9.75U AS=4.29P AD=4.29P PS=20.38U
+ PD=20.38U
M$319 \$1937 S3P \$1957 VDD pfet_06v0 L=1U W=1.1U AS=0.484P AD=0.484P PS=3.08U
+ PD=3.08U
M$320 \$1860 S3N \$1957 VDD pfet_06v0 L=1U W=1U AS=0.44P AD=0.44P PS=2.88U
+ PD=2.88U
M$321 \$1859 \$1862 VDD VDD pfet_06v0 L=1U W=5U AS=2.2P AD=1.65P PS=10.88U
+ PD=5.66U
M$322 \$1862 \$1961 \$1859 VDD pfet_06v0 L=1U W=5U AS=1.65P AD=1.65P PS=5.66U
+ PD=5.66U
M$323 \$1861 \$1864 \$1862 VDD pfet_06v0 L=1U W=5U AS=1.65P AD=2.2P PS=5.66U
+ PD=10.88U
M$324 \$1858 \$1862 VDD VDD pfet_06v0 L=1U W=5U AS=2.2P AD=1.65P PS=10.88U
+ PD=5.66U
M$325 \$1962 \$1961 \$1858 VDD pfet_06v0 L=1U W=5U AS=1.65P AD=1.65P PS=5.66U
+ PD=5.66U
M$326 \$1863 \$1864 \$1962 VDD pfet_06v0 L=1U W=5U AS=1.65P AD=2.2P PS=5.66U
+ PD=10.88U
M$327 \$2801 \$21 \$2871 VDD pfet_06v0 L=1U W=10U AS=4.4P AD=2.6P PS=20.88U
+ PD=10.52U
M$328 \$2871 \$21 \$2801 VDD pfet_06v0 L=1U W=10U AS=2.6P AD=4.4P PS=10.52U
+ PD=20.88U
M$329 \$2799 \$43 \$2871 VDD pfet_06v0 L=1U W=10U AS=4.4P AD=2.6P PS=20.88U
+ PD=10.52U
M$330 \$2871 \$43 \$2799 VDD pfet_06v0 L=1U W=10U AS=2.6P AD=4.4P PS=10.52U
+ PD=20.88U
M$331 \$1866 \$1962 VDD VDD pfet_06v0 L=1U W=0.5U AS=0.22P AD=0.22P PS=1.88U
+ PD=1.88U
M$332 \$1866 \$1962 VDD VDD pfet_06v0 L=1U W=0.5U AS=0.22P AD=0.22P PS=1.88U
+ PD=1.88U
M$333 \$1866 \$1962 VDD VDD pfet_06v0 L=1U W=0.5U AS=0.22P AD=0.22P PS=1.88U
+ PD=1.88U
M$334 \$1866 \$1962 VDD VDD pfet_06v0 L=1U W=0.5U AS=0.22P AD=0.22P PS=1.88U
+ PD=1.88U
M$335 \$1961 \$1961 VDD VDD pfet_06v0 L=1U W=2U AS=0.88P AD=0.88P PS=4.88U
+ PD=4.88U
M$336 \$2803 \$2781 VDD VDD pfet_06v0 L=1U W=10U AS=4.4P AD=2.6P PS=20.88U
+ PD=10.52U
M$337 VDD \$2781 \$2803 VDD pfet_06v0 L=1U W=10U AS=2.6P AD=2.6P PS=10.52U
+ PD=10.52U
M$338 \$2803 \$2781 VDD VDD pfet_06v0 L=1U W=10U AS=2.6P AD=4.4P PS=10.52U
+ PD=20.88U
M$339 VDD VSS VDD VDD pfet_06v0 L=2U W=9.75U AS=4.29P AD=4.29P PS=20.38U
+ PD=20.38U
M$340 VDD VSS VDD VDD pfet_06v0 L=2U W=9.75U AS=4.29P AD=4.29P PS=20.38U
+ PD=20.38U
M$341 \$1943 S4P \$1958 VDD pfet_06v0 L=1U W=1.1U AS=0.484P AD=0.484P PS=3.08U
+ PD=3.08U
M$342 \$1870 S4N \$1958 VDD pfet_06v0 L=1U W=1U AS=0.44P AD=0.44P PS=2.88U
+ PD=2.88U
M$343 \$1869 \$1872 VDD VDD pfet_06v0 L=1U W=5U AS=2.2P AD=1.65P PS=10.88U
+ PD=5.66U
M$344 \$1872 \$1963 \$1869 VDD pfet_06v0 L=1U W=5U AS=1.65P AD=1.65P PS=5.66U
+ PD=5.66U
M$345 \$1871 \$1874 \$1872 VDD pfet_06v0 L=1U W=5U AS=1.65P AD=2.2P PS=5.66U
+ PD=10.88U
M$346 \$1868 \$1872 VDD VDD pfet_06v0 L=1U W=5U AS=2.2P AD=1.65P PS=10.88U
+ PD=5.66U
M$347 \$1964 \$1963 \$1868 VDD pfet_06v0 L=1U W=5U AS=1.65P AD=1.65P PS=5.66U
+ PD=5.66U
M$348 \$1873 \$1874 \$1964 VDD pfet_06v0 L=1U W=5U AS=1.65P AD=2.2P PS=5.66U
+ PD=10.88U
M$349 \$2810 \$32 \$2872 VDD pfet_06v0 L=1U W=10U AS=4.4P AD=2.6P PS=20.88U
+ PD=10.52U
M$350 \$2872 \$32 \$2810 VDD pfet_06v0 L=1U W=10U AS=2.6P AD=4.4P PS=10.52U
+ PD=20.88U
M$351 \$1876 \$1964 VDD VDD pfet_06v0 L=1U W=0.5U AS=0.22P AD=0.22P PS=1.88U
+ PD=1.88U
M$352 \$2808 \$43 \$2872 VDD pfet_06v0 L=1U W=10U AS=4.4P AD=2.6P PS=20.88U
+ PD=10.52U
M$353 \$2872 \$43 \$2808 VDD pfet_06v0 L=1U W=10U AS=2.6P AD=4.4P PS=10.52U
+ PD=20.88U
M$354 \$1876 \$1964 VDD VDD pfet_06v0 L=1U W=0.5U AS=0.22P AD=0.22P PS=1.88U
+ PD=1.88U
M$355 \$1876 \$1964 VDD VDD pfet_06v0 L=1U W=0.5U AS=0.22P AD=0.22P PS=1.88U
+ PD=1.88U
M$356 \$1876 \$1964 VDD VDD pfet_06v0 L=1U W=0.5U AS=0.22P AD=0.22P PS=1.88U
+ PD=1.88U
M$357 \$1963 \$1963 VDD VDD pfet_06v0 L=1U W=2U AS=0.88P AD=0.88P PS=4.88U
+ PD=4.88U
M$358 \$2812 \$2786 VDD VDD pfet_06v0 L=1U W=10U AS=4.4P AD=2.6P PS=20.88U
+ PD=10.52U
M$359 VDD \$2786 \$2812 VDD pfet_06v0 L=1U W=10U AS=2.6P AD=2.6P PS=10.52U
+ PD=10.52U
M$360 \$2812 \$2786 VDD VDD pfet_06v0 L=1U W=10U AS=2.6P AD=4.4P PS=10.52U
+ PD=20.88U
M$361 VDD VSS VDD VDD pfet_06v0 L=2U W=9.75U AS=4.29P AD=4.29P PS=20.38U
+ PD=20.38U
M$362 \$1945 S2P \$1959 VDD pfet_06v0 L=1U W=1.1U AS=0.484P AD=0.484P PS=3.08U
+ PD=3.08U
M$363 \$1880 S2N \$1959 VDD pfet_06v0 L=1U W=1U AS=0.44P AD=0.44P PS=2.88U
+ PD=2.88U
M$364 VDD VSS VDD VDD pfet_06v0 L=2U W=9.75U AS=4.29P AD=4.29P PS=20.38U
+ PD=20.38U
M$365 \$1879 \$1882 VDD VDD pfet_06v0 L=1U W=5U AS=2.2P AD=1.65P PS=10.88U
+ PD=5.66U
M$366 \$1882 \$1965 \$1879 VDD pfet_06v0 L=1U W=5U AS=1.65P AD=1.65P PS=5.66U
+ PD=5.66U
M$367 \$1881 \$1884 \$1882 VDD pfet_06v0 L=1U W=5U AS=1.65P AD=2.2P PS=5.66U
+ PD=10.88U
M$368 \$1878 \$1882 VDD VDD pfet_06v0 L=1U W=5U AS=2.2P AD=1.65P PS=10.88U
+ PD=5.66U
M$369 \$1966 \$1965 \$1878 VDD pfet_06v0 L=1U W=5U AS=1.65P AD=1.65P PS=5.66U
+ PD=5.66U
M$370 \$1883 \$1884 \$1966 VDD pfet_06v0 L=1U W=5U AS=1.65P AD=2.2P PS=5.66U
+ PD=10.88U
M$371 \$1886 \$1966 VDD VDD pfet_06v0 L=1U W=0.5U AS=0.22P AD=0.22P PS=1.88U
+ PD=1.88U
M$372 \$1886 \$1966 VDD VDD pfet_06v0 L=1U W=0.5U AS=0.22P AD=0.22P PS=1.88U
+ PD=1.88U
M$373 \$2819 \$32 \$2873 VDD pfet_06v0 L=1U W=10U AS=4.4P AD=2.6P PS=20.88U
+ PD=10.52U
M$374 \$2873 \$32 \$2819 VDD pfet_06v0 L=1U W=10U AS=2.6P AD=4.4P PS=10.52U
+ PD=20.88U
M$375 \$1886 \$1966 VDD VDD pfet_06v0 L=1U W=0.5U AS=0.22P AD=0.22P PS=1.88U
+ PD=1.88U
M$376 \$2817 \$21 \$2873 VDD pfet_06v0 L=1U W=10U AS=4.4P AD=2.6P PS=20.88U
+ PD=10.52U
M$377 \$2873 \$21 \$2817 VDD pfet_06v0 L=1U W=10U AS=2.6P AD=4.4P PS=10.52U
+ PD=20.88U
M$378 \$1886 \$1966 VDD VDD pfet_06v0 L=1U W=0.5U AS=0.22P AD=0.22P PS=1.88U
+ PD=1.88U
M$379 \$1965 \$1965 VDD VDD pfet_06v0 L=1U W=2U AS=0.88P AD=0.88P PS=4.88U
+ PD=4.88U
M$380 \$1949 S3P \$1960 VDD pfet_06v0 L=1U W=1.1U AS=0.484P AD=0.484P PS=3.08U
+ PD=3.08U
M$381 \$2821 \$2790 VDD VDD pfet_06v0 L=1U W=10U AS=4.4P AD=2.6P PS=20.88U
+ PD=10.52U
M$382 VDD \$2790 \$2821 VDD pfet_06v0 L=1U W=10U AS=2.6P AD=2.6P PS=10.52U
+ PD=10.52U
M$383 \$2821 \$2790 VDD VDD pfet_06v0 L=1U W=10U AS=2.6P AD=4.4P PS=10.52U
+ PD=20.88U
M$384 \$1890 S3N \$1960 VDD pfet_06v0 L=1U W=1U AS=0.44P AD=0.44P PS=2.88U
+ PD=2.88U
M$385 \$1889 \$1892 VDD VDD pfet_06v0 L=1U W=5U AS=2.2P AD=1.65P PS=10.88U
+ PD=5.66U
M$386 \$1892 \$1967 \$1889 VDD pfet_06v0 L=1U W=5U AS=1.65P AD=1.65P PS=5.66U
+ PD=5.66U
M$387 \$1891 \$1894 \$1892 VDD pfet_06v0 L=1U W=5U AS=1.65P AD=2.2P PS=5.66U
+ PD=10.88U
M$388 VDD VSS VDD VDD pfet_06v0 L=2U W=9.75U AS=4.29P AD=4.29P PS=20.38U
+ PD=20.38U
M$389 \$1888 \$1892 VDD VDD pfet_06v0 L=1U W=5U AS=2.2P AD=1.65P PS=10.88U
+ PD=5.66U
M$390 \$1968 \$1967 \$1888 VDD pfet_06v0 L=1U W=5U AS=1.65P AD=1.65P PS=5.66U
+ PD=5.66U
M$391 \$1893 \$1894 \$1968 VDD pfet_06v0 L=1U W=5U AS=1.65P AD=2.2P PS=5.66U
+ PD=10.88U
M$392 VDD VSS VDD VDD pfet_06v0 L=2U W=9.75U AS=4.29P AD=4.29P PS=20.38U
+ PD=20.38U
M$393 \$1896 \$1968 VDD VDD pfet_06v0 L=1U W=0.5U AS=0.22P AD=0.22P PS=1.88U
+ PD=1.88U
M$394 \$1896 \$1968 VDD VDD pfet_06v0 L=1U W=0.5U AS=0.22P AD=0.22P PS=1.88U
+ PD=1.88U
M$395 \$1896 \$1968 VDD VDD pfet_06v0 L=1U W=0.5U AS=0.22P AD=0.22P PS=1.88U
+ PD=1.88U
M$396 \$1896 \$1968 VDD VDD pfet_06v0 L=1U W=0.5U AS=0.22P AD=0.22P PS=1.88U
+ PD=1.88U
M$397 \$1967 \$1967 VDD VDD pfet_06v0 L=1U W=2U AS=0.88P AD=0.88P PS=4.88U
+ PD=4.88U
M$398 \$4546 \$3404 VDD VDD pfet_06v0 L=1U W=10U AS=4.4P AD=2.5P PS=20.88U
+ PD=10.5U
M$399 \$2795 \$3483 \$4546 VDD pfet_06v0 L=1U W=10U AS=2.5P AD=4.4P PS=10.5U
+ PD=20.88U
M$400 \$4547 \$3404 VDD VDD pfet_06v0 L=1U W=10U AS=4.4P AD=2.5P PS=20.88U
+ PD=10.5U
M$401 \$2780 \$3483 \$4547 VDD pfet_06v0 L=1U W=10U AS=2.5P AD=4.4P PS=10.5U
+ PD=20.88U
M$402 \$4548 \$3404 VDD VDD pfet_06v0 L=1U W=10U AS=4.4P AD=2.5P PS=20.88U
+ PD=10.5U
M$403 \$3404 \$3483 \$4548 VDD pfet_06v0 L=1U W=10U AS=2.5P AD=4.4P PS=10.5U
+ PD=20.88U
M$404 \$4549 \$3404 VDD VDD pfet_06v0 L=1U W=10U AS=4.4P AD=2.5P PS=20.88U
+ PD=10.5U
M$405 \$2871 \$3483 \$4549 VDD pfet_06v0 L=1U W=10U AS=2.5P AD=3.3P PS=10.5U
+ PD=10.66U
M$406 \$4550 \$3483 \$2871 VDD pfet_06v0 L=1U W=10U AS=3.3P AD=2.5P PS=10.66U
+ PD=10.5U
M$407 VDD \$3404 \$4550 VDD pfet_06v0 L=1U W=10U AS=2.5P AD=4.4P PS=10.5U
+ PD=20.88U
M$408 \$4552 \$2859 VDD VDD pfet_06v0 L=1U W=10U AS=4.4P AD=2.5P PS=20.88U
+ PD=10.5U
M$409 \$2859 \$3483 \$4552 VDD pfet_06v0 L=1U W=10U AS=2.5P AD=3.3P PS=10.5U
+ PD=10.66U
M$410 \$2782 \$2782 \$2859 VDD pfet_06v0 L=1U W=10U AS=3.3P AD=4.4P PS=10.66U
+ PD=20.88U
M$411 \$4553 \$3404 VDD VDD pfet_06v0 L=1U W=10U AS=4.4P AD=2.5P PS=20.88U
+ PD=10.5U
M$412 \$2828 \$3483 \$4553 VDD pfet_06v0 L=1U W=10U AS=2.5P AD=4.4P PS=10.5U
+ PD=20.88U
M$413 \$4555 \$3405 VDD VDD pfet_06v0 L=1U W=10U AS=4.4P AD=2.5P PS=20.88U
+ PD=10.5U
M$414 \$2804 \$3485 \$4555 VDD pfet_06v0 L=1U W=10U AS=2.5P AD=4.4P PS=10.5U
+ PD=20.88U
M$415 \$4556 \$3405 VDD VDD pfet_06v0 L=1U W=10U AS=4.4P AD=2.5P PS=20.88U
+ PD=10.5U
M$416 \$2785 \$3485 \$4556 VDD pfet_06v0 L=1U W=10U AS=2.5P AD=4.4P PS=10.5U
+ PD=20.88U
M$417 \$4557 \$3405 VDD VDD pfet_06v0 L=1U W=10U AS=4.4P AD=2.5P PS=20.88U
+ PD=10.5U
M$418 \$3405 \$3485 \$4557 VDD pfet_06v0 L=1U W=10U AS=2.5P AD=4.4P PS=10.5U
+ PD=20.88U
M$419 \$4558 \$3405 VDD VDD pfet_06v0 L=1U W=10U AS=4.4P AD=2.5P PS=20.88U
+ PD=10.5U
M$420 \$2872 \$3485 \$4558 VDD pfet_06v0 L=1U W=10U AS=2.5P AD=3.3P PS=10.5U
+ PD=10.66U
M$421 \$4559 \$3485 \$2872 VDD pfet_06v0 L=1U W=10U AS=3.3P AD=2.5P PS=10.66U
+ PD=10.5U
M$422 VDD \$3405 \$4559 VDD pfet_06v0 L=1U W=10U AS=2.5P AD=4.4P PS=10.5U
+ PD=20.88U
M$423 \$4560 \$2862 VDD VDD pfet_06v0 L=1U W=10U AS=4.4P AD=2.5P PS=20.88U
+ PD=10.5U
M$424 \$2862 \$3485 \$4560 VDD pfet_06v0 L=1U W=10U AS=2.5P AD=3.3P PS=10.5U
+ PD=10.66U
M$425 \$2787 \$2787 \$2862 VDD pfet_06v0 L=1U W=10U AS=3.3P AD=4.4P PS=10.66U
+ PD=20.88U
M$426 \$4561 \$3405 VDD VDD pfet_06v0 L=1U W=10U AS=4.4P AD=2.5P PS=20.88U
+ PD=10.5U
M$427 \$2829 \$3485 \$4561 VDD pfet_06v0 L=1U W=10U AS=2.5P AD=4.4P PS=10.5U
+ PD=20.88U
M$428 \$4562 \$3406 VDD VDD pfet_06v0 L=1U W=10U AS=4.4P AD=2.5P PS=20.88U
+ PD=10.5U
M$429 \$2813 \$3487 \$4562 VDD pfet_06v0 L=1U W=10U AS=2.5P AD=4.4P PS=10.5U
+ PD=20.88U
M$430 \$4563 \$3406 VDD VDD pfet_06v0 L=1U W=10U AS=4.4P AD=2.5P PS=20.88U
+ PD=10.5U
M$431 \$2789 \$3487 \$4563 VDD pfet_06v0 L=1U W=10U AS=2.5P AD=4.4P PS=10.5U
+ PD=20.88U
M$432 \$4564 \$3406 VDD VDD pfet_06v0 L=1U W=10U AS=4.4P AD=2.5P PS=20.88U
+ PD=10.5U
M$433 \$3406 \$3487 \$4564 VDD pfet_06v0 L=1U W=10U AS=2.5P AD=4.4P PS=10.5U
+ PD=20.88U
M$434 \$4565 \$3406 VDD VDD pfet_06v0 L=1U W=10U AS=4.4P AD=2.5P PS=20.88U
+ PD=10.5U
M$435 \$2873 \$3487 \$4565 VDD pfet_06v0 L=1U W=10U AS=2.5P AD=3.3P PS=10.5U
+ PD=10.66U
M$436 \$4566 \$3487 \$2873 VDD pfet_06v0 L=1U W=10U AS=3.3P AD=2.5P PS=10.66U
+ PD=10.5U
M$437 VDD \$3406 \$4566 VDD pfet_06v0 L=1U W=10U AS=2.5P AD=4.4P PS=10.5U
+ PD=20.88U
M$438 \$4554 \$2865 VDD VDD pfet_06v0 L=1U W=10U AS=4.4P AD=2.5P PS=20.88U
+ PD=10.5U
M$439 \$2865 \$3487 \$4554 VDD pfet_06v0 L=1U W=10U AS=2.5P AD=3.3P PS=10.5U
+ PD=10.66U
M$440 \$2791 \$2791 \$2865 VDD pfet_06v0 L=1U W=10U AS=3.3P AD=4.4P PS=10.66U
+ PD=20.88U
M$441 \$4551 \$3406 VDD VDD pfet_06v0 L=1U W=10U AS=4.4P AD=2.5P PS=20.88U
+ PD=10.5U
M$442 \$2830 \$3487 \$4551 VDD pfet_06v0 L=1U W=10U AS=2.5P AD=4.4P PS=10.5U
+ PD=20.88U
M$443 VDD VSS VDD VDD pfet_06v0 L=2U W=9.75U AS=4.29P AD=4.29P PS=20.38U
+ PD=20.38U
M$444 \$3483 \$3483 VDD VDD pfet_06v0 L=1U W=2U AS=0.88P AD=0.88P PS=4.88U
+ PD=4.88U
M$445 \$4592 \$54 \$4739 VDD pfet_06v0 L=1U W=10U AS=4.4P AD=2.6P PS=20.88U
+ PD=10.52U
M$446 \$4739 \$54 \$4592 VDD pfet_06v0 L=1U W=10U AS=2.6P AD=4.4P PS=10.52U
+ PD=20.88U
M$447 \$4590 \$955 \$4739 VDD pfet_06v0 L=1U W=10U AS=4.4P AD=2.6P PS=20.88U
+ PD=10.52U
M$448 \$4739 \$955 \$4590 VDD pfet_06v0 L=1U W=10U AS=2.6P AD=4.4P PS=10.52U
+ PD=20.88U
M$449 \$2949 \$3483 \$2798 VDD pfet_06v0 L=1U W=5U AS=2.2P AD=1.3P PS=10.88U
+ PD=5.52U
M$450 \$2798 \$3483 \$2949 VDD pfet_06v0 L=1U W=5U AS=1.3P AD=2.2P PS=5.52U
+ PD=10.88U
M$451 \$2781 \$3483 \$2797 VDD pfet_06v0 L=1U W=5U AS=2.2P AD=1.3P PS=10.88U
+ PD=5.52U
M$452 \$2797 \$3483 \$2781 VDD pfet_06v0 L=1U W=5U AS=1.3P AD=2.2P PS=5.52U
+ PD=10.88U
M$453 \$2798 \$2949 VDD VDD pfet_06v0 L=1U W=5U AS=2.2P AD=1.3P PS=10.88U
+ PD=5.52U
M$454 VDD \$2949 \$2798 VDD pfet_06v0 L=1U W=5U AS=1.3P AD=1.3P PS=5.52U
+ PD=5.52U
M$455 \$2798 \$2949 VDD VDD pfet_06v0 L=1U W=5U AS=1.3P AD=1.3P PS=5.52U
+ PD=5.52U
M$456 VDD \$2949 \$2798 VDD pfet_06v0 L=1U W=5U AS=1.3P AD=2.2P PS=5.52U
+ PD=10.88U
M$457 \$2797 \$2949 VDD VDD pfet_06v0 L=1U W=5U AS=2.2P AD=1.3P PS=10.88U
+ PD=5.52U
M$458 VDD \$2949 \$2797 VDD pfet_06v0 L=1U W=5U AS=1.3P AD=1.3P PS=5.52U
+ PD=5.52U
M$459 \$2797 \$2949 VDD VDD pfet_06v0 L=1U W=5U AS=1.3P AD=1.3P PS=5.52U
+ PD=5.52U
M$460 VDD \$2949 \$2797 VDD pfet_06v0 L=1U W=5U AS=1.3P AD=2.2P PS=5.52U
+ PD=10.88U
M$461 \$2800 \$2782 \$2949 VDD pfet_06v0 L=1U W=5U AS=2.2P AD=2.2P PS=10.88U
+ PD=10.88U
M$462 \$2802 \$2782 \$2781 VDD pfet_06v0 L=1U W=5U AS=2.2P AD=2.2P PS=10.88U
+ PD=10.88U
M$463 \$4594 \$4572 VDD VDD pfet_06v0 L=1U W=10U AS=4.4P AD=2.6P PS=20.88U
+ PD=10.52U
M$464 VDD \$4572 \$4594 VDD pfet_06v0 L=1U W=10U AS=2.6P AD=2.6P PS=10.52U
+ PD=10.52U
M$465 \$4594 \$4572 VDD VDD pfet_06v0 L=1U W=10U AS=2.6P AD=4.4P PS=10.52U
+ PD=20.88U
M$466 VDD VSS VDD VDD pfet_06v0 L=2U W=9.75U AS=4.29P AD=4.29P PS=20.38U
+ PD=20.38U
M$467 VDD VSS VDD VDD pfet_06v0 L=2U W=9.75U AS=4.29P AD=4.29P PS=20.38U
+ PD=20.38U
M$468 \$3485 \$3485 VDD VDD pfet_06v0 L=1U W=2U AS=0.88P AD=0.88P PS=4.88U
+ PD=4.88U
M$469 \$4600 \$944 \$4741 VDD pfet_06v0 L=1U W=10U AS=4.4P AD=2.6P PS=20.88U
+ PD=10.52U
M$470 \$4741 \$944 \$4600 VDD pfet_06v0 L=1U W=10U AS=2.6P AD=4.4P PS=10.52U
+ PD=20.88U
M$471 \$4598 \$955 \$4741 VDD pfet_06v0 L=1U W=10U AS=4.4P AD=2.6P PS=20.88U
+ PD=10.52U
M$472 \$4741 \$955 \$4598 VDD pfet_06v0 L=1U W=10U AS=2.6P AD=4.4P PS=10.52U
+ PD=20.88U
M$473 \$2950 \$3485 \$2807 VDD pfet_06v0 L=1U W=5U AS=2.2P AD=1.3P PS=10.88U
+ PD=5.52U
M$474 \$2807 \$3485 \$2950 VDD pfet_06v0 L=1U W=5U AS=1.3P AD=2.2P PS=5.52U
+ PD=10.88U
M$475 \$2786 \$3485 \$2806 VDD pfet_06v0 L=1U W=5U AS=2.2P AD=1.3P PS=10.88U
+ PD=5.52U
M$476 \$2806 \$3485 \$2786 VDD pfet_06v0 L=1U W=5U AS=1.3P AD=2.2P PS=5.52U
+ PD=10.88U
M$477 \$2807 \$2950 VDD VDD pfet_06v0 L=1U W=5U AS=2.2P AD=1.3P PS=10.88U
+ PD=5.52U
M$478 VDD \$2950 \$2807 VDD pfet_06v0 L=1U W=5U AS=1.3P AD=1.3P PS=5.52U
+ PD=5.52U
M$479 \$2807 \$2950 VDD VDD pfet_06v0 L=1U W=5U AS=1.3P AD=1.3P PS=5.52U
+ PD=5.52U
M$480 VDD \$2950 \$2807 VDD pfet_06v0 L=1U W=5U AS=1.3P AD=2.2P PS=5.52U
+ PD=10.88U
M$481 \$2806 \$2950 VDD VDD pfet_06v0 L=1U W=5U AS=2.2P AD=1.3P PS=10.88U
+ PD=5.52U
M$482 VDD \$2950 \$2806 VDD pfet_06v0 L=1U W=5U AS=1.3P AD=1.3P PS=5.52U
+ PD=5.52U
M$483 \$2806 \$2950 VDD VDD pfet_06v0 L=1U W=5U AS=1.3P AD=1.3P PS=5.52U
+ PD=5.52U
M$484 VDD \$2950 \$2806 VDD pfet_06v0 L=1U W=5U AS=1.3P AD=2.2P PS=5.52U
+ PD=10.88U
M$485 \$2809 \$2787 \$2950 VDD pfet_06v0 L=1U W=5U AS=2.2P AD=2.2P PS=10.88U
+ PD=10.88U
M$486 \$2811 \$2787 \$2786 VDD pfet_06v0 L=1U W=5U AS=2.2P AD=2.2P PS=10.88U
+ PD=10.88U
M$487 \$4602 \$4576 VDD VDD pfet_06v0 L=1U W=10U AS=4.4P AD=2.6P PS=20.88U
+ PD=10.52U
M$488 VDD \$4576 \$4602 VDD pfet_06v0 L=1U W=10U AS=2.6P AD=2.6P PS=10.52U
+ PD=10.52U
M$489 \$4602 \$4576 VDD VDD pfet_06v0 L=1U W=10U AS=2.6P AD=4.4P PS=10.52U
+ PD=20.88U
M$490 VDD VSS VDD VDD pfet_06v0 L=2U W=9.75U AS=4.29P AD=4.29P PS=20.38U
+ PD=20.38U
M$491 VDD VSS VDD VDD pfet_06v0 L=2U W=9.75U AS=4.29P AD=4.29P PS=20.38U
+ PD=20.38U
M$492 \$3487 \$3487 VDD VDD pfet_06v0 L=1U W=2U AS=0.88P AD=0.88P PS=4.88U
+ PD=4.88U
M$493 \$4608 \$944 \$4743 VDD pfet_06v0 L=1U W=10U AS=4.4P AD=2.6P PS=20.88U
+ PD=10.52U
M$494 \$4743 \$944 \$4608 VDD pfet_06v0 L=1U W=10U AS=2.6P AD=4.4P PS=10.52U
+ PD=20.88U
M$495 \$4606 \$54 \$4743 VDD pfet_06v0 L=1U W=10U AS=4.4P AD=2.6P PS=20.88U
+ PD=10.52U
M$496 \$4743 \$54 \$4606 VDD pfet_06v0 L=1U W=10U AS=2.6P AD=4.4P PS=10.52U
+ PD=20.88U
M$497 \$2951 \$3487 \$2816 VDD pfet_06v0 L=1U W=5U AS=2.2P AD=1.3P PS=10.88U
+ PD=5.52U
M$498 \$2816 \$3487 \$2951 VDD pfet_06v0 L=1U W=5U AS=1.3P AD=2.2P PS=5.52U
+ PD=10.88U
M$499 \$2790 \$3487 \$2815 VDD pfet_06v0 L=1U W=5U AS=2.2P AD=1.3P PS=10.88U
+ PD=5.52U
M$500 \$2815 \$3487 \$2790 VDD pfet_06v0 L=1U W=5U AS=1.3P AD=2.2P PS=5.52U
+ PD=10.88U
M$501 \$2816 \$2951 VDD VDD pfet_06v0 L=1U W=5U AS=2.2P AD=1.3P PS=10.88U
+ PD=5.52U
M$502 VDD \$2951 \$2816 VDD pfet_06v0 L=1U W=5U AS=1.3P AD=1.3P PS=5.52U
+ PD=5.52U
M$503 \$2816 \$2951 VDD VDD pfet_06v0 L=1U W=5U AS=1.3P AD=1.3P PS=5.52U
+ PD=5.52U
M$504 VDD \$2951 \$2816 VDD pfet_06v0 L=1U W=5U AS=1.3P AD=2.2P PS=5.52U
+ PD=10.88U
M$505 \$2815 \$2951 VDD VDD pfet_06v0 L=1U W=5U AS=2.2P AD=1.3P PS=10.88U
+ PD=5.52U
M$506 VDD \$2951 \$2815 VDD pfet_06v0 L=1U W=5U AS=1.3P AD=1.3P PS=5.52U
+ PD=5.52U
M$507 \$2815 \$2951 VDD VDD pfet_06v0 L=1U W=5U AS=1.3P AD=1.3P PS=5.52U
+ PD=5.52U
M$508 VDD \$2951 \$2815 VDD pfet_06v0 L=1U W=5U AS=1.3P AD=2.2P PS=5.52U
+ PD=10.88U
M$509 \$2818 \$2791 \$2951 VDD pfet_06v0 L=1U W=5U AS=2.2P AD=2.2P PS=10.88U
+ PD=10.88U
M$510 \$2820 \$2791 \$2790 VDD pfet_06v0 L=1U W=5U AS=2.2P AD=2.2P PS=10.88U
+ PD=10.88U
M$511 \$4610 \$4581 VDD VDD pfet_06v0 L=1U W=10U AS=4.4P AD=2.6P PS=20.88U
+ PD=10.52U
M$512 VDD \$4581 \$4610 VDD pfet_06v0 L=1U W=10U AS=2.6P AD=2.6P PS=10.52U
+ PD=10.52U
M$513 \$4610 \$4581 VDD VDD pfet_06v0 L=1U W=10U AS=2.6P AD=4.4P PS=10.52U
+ PD=20.88U
M$514 VDD VSS VDD VDD pfet_06v0 L=2U W=9.75U AS=4.29P AD=4.29P PS=20.38U
+ PD=20.38U
M$515 VDD VSS VDD VDD pfet_06v0 L=2U W=9.75U AS=4.29P AD=4.29P PS=20.38U
+ PD=20.38U
M$516 X X VDD VDD pfet_06v0 L=1U W=2U AS=0.88P AD=0.52P PS=4.88U PD=2.52U
M$517 VDD X X VDD pfet_06v0 L=1U W=2U AS=0.52P AD=0.52P PS=2.52U PD=2.52U
M$518 X X VDD VDD pfet_06v0 L=1U W=2U AS=0.52P AD=0.52P PS=2.52U PD=2.52U
M$519 VDD X X VDD pfet_06v0 L=1U W=2U AS=0.52P AD=0.52P PS=2.52U PD=2.52U
M$520 X X VDD VDD pfet_06v0 L=1U W=2U AS=0.52P AD=0.52P PS=2.52U PD=2.52U
M$521 VDD X X VDD pfet_06v0 L=1U W=2U AS=0.52P AD=0.88P PS=2.52U PD=4.88U
M$522 \$2793 \$2793 VDD VDD pfet_06v0 L=1U W=2U AS=0.88P AD=0.88P PS=4.88U
+ PD=4.88U
M$523 \$6335 \$5122 VDD VDD pfet_06v0 L=1U W=10U AS=4.4P AD=2.5P PS=20.88U
+ PD=10.5U
M$524 \$4617 \$5123 \$6335 VDD pfet_06v0 L=1U W=10U AS=2.5P AD=4.4P PS=10.5U
+ PD=20.88U
M$525 \$6336 \$5122 VDD VDD pfet_06v0 L=1U W=10U AS=4.4P AD=2.5P PS=20.88U
+ PD=10.5U
M$526 \$4571 \$5123 \$6336 VDD pfet_06v0 L=1U W=10U AS=2.5P AD=4.4P PS=10.5U
+ PD=20.88U
M$527 \$6337 \$5122 VDD VDD pfet_06v0 L=1U W=10U AS=4.4P AD=2.5P PS=20.88U
+ PD=10.5U
M$528 \$5122 \$5123 \$6337 VDD pfet_06v0 L=1U W=10U AS=2.5P AD=4.4P PS=10.5U
+ PD=20.88U
M$529 \$6338 \$5122 VDD VDD pfet_06v0 L=1U W=10U AS=4.4P AD=2.5P PS=20.88U
+ PD=10.5U
M$530 \$4739 \$5123 \$6338 VDD pfet_06v0 L=1U W=10U AS=2.5P AD=3.3P PS=10.5U
+ PD=10.66U
M$531 \$6339 \$5123 \$4739 VDD pfet_06v0 L=1U W=10U AS=3.3P AD=2.5P PS=10.66U
+ PD=10.5U
M$532 VDD \$5122 \$6339 VDD pfet_06v0 L=1U W=10U AS=2.5P AD=4.4P PS=10.5U
+ PD=20.88U
M$533 \$6342 \$4660 VDD VDD pfet_06v0 L=1U W=10U AS=4.4P AD=2.5P PS=20.88U
+ PD=10.5U
M$534 \$4660 \$5123 \$6342 VDD pfet_06v0 L=1U W=10U AS=2.5P AD=3.3P PS=10.5U
+ PD=10.66U
M$535 \$4573 \$4573 \$4660 VDD pfet_06v0 L=1U W=10U AS=3.3P AD=4.4P PS=10.66U
+ PD=20.88U
M$536 \$6343 \$5122 VDD VDD pfet_06v0 L=1U W=10U AS=4.4P AD=2.5P PS=20.88U
+ PD=10.5U
M$537 \$4622 \$5123 \$6343 VDD pfet_06v0 L=1U W=10U AS=2.5P AD=4.4P PS=10.5U
+ PD=20.88U
M$538 \$6344 \$5125 VDD VDD pfet_06v0 L=1U W=10U AS=4.4P AD=2.5P PS=20.88U
+ PD=10.5U
M$539 \$4618 \$5126 \$6344 VDD pfet_06v0 L=1U W=10U AS=2.5P AD=4.4P PS=10.5U
+ PD=20.88U
M$540 \$6345 \$5125 VDD VDD pfet_06v0 L=1U W=10U AS=4.4P AD=2.5P PS=20.88U
+ PD=10.5U
M$541 \$4575 \$5126 \$6345 VDD pfet_06v0 L=1U W=10U AS=2.5P AD=4.4P PS=10.5U
+ PD=20.88U
M$542 \$6346 \$5125 VDD VDD pfet_06v0 L=1U W=10U AS=4.4P AD=2.5P PS=20.88U
+ PD=10.5U
M$543 \$5125 \$5126 \$6346 VDD pfet_06v0 L=1U W=10U AS=2.5P AD=4.4P PS=10.5U
+ PD=20.88U
M$544 \$6347 \$5125 VDD VDD pfet_06v0 L=1U W=10U AS=4.4P AD=2.5P PS=20.88U
+ PD=10.5U
M$545 \$4741 \$5126 \$6347 VDD pfet_06v0 L=1U W=10U AS=2.5P AD=3.3P PS=10.5U
+ PD=10.66U
M$546 \$6348 \$5126 \$4741 VDD pfet_06v0 L=1U W=10U AS=3.3P AD=2.5P PS=10.66U
+ PD=10.5U
M$547 VDD \$5125 \$6348 VDD pfet_06v0 L=1U W=10U AS=2.5P AD=4.4P PS=10.5U
+ PD=20.88U
M$548 \$6352 \$4661 VDD VDD pfet_06v0 L=1U W=10U AS=4.4P AD=2.5P PS=20.88U
+ PD=10.5U
M$549 \$4661 \$5126 \$6352 VDD pfet_06v0 L=1U W=10U AS=2.5P AD=3.3P PS=10.5U
+ PD=10.66U
M$550 \$4577 \$4577 \$4661 VDD pfet_06v0 L=1U W=10U AS=3.3P AD=4.4P PS=10.66U
+ PD=20.88U
M$551 \$6353 \$5125 VDD VDD pfet_06v0 L=1U W=10U AS=4.4P AD=2.5P PS=20.88U
+ PD=10.5U
M$552 \$4625 \$5126 \$6353 VDD pfet_06v0 L=1U W=10U AS=2.5P AD=4.4P PS=10.5U
+ PD=20.88U
M$553 \$6355 \$5128 VDD VDD pfet_06v0 L=1U W=10U AS=4.4P AD=2.5P PS=20.88U
+ PD=10.5U
M$554 \$4619 \$5129 \$6355 VDD pfet_06v0 L=1U W=10U AS=2.5P AD=4.4P PS=10.5U
+ PD=20.88U
M$555 \$6354 \$5128 VDD VDD pfet_06v0 L=1U W=10U AS=4.4P AD=2.5P PS=20.88U
+ PD=10.5U
M$556 \$4580 \$5129 \$6354 VDD pfet_06v0 L=1U W=10U AS=2.5P AD=4.4P PS=10.5U
+ PD=20.88U
M$557 \$6351 \$5128 VDD VDD pfet_06v0 L=1U W=10U AS=4.4P AD=2.5P PS=20.88U
+ PD=10.5U
M$558 \$5128 \$5129 \$6351 VDD pfet_06v0 L=1U W=10U AS=2.5P AD=4.4P PS=10.5U
+ PD=20.88U
M$559 \$6350 \$5128 VDD VDD pfet_06v0 L=1U W=10U AS=4.4P AD=2.5P PS=20.88U
+ PD=10.5U
M$560 \$4743 \$5129 \$6350 VDD pfet_06v0 L=1U W=10U AS=2.5P AD=3.3P PS=10.5U
+ PD=10.66U
M$561 \$6349 \$5129 \$4743 VDD pfet_06v0 L=1U W=10U AS=3.3P AD=2.5P PS=10.66U
+ PD=10.5U
M$562 VDD \$5128 \$6349 VDD pfet_06v0 L=1U W=10U AS=2.5P AD=4.4P PS=10.5U
+ PD=20.88U
M$563 \$6341 \$4662 VDD VDD pfet_06v0 L=1U W=10U AS=4.4P AD=2.5P PS=20.88U
+ PD=10.5U
M$564 \$4662 \$5129 \$6341 VDD pfet_06v0 L=1U W=10U AS=2.5P AD=3.3P PS=10.5U
+ PD=10.66U
M$565 \$4582 \$4582 \$4662 VDD pfet_06v0 L=1U W=10U AS=3.3P AD=4.4P PS=10.66U
+ PD=20.88U
M$566 \$6340 \$5128 VDD VDD pfet_06v0 L=1U W=10U AS=4.4P AD=2.5P PS=20.88U
+ PD=10.5U
M$567 \$4628 \$5129 \$6340 VDD pfet_06v0 L=1U W=10U AS=2.5P AD=4.4P PS=10.5U
+ PD=20.88U
M$568 VDD VSS VDD VDD pfet_06v0 L=2U W=9.75U AS=4.29P AD=4.29P PS=20.38U
+ PD=20.38U
M$569 \$5123 \$5123 VDD VDD pfet_06v0 L=1U W=2U AS=0.88P AD=0.88P PS=4.88U
+ PD=4.88U
M$570 \$6382 \$966 \$6451 VDD pfet_06v0 L=1U W=10U AS=4.4P AD=2.6P PS=20.88U
+ PD=10.52U
M$571 \$6451 \$966 \$6382 VDD pfet_06v0 L=1U W=10U AS=2.6P AD=4.4P PS=10.52U
+ PD=20.88U
M$572 \$6380 \$1866 \$6451 VDD pfet_06v0 L=1U W=10U AS=4.4P AD=2.6P PS=20.88U
+ PD=10.52U
M$573 \$6451 \$1866 \$6380 VDD pfet_06v0 L=1U W=10U AS=2.6P AD=4.4P PS=10.52U
+ PD=20.88U
M$574 \$4740 \$5123 \$4589 VDD pfet_06v0 L=1U W=5U AS=2.2P AD=1.3P PS=10.88U
+ PD=5.52U
M$575 \$4589 \$5123 \$4740 VDD pfet_06v0 L=1U W=5U AS=1.3P AD=2.2P PS=5.52U
+ PD=10.88U
M$576 \$4572 \$5123 \$4588 VDD pfet_06v0 L=1U W=5U AS=2.2P AD=1.3P PS=10.88U
+ PD=5.52U
M$577 \$4588 \$5123 \$4572 VDD pfet_06v0 L=1U W=5U AS=1.3P AD=2.2P PS=5.52U
+ PD=10.88U
M$578 \$4589 \$4740 VDD VDD pfet_06v0 L=1U W=5U AS=2.2P AD=1.3P PS=10.88U
+ PD=5.52U
M$579 VDD \$4740 \$4589 VDD pfet_06v0 L=1U W=5U AS=1.3P AD=1.3P PS=5.52U
+ PD=5.52U
M$580 \$4589 \$4740 VDD VDD pfet_06v0 L=1U W=5U AS=1.3P AD=1.3P PS=5.52U
+ PD=5.52U
M$581 VDD \$4740 \$4589 VDD pfet_06v0 L=1U W=5U AS=1.3P AD=2.2P PS=5.52U
+ PD=10.88U
M$582 \$4588 \$4740 VDD VDD pfet_06v0 L=1U W=5U AS=2.2P AD=1.3P PS=10.88U
+ PD=5.52U
M$583 VDD \$4740 \$4588 VDD pfet_06v0 L=1U W=5U AS=1.3P AD=1.3P PS=5.52U
+ PD=5.52U
M$584 \$4588 \$4740 VDD VDD pfet_06v0 L=1U W=5U AS=1.3P AD=1.3P PS=5.52U
+ PD=5.52U
M$585 VDD \$4740 \$4588 VDD pfet_06v0 L=1U W=5U AS=1.3P AD=2.2P PS=5.52U
+ PD=10.88U
M$586 \$4591 \$4573 \$4740 VDD pfet_06v0 L=1U W=5U AS=2.2P AD=2.2P PS=10.88U
+ PD=10.88U
M$587 \$4593 \$4573 \$4572 VDD pfet_06v0 L=1U W=5U AS=2.2P AD=2.2P PS=10.88U
+ PD=10.88U
M$588 \$6384 \$6363 VDD VDD pfet_06v0 L=1U W=10U AS=4.4P AD=2.6P PS=20.88U
+ PD=10.52U
M$589 VDD \$6363 \$6384 VDD pfet_06v0 L=1U W=10U AS=2.6P AD=2.6P PS=10.52U
+ PD=10.52U
M$590 \$6384 \$6363 VDD VDD pfet_06v0 L=1U W=10U AS=2.6P AD=4.4P PS=10.52U
+ PD=20.88U
M$591 VDD VSS VDD VDD pfet_06v0 L=2U W=9.75U AS=4.29P AD=4.29P PS=20.38U
+ PD=20.38U
M$592 VDD VSS VDD VDD pfet_06v0 L=2U W=9.75U AS=4.29P AD=4.29P PS=20.38U
+ PD=20.38U
M$593 \$5126 \$5126 VDD VDD pfet_06v0 L=1U W=2U AS=0.88P AD=0.88P PS=4.88U
+ PD=4.88U
M$594 \$6390 \$977 \$6452 VDD pfet_06v0 L=1U W=10U AS=4.4P AD=2.6P PS=20.88U
+ PD=10.52U
M$595 \$6452 \$977 \$6390 VDD pfet_06v0 L=1U W=10U AS=2.6P AD=4.4P PS=10.52U
+ PD=20.88U
M$596 \$6388 \$1866 \$6452 VDD pfet_06v0 L=1U W=10U AS=4.4P AD=2.6P PS=20.88U
+ PD=10.52U
M$597 \$6452 \$1866 \$6388 VDD pfet_06v0 L=1U W=10U AS=2.6P AD=4.4P PS=10.52U
+ PD=20.88U
M$598 \$4742 \$5126 \$4597 VDD pfet_06v0 L=1U W=5U AS=2.2P AD=1.3P PS=10.88U
+ PD=5.52U
M$599 \$4597 \$5126 \$4742 VDD pfet_06v0 L=1U W=5U AS=1.3P AD=2.2P PS=5.52U
+ PD=10.88U
M$600 \$4576 \$5126 \$4596 VDD pfet_06v0 L=1U W=5U AS=2.2P AD=1.3P PS=10.88U
+ PD=5.52U
M$601 \$4596 \$5126 \$4576 VDD pfet_06v0 L=1U W=5U AS=1.3P AD=2.2P PS=5.52U
+ PD=10.88U
M$602 \$4597 \$4742 VDD VDD pfet_06v0 L=1U W=5U AS=2.2P AD=1.3P PS=10.88U
+ PD=5.52U
M$603 VDD \$4742 \$4597 VDD pfet_06v0 L=1U W=5U AS=1.3P AD=1.3P PS=5.52U
+ PD=5.52U
M$604 \$4597 \$4742 VDD VDD pfet_06v0 L=1U W=5U AS=1.3P AD=1.3P PS=5.52U
+ PD=5.52U
M$605 VDD \$4742 \$4597 VDD pfet_06v0 L=1U W=5U AS=1.3P AD=2.2P PS=5.52U
+ PD=10.88U
M$606 \$4596 \$4742 VDD VDD pfet_06v0 L=1U W=5U AS=2.2P AD=1.3P PS=10.88U
+ PD=5.52U
M$607 VDD \$4742 \$4596 VDD pfet_06v0 L=1U W=5U AS=1.3P AD=1.3P PS=5.52U
+ PD=5.52U
M$608 \$4596 \$4742 VDD VDD pfet_06v0 L=1U W=5U AS=1.3P AD=1.3P PS=5.52U
+ PD=5.52U
M$609 VDD \$4742 \$4596 VDD pfet_06v0 L=1U W=5U AS=1.3P AD=2.2P PS=5.52U
+ PD=10.88U
M$610 \$4599 \$4577 \$4742 VDD pfet_06v0 L=1U W=5U AS=2.2P AD=2.2P PS=10.88U
+ PD=10.88U
M$611 \$4601 \$4577 \$4576 VDD pfet_06v0 L=1U W=5U AS=2.2P AD=2.2P PS=10.88U
+ PD=10.88U
M$612 \$6392 \$6367 VDD VDD pfet_06v0 L=1U W=10U AS=4.4P AD=2.6P PS=20.88U
+ PD=10.52U
M$613 VDD \$6367 \$6392 VDD pfet_06v0 L=1U W=10U AS=2.6P AD=2.6P PS=10.52U
+ PD=10.52U
M$614 \$6392 \$6367 VDD VDD pfet_06v0 L=1U W=10U AS=2.6P AD=4.4P PS=10.52U
+ PD=20.88U
M$615 VDD VSS VDD VDD pfet_06v0 L=2U W=9.75U AS=4.29P AD=4.29P PS=20.38U
+ PD=20.38U
M$616 VDD VSS VDD VDD pfet_06v0 L=2U W=9.75U AS=4.29P AD=4.29P PS=20.38U
+ PD=20.38U
M$617 \$5129 \$5129 VDD VDD pfet_06v0 L=1U W=2U AS=0.88P AD=0.88P PS=4.88U
+ PD=4.88U
M$618 \$6398 \$977 \$6453 VDD pfet_06v0 L=1U W=10U AS=4.4P AD=2.6P PS=20.88U
+ PD=10.52U
M$619 \$6453 \$977 \$6398 VDD pfet_06v0 L=1U W=10U AS=2.6P AD=4.4P PS=10.52U
+ PD=20.88U
M$620 \$6396 \$966 \$6453 VDD pfet_06v0 L=1U W=10U AS=4.4P AD=2.6P PS=20.88U
+ PD=10.52U
M$621 \$6453 \$966 \$6396 VDD pfet_06v0 L=1U W=10U AS=2.6P AD=4.4P PS=10.52U
+ PD=20.88U
M$622 \$4744 \$5129 \$4605 VDD pfet_06v0 L=1U W=5U AS=2.2P AD=1.3P PS=10.88U
+ PD=5.52U
M$623 \$4605 \$5129 \$4744 VDD pfet_06v0 L=1U W=5U AS=1.3P AD=2.2P PS=5.52U
+ PD=10.88U
M$624 \$4581 \$5129 \$4604 VDD pfet_06v0 L=1U W=5U AS=2.2P AD=1.3P PS=10.88U
+ PD=5.52U
M$625 \$4604 \$5129 \$4581 VDD pfet_06v0 L=1U W=5U AS=1.3P AD=2.2P PS=5.52U
+ PD=10.88U
M$626 \$4605 \$4744 VDD VDD pfet_06v0 L=1U W=5U AS=2.2P AD=1.3P PS=10.88U
+ PD=5.52U
M$627 VDD \$4744 \$4605 VDD pfet_06v0 L=1U W=5U AS=1.3P AD=1.3P PS=5.52U
+ PD=5.52U
M$628 \$4605 \$4744 VDD VDD pfet_06v0 L=1U W=5U AS=1.3P AD=1.3P PS=5.52U
+ PD=5.52U
M$629 VDD \$4744 \$4605 VDD pfet_06v0 L=1U W=5U AS=1.3P AD=2.2P PS=5.52U
+ PD=10.88U
M$630 \$4604 \$4744 VDD VDD pfet_06v0 L=1U W=5U AS=2.2P AD=1.3P PS=10.88U
+ PD=5.52U
M$631 VDD \$4744 \$4604 VDD pfet_06v0 L=1U W=5U AS=1.3P AD=1.3P PS=5.52U
+ PD=5.52U
M$632 \$4604 \$4744 VDD VDD pfet_06v0 L=1U W=5U AS=1.3P AD=1.3P PS=5.52U
+ PD=5.52U
M$633 VDD \$4744 \$4604 VDD pfet_06v0 L=1U W=5U AS=1.3P AD=2.2P PS=5.52U
+ PD=10.88U
M$634 \$4607 \$4582 \$4744 VDD pfet_06v0 L=1U W=5U AS=2.2P AD=2.2P PS=10.88U
+ PD=10.88U
M$635 \$4609 \$4582 \$4581 VDD pfet_06v0 L=1U W=5U AS=2.2P AD=2.2P PS=10.88U
+ PD=10.88U
M$636 \$6400 \$6372 VDD VDD pfet_06v0 L=1U W=10U AS=4.4P AD=2.6P PS=20.88U
+ PD=10.52U
M$637 VDD \$6372 \$6400 VDD pfet_06v0 L=1U W=10U AS=2.6P AD=2.6P PS=10.52U
+ PD=10.52U
M$638 \$6400 \$6372 VDD VDD pfet_06v0 L=1U W=10U AS=2.6P AD=4.4P PS=10.52U
+ PD=20.88U
M$639 VDD VSS VDD VDD pfet_06v0 L=2U W=9.75U AS=4.29P AD=4.29P PS=20.38U
+ PD=20.38U
M$640 VDD VSS VDD VDD pfet_06v0 L=2U W=9.75U AS=4.29P AD=4.29P PS=20.38U
+ PD=20.38U
M$641 Y Y VDD VDD pfet_06v0 L=1U W=2U AS=0.88P AD=0.52P PS=4.88U PD=2.52U
M$642 VDD Y Y VDD pfet_06v0 L=1U W=2U AS=0.52P AD=0.52P PS=2.52U PD=2.52U
M$643 Y Y VDD VDD pfet_06v0 L=1U W=2U AS=0.52P AD=0.52P PS=2.52U PD=2.52U
M$644 VDD Y Y VDD pfet_06v0 L=1U W=2U AS=0.52P AD=0.52P PS=2.52U PD=2.52U
M$645 Y Y VDD VDD pfet_06v0 L=1U W=2U AS=0.52P AD=0.52P PS=2.52U PD=2.52U
M$646 VDD Y Y VDD pfet_06v0 L=1U W=2U AS=0.52P AD=0.88P PS=2.52U PD=4.88U
M$647 \$4584 \$4584 VDD VDD pfet_06v0 L=1U W=2U AS=0.88P AD=0.88P PS=4.88U
+ PD=4.88U
M$648 \$8126 \$6835 VDD VDD pfet_06v0 L=1U W=10U AS=4.4P AD=2.5P PS=20.88U
+ PD=10.5U
M$649 \$6407 \$6989 \$8126 VDD pfet_06v0 L=1U W=10U AS=2.5P AD=4.4P PS=10.5U
+ PD=20.88U
M$650 \$8127 \$6835 VDD VDD pfet_06v0 L=1U W=10U AS=4.4P AD=2.5P PS=20.88U
+ PD=10.5U
M$651 \$6362 \$6989 \$8127 VDD pfet_06v0 L=1U W=10U AS=2.5P AD=4.4P PS=10.5U
+ PD=20.88U
M$652 \$8129 \$6835 VDD VDD pfet_06v0 L=1U W=10U AS=4.4P AD=2.5P PS=20.88U
+ PD=10.5U
M$653 \$6835 \$6989 \$8129 VDD pfet_06v0 L=1U W=10U AS=2.5P AD=4.4P PS=10.5U
+ PD=20.88U
M$654 \$8130 \$6835 VDD VDD pfet_06v0 L=1U W=10U AS=4.4P AD=2.5P PS=20.88U
+ PD=10.5U
M$655 \$6451 \$6989 \$8130 VDD pfet_06v0 L=1U W=10U AS=2.5P AD=3.3P PS=10.5U
+ PD=10.66U
M$656 \$8132 \$6989 \$6451 VDD pfet_06v0 L=1U W=10U AS=3.3P AD=2.5P PS=10.66U
+ PD=10.5U
M$657 VDD \$6835 \$8132 VDD pfet_06v0 L=1U W=10U AS=2.5P AD=4.4P PS=10.5U
+ PD=20.88U
M$658 \$8136 \$6439 VDD VDD pfet_06v0 L=1U W=10U AS=4.4P AD=2.5P PS=20.88U
+ PD=10.5U
M$659 \$6439 \$6989 \$8136 VDD pfet_06v0 L=1U W=10U AS=2.5P AD=3.3P PS=10.5U
+ PD=10.66U
M$660 \$6364 \$6364 \$6439 VDD pfet_06v0 L=1U W=10U AS=3.3P AD=4.4P PS=10.66U
+ PD=20.88U
M$661 \$8138 \$6835 VDD VDD pfet_06v0 L=1U W=10U AS=4.4P AD=2.5P PS=20.88U
+ PD=10.5U
M$662 \$6412 \$6989 \$8138 VDD pfet_06v0 L=1U W=10U AS=2.5P AD=4.4P PS=10.5U
+ PD=20.88U
M$663 \$8141 \$6836 VDD VDD pfet_06v0 L=1U W=10U AS=4.4P AD=2.5P PS=20.88U
+ PD=10.5U
M$664 \$6408 \$6991 \$8141 VDD pfet_06v0 L=1U W=10U AS=2.5P AD=4.4P PS=10.5U
+ PD=20.88U
M$665 \$8143 \$6836 VDD VDD pfet_06v0 L=1U W=10U AS=4.4P AD=2.5P PS=20.88U
+ PD=10.5U
M$666 \$6366 \$6991 \$8143 VDD pfet_06v0 L=1U W=10U AS=2.5P AD=4.4P PS=10.5U
+ PD=20.88U
M$667 \$8144 \$6836 VDD VDD pfet_06v0 L=1U W=10U AS=4.4P AD=2.5P PS=20.88U
+ PD=10.5U
M$668 \$6836 \$6991 \$8144 VDD pfet_06v0 L=1U W=10U AS=2.5P AD=4.4P PS=10.5U
+ PD=20.88U
M$669 \$8145 \$6836 VDD VDD pfet_06v0 L=1U W=10U AS=4.4P AD=2.5P PS=20.88U
+ PD=10.5U
M$670 \$6452 \$6991 \$8145 VDD pfet_06v0 L=1U W=10U AS=2.5P AD=3.3P PS=10.5U
+ PD=10.66U
M$671 \$8146 \$6991 \$6452 VDD pfet_06v0 L=1U W=10U AS=3.3P AD=2.5P PS=10.66U
+ PD=10.5U
M$672 VDD \$6836 \$8146 VDD pfet_06v0 L=1U W=10U AS=2.5P AD=4.4P PS=10.5U
+ PD=20.88U
M$673 \$8142 \$6442 VDD VDD pfet_06v0 L=1U W=10U AS=4.4P AD=2.5P PS=20.88U
+ PD=10.5U
M$674 \$6442 \$6991 \$8142 VDD pfet_06v0 L=1U W=10U AS=2.5P AD=3.3P PS=10.5U
+ PD=10.66U
M$675 \$6368 \$6368 \$6442 VDD pfet_06v0 L=1U W=10U AS=3.3P AD=4.4P PS=10.66U
+ PD=20.88U
M$676 \$8140 \$6836 VDD VDD pfet_06v0 L=1U W=10U AS=4.4P AD=2.5P PS=20.88U
+ PD=10.5U
M$677 \$6415 \$6991 \$8140 VDD pfet_06v0 L=1U W=10U AS=2.5P AD=4.4P PS=10.5U
+ PD=20.88U
M$678 \$8139 \$6837 VDD VDD pfet_06v0 L=1U W=10U AS=4.4P AD=2.5P PS=20.88U
+ PD=10.5U
M$679 \$6409 \$6993 \$8139 VDD pfet_06v0 L=1U W=10U AS=2.5P AD=4.4P PS=10.5U
+ PD=20.88U
M$680 \$8137 \$6837 VDD VDD pfet_06v0 L=1U W=10U AS=4.4P AD=2.5P PS=20.88U
+ PD=10.5U
M$681 \$6371 \$6993 \$8137 VDD pfet_06v0 L=1U W=10U AS=2.5P AD=4.4P PS=10.5U
+ PD=20.88U
M$682 \$8135 \$6837 VDD VDD pfet_06v0 L=1U W=10U AS=4.4P AD=2.5P PS=20.88U
+ PD=10.5U
M$683 \$6837 \$6993 \$8135 VDD pfet_06v0 L=1U W=10U AS=2.5P AD=4.4P PS=10.5U
+ PD=20.88U
M$684 \$8134 \$6837 VDD VDD pfet_06v0 L=1U W=10U AS=4.4P AD=2.5P PS=20.88U
+ PD=10.5U
M$685 \$6453 \$6993 \$8134 VDD pfet_06v0 L=1U W=10U AS=2.5P AD=3.3P PS=10.5U
+ PD=10.66U
M$686 \$8133 \$6993 \$6453 VDD pfet_06v0 L=1U W=10U AS=3.3P AD=2.5P PS=10.66U
+ PD=10.5U
M$687 VDD \$6837 \$8133 VDD pfet_06v0 L=1U W=10U AS=2.5P AD=4.4P PS=10.5U
+ PD=20.88U
M$688 \$8131 \$6445 VDD VDD pfet_06v0 L=1U W=10U AS=4.4P AD=2.5P PS=20.88U
+ PD=10.5U
M$689 \$6445 \$6993 \$8131 VDD pfet_06v0 L=1U W=10U AS=2.5P AD=3.3P PS=10.5U
+ PD=10.66U
M$690 \$6373 \$6373 \$6445 VDD pfet_06v0 L=1U W=10U AS=3.3P AD=4.4P PS=10.66U
+ PD=20.88U
M$691 \$8128 \$6837 VDD VDD pfet_06v0 L=1U W=10U AS=4.4P AD=2.5P PS=20.88U
+ PD=10.5U
M$692 \$6418 \$6993 \$8128 VDD pfet_06v0 L=1U W=10U AS=2.5P AD=4.4P PS=10.5U
+ PD=20.88U
M$693 VDD VSS VDD VDD pfet_06v0 L=2U W=9.75U AS=4.29P AD=4.29P PS=20.38U
+ PD=20.38U
M$694 \$6989 \$6989 VDD VDD pfet_06v0 L=1U W=2U AS=0.88P AD=0.88P PS=4.88U
+ PD=4.88U
M$695 \$6531 \$6989 \$6379 VDD pfet_06v0 L=1U W=5U AS=2.2P AD=1.3P PS=10.88U
+ PD=5.52U
M$696 \$6379 \$6989 \$6531 VDD pfet_06v0 L=1U W=5U AS=1.3P AD=2.2P PS=5.52U
+ PD=10.88U
M$697 \$6363 \$6989 \$6378 VDD pfet_06v0 L=1U W=5U AS=2.2P AD=1.3P PS=10.88U
+ PD=5.52U
M$698 \$6378 \$6989 \$6363 VDD pfet_06v0 L=1U W=5U AS=1.3P AD=2.2P PS=5.52U
+ PD=10.88U
M$699 \$6379 \$6531 VDD VDD pfet_06v0 L=1U W=5U AS=2.2P AD=1.3P PS=10.88U
+ PD=5.52U
M$700 VDD \$6531 \$6379 VDD pfet_06v0 L=1U W=5U AS=1.3P AD=1.3P PS=5.52U
+ PD=5.52U
M$701 \$6379 \$6531 VDD VDD pfet_06v0 L=1U W=5U AS=1.3P AD=1.3P PS=5.52U
+ PD=5.52U
M$702 VDD \$6531 \$6379 VDD pfet_06v0 L=1U W=5U AS=1.3P AD=2.2P PS=5.52U
+ PD=10.88U
M$703 \$6378 \$6531 VDD VDD pfet_06v0 L=1U W=5U AS=2.2P AD=1.3P PS=10.88U
+ PD=5.52U
M$704 VDD \$6531 \$6378 VDD pfet_06v0 L=1U W=5U AS=1.3P AD=1.3P PS=5.52U
+ PD=5.52U
M$705 \$6378 \$6531 VDD VDD pfet_06v0 L=1U W=5U AS=1.3P AD=1.3P PS=5.52U
+ PD=5.52U
M$706 VDD \$6531 \$6378 VDD pfet_06v0 L=1U W=5U AS=1.3P AD=2.2P PS=5.52U
+ PD=10.88U
M$707 \$6381 \$6364 \$6531 VDD pfet_06v0 L=1U W=5U AS=2.2P AD=2.2P PS=10.88U
+ PD=10.88U
M$708 \$6383 \$6364 \$6363 VDD pfet_06v0 L=1U W=5U AS=2.2P AD=2.2P PS=10.88U
+ PD=10.88U
M$709 VDD VSS VDD VDD pfet_06v0 L=2U W=9.75U AS=4.29P AD=4.29P PS=20.38U
+ PD=20.38U
M$710 VDD VSS VDD VDD pfet_06v0 L=2U W=9.75U AS=4.29P AD=4.29P PS=20.38U
+ PD=20.38U
M$711 \$6991 \$6991 VDD VDD pfet_06v0 L=1U W=2U AS=0.88P AD=0.88P PS=4.88U
+ PD=4.88U
M$712 \$6532 \$6991 \$6387 VDD pfet_06v0 L=1U W=5U AS=2.2P AD=1.3P PS=10.88U
+ PD=5.52U
M$713 \$6387 \$6991 \$6532 VDD pfet_06v0 L=1U W=5U AS=1.3P AD=2.2P PS=5.52U
+ PD=10.88U
M$714 \$6367 \$6991 \$6386 VDD pfet_06v0 L=1U W=5U AS=2.2P AD=1.3P PS=10.88U
+ PD=5.52U
M$715 \$6386 \$6991 \$6367 VDD pfet_06v0 L=1U W=5U AS=1.3P AD=2.2P PS=5.52U
+ PD=10.88U
M$716 \$6387 \$6532 VDD VDD pfet_06v0 L=1U W=5U AS=2.2P AD=1.3P PS=10.88U
+ PD=5.52U
M$717 VDD \$6532 \$6387 VDD pfet_06v0 L=1U W=5U AS=1.3P AD=1.3P PS=5.52U
+ PD=5.52U
M$718 \$6387 \$6532 VDD VDD pfet_06v0 L=1U W=5U AS=1.3P AD=1.3P PS=5.52U
+ PD=5.52U
M$719 VDD \$6532 \$6387 VDD pfet_06v0 L=1U W=5U AS=1.3P AD=2.2P PS=5.52U
+ PD=10.88U
M$720 \$6386 \$6532 VDD VDD pfet_06v0 L=1U W=5U AS=2.2P AD=1.3P PS=10.88U
+ PD=5.52U
M$721 VDD \$6532 \$6386 VDD pfet_06v0 L=1U W=5U AS=1.3P AD=1.3P PS=5.52U
+ PD=5.52U
M$722 \$6386 \$6532 VDD VDD pfet_06v0 L=1U W=5U AS=1.3P AD=1.3P PS=5.52U
+ PD=5.52U
M$723 VDD \$6532 \$6386 VDD pfet_06v0 L=1U W=5U AS=1.3P AD=2.2P PS=5.52U
+ PD=10.88U
M$724 \$6389 \$6368 \$6532 VDD pfet_06v0 L=1U W=5U AS=2.2P AD=2.2P PS=10.88U
+ PD=10.88U
M$725 \$6391 \$6368 \$6367 VDD pfet_06v0 L=1U W=5U AS=2.2P AD=2.2P PS=10.88U
+ PD=10.88U
M$726 VDD VSS VDD VDD pfet_06v0 L=2U W=9.75U AS=4.29P AD=4.29P PS=20.38U
+ PD=20.38U
M$727 VDD VSS VDD VDD pfet_06v0 L=2U W=9.75U AS=4.29P AD=4.29P PS=20.38U
+ PD=20.38U
M$728 \$6993 \$6993 VDD VDD pfet_06v0 L=1U W=2U AS=0.88P AD=0.88P PS=4.88U
+ PD=4.88U
M$729 \$6533 \$6993 \$6395 VDD pfet_06v0 L=1U W=5U AS=2.2P AD=1.3P PS=10.88U
+ PD=5.52U
M$730 \$6395 \$6993 \$6533 VDD pfet_06v0 L=1U W=5U AS=1.3P AD=2.2P PS=5.52U
+ PD=10.88U
M$731 \$6372 \$6993 \$6394 VDD pfet_06v0 L=1U W=5U AS=2.2P AD=1.3P PS=10.88U
+ PD=5.52U
M$732 \$6394 \$6993 \$6372 VDD pfet_06v0 L=1U W=5U AS=1.3P AD=2.2P PS=5.52U
+ PD=10.88U
M$733 \$6395 \$6533 VDD VDD pfet_06v0 L=1U W=5U AS=2.2P AD=1.3P PS=10.88U
+ PD=5.52U
M$734 VDD \$6533 \$6395 VDD pfet_06v0 L=1U W=5U AS=1.3P AD=1.3P PS=5.52U
+ PD=5.52U
M$735 \$6395 \$6533 VDD VDD pfet_06v0 L=1U W=5U AS=1.3P AD=1.3P PS=5.52U
+ PD=5.52U
M$736 VDD \$6533 \$6395 VDD pfet_06v0 L=1U W=5U AS=1.3P AD=2.2P PS=5.52U
+ PD=10.88U
M$737 \$6394 \$6533 VDD VDD pfet_06v0 L=1U W=5U AS=2.2P AD=1.3P PS=10.88U
+ PD=5.52U
M$738 VDD \$6533 \$6394 VDD pfet_06v0 L=1U W=5U AS=1.3P AD=1.3P PS=5.52U
+ PD=5.52U
M$739 \$6394 \$6533 VDD VDD pfet_06v0 L=1U W=5U AS=1.3P AD=1.3P PS=5.52U
+ PD=5.52U
M$740 VDD \$6533 \$6394 VDD pfet_06v0 L=1U W=5U AS=1.3P AD=2.2P PS=5.52U
+ PD=10.88U
M$741 \$6397 \$6373 \$6533 VDD pfet_06v0 L=1U W=5U AS=2.2P AD=2.2P PS=10.88U
+ PD=10.88U
M$742 \$6399 \$6373 \$6372 VDD pfet_06v0 L=1U W=5U AS=2.2P AD=2.2P PS=10.88U
+ PD=10.88U
M$743 VDD VSS VDD VDD pfet_06v0 L=2U W=9.75U AS=4.29P AD=4.29P PS=20.38U
+ PD=20.38U
M$744 VDD VSS VDD VDD pfet_06v0 L=2U W=9.75U AS=4.29P AD=4.29P PS=20.38U
+ PD=20.38U
M$745 Z Z VDD VDD pfet_06v0 L=1U W=2U AS=0.88P AD=0.52P PS=4.88U PD=2.52U
M$746 VDD Z Z VDD pfet_06v0 L=1U W=2U AS=0.52P AD=0.52P PS=2.52U PD=2.52U
M$747 Z Z VDD VDD pfet_06v0 L=1U W=2U AS=0.52P AD=0.52P PS=2.52U PD=2.52U
M$748 VDD Z Z VDD pfet_06v0 L=1U W=2U AS=0.52P AD=0.52P PS=2.52U PD=2.52U
M$749 Z Z VDD VDD pfet_06v0 L=1U W=2U AS=0.52P AD=0.52P PS=2.52U PD=2.52U
M$750 VDD Z Z VDD pfet_06v0 L=1U W=2U AS=0.52P AD=0.88P PS=2.52U PD=4.88U
M$751 \$8420 \$2821 \$6684 VDD pfet_06v0 L=1U W=3U AS=1.32P AD=0.75P PS=6.88U
+ PD=3.5U
M$752 VDD \$2812 \$8420 VDD pfet_06v0 L=1U W=3U AS=0.75P AD=1.32P PS=3.5U
+ PD=6.88U
M$753 \$8163 \$2803 VDD VDD pfet_06v0 L=1U W=3U AS=1.32P AD=1.32P PS=6.88U
+ PD=6.88U
M$754 \$4659 \$8191 VDD VDD pfet_06v0 L=1U W=3U AS=1.32P AD=1.32P PS=6.88U
+ PD=6.88U
M$755 \$6375 \$6375 VDD VDD pfet_06v0 L=1U W=2U AS=0.88P AD=0.88P PS=4.88U
+ PD=4.88U
M$756 \$8191 \$2821 VDD VDD pfet_06v0 L=1U W=3U AS=1.32P AD=0.99P PS=6.88U
+ PD=3.66U
M$757 VDD \$8163 \$8191 VDD pfet_06v0 L=1U W=3U AS=0.99P AD=1.32P PS=3.66U
+ PD=6.88U
M$758 \$3328 \$8192 VDD VDD pfet_06v0 L=1U W=3U AS=1.32P AD=1.32P PS=6.88U
+ PD=6.88U
M$759 \$8192 \$2803 VDD VDD pfet_06v0 L=1U W=3U AS=1.32P AD=0.99P PS=6.88U
+ PD=3.66U
M$760 VDD \$2812 \$8192 VDD pfet_06v0 L=1U W=3U AS=0.99P AD=1.32P PS=3.66U
+ PD=6.88U
M$761 VDD VSS VDD VDD pfet_06v0 L=2U W=1.5U AS=0.66P AD=0.66P PS=3.88U PD=3.88U
M$762 VDD VSS VDD VDD pfet_06v0 L=2U W=1.5U AS=0.66P AD=0.66P PS=3.88U PD=3.88U
M$763 VDD VSS VDD VDD pfet_06v0 L=2U W=1.5U AS=0.66P AD=0.66P PS=3.88U PD=3.88U
M$764 VDD VSS VDD VDD pfet_06v0 L=2U W=1.5U AS=0.66P AD=0.66P PS=3.88U PD=3.88U
M$765 \$8170 \$1876 \$8311 VDD pfet_06v0 L=1U W=10U AS=4.4P AD=2.6P PS=20.88U
+ PD=10.52U
M$766 \$8311 \$1876 \$8170 VDD pfet_06v0 L=1U W=10U AS=2.6P AD=4.4P PS=10.52U
+ PD=20.88U
M$767 \$8168 \$1896 \$8311 VDD pfet_06v0 L=1U W=10U AS=4.4P AD=2.6P PS=20.88U
+ PD=10.52U
M$768 \$8311 \$1896 \$8168 VDD pfet_06v0 L=1U W=10U AS=2.6P AD=4.4P PS=10.52U
+ PD=20.88U
M$769 \$8172 \$8152 VDD VDD pfet_06v0 L=1U W=10U AS=4.4P AD=2.6P PS=20.88U
+ PD=10.52U
M$770 VDD \$8152 \$8172 VDD pfet_06v0 L=1U W=10U AS=2.6P AD=2.6P PS=10.52U
+ PD=10.52U
M$771 \$8172 \$8152 VDD VDD pfet_06v0 L=1U W=10U AS=2.6P AD=4.4P PS=10.52U
+ PD=20.88U
M$772 \$8179 \$1886 \$8313 VDD pfet_06v0 L=1U W=10U AS=4.4P AD=2.6P PS=20.88U
+ PD=10.52U
M$773 \$8313 \$1886 \$8179 VDD pfet_06v0 L=1U W=10U AS=2.6P AD=4.4P PS=10.52U
+ PD=20.88U
M$774 \$8177 \$1896 \$8313 VDD pfet_06v0 L=1U W=10U AS=4.4P AD=2.6P PS=20.88U
+ PD=10.52U
M$775 \$8313 \$1896 \$8177 VDD pfet_06v0 L=1U W=10U AS=2.6P AD=4.4P PS=10.52U
+ PD=20.88U
M$776 \$8181 \$8156 VDD VDD pfet_06v0 L=1U W=10U AS=4.4P AD=2.6P PS=20.88U
+ PD=10.52U
M$777 VDD \$8156 \$8181 VDD pfet_06v0 L=1U W=10U AS=2.6P AD=2.6P PS=10.52U
+ PD=10.52U
M$778 \$8181 \$8156 VDD VDD pfet_06v0 L=1U W=10U AS=2.6P AD=4.4P PS=10.52U
+ PD=20.88U
M$779 \$8188 \$1886 \$8315 VDD pfet_06v0 L=1U W=10U AS=4.4P AD=2.6P PS=20.88U
+ PD=10.52U
M$780 \$8315 \$1886 \$8188 VDD pfet_06v0 L=1U W=10U AS=2.6P AD=4.4P PS=10.52U
+ PD=20.88U
M$781 \$8186 \$1876 \$8315 VDD pfet_06v0 L=1U W=10U AS=4.4P AD=2.6P PS=20.88U
+ PD=10.52U
M$782 \$8315 \$1876 \$8186 VDD pfet_06v0 L=1U W=10U AS=2.6P AD=4.4P PS=10.52U
+ PD=20.88U
M$783 \$8190 \$8160 VDD VDD pfet_06v0 L=1U W=10U AS=4.4P AD=2.6P PS=20.88U
+ PD=10.52U
M$784 VDD \$8160 \$8190 VDD pfet_06v0 L=1U W=10U AS=2.6P AD=2.6P PS=10.52U
+ PD=10.52U
M$785 \$8190 \$8160 VDD VDD pfet_06v0 L=1U W=10U AS=2.6P AD=4.4P PS=10.52U
+ PD=20.88U
M$786 \$9906 \$8694 VDD VDD pfet_06v0 L=1U W=10U AS=4.4P AD=2.5P PS=20.88U
+ PD=10.5U
M$787 \$8164 \$8695 \$9906 VDD pfet_06v0 L=1U W=10U AS=2.5P AD=4.4P PS=10.5U
+ PD=20.88U
M$788 \$9907 \$8694 VDD VDD pfet_06v0 L=1U W=10U AS=4.4P AD=2.5P PS=20.88U
+ PD=10.5U
M$789 \$8151 \$8695 \$9907 VDD pfet_06v0 L=1U W=10U AS=2.5P AD=4.4P PS=10.5U
+ PD=20.88U
M$790 \$9908 \$8694 VDD VDD pfet_06v0 L=1U W=10U AS=4.4P AD=2.5P PS=20.88U
+ PD=10.5U
M$791 \$8694 \$8695 \$9908 VDD pfet_06v0 L=1U W=10U AS=2.5P AD=4.4P PS=10.5U
+ PD=20.88U
M$792 \$9909 \$8694 VDD VDD pfet_06v0 L=1U W=10U AS=4.4P AD=2.5P PS=20.88U
+ PD=10.5U
M$793 \$8311 \$8695 \$9909 VDD pfet_06v0 L=1U W=10U AS=2.5P AD=3.3P PS=10.5U
+ PD=10.66U
M$794 \$9910 \$8695 \$8311 VDD pfet_06v0 L=1U W=10U AS=3.3P AD=2.5P PS=10.66U
+ PD=10.5U
M$795 VDD \$8694 \$9910 VDD pfet_06v0 L=1U W=10U AS=2.5P AD=4.4P PS=10.5U
+ PD=20.88U
M$796 \$9913 \$8229 VDD VDD pfet_06v0 L=1U W=10U AS=4.4P AD=2.5P PS=20.88U
+ PD=10.5U
M$797 \$8229 \$8695 \$9913 VDD pfet_06v0 L=1U W=10U AS=2.5P AD=3.3P PS=10.5U
+ PD=10.66U
M$798 \$8153 \$8153 \$8229 VDD pfet_06v0 L=1U W=10U AS=3.3P AD=4.4P PS=10.66U
+ PD=20.88U
M$799 \$9914 \$8694 VDD VDD pfet_06v0 L=1U W=10U AS=4.4P AD=2.5P PS=20.88U
+ PD=10.5U
M$800 \$8201 \$8695 \$9914 VDD pfet_06v0 L=1U W=10U AS=2.5P AD=4.4P PS=10.5U
+ PD=20.88U
M$801 \$9915 \$8697 VDD VDD pfet_06v0 L=1U W=10U AS=4.4P AD=2.5P PS=20.88U
+ PD=10.5U
M$802 \$8173 \$8698 \$9915 VDD pfet_06v0 L=1U W=10U AS=2.5P AD=4.4P PS=10.5U
+ PD=20.88U
M$803 \$9916 \$8697 VDD VDD pfet_06v0 L=1U W=10U AS=4.4P AD=2.5P PS=20.88U
+ PD=10.5U
M$804 \$8155 \$8698 \$9916 VDD pfet_06v0 L=1U W=10U AS=2.5P AD=4.4P PS=10.5U
+ PD=20.88U
M$805 \$9917 \$8697 VDD VDD pfet_06v0 L=1U W=10U AS=4.4P AD=2.5P PS=20.88U
+ PD=10.5U
M$806 \$8697 \$8698 \$9917 VDD pfet_06v0 L=1U W=10U AS=2.5P AD=4.4P PS=10.5U
+ PD=20.88U
M$807 \$9918 \$8697 VDD VDD pfet_06v0 L=1U W=10U AS=4.4P AD=2.5P PS=20.88U
+ PD=10.5U
M$808 \$8313 \$8698 \$9918 VDD pfet_06v0 L=1U W=10U AS=2.5P AD=3.3P PS=10.5U
+ PD=10.66U
M$809 \$9919 \$8698 \$8313 VDD pfet_06v0 L=1U W=10U AS=3.3P AD=2.5P PS=10.66U
+ PD=10.5U
M$810 VDD \$8697 \$9919 VDD pfet_06v0 L=1U W=10U AS=2.5P AD=4.4P PS=10.5U
+ PD=20.88U
M$811 \$9920 \$8232 VDD VDD pfet_06v0 L=1U W=10U AS=4.4P AD=2.5P PS=20.88U
+ PD=10.5U
M$812 \$8232 \$8698 \$9920 VDD pfet_06v0 L=1U W=10U AS=2.5P AD=3.3P PS=10.5U
+ PD=10.66U
M$813 \$8157 \$8157 \$8232 VDD pfet_06v0 L=1U W=10U AS=3.3P AD=4.4P PS=10.66U
+ PD=20.88U
M$814 \$9921 \$8697 VDD VDD pfet_06v0 L=1U W=10U AS=4.4P AD=2.5P PS=20.88U
+ PD=10.5U
M$815 \$8202 \$8698 \$9921 VDD pfet_06v0 L=1U W=10U AS=2.5P AD=4.4P PS=10.5U
+ PD=20.88U
M$816 \$9922 \$8700 VDD VDD pfet_06v0 L=1U W=10U AS=4.4P AD=2.5P PS=20.88U
+ PD=10.5U
M$817 \$8182 \$8701 \$9922 VDD pfet_06v0 L=1U W=10U AS=2.5P AD=4.4P PS=10.5U
+ PD=20.88U
M$818 \$9923 \$8700 VDD VDD pfet_06v0 L=1U W=10U AS=4.4P AD=2.5P PS=20.88U
+ PD=10.5U
M$819 \$8159 \$8701 \$9923 VDD pfet_06v0 L=1U W=10U AS=2.5P AD=4.4P PS=10.5U
+ PD=20.88U
M$820 \$9924 \$8700 VDD VDD pfet_06v0 L=1U W=10U AS=4.4P AD=2.5P PS=20.88U
+ PD=10.5U
M$821 \$8700 \$8701 \$9924 VDD pfet_06v0 L=1U W=10U AS=2.5P AD=4.4P PS=10.5U
+ PD=20.88U
M$822 \$9925 \$8700 VDD VDD pfet_06v0 L=1U W=10U AS=4.4P AD=2.5P PS=20.88U
+ PD=10.5U
M$823 \$8315 \$8701 \$9925 VDD pfet_06v0 L=1U W=10U AS=2.5P AD=3.3P PS=10.5U
+ PD=10.66U
M$824 \$9926 \$8701 \$8315 VDD pfet_06v0 L=1U W=10U AS=3.3P AD=2.5P PS=10.66U
+ PD=10.5U
M$825 VDD \$8700 \$9926 VDD pfet_06v0 L=1U W=10U AS=2.5P AD=4.4P PS=10.5U
+ PD=20.88U
M$826 \$9912 \$8235 VDD VDD pfet_06v0 L=1U W=10U AS=4.4P AD=2.5P PS=20.88U
+ PD=10.5U
M$827 \$8235 \$8701 \$9912 VDD pfet_06v0 L=1U W=10U AS=2.5P AD=3.3P PS=10.5U
+ PD=10.66U
M$828 \$8161 \$8161 \$8235 VDD pfet_06v0 L=1U W=10U AS=3.3P AD=4.4P PS=10.66U
+ PD=20.88U
M$829 \$9911 \$8700 VDD VDD pfet_06v0 L=1U W=10U AS=4.4P AD=2.5P PS=20.88U
+ PD=10.5U
M$830 \$8203 \$8701 \$9911 VDD pfet_06v0 L=1U W=10U AS=2.5P AD=4.4P PS=10.5U
+ PD=20.88U
M$831 VDD VSS VDD VDD pfet_06v0 L=2U W=1.5U AS=0.66P AD=0.66P PS=3.88U PD=3.88U
M$832 \$8695 \$8695 VDD VDD pfet_06v0 L=1U W=2U AS=0.88P AD=0.88P PS=4.88U
+ PD=4.88U
M$833 VDD VSS VDD VDD pfet_06v0 L=2U W=1.5U AS=0.66P AD=0.66P PS=3.88U PD=3.88U
M$834 VDD VSS VDD VDD pfet_06v0 L=2U W=1.5U AS=0.66P AD=0.66P PS=3.88U PD=3.88U
M$835 \$8312 \$8695 \$8167 VDD pfet_06v0 L=1U W=5U AS=2.2P AD=1.3P PS=10.88U
+ PD=5.52U
M$836 \$8167 \$8695 \$8312 VDD pfet_06v0 L=1U W=5U AS=1.3P AD=2.2P PS=5.52U
+ PD=10.88U
M$837 \$8152 \$8695 \$8166 VDD pfet_06v0 L=1U W=5U AS=2.2P AD=1.3P PS=10.88U
+ PD=5.52U
M$838 \$8166 \$8695 \$8152 VDD pfet_06v0 L=1U W=5U AS=1.3P AD=2.2P PS=5.52U
+ PD=10.88U
M$839 \$8167 \$8312 VDD VDD pfet_06v0 L=1U W=5U AS=2.2P AD=1.3P PS=10.88U
+ PD=5.52U
M$840 VDD \$8312 \$8167 VDD pfet_06v0 L=1U W=5U AS=1.3P AD=1.3P PS=5.52U
+ PD=5.52U
M$841 \$8167 \$8312 VDD VDD pfet_06v0 L=1U W=5U AS=1.3P AD=1.3P PS=5.52U
+ PD=5.52U
M$842 VDD \$8312 \$8167 VDD pfet_06v0 L=1U W=5U AS=1.3P AD=2.2P PS=5.52U
+ PD=10.88U
M$843 \$8166 \$8312 VDD VDD pfet_06v0 L=1U W=5U AS=2.2P AD=1.3P PS=10.88U
+ PD=5.52U
M$844 VDD \$8312 \$8166 VDD pfet_06v0 L=1U W=5U AS=1.3P AD=1.3P PS=5.52U
+ PD=5.52U
M$845 \$8166 \$8312 VDD VDD pfet_06v0 L=1U W=5U AS=1.3P AD=1.3P PS=5.52U
+ PD=5.52U
M$846 VDD \$8312 \$8166 VDD pfet_06v0 L=1U W=5U AS=1.3P AD=2.2P PS=5.52U
+ PD=10.88U
M$847 \$8169 \$8153 \$8312 VDD pfet_06v0 L=1U W=5U AS=2.2P AD=2.2P PS=10.88U
+ PD=10.88U
M$848 \$8171 \$8153 \$8152 VDD pfet_06v0 L=1U W=5U AS=2.2P AD=2.2P PS=10.88U
+ PD=10.88U
M$849 VDD VSS VDD VDD pfet_06v0 L=2U W=1.5U AS=0.66P AD=0.66P PS=3.88U PD=3.88U
M$850 VDD VSS VDD VDD pfet_06v0 L=2U W=1.5U AS=0.66P AD=0.66P PS=3.88U PD=3.88U
M$851 \$8698 \$8698 VDD VDD pfet_06v0 L=1U W=2U AS=0.88P AD=0.88P PS=4.88U
+ PD=4.88U
M$852 VDD VSS VDD VDD pfet_06v0 L=2U W=1.5U AS=0.66P AD=0.66P PS=3.88U PD=3.88U
M$853 VDD VSS VDD VDD pfet_06v0 L=2U W=1.5U AS=0.66P AD=0.66P PS=3.88U PD=3.88U
M$854 VDD VSS VDD VDD pfet_06v0 L=2U W=1.5U AS=0.66P AD=0.66P PS=3.88U PD=3.88U
M$855 VDD VSS VDD VDD pfet_06v0 L=2U W=1.5U AS=0.66P AD=0.66P PS=3.88U PD=3.88U
M$856 VDD VSS VDD VDD pfet_06v0 L=2U W=1.5U AS=0.66P AD=0.66P PS=3.88U PD=3.88U
M$857 \$8314 \$8698 \$8176 VDD pfet_06v0 L=1U W=5U AS=2.2P AD=1.3P PS=10.88U
+ PD=5.52U
M$858 \$8176 \$8698 \$8314 VDD pfet_06v0 L=1U W=5U AS=1.3P AD=2.2P PS=5.52U
+ PD=10.88U
M$859 VDD VSS VDD VDD pfet_06v0 L=2U W=1.5U AS=0.66P AD=0.66P PS=3.88U PD=3.88U
M$860 \$8156 \$8698 \$8175 VDD pfet_06v0 L=1U W=5U AS=2.2P AD=1.3P PS=10.88U
+ PD=5.52U
M$861 \$8175 \$8698 \$8156 VDD pfet_06v0 L=1U W=5U AS=1.3P AD=2.2P PS=5.52U
+ PD=10.88U
M$862 VDD VSS VDD VDD pfet_06v0 L=2U W=1.5U AS=0.66P AD=0.66P PS=3.88U PD=3.88U
M$863 \$8176 \$8314 VDD VDD pfet_06v0 L=1U W=5U AS=2.2P AD=1.3P PS=10.88U
+ PD=5.52U
M$864 VDD \$8314 \$8176 VDD pfet_06v0 L=1U W=5U AS=1.3P AD=1.3P PS=5.52U
+ PD=5.52U
M$865 \$8176 \$8314 VDD VDD pfet_06v0 L=1U W=5U AS=1.3P AD=1.3P PS=5.52U
+ PD=5.52U
M$866 VDD \$8314 \$8176 VDD pfet_06v0 L=1U W=5U AS=1.3P AD=2.2P PS=5.52U
+ PD=10.88U
M$867 VDD VSS VDD VDD pfet_06v0 L=2U W=1.5U AS=0.66P AD=0.66P PS=3.88U PD=3.88U
M$868 \$8175 \$8314 VDD VDD pfet_06v0 L=1U W=5U AS=2.2P AD=1.3P PS=10.88U
+ PD=5.52U
M$869 VDD \$8314 \$8175 VDD pfet_06v0 L=1U W=5U AS=1.3P AD=1.3P PS=5.52U
+ PD=5.52U
M$870 \$8175 \$8314 VDD VDD pfet_06v0 L=1U W=5U AS=1.3P AD=1.3P PS=5.52U
+ PD=5.52U
M$871 VDD \$8314 \$8175 VDD pfet_06v0 L=1U W=5U AS=1.3P AD=2.2P PS=5.52U
+ PD=10.88U
M$872 VDD VSS VDD VDD pfet_06v0 L=2U W=1.5U AS=0.66P AD=0.66P PS=3.88U PD=3.88U
M$873 VDD VSS VDD VDD pfet_06v0 L=2U W=1.5U AS=0.66P AD=0.66P PS=3.88U PD=3.88U
M$874 \$8178 \$8157 \$8314 VDD pfet_06v0 L=1U W=5U AS=2.2P AD=2.2P PS=10.88U
+ PD=10.88U
M$875 VDD VSS VDD VDD pfet_06v0 L=2U W=1.5U AS=0.66P AD=0.66P PS=3.88U PD=3.88U
M$876 \$8180 \$8157 \$8156 VDD pfet_06v0 L=1U W=5U AS=2.2P AD=2.2P PS=10.88U
+ PD=10.88U
M$877 VDD VSS VDD VDD pfet_06v0 L=2U W=1.5U AS=0.66P AD=0.66P PS=3.88U PD=3.88U
M$878 VDD VSS VDD VDD pfet_06v0 L=2U W=1.5U AS=0.66P AD=0.66P PS=3.88U PD=3.88U
M$879 VDD VSS VDD VDD pfet_06v0 L=2U W=1.5U AS=0.66P AD=0.66P PS=3.88U PD=3.88U
M$880 VDD VSS VDD VDD pfet_06v0 L=2U W=1.5U AS=0.66P AD=0.66P PS=3.88U PD=3.88U
M$881 VDD VSS VDD VDD pfet_06v0 L=2U W=1.5U AS=0.66P AD=0.66P PS=3.88U PD=3.88U
M$882 VDD VSS VDD VDD pfet_06v0 L=2U W=1.5U AS=0.66P AD=0.66P PS=3.88U PD=3.88U
M$883 VDD VSS VDD VDD pfet_06v0 L=2U W=1.5U AS=0.66P AD=0.66P PS=3.88U PD=3.88U
M$884 VDD VSS VDD VDD pfet_06v0 L=2U W=1.5U AS=0.66P AD=0.66P PS=3.88U PD=3.88U
M$885 VDD VSS VDD VDD pfet_06v0 L=2U W=1.5U AS=0.66P AD=0.66P PS=3.88U PD=3.88U
M$886 \$8701 \$8701 VDD VDD pfet_06v0 L=1U W=2U AS=0.88P AD=0.88P PS=4.88U
+ PD=4.88U
M$887 VDD VSS VDD VDD pfet_06v0 L=2U W=1.5U AS=0.66P AD=0.66P PS=3.88U PD=3.88U
M$888 VDD VSS VDD VDD pfet_06v0 L=2U W=1.5U AS=0.66P AD=0.66P PS=3.88U PD=3.88U
M$889 VDD VSS VDD VDD pfet_06v0 L=2U W=1.5U AS=0.66P AD=0.66P PS=3.88U PD=3.88U
M$890 VDD VSS VDD VDD pfet_06v0 L=2U W=1.5U AS=0.66P AD=0.66P PS=3.88U PD=3.88U
M$891 VDD VSS VDD VDD pfet_06v0 L=2U W=1.5U AS=0.66P AD=0.66P PS=3.88U PD=3.88U
M$892 VDD VSS VDD VDD pfet_06v0 L=2U W=1.5U AS=0.66P AD=0.66P PS=3.88U PD=3.88U
M$893 \$8316 \$8701 \$8185 VDD pfet_06v0 L=1U W=5U AS=2.2P AD=1.3P PS=10.88U
+ PD=5.52U
M$894 \$8185 \$8701 \$8316 VDD pfet_06v0 L=1U W=5U AS=1.3P AD=2.2P PS=5.52U
+ PD=10.88U
M$895 VDD VSS VDD VDD pfet_06v0 L=2U W=1.5U AS=0.66P AD=0.66P PS=3.88U PD=3.88U
M$896 \$8160 \$8701 \$8184 VDD pfet_06v0 L=1U W=5U AS=2.2P AD=1.3P PS=10.88U
+ PD=5.52U
M$897 \$8184 \$8701 \$8160 VDD pfet_06v0 L=1U W=5U AS=1.3P AD=2.2P PS=5.52U
+ PD=10.88U
M$898 VDD VSS VDD VDD pfet_06v0 L=2U W=1.5U AS=0.66P AD=0.66P PS=3.88U PD=3.88U
M$899 \$8185 \$8316 VDD VDD pfet_06v0 L=1U W=5U AS=2.2P AD=1.3P PS=10.88U
+ PD=5.52U
M$900 VDD \$8316 \$8185 VDD pfet_06v0 L=1U W=5U AS=1.3P AD=1.3P PS=5.52U
+ PD=5.52U
M$901 \$8185 \$8316 VDD VDD pfet_06v0 L=1U W=5U AS=1.3P AD=1.3P PS=5.52U
+ PD=5.52U
M$902 VDD \$8316 \$8185 VDD pfet_06v0 L=1U W=5U AS=1.3P AD=2.2P PS=5.52U
+ PD=10.88U
M$903 VDD VSS VDD VDD pfet_06v0 L=2U W=1.5U AS=0.66P AD=0.66P PS=3.88U PD=3.88U
M$904 \$8184 \$8316 VDD VDD pfet_06v0 L=1U W=5U AS=2.2P AD=1.3P PS=10.88U
+ PD=5.52U
M$905 VDD \$8316 \$8184 VDD pfet_06v0 L=1U W=5U AS=1.3P AD=1.3P PS=5.52U
+ PD=5.52U
M$906 \$8184 \$8316 VDD VDD pfet_06v0 L=1U W=5U AS=1.3P AD=1.3P PS=5.52U
+ PD=5.52U
M$907 VDD \$8316 \$8184 VDD pfet_06v0 L=1U W=5U AS=1.3P AD=2.2P PS=5.52U
+ PD=10.88U
M$908 VDD VSS VDD VDD pfet_06v0 L=2U W=1.5U AS=0.66P AD=0.66P PS=3.88U PD=3.88U
M$909 VDD VSS VDD VDD pfet_06v0 L=2U W=1.5U AS=0.66P AD=0.66P PS=3.88U PD=3.88U
M$910 \$8187 \$8161 \$8316 VDD pfet_06v0 L=1U W=5U AS=2.2P AD=2.2P PS=10.88U
+ PD=10.88U
M$911 VDD VSS VDD VDD pfet_06v0 L=2U W=1.5U AS=0.66P AD=0.66P PS=3.88U PD=3.88U
M$912 \$8189 \$8161 \$8160 VDD pfet_06v0 L=1U W=5U AS=2.2P AD=2.2P PS=10.88U
+ PD=10.88U
M$913 VDD VSS VDD VDD pfet_06v0 L=2U W=1.5U AS=0.66P AD=0.66P PS=3.88U PD=3.88U
M$914 VDD VSS VDD VDD pfet_06v0 L=2U W=1.5U AS=0.66P AD=0.66P PS=3.88U PD=3.88U
M$915 VDD VSS VDD VDD pfet_06v0 L=2U W=1.5U AS=0.66P AD=0.66P PS=3.88U PD=3.88U
M$916 VDD VSS VDD VDD pfet_06v0 L=2U W=1.5U AS=0.66P AD=0.66P PS=3.88U PD=3.88U
M$917 VDD VSS VDD VDD pfet_06v0 L=2U W=1.5U AS=0.66P AD=0.66P PS=3.88U PD=3.88U
M$918 VDD VSS VDD VDD pfet_06v0 L=2U W=1.5U AS=0.66P AD=0.66P PS=3.88U PD=3.88U
M$919 VDD VSS VDD VDD pfet_06v0 L=2U W=1.5U AS=0.66P AD=0.66P PS=3.88U PD=3.88U
M$920 VDD VSS VDD VDD pfet_06v0 L=2U W=1.5U AS=0.66P AD=0.66P PS=3.88U PD=3.88U
M$921 VDD VSS VDD VDD pfet_06v0 L=2U W=1.5U AS=0.66P AD=0.66P PS=3.88U PD=3.88U
M$922 VDD VSS VDD VDD pfet_06v0 L=2U W=1.5U AS=0.66P AD=0.66P PS=3.88U PD=3.88U
M$923 VDD VSS VDD VDD pfet_06v0 L=2U W=1.5U AS=0.66P AD=0.66P PS=3.88U PD=3.88U
M$924 VDD VSS VDD VDD pfet_06v0 L=2U W=1.5U AS=0.66P AD=0.66P PS=3.88U PD=3.88U
M$925 VDD VSS VDD VDD pfet_06v0 L=2U W=1.5U AS=0.66P AD=0.66P PS=3.88U PD=3.88U
M$926 VDD VSS VDD VDD pfet_06v0 L=2U W=1.5U AS=0.66P AD=0.66P PS=3.88U PD=3.88U
M$927 VDD VSS VDD VDD pfet_06v0 L=2U W=1.5U AS=0.66P AD=0.66P PS=3.88U PD=3.88U
M$928 VDD VSS VDD VDD pfet_06v0 L=2U W=1.5U AS=0.66P AD=0.66P PS=3.88U PD=3.88U
M$929 VDD VSS VDD VDD pfet_06v0 L=2U W=1.5U AS=0.66P AD=0.66P PS=3.88U PD=3.88U
M$930 \$9953 \$4610 \$6995 VDD pfet_06v0 L=1U W=3U AS=1.32P AD=0.75P PS=6.88U
+ PD=3.5U
M$931 VDD \$4602 \$9953 VDD pfet_06v0 L=1U W=3U AS=0.75P AD=1.32P PS=3.5U
+ PD=6.88U
M$932 \$9931 \$4594 VDD VDD pfet_06v0 L=1U W=3U AS=1.32P AD=1.32P PS=6.88U
+ PD=6.88U
M$933 \$4656 \$9932 VDD VDD pfet_06v0 L=1U W=3U AS=1.32P AD=1.32P PS=6.88U
+ PD=6.88U
M$934 \$9932 \$4610 VDD VDD pfet_06v0 L=1U W=3U AS=1.32P AD=0.99P PS=6.88U
+ PD=3.66U
M$935 VDD \$9931 \$9932 VDD pfet_06v0 L=1U W=3U AS=0.99P AD=1.32P PS=3.66U
+ PD=6.88U
M$936 \$2856 \$9933 VDD VDD pfet_06v0 L=1U W=3U AS=1.32P AD=1.32P PS=6.88U
+ PD=6.88U
M$937 \$9933 \$4594 VDD VDD pfet_06v0 L=1U W=3U AS=1.32P AD=0.99P PS=6.88U
+ PD=3.66U
M$938 VDD \$4602 \$9933 VDD pfet_06v0 L=1U W=3U AS=0.99P AD=1.32P PS=3.66U
+ PD=6.88U
M$939 \$9954 \$6400 \$6370 VDD pfet_06v0 L=1U W=3U AS=1.32P AD=0.75P PS=6.88U
+ PD=3.5U
M$940 VDD \$6392 \$9954 VDD pfet_06v0 L=1U W=3U AS=0.75P AD=1.32P PS=3.5U
+ PD=6.88U
M$941 \$9934 \$6384 VDD VDD pfet_06v0 L=1U W=3U AS=1.32P AD=1.32P PS=6.88U
+ PD=6.88U
M$942 \$4579 \$9935 VDD VDD pfet_06v0 L=1U W=3U AS=1.32P AD=1.32P PS=6.88U
+ PD=6.88U
M$943 \$9935 \$6400 VDD VDD pfet_06v0 L=1U W=3U AS=1.32P AD=0.99P PS=6.88U
+ PD=3.66U
M$944 VDD \$9934 \$9935 VDD pfet_06v0 L=1U W=3U AS=0.99P AD=1.32P PS=3.66U
+ PD=6.88U
M$945 \$2784 \$9936 VDD VDD pfet_06v0 L=1U W=3U AS=1.32P AD=1.32P PS=6.88U
+ PD=6.88U
M$946 \$9936 \$6384 VDD VDD pfet_06v0 L=1U W=3U AS=1.32P AD=0.99P PS=6.88U
+ PD=3.66U
M$947 VDD \$6392 \$9936 VDD pfet_06v0 L=1U W=3U AS=0.99P AD=1.32P PS=3.66U
+ PD=6.88U
M$948 \$9955 \$8190 \$6447 VDD pfet_06v0 L=1U W=3U AS=1.32P AD=0.75P PS=6.88U
+ PD=3.5U
M$949 VDD \$8181 \$9955 VDD pfet_06v0 L=1U W=3U AS=0.75P AD=1.32P PS=3.5U
+ PD=6.88U
M$950 \$9937 \$8172 VDD VDD pfet_06v0 L=1U W=3U AS=1.32P AD=1.32P PS=6.88U
+ PD=6.88U
M$951 \$4654 \$9938 VDD VDD pfet_06v0 L=1U W=3U AS=1.32P AD=1.32P PS=6.88U
+ PD=6.88U
M$952 \$9938 \$8190 VDD VDD pfet_06v0 L=1U W=3U AS=1.32P AD=0.99P PS=6.88U
+ PD=3.66U
M$953 VDD \$9937 \$9938 VDD pfet_06v0 L=1U W=3U AS=0.99P AD=1.32P PS=3.66U
+ PD=6.88U
M$954 \$2855 \$9939 VDD VDD pfet_06v0 L=1U W=3U AS=1.32P AD=1.32P PS=6.88U
+ PD=6.88U
M$955 \$9939 \$8172 VDD VDD pfet_06v0 L=1U W=3U AS=1.32P AD=0.99P PS=6.88U
+ PD=3.66U
M$956 VDD \$8181 \$9939 VDD pfet_06v0 L=1U W=3U AS=0.99P AD=1.32P PS=3.66U
+ PD=6.88U
M$957 \$2779 X VSS VSS nfet_05v0 L=0.6U W=1.32U AS=0.5808P AD=0.5808P PS=3.52U
+ PD=3.52U
M$958 XP \$2779 VSS VSS nfet_05v0 L=0.6U W=1.32U AS=0.5808P AD=0.5808P PS=3.52U
+ PD=3.52U
M$959 XN XP VSS VSS nfet_05v0 L=0.6U W=1.32U AS=0.5808P AD=0.5808P PS=3.52U
+ PD=3.52U
M$960 \$4570 Y VSS VSS nfet_05v0 L=0.6U W=1.32U AS=0.5808P AD=0.5808P PS=3.52U
+ PD=3.52U
M$961 YP \$4570 VSS VSS nfet_05v0 L=0.6U W=1.32U AS=0.5808P AD=0.5808P PS=3.52U
+ PD=3.52U
M$962 YN YP VSS VSS nfet_05v0 L=0.6U W=1.32U AS=0.5808P AD=0.5808P PS=3.52U
+ PD=3.52U
M$963 \$6361 Z VSS VSS nfet_05v0 L=0.6U W=1.32U AS=0.5808P AD=0.5808P PS=3.52U
+ PD=3.52U
M$964 ZP \$6361 VSS VSS nfet_05v0 L=0.6U W=1.32U AS=0.5808P AD=0.5808P PS=3.52U
+ PD=3.52U
M$965 ZN ZP VSS VSS nfet_05v0 L=0.6U W=1.32U AS=0.5808P AD=0.5808P PS=3.52U
+ PD=3.52U
M$966 \$67 \$87 VSS VSS nfet_06v0 L=1U W=5U AS=2.2P AD=1.25P PS=10.88U PD=5.5U
M$967 \$11 \$88 \$67 VSS nfet_06v0 L=1U W=5U AS=1.25P AD=2.2P PS=5.5U PD=10.88U
M$968 \$69 \$87 VSS VSS nfet_06v0 L=1U W=5U AS=2.2P AD=1.25P PS=10.88U PD=5.5U
M$969 \$11 \$88 \$69 VSS nfet_06v0 L=1U W=5U AS=1.25P AD=2.2P PS=5.5U PD=10.88U
M$970 \$12 S2P \$11 VSS nfet_06v0 L=1U W=1U AS=0.44P AD=0.44P PS=2.88U PD=2.88U
M$971 \$13 S2N \$11 VSS nfet_06v0 L=1U W=1U AS=0.44P AD=0.44P PS=2.88U PD=2.88U
M$972 \$14 \$15 VSS VSS nfet_06v0 L=1U W=2.5U AS=1.1P AD=0.825P PS=5.88U
+ PD=3.16U
M$973 \$15 \$88 \$14 VSS nfet_06v0 L=1U W=2.5U AS=0.825P AD=0.825P PS=3.16U
+ PD=3.16U
M$974 \$16 \$63 \$15 VSS nfet_06v0 L=1U W=2.5U AS=0.825P AD=1.1P PS=3.16U
+ PD=5.88U
M$975 \$104 \$15 VSS VSS nfet_06v0 L=1U W=2.5U AS=1.1P AD=0.825P PS=5.88U
+ PD=3.16U
M$976 \$17 \$88 \$104 VSS nfet_06v0 L=1U W=2.5U AS=0.825P AD=0.825P PS=3.16U
+ PD=3.16U
M$977 \$18 \$63 \$17 VSS nfet_06v0 L=1U W=2.5U AS=0.825P AD=1.1P PS=3.16U
+ PD=5.88U
M$978 \$71 \$87 VSS VSS nfet_06v0 L=1U W=5U AS=2.2P AD=1.25P PS=10.88U PD=5.5U
M$979 \$19 \$88 \$71 VSS nfet_06v0 L=1U W=5U AS=1.25P AD=2.2P PS=5.5U PD=10.88U
M$980 \$72 \$20 VSS VSS nfet_06v0 L=1U W=5U AS=2.2P AD=1.25P PS=10.88U PD=5.5U
M$981 \$20 \$88 \$72 VSS nfet_06v0 L=1U W=5U AS=1.25P AD=1.65P PS=5.5U PD=5.66U
M$982 \$63 \$63 \$20 VSS nfet_06v0 L=1U W=5U AS=1.65P AD=2.2P PS=5.66U PD=10.88U
M$983 \$21 \$17 VSS VSS nfet_06v0 L=1U W=1U AS=0.44P AD=0.44P PS=2.88U PD=2.88U
M$984 \$88 \$88 VSS VSS nfet_06v0 L=1U W=1U AS=0.44P AD=0.44P PS=2.88U PD=2.88U
M$985 \$74 \$87 VSS VSS nfet_06v0 L=1U W=5U AS=2.2P AD=1.25P PS=10.88U PD=5.5U
M$986 \$87 \$88 \$74 VSS nfet_06v0 L=1U W=5U AS=1.25P AD=2.2P PS=5.5U PD=10.88U
M$987 \$57 \$120 VSS VSS nfet_06v0 L=1U W=1U AS=0.44P AD=0.25P PS=2.88U PD=1.5U
M$988 \$111 \$120 \$57 VSS nfet_06v0 L=1U W=1U AS=0.25P AD=0.44P PS=1.5U
+ PD=2.88U
M$989 \$58 \$120 VSS VSS nfet_06v0 L=1U W=1U AS=0.44P AD=0.25P PS=2.88U PD=1.5U
M$990 \$120 \$120 \$58 VSS nfet_06v0 L=1U W=1U AS=0.25P AD=0.44P PS=1.5U
+ PD=2.88U
M$991 \$75 \$89 VSS VSS nfet_06v0 L=1U W=5U AS=2.2P AD=1.25P PS=10.88U PD=5.5U
M$992 \$22 \$90 \$75 VSS nfet_06v0 L=1U W=5U AS=1.25P AD=2.2P PS=5.5U PD=10.88U
M$993 \$76 \$89 VSS VSS nfet_06v0 L=1U W=5U AS=2.2P AD=1.25P PS=10.88U PD=5.5U
M$994 \$22 \$90 \$76 VSS nfet_06v0 L=1U W=5U AS=1.25P AD=2.2P PS=5.5U PD=10.88U
M$995 \$23 S3P \$22 VSS nfet_06v0 L=1U W=1U AS=0.44P AD=0.44P PS=2.88U PD=2.88U
M$996 \$24 S3N \$22 VSS nfet_06v0 L=1U W=1U AS=0.44P AD=0.44P PS=2.88U PD=2.88U
M$997 \$25 \$26 VSS VSS nfet_06v0 L=1U W=2.5U AS=1.1P AD=0.825P PS=5.88U
+ PD=3.16U
M$998 \$26 \$90 \$25 VSS nfet_06v0 L=1U W=2.5U AS=0.825P AD=0.825P PS=3.16U
+ PD=3.16U
M$999 \$27 \$64 \$26 VSS nfet_06v0 L=1U W=2.5U AS=0.825P AD=1.1P PS=3.16U
+ PD=5.88U
M$1000 \$98 \$26 VSS VSS nfet_06v0 L=1U W=2.5U AS=1.1P AD=0.825P PS=5.88U
+ PD=3.16U
M$1001 \$28 \$90 \$98 VSS nfet_06v0 L=1U W=2.5U AS=0.825P AD=0.825P PS=3.16U
+ PD=3.16U
M$1002 \$29 \$64 \$28 VSS nfet_06v0 L=1U W=2.5U AS=0.825P AD=1.1P PS=3.16U
+ PD=5.88U
M$1003 \$79 \$89 VSS VSS nfet_06v0 L=1U W=5U AS=2.2P AD=1.25P PS=10.88U PD=5.5U
M$1004 \$30 \$90 \$79 VSS nfet_06v0 L=1U W=5U AS=1.25P AD=2.2P PS=5.5U PD=10.88U
M$1005 \$80 \$31 VSS VSS nfet_06v0 L=1U W=5U AS=2.2P AD=1.25P PS=10.88U PD=5.5U
M$1006 \$31 \$90 \$80 VSS nfet_06v0 L=1U W=5U AS=1.25P AD=1.65P PS=5.5U PD=5.66U
M$1007 \$64 \$64 \$31 VSS nfet_06v0 L=1U W=5U AS=1.65P AD=2.2P PS=5.66U
+ PD=10.88U
M$1008 \$32 \$28 VSS VSS nfet_06v0 L=1U W=1U AS=0.44P AD=0.44P PS=2.88U PD=2.88U
M$1009 \$90 \$90 VSS VSS nfet_06v0 L=1U W=1U AS=0.44P AD=0.44P PS=2.88U PD=2.88U
M$1010 \$81 \$89 VSS VSS nfet_06v0 L=1U W=5U AS=2.2P AD=1.25P PS=10.88U PD=5.5U
M$1011 \$89 \$90 \$81 VSS nfet_06v0 L=1U W=5U AS=1.25P AD=2.2P PS=5.5U PD=10.88U
M$1012 \$60 \$121 VSS VSS nfet_06v0 L=1U W=1U AS=0.44P AD=0.25P PS=2.88U PD=1.5U
M$1013 \$112 \$121 \$60 VSS nfet_06v0 L=1U W=1U AS=0.25P AD=0.44P PS=1.5U
+ PD=2.88U
M$1014 \$61 \$121 VSS VSS nfet_06v0 L=1U W=1U AS=0.44P AD=0.25P PS=2.88U PD=1.5U
M$1015 \$121 \$121 \$61 VSS nfet_06v0 L=1U W=1U AS=0.25P AD=0.44P PS=1.5U
+ PD=2.88U
M$1016 \$83 \$91 VSS VSS nfet_06v0 L=1U W=5U AS=2.2P AD=1.25P PS=10.88U PD=5.5U
M$1017 \$33 \$92 \$83 VSS nfet_06v0 L=1U W=5U AS=1.25P AD=2.2P PS=5.5U PD=10.88U
M$1018 \$85 \$91 VSS VSS nfet_06v0 L=1U W=5U AS=2.2P AD=1.25P PS=10.88U PD=5.5U
M$1019 \$33 \$92 \$85 VSS nfet_06v0 L=1U W=5U AS=1.25P AD=2.2P PS=5.5U PD=10.88U
M$1020 \$34 S1P \$33 VSS nfet_06v0 L=1U W=1U AS=0.44P AD=0.44P PS=2.88U PD=2.88U
M$1021 \$35 S1N \$33 VSS nfet_06v0 L=1U W=1U AS=0.44P AD=0.44P PS=2.88U PD=2.88U
M$1022 \$36 \$37 VSS VSS nfet_06v0 L=1U W=2.5U AS=1.1P AD=0.825P PS=5.88U
+ PD=3.16U
M$1023 \$37 \$92 \$36 VSS nfet_06v0 L=1U W=2.5U AS=0.825P AD=0.825P PS=3.16U
+ PD=3.16U
M$1024 \$38 \$65 \$37 VSS nfet_06v0 L=1U W=2.5U AS=0.825P AD=1.1P PS=3.16U
+ PD=5.88U
M$1025 \$107 \$37 VSS VSS nfet_06v0 L=1U W=2.5U AS=1.1P AD=0.825P PS=5.88U
+ PD=3.16U
M$1026 \$39 \$92 \$107 VSS nfet_06v0 L=1U W=2.5U AS=0.825P AD=0.825P PS=3.16U
+ PD=3.16U
M$1027 \$40 \$65 \$39 VSS nfet_06v0 L=1U W=2.5U AS=0.825P AD=1.1P PS=3.16U
+ PD=5.88U
M$1028 \$86 \$91 VSS VSS nfet_06v0 L=1U W=5U AS=2.2P AD=1.25P PS=10.88U PD=5.5U
M$1029 \$41 \$92 \$86 VSS nfet_06v0 L=1U W=5U AS=1.25P AD=2.2P PS=5.5U PD=10.88U
M$1030 \$84 \$42 VSS VSS nfet_06v0 L=1U W=5U AS=2.2P AD=1.25P PS=10.88U PD=5.5U
M$1031 \$42 \$92 \$84 VSS nfet_06v0 L=1U W=5U AS=1.25P AD=1.65P PS=5.5U PD=5.66U
M$1032 \$65 \$65 \$42 VSS nfet_06v0 L=1U W=5U AS=1.65P AD=2.2P PS=5.66U
+ PD=10.88U
M$1033 \$43 \$39 VSS VSS nfet_06v0 L=1U W=1U AS=0.44P AD=0.44P PS=2.88U PD=2.88U
M$1034 \$92 \$92 VSS VSS nfet_06v0 L=1U W=1U AS=0.44P AD=0.44P PS=2.88U PD=2.88U
M$1035 \$82 \$91 VSS VSS nfet_06v0 L=1U W=5U AS=2.2P AD=1.25P PS=10.88U PD=5.5U
M$1036 \$91 \$92 \$82 VSS nfet_06v0 L=1U W=5U AS=1.25P AD=2.2P PS=5.5U PD=10.88U
M$1037 \$62 \$122 VSS VSS nfet_06v0 L=1U W=1U AS=0.44P AD=0.25P PS=2.88U PD=1.5U
M$1038 \$113 \$122 \$62 VSS nfet_06v0 L=1U W=1U AS=0.25P AD=0.44P PS=1.5U
+ PD=2.88U
M$1039 \$59 \$122 VSS VSS nfet_06v0 L=1U W=1U AS=0.44P AD=0.25P PS=2.88U PD=1.5U
M$1040 \$122 \$122 \$59 VSS nfet_06v0 L=1U W=1U AS=0.25P AD=0.44P PS=1.5U
+ PD=2.88U
M$1041 \$78 \$93 VSS VSS nfet_06v0 L=1U W=5U AS=2.2P AD=1.25P PS=10.88U PD=5.5U
M$1042 \$44 \$94 \$78 VSS nfet_06v0 L=1U W=5U AS=1.25P AD=2.2P PS=5.5U PD=10.88U
M$1043 \$77 \$93 VSS VSS nfet_06v0 L=1U W=5U AS=2.2P AD=1.25P PS=10.88U PD=5.5U
M$1044 \$44 \$94 \$77 VSS nfet_06v0 L=1U W=5U AS=1.25P AD=2.2P PS=5.5U PD=10.88U
M$1045 \$45 S2P \$44 VSS nfet_06v0 L=1U W=1U AS=0.44P AD=0.44P PS=2.88U PD=2.88U
M$1046 \$46 S2N \$44 VSS nfet_06v0 L=1U W=1U AS=0.44P AD=0.44P PS=2.88U PD=2.88U
M$1047 \$47 \$48 VSS VSS nfet_06v0 L=1U W=2.5U AS=1.1P AD=0.825P PS=5.88U
+ PD=3.16U
M$1048 \$48 \$94 \$47 VSS nfet_06v0 L=1U W=2.5U AS=0.825P AD=0.825P PS=3.16U
+ PD=3.16U
M$1049 \$49 \$66 \$48 VSS nfet_06v0 L=1U W=2.5U AS=0.825P AD=1.1P PS=3.16U
+ PD=5.88U
M$1050 \$109 \$48 VSS VSS nfet_06v0 L=1U W=2.5U AS=1.1P AD=0.825P PS=5.88U
+ PD=3.16U
M$1051 \$50 \$94 \$109 VSS nfet_06v0 L=1U W=2.5U AS=0.825P AD=0.825P PS=3.16U
+ PD=3.16U
M$1052 \$51 \$66 \$50 VSS nfet_06v0 L=1U W=2.5U AS=0.825P AD=1.1P PS=3.16U
+ PD=5.88U
M$1053 \$73 \$93 VSS VSS nfet_06v0 L=1U W=5U AS=2.2P AD=1.25P PS=10.88U PD=5.5U
M$1054 \$52 \$94 \$73 VSS nfet_06v0 L=1U W=5U AS=1.25P AD=2.2P PS=5.5U PD=10.88U
M$1055 \$70 \$53 VSS VSS nfet_06v0 L=1U W=5U AS=2.2P AD=1.25P PS=10.88U PD=5.5U
M$1056 \$53 \$94 \$70 VSS nfet_06v0 L=1U W=5U AS=1.25P AD=1.65P PS=5.5U PD=5.66U
M$1057 \$66 \$66 \$53 VSS nfet_06v0 L=1U W=5U AS=1.65P AD=2.2P PS=5.66U
+ PD=10.88U
M$1058 \$54 \$50 VSS VSS nfet_06v0 L=1U W=1U AS=0.44P AD=0.44P PS=2.88U PD=2.88U
M$1059 \$94 \$94 VSS VSS nfet_06v0 L=1U W=1U AS=0.44P AD=0.44P PS=2.88U PD=2.88U
M$1060 \$68 \$93 VSS VSS nfet_06v0 L=1U W=5U AS=2.2P AD=1.25P PS=10.88U PD=5.5U
M$1061 \$93 \$94 \$68 VSS nfet_06v0 L=1U W=5U AS=1.25P AD=2.2P PS=5.5U PD=10.88U
M$1062 \$56 \$123 VSS VSS nfet_06v0 L=1U W=1U AS=0.44P AD=0.25P PS=2.88U PD=1.5U
M$1063 \$114 \$123 \$56 VSS nfet_06v0 L=1U W=1U AS=0.25P AD=0.44P PS=1.5U
+ PD=2.88U
M$1064 \$55 \$123 VSS VSS nfet_06v0 L=1U W=1U AS=0.44P AD=0.25P PS=2.88U PD=1.5U
M$1065 \$123 \$123 \$55 VSS nfet_06v0 L=1U W=1U AS=0.25P AD=0.44P PS=1.5U
+ PD=2.88U
M$1066 VSS VDD VSS VSS nfet_06v0 L=2U W=18U AS=7.92P AD=7.92P PS=36.88U
+ PD=36.88U
M$1067 \$998 \$990 VSS VSS nfet_06v0 L=1U W=5U AS=2.2P AD=1.25P PS=10.88U
+ PD=5.5U
M$1068 \$934 \$991 \$998 VSS nfet_06v0 L=1U W=5U AS=1.25P AD=2.2P PS=5.5U
+ PD=10.88U
M$1069 \$1000 \$990 VSS VSS nfet_06v0 L=1U W=5U AS=2.2P AD=1.25P PS=10.88U
+ PD=5.5U
M$1070 \$934 \$991 \$1000 VSS nfet_06v0 L=1U W=5U AS=1.25P AD=2.2P PS=5.5U
+ PD=10.88U
M$1071 \$935 S4P \$934 VSS nfet_06v0 L=1U W=1U AS=0.44P AD=0.44P PS=2.88U
+ PD=2.88U
M$1072 \$936 S4N \$934 VSS nfet_06v0 L=1U W=1U AS=0.44P AD=0.44P PS=2.88U
+ PD=2.88U
M$1073 \$937 \$938 VSS VSS nfet_06v0 L=1U W=2.5U AS=1.1P AD=0.825P PS=5.88U
+ PD=3.16U
M$1074 \$938 \$991 \$937 VSS nfet_06v0 L=1U W=2.5U AS=0.825P AD=0.825P PS=3.16U
+ PD=3.16U
M$1075 \$939 \$986 \$938 VSS nfet_06v0 L=1U W=2.5U AS=0.825P AD=1.1P PS=3.16U
+ PD=5.88U
M$1076 \$1020 \$938 VSS VSS nfet_06v0 L=1U W=2.5U AS=1.1P AD=0.825P PS=5.88U
+ PD=3.16U
M$1077 \$940 \$991 \$1020 VSS nfet_06v0 L=1U W=2.5U AS=0.825P AD=0.825P
+ PS=3.16U PD=3.16U
M$1078 \$941 \$986 \$940 VSS nfet_06v0 L=1U W=2.5U AS=0.825P AD=1.1P PS=3.16U
+ PD=5.88U
M$1079 \$1003 \$990 VSS VSS nfet_06v0 L=1U W=5U AS=2.2P AD=1.25P PS=10.88U
+ PD=5.5U
M$1080 \$942 \$991 \$1003 VSS nfet_06v0 L=1U W=5U AS=1.25P AD=2.2P PS=5.5U
+ PD=10.88U
M$1081 \$1004 \$943 VSS VSS nfet_06v0 L=1U W=5U AS=2.2P AD=1.25P PS=10.88U
+ PD=5.5U
M$1082 \$943 \$991 \$1004 VSS nfet_06v0 L=1U W=5U AS=1.25P AD=1.65P PS=5.5U
+ PD=5.66U
M$1083 \$986 \$986 \$943 VSS nfet_06v0 L=1U W=5U AS=1.65P AD=2.2P PS=5.66U
+ PD=10.88U
M$1084 \$944 \$940 VSS VSS nfet_06v0 L=1U W=1U AS=0.44P AD=0.44P PS=2.88U
+ PD=2.88U
M$1085 \$991 \$991 VSS VSS nfet_06v0 L=1U W=1U AS=0.44P AD=0.44P PS=2.88U
+ PD=2.88U
M$1086 \$1005 \$990 VSS VSS nfet_06v0 L=1U W=5U AS=2.2P AD=1.25P PS=10.88U
+ PD=5.5U
M$1087 \$990 \$991 \$1005 VSS nfet_06v0 L=1U W=5U AS=1.25P AD=2.2P PS=5.5U
+ PD=10.88U
M$1088 \$980 \$1044 VSS VSS nfet_06v0 L=1U W=1U AS=0.44P AD=0.25P PS=2.88U
+ PD=1.5U
M$1089 \$1034 \$1044 \$980 VSS nfet_06v0 L=1U W=1U AS=0.25P AD=0.44P PS=1.5U
+ PD=2.88U
M$1090 \$981 \$1044 VSS VSS nfet_06v0 L=1U W=1U AS=0.44P AD=0.25P PS=2.88U
+ PD=1.5U
M$1091 \$1044 \$1044 \$981 VSS nfet_06v0 L=1U W=1U AS=0.25P AD=0.44P PS=1.5U
+ PD=2.88U
M$1092 VSS VDD VSS VSS nfet_06v0 L=2U W=18U AS=7.92P AD=7.92P PS=36.88U
+ PD=36.88U
M$1093 VSS VDD VSS VSS nfet_06v0 L=2U W=18U AS=7.92P AD=7.92P PS=36.88U
+ PD=36.88U
M$1094 \$1008 \$992 VSS VSS nfet_06v0 L=1U W=5U AS=2.2P AD=1.25P PS=10.88U
+ PD=5.5U
M$1095 \$945 \$993 \$1008 VSS nfet_06v0 L=1U W=5U AS=1.25P AD=2.2P PS=5.5U
+ PD=10.88U
M$1096 \$1009 \$992 VSS VSS nfet_06v0 L=1U W=5U AS=2.2P AD=1.25P PS=10.88U
+ PD=5.5U
M$1097 \$945 \$993 \$1009 VSS nfet_06v0 L=1U W=5U AS=1.25P AD=2.2P PS=5.5U
+ PD=10.88U
M$1098 \$946 S1P \$945 VSS nfet_06v0 L=1U W=1U AS=0.44P AD=0.44P PS=2.88U
+ PD=2.88U
M$1099 \$947 S1N \$945 VSS nfet_06v0 L=1U W=1U AS=0.44P AD=0.44P PS=2.88U
+ PD=2.88U
M$1100 \$948 \$949 VSS VSS nfet_06v0 L=1U W=2.5U AS=1.1P AD=0.825P PS=5.88U
+ PD=3.16U
M$1101 \$949 \$993 \$948 VSS nfet_06v0 L=1U W=2.5U AS=0.825P AD=0.825P PS=3.16U
+ PD=3.16U
M$1102 \$950 \$987 \$949 VSS nfet_06v0 L=1U W=2.5U AS=0.825P AD=1.1P PS=3.16U
+ PD=5.88U
M$1103 \$1029 \$949 VSS VSS nfet_06v0 L=1U W=2.5U AS=1.1P AD=0.825P PS=5.88U
+ PD=3.16U
M$1104 \$951 \$993 \$1029 VSS nfet_06v0 L=1U W=2.5U AS=0.825P AD=0.825P
+ PS=3.16U PD=3.16U
M$1105 \$952 \$987 \$951 VSS nfet_06v0 L=1U W=2.5U AS=0.825P AD=1.1P PS=3.16U
+ PD=5.88U
M$1106 \$1011 \$992 VSS VSS nfet_06v0 L=1U W=5U AS=2.2P AD=1.25P PS=10.88U
+ PD=5.5U
M$1107 \$953 \$993 \$1011 VSS nfet_06v0 L=1U W=5U AS=1.25P AD=2.2P PS=5.5U
+ PD=10.88U
M$1108 \$1013 \$954 VSS VSS nfet_06v0 L=1U W=5U AS=2.2P AD=1.25P PS=10.88U
+ PD=5.5U
M$1109 \$954 \$993 \$1013 VSS nfet_06v0 L=1U W=5U AS=1.25P AD=1.65P PS=5.5U
+ PD=5.66U
M$1110 \$987 \$987 \$954 VSS nfet_06v0 L=1U W=5U AS=1.65P AD=2.2P PS=5.66U
+ PD=10.88U
M$1111 \$955 \$951 VSS VSS nfet_06v0 L=1U W=1U AS=0.44P AD=0.44P PS=2.88U
+ PD=2.88U
M$1112 \$993 \$993 VSS VSS nfet_06v0 L=1U W=1U AS=0.44P AD=0.44P PS=2.88U
+ PD=2.88U
M$1113 \$1015 \$992 VSS VSS nfet_06v0 L=1U W=5U AS=2.2P AD=1.25P PS=10.88U
+ PD=5.5U
M$1114 \$992 \$993 \$1015 VSS nfet_06v0 L=1U W=5U AS=1.25P AD=2.2P PS=5.5U
+ PD=10.88U
M$1115 \$982 \$1045 VSS VSS nfet_06v0 L=1U W=1U AS=0.44P AD=0.25P PS=2.88U
+ PD=1.5U
M$1116 \$1035 \$1045 \$982 VSS nfet_06v0 L=1U W=1U AS=0.25P AD=0.44P PS=1.5U
+ PD=2.88U
M$1117 \$983 \$1045 VSS VSS nfet_06v0 L=1U W=1U AS=0.44P AD=0.25P PS=2.88U
+ PD=1.5U
M$1118 \$1045 \$1045 \$983 VSS nfet_06v0 L=1U W=1U AS=0.25P AD=0.44P PS=1.5U
+ PD=2.88U
M$1119 VSS VDD VSS VSS nfet_06v0 L=2U W=18U AS=7.92P AD=7.92P PS=36.88U
+ PD=36.88U
M$1120 VSS VDD VSS VSS nfet_06v0 L=2U W=18U AS=7.92P AD=7.92P PS=36.88U
+ PD=36.88U
M$1121 \$1016 \$994 VSS VSS nfet_06v0 L=1U W=5U AS=2.2P AD=1.25P PS=10.88U
+ PD=5.5U
M$1122 \$956 \$995 \$1016 VSS nfet_06v0 L=1U W=5U AS=1.25P AD=2.2P PS=5.5U
+ PD=10.88U
M$1123 \$1017 \$994 VSS VSS nfet_06v0 L=1U W=5U AS=2.2P AD=1.25P PS=10.88U
+ PD=5.5U
M$1124 \$956 \$995 \$1017 VSS nfet_06v0 L=1U W=5U AS=1.25P AD=2.2P PS=5.5U
+ PD=10.88U
M$1125 \$957 S4P \$956 VSS nfet_06v0 L=1U W=1U AS=0.44P AD=0.44P PS=2.88U
+ PD=2.88U
M$1126 \$958 S4N \$956 VSS nfet_06v0 L=1U W=1U AS=0.44P AD=0.44P PS=2.88U
+ PD=2.88U
M$1127 \$959 \$960 VSS VSS nfet_06v0 L=1U W=2.5U AS=1.1P AD=0.825P PS=5.88U
+ PD=3.16U
M$1128 \$960 \$995 \$959 VSS nfet_06v0 L=1U W=2.5U AS=0.825P AD=0.825P PS=3.16U
+ PD=3.16U
M$1129 \$961 \$988 \$960 VSS nfet_06v0 L=1U W=2.5U AS=0.825P AD=1.1P PS=3.16U
+ PD=5.88U
M$1130 \$1023 \$960 VSS VSS nfet_06v0 L=1U W=2.5U AS=1.1P AD=0.825P PS=5.88U
+ PD=3.16U
M$1131 \$962 \$995 \$1023 VSS nfet_06v0 L=1U W=2.5U AS=0.825P AD=0.825P
+ PS=3.16U PD=3.16U
M$1132 \$963 \$988 \$962 VSS nfet_06v0 L=1U W=2.5U AS=0.825P AD=1.1P PS=3.16U
+ PD=5.88U
M$1133 \$1014 \$994 VSS VSS nfet_06v0 L=1U W=5U AS=2.2P AD=1.25P PS=10.88U
+ PD=5.5U
M$1134 \$964 \$995 \$1014 VSS nfet_06v0 L=1U W=5U AS=1.25P AD=2.2P PS=5.5U
+ PD=10.88U
M$1135 \$1012 \$965 VSS VSS nfet_06v0 L=1U W=5U AS=2.2P AD=1.25P PS=10.88U
+ PD=5.5U
M$1136 \$965 \$995 \$1012 VSS nfet_06v0 L=1U W=5U AS=1.25P AD=1.65P PS=5.5U
+ PD=5.66U
M$1137 \$988 \$988 \$965 VSS nfet_06v0 L=1U W=5U AS=1.65P AD=2.2P PS=5.66U
+ PD=10.88U
M$1138 \$966 \$962 VSS VSS nfet_06v0 L=1U W=1U AS=0.44P AD=0.44P PS=2.88U
+ PD=2.88U
M$1139 \$995 \$995 VSS VSS nfet_06v0 L=1U W=1U AS=0.44P AD=0.44P PS=2.88U
+ PD=2.88U
M$1140 \$1010 \$994 VSS VSS nfet_06v0 L=1U W=5U AS=2.2P AD=1.25P PS=10.88U
+ PD=5.5U
M$1141 \$994 \$995 \$1010 VSS nfet_06v0 L=1U W=5U AS=1.25P AD=2.2P PS=5.5U
+ PD=10.88U
M$1142 \$985 \$1046 VSS VSS nfet_06v0 L=1U W=1U AS=0.44P AD=0.25P PS=2.88U
+ PD=1.5U
M$1143 \$1036 \$1046 \$985 VSS nfet_06v0 L=1U W=1U AS=0.25P AD=0.44P PS=1.5U
+ PD=2.88U
M$1144 \$984 \$1046 VSS VSS nfet_06v0 L=1U W=1U AS=0.44P AD=0.25P PS=2.88U
+ PD=1.5U
M$1145 \$1046 \$1046 \$984 VSS nfet_06v0 L=1U W=1U AS=0.25P AD=0.44P PS=1.5U
+ PD=2.88U
M$1146 VSS VDD VSS VSS nfet_06v0 L=2U W=18U AS=7.92P AD=7.92P PS=36.88U
+ PD=36.88U
M$1147 VSS VDD VSS VSS nfet_06v0 L=2U W=18U AS=7.92P AD=7.92P PS=36.88U
+ PD=36.88U
M$1148 \$1007 \$996 VSS VSS nfet_06v0 L=1U W=5U AS=2.2P AD=1.25P PS=10.88U
+ PD=5.5U
M$1149 \$967 \$997 \$1007 VSS nfet_06v0 L=1U W=5U AS=1.25P AD=2.2P PS=5.5U
+ PD=10.88U
M$1150 \$1006 \$996 VSS VSS nfet_06v0 L=1U W=5U AS=2.2P AD=1.25P PS=10.88U
+ PD=5.5U
M$1151 \$967 \$997 \$1006 VSS nfet_06v0 L=1U W=5U AS=1.25P AD=2.2P PS=5.5U
+ PD=10.88U
M$1152 \$968 S1P \$967 VSS nfet_06v0 L=1U W=1U AS=0.44P AD=0.44P PS=2.88U
+ PD=2.88U
M$1153 \$969 S1N \$967 VSS nfet_06v0 L=1U W=1U AS=0.44P AD=0.44P PS=2.88U
+ PD=2.88U
M$1154 \$970 \$971 VSS VSS nfet_06v0 L=1U W=2.5U AS=1.1P AD=0.825P PS=5.88U
+ PD=3.16U
M$1155 \$971 \$997 \$970 VSS nfet_06v0 L=1U W=2.5U AS=0.825P AD=0.825P PS=3.16U
+ PD=3.16U
M$1156 \$972 \$989 \$971 VSS nfet_06v0 L=1U W=2.5U AS=0.825P AD=1.1P PS=3.16U
+ PD=5.88U
M$1157 \$1032 \$971 VSS VSS nfet_06v0 L=1U W=2.5U AS=1.1P AD=0.825P PS=5.88U
+ PD=3.16U
M$1158 \$973 \$997 \$1032 VSS nfet_06v0 L=1U W=2.5U AS=0.825P AD=0.825P
+ PS=3.16U PD=3.16U
M$1159 \$974 \$989 \$973 VSS nfet_06v0 L=1U W=2.5U AS=0.825P AD=1.1P PS=3.16U
+ PD=5.88U
M$1160 \$1002 \$996 VSS VSS nfet_06v0 L=1U W=5U AS=2.2P AD=1.25P PS=10.88U
+ PD=5.5U
M$1161 \$975 \$997 \$1002 VSS nfet_06v0 L=1U W=5U AS=1.25P AD=2.2P PS=5.5U
+ PD=10.88U
M$1162 \$1001 \$976 VSS VSS nfet_06v0 L=1U W=5U AS=2.2P AD=1.25P PS=10.88U
+ PD=5.5U
M$1163 \$976 \$997 \$1001 VSS nfet_06v0 L=1U W=5U AS=1.25P AD=1.65P PS=5.5U
+ PD=5.66U
M$1164 \$989 \$989 \$976 VSS nfet_06v0 L=1U W=5U AS=1.65P AD=2.2P PS=5.66U
+ PD=10.88U
M$1165 \$977 \$973 VSS VSS nfet_06v0 L=1U W=1U AS=0.44P AD=0.44P PS=2.88U
+ PD=2.88U
M$1166 \$997 \$997 VSS VSS nfet_06v0 L=1U W=1U AS=0.44P AD=0.44P PS=2.88U
+ PD=2.88U
M$1167 \$999 \$996 VSS VSS nfet_06v0 L=1U W=5U AS=2.2P AD=1.25P PS=10.88U
+ PD=5.5U
M$1168 \$996 \$997 \$999 VSS nfet_06v0 L=1U W=5U AS=1.25P AD=2.2P PS=5.5U
+ PD=10.88U
M$1169 \$979 \$1047 VSS VSS nfet_06v0 L=1U W=1U AS=0.44P AD=0.25P PS=2.88U
+ PD=1.5U
M$1170 \$1037 \$1047 \$979 VSS nfet_06v0 L=1U W=1U AS=0.25P AD=0.44P PS=1.5U
+ PD=2.88U
M$1171 \$978 \$1047 VSS VSS nfet_06v0 L=1U W=1U AS=0.44P AD=0.25P PS=2.88U
+ PD=1.5U
M$1172 \$1047 \$1047 \$978 VSS nfet_06v0 L=1U W=1U AS=0.25P AD=0.44P PS=1.5U
+ PD=2.88U
M$1173 VSS VDD VSS VSS nfet_06v0 L=2U W=18U AS=7.92P AD=7.92P PS=36.88U
+ PD=36.88U
M$1174 VSS VDD VSS VSS nfet_06v0 L=2U W=18U AS=7.92P AD=7.92P PS=36.88U
+ PD=36.88U
M$1175 \$1917 \$1909 VSS VSS nfet_06v0 L=1U W=5U AS=2.2P AD=1.25P PS=10.88U
+ PD=5.5U
M$1176 \$1857 \$1910 \$1917 VSS nfet_06v0 L=1U W=5U AS=1.25P AD=2.2P PS=5.5U
+ PD=10.88U
M$1177 \$1919 \$1909 VSS VSS nfet_06v0 L=1U W=5U AS=2.2P AD=1.25P PS=10.88U
+ PD=5.5U
M$1178 \$1857 \$1910 \$1919 VSS nfet_06v0 L=1U W=5U AS=1.25P AD=2.2P PS=5.5U
+ PD=10.88U
M$1179 \$1858 S3P \$1857 VSS nfet_06v0 L=1U W=1U AS=0.44P AD=0.44P PS=2.88U
+ PD=2.88U
M$1180 \$1859 S3N \$1857 VSS nfet_06v0 L=1U W=1U AS=0.44P AD=0.44P PS=2.88U
+ PD=2.88U
M$1181 \$1860 \$1861 VSS VSS nfet_06v0 L=1U W=2.5U AS=1.1P AD=0.825P PS=5.88U
+ PD=3.16U
M$1182 \$1861 \$1910 \$1860 VSS nfet_06v0 L=1U W=2.5U AS=0.825P AD=0.825P
+ PS=3.16U PD=3.16U
M$1183 \$1862 \$1905 \$1861 VSS nfet_06v0 L=1U W=2.5U AS=0.825P AD=1.1P
+ PS=3.16U PD=5.88U
M$1184 \$1937 \$1861 VSS VSS nfet_06v0 L=1U W=2.5U AS=1.1P AD=0.825P PS=5.88U
+ PD=3.16U
M$1185 \$1863 \$1910 \$1937 VSS nfet_06v0 L=1U W=2.5U AS=0.825P AD=0.825P
+ PS=3.16U PD=3.16U
M$1186 \$1962 \$1905 \$1863 VSS nfet_06v0 L=1U W=2.5U AS=0.825P AD=1.1P
+ PS=3.16U PD=5.88U
M$1187 \$1922 \$1909 VSS VSS nfet_06v0 L=1U W=5U AS=2.2P AD=1.25P PS=10.88U
+ PD=5.5U
M$1188 \$1864 \$1910 \$1922 VSS nfet_06v0 L=1U W=5U AS=1.25P AD=2.2P PS=5.5U
+ PD=10.88U
M$1189 \$1923 \$1865 VSS VSS nfet_06v0 L=1U W=5U AS=2.2P AD=1.25P PS=10.88U
+ PD=5.5U
M$1190 \$1865 \$1910 \$1923 VSS nfet_06v0 L=1U W=5U AS=1.25P AD=1.65P PS=5.5U
+ PD=5.66U
M$1191 \$1905 \$1905 \$1865 VSS nfet_06v0 L=1U W=5U AS=1.65P AD=2.2P PS=5.66U
+ PD=10.88U
M$1192 \$1866 \$1863 VSS VSS nfet_06v0 L=1U W=1U AS=0.44P AD=0.44P PS=2.88U
+ PD=2.88U
M$1193 \$1910 \$1910 VSS VSS nfet_06v0 L=1U W=1U AS=0.44P AD=0.44P PS=2.88U
+ PD=2.88U
M$1194 \$1924 \$1909 VSS VSS nfet_06v0 L=1U W=5U AS=2.2P AD=1.25P PS=10.88U
+ PD=5.5U
M$1195 \$1909 \$1910 \$1924 VSS nfet_06v0 L=1U W=5U AS=1.25P AD=2.2P PS=5.5U
+ PD=10.88U
M$1196 \$1899 \$1961 VSS VSS nfet_06v0 L=1U W=1U AS=0.44P AD=0.25P PS=2.88U
+ PD=1.5U
M$1197 \$1953 \$1961 \$1899 VSS nfet_06v0 L=1U W=1U AS=0.25P AD=0.44P PS=1.5U
+ PD=2.88U
M$1198 \$1900 \$1961 VSS VSS nfet_06v0 L=1U W=1U AS=0.44P AD=0.25P PS=2.88U
+ PD=1.5U
M$1199 \$1961 \$1961 \$1900 VSS nfet_06v0 L=1U W=1U AS=0.25P AD=0.44P PS=1.5U
+ PD=2.88U
M$1200 VSS VDD VSS VSS nfet_06v0 L=2U W=18U AS=7.92P AD=7.92P PS=36.88U
+ PD=36.88U
M$1201 VSS VDD VSS VSS nfet_06v0 L=2U W=18U AS=7.92P AD=7.92P PS=36.88U
+ PD=36.88U
M$1202 \$1927 \$1911 VSS VSS nfet_06v0 L=1U W=5U AS=2.2P AD=1.25P PS=10.88U
+ PD=5.5U
M$1203 \$1867 \$1912 \$1927 VSS nfet_06v0 L=1U W=5U AS=1.25P AD=2.2P PS=5.5U
+ PD=10.88U
M$1204 \$1928 \$1911 VSS VSS nfet_06v0 L=1U W=5U AS=2.2P AD=1.25P PS=10.88U
+ PD=5.5U
M$1205 \$1867 \$1912 \$1928 VSS nfet_06v0 L=1U W=5U AS=1.25P AD=2.2P PS=5.5U
+ PD=10.88U
M$1206 \$1868 S4P \$1867 VSS nfet_06v0 L=1U W=1U AS=0.44P AD=0.44P PS=2.88U
+ PD=2.88U
M$1207 \$1869 S4N \$1867 VSS nfet_06v0 L=1U W=1U AS=0.44P AD=0.44P PS=2.88U
+ PD=2.88U
M$1208 \$1870 \$1871 VSS VSS nfet_06v0 L=1U W=2.5U AS=1.1P AD=0.825P PS=5.88U
+ PD=3.16U
M$1209 \$1871 \$1912 \$1870 VSS nfet_06v0 L=1U W=2.5U AS=0.825P AD=0.825P
+ PS=3.16U PD=3.16U
M$1210 \$1872 \$1906 \$1871 VSS nfet_06v0 L=1U W=2.5U AS=0.825P AD=1.1P
+ PS=3.16U PD=5.88U
M$1211 \$1943 \$1871 VSS VSS nfet_06v0 L=1U W=2.5U AS=1.1P AD=0.825P PS=5.88U
+ PD=3.16U
M$1212 \$1873 \$1912 \$1943 VSS nfet_06v0 L=1U W=2.5U AS=0.825P AD=0.825P
+ PS=3.16U PD=3.16U
M$1213 \$1964 \$1906 \$1873 VSS nfet_06v0 L=1U W=2.5U AS=0.825P AD=1.1P
+ PS=3.16U PD=5.88U
M$1214 \$1930 \$1911 VSS VSS nfet_06v0 L=1U W=5U AS=2.2P AD=1.25P PS=10.88U
+ PD=5.5U
M$1215 \$1874 \$1912 \$1930 VSS nfet_06v0 L=1U W=5U AS=1.25P AD=2.2P PS=5.5U
+ PD=10.88U
M$1216 \$1932 \$1875 VSS VSS nfet_06v0 L=1U W=5U AS=2.2P AD=1.25P PS=10.88U
+ PD=5.5U
M$1217 \$1875 \$1912 \$1932 VSS nfet_06v0 L=1U W=5U AS=1.25P AD=1.65P PS=5.5U
+ PD=5.66U
M$1218 \$1906 \$1906 \$1875 VSS nfet_06v0 L=1U W=5U AS=1.65P AD=2.2P PS=5.66U
+ PD=10.88U
M$1219 \$1876 \$1873 VSS VSS nfet_06v0 L=1U W=1U AS=0.44P AD=0.44P PS=2.88U
+ PD=2.88U
M$1220 \$1912 \$1912 VSS VSS nfet_06v0 L=1U W=1U AS=0.44P AD=0.44P PS=2.88U
+ PD=2.88U
M$1221 \$1934 \$1911 VSS VSS nfet_06v0 L=1U W=5U AS=2.2P AD=1.25P PS=10.88U
+ PD=5.5U
M$1222 \$1911 \$1912 \$1934 VSS nfet_06v0 L=1U W=5U AS=1.25P AD=2.2P PS=5.5U
+ PD=10.88U
M$1223 \$1901 \$1963 VSS VSS nfet_06v0 L=1U W=1U AS=0.44P AD=0.25P PS=2.88U
+ PD=1.5U
M$1224 \$1954 \$1963 \$1901 VSS nfet_06v0 L=1U W=1U AS=0.25P AD=0.44P PS=1.5U
+ PD=2.88U
M$1225 \$1902 \$1963 VSS VSS nfet_06v0 L=1U W=1U AS=0.44P AD=0.25P PS=2.88U
+ PD=1.5U
M$1226 \$1963 \$1963 \$1902 VSS nfet_06v0 L=1U W=1U AS=0.25P AD=0.44P PS=1.5U
+ PD=2.88U
M$1227 VSS VDD VSS VSS nfet_06v0 L=2U W=18U AS=7.92P AD=7.92P PS=36.88U
+ PD=36.88U
M$1228 VSS VDD VSS VSS nfet_06v0 L=2U W=18U AS=7.92P AD=7.92P PS=36.88U
+ PD=36.88U
M$1229 \$1936 \$1913 VSS VSS nfet_06v0 L=1U W=5U AS=2.2P AD=1.25P PS=10.88U
+ PD=5.5U
M$1230 \$1877 \$1914 \$1936 VSS nfet_06v0 L=1U W=5U AS=1.25P AD=2.2P PS=5.5U
+ PD=10.88U
M$1231 \$1935 \$1913 VSS VSS nfet_06v0 L=1U W=5U AS=2.2P AD=1.25P PS=10.88U
+ PD=5.5U
M$1232 \$1877 \$1914 \$1935 VSS nfet_06v0 L=1U W=5U AS=1.25P AD=2.2P PS=5.5U
+ PD=10.88U
M$1233 \$1878 S2P \$1877 VSS nfet_06v0 L=1U W=1U AS=0.44P AD=0.44P PS=2.88U
+ PD=2.88U
M$1234 \$1879 S2N \$1877 VSS nfet_06v0 L=1U W=1U AS=0.44P AD=0.44P PS=2.88U
+ PD=2.88U
M$1235 \$1880 \$1881 VSS VSS nfet_06v0 L=1U W=2.5U AS=1.1P AD=0.825P PS=5.88U
+ PD=3.16U
M$1236 \$1881 \$1914 \$1880 VSS nfet_06v0 L=1U W=2.5U AS=0.825P AD=0.825P
+ PS=3.16U PD=3.16U
M$1237 \$1882 \$1907 \$1881 VSS nfet_06v0 L=1U W=2.5U AS=0.825P AD=1.1P
+ PS=3.16U PD=5.88U
M$1238 \$1945 \$1881 VSS VSS nfet_06v0 L=1U W=2.5U AS=1.1P AD=0.825P PS=5.88U
+ PD=3.16U
M$1239 \$1883 \$1914 \$1945 VSS nfet_06v0 L=1U W=2.5U AS=0.825P AD=0.825P
+ PS=3.16U PD=3.16U
M$1240 \$1966 \$1907 \$1883 VSS nfet_06v0 L=1U W=2.5U AS=0.825P AD=1.1P
+ PS=3.16U PD=5.88U
M$1241 \$1933 \$1913 VSS VSS nfet_06v0 L=1U W=5U AS=2.2P AD=1.25P PS=10.88U
+ PD=5.5U
M$1242 \$1884 \$1914 \$1933 VSS nfet_06v0 L=1U W=5U AS=1.25P AD=2.2P PS=5.5U
+ PD=10.88U
M$1243 \$1931 \$1885 VSS VSS nfet_06v0 L=1U W=5U AS=2.2P AD=1.25P PS=10.88U
+ PD=5.5U
M$1244 \$1885 \$1914 \$1931 VSS nfet_06v0 L=1U W=5U AS=1.25P AD=1.65P PS=5.5U
+ PD=5.66U
M$1245 \$1907 \$1907 \$1885 VSS nfet_06v0 L=1U W=5U AS=1.65P AD=2.2P PS=5.66U
+ PD=10.88U
M$1246 \$1886 \$1883 VSS VSS nfet_06v0 L=1U W=1U AS=0.44P AD=0.44P PS=2.88U
+ PD=2.88U
M$1247 \$1914 \$1914 VSS VSS nfet_06v0 L=1U W=1U AS=0.44P AD=0.44P PS=2.88U
+ PD=2.88U
M$1248 \$1929 \$1913 VSS VSS nfet_06v0 L=1U W=5U AS=2.2P AD=1.25P PS=10.88U
+ PD=5.5U
M$1249 \$1913 \$1914 \$1929 VSS nfet_06v0 L=1U W=5U AS=1.25P AD=2.2P PS=5.5U
+ PD=10.88U
M$1250 \$1904 \$1965 VSS VSS nfet_06v0 L=1U W=1U AS=0.44P AD=0.25P PS=2.88U
+ PD=1.5U
M$1251 \$1955 \$1965 \$1904 VSS nfet_06v0 L=1U W=1U AS=0.25P AD=0.44P PS=1.5U
+ PD=2.88U
M$1252 \$1903 \$1965 VSS VSS nfet_06v0 L=1U W=1U AS=0.44P AD=0.25P PS=2.88U
+ PD=1.5U
M$1253 \$1965 \$1965 \$1903 VSS nfet_06v0 L=1U W=1U AS=0.25P AD=0.44P PS=1.5U
+ PD=2.88U
M$1254 VSS VDD VSS VSS nfet_06v0 L=2U W=18U AS=7.92P AD=7.92P PS=36.88U
+ PD=36.88U
M$1255 VSS VDD VSS VSS nfet_06v0 L=2U W=18U AS=7.92P AD=7.92P PS=36.88U
+ PD=36.88U
M$1256 \$1926 \$1915 VSS VSS nfet_06v0 L=1U W=5U AS=2.2P AD=1.25P PS=10.88U
+ PD=5.5U
M$1257 \$1887 \$1916 \$1926 VSS nfet_06v0 L=1U W=5U AS=1.25P AD=2.2P PS=5.5U
+ PD=10.88U
M$1258 \$1925 \$1915 VSS VSS nfet_06v0 L=1U W=5U AS=2.2P AD=1.25P PS=10.88U
+ PD=5.5U
M$1259 \$1887 \$1916 \$1925 VSS nfet_06v0 L=1U W=5U AS=1.25P AD=2.2P PS=5.5U
+ PD=10.88U
M$1260 \$1888 S3P \$1887 VSS nfet_06v0 L=1U W=1U AS=0.44P AD=0.44P PS=2.88U
+ PD=2.88U
M$1261 \$1889 S3N \$1887 VSS nfet_06v0 L=1U W=1U AS=0.44P AD=0.44P PS=2.88U
+ PD=2.88U
M$1262 \$1890 \$1891 VSS VSS nfet_06v0 L=1U W=2.5U AS=1.1P AD=0.825P PS=5.88U
+ PD=3.16U
M$1263 \$1891 \$1916 \$1890 VSS nfet_06v0 L=1U W=2.5U AS=0.825P AD=0.825P
+ PS=3.16U PD=3.16U
M$1264 \$1892 \$1908 \$1891 VSS nfet_06v0 L=1U W=2.5U AS=0.825P AD=1.1P
+ PS=3.16U PD=5.88U
M$1265 \$1949 \$1891 VSS VSS nfet_06v0 L=1U W=2.5U AS=1.1P AD=0.825P PS=5.88U
+ PD=3.16U
M$1266 \$1893 \$1916 \$1949 VSS nfet_06v0 L=1U W=2.5U AS=0.825P AD=0.825P
+ PS=3.16U PD=3.16U
M$1267 \$1968 \$1908 \$1893 VSS nfet_06v0 L=1U W=2.5U AS=0.825P AD=1.1P
+ PS=3.16U PD=5.88U
M$1268 \$1921 \$1915 VSS VSS nfet_06v0 L=1U W=5U AS=2.2P AD=1.25P PS=10.88U
+ PD=5.5U
M$1269 \$1894 \$1916 \$1921 VSS nfet_06v0 L=1U W=5U AS=1.25P AD=2.2P PS=5.5U
+ PD=10.88U
M$1270 \$1920 \$1895 VSS VSS nfet_06v0 L=1U W=5U AS=2.2P AD=1.25P PS=10.88U
+ PD=5.5U
M$1271 \$1895 \$1916 \$1920 VSS nfet_06v0 L=1U W=5U AS=1.25P AD=1.65P PS=5.5U
+ PD=5.66U
M$1272 \$1908 \$1908 \$1895 VSS nfet_06v0 L=1U W=5U AS=1.65P AD=2.2P PS=5.66U
+ PD=10.88U
M$1273 \$1896 \$1893 VSS VSS nfet_06v0 L=1U W=1U AS=0.44P AD=0.44P PS=2.88U
+ PD=2.88U
M$1274 \$1916 \$1916 VSS VSS nfet_06v0 L=1U W=1U AS=0.44P AD=0.44P PS=2.88U
+ PD=2.88U
M$1275 \$1918 \$1915 VSS VSS nfet_06v0 L=1U W=5U AS=2.2P AD=1.25P PS=10.88U
+ PD=5.5U
M$1276 \$1915 \$1916 \$1918 VSS nfet_06v0 L=1U W=5U AS=1.25P AD=2.2P PS=5.5U
+ PD=10.88U
M$1277 \$1898 \$1967 VSS VSS nfet_06v0 L=1U W=1U AS=0.44P AD=0.25P PS=2.88U
+ PD=1.5U
M$1278 \$1956 \$1967 \$1898 VSS nfet_06v0 L=1U W=1U AS=0.25P AD=0.44P PS=1.5U
+ PD=2.88U
M$1279 \$1897 \$1967 VSS VSS nfet_06v0 L=1U W=1U AS=0.44P AD=0.25P PS=2.88U
+ PD=1.5U
M$1280 \$1967 \$1967 \$1897 VSS nfet_06v0 L=1U W=1U AS=0.25P AD=0.44P PS=1.5U
+ PD=2.88U
M$1281 VSS VDD VSS VSS nfet_06v0 L=2U W=18U AS=7.92P AD=7.92P PS=36.88U
+ PD=36.88U
M$1282 VSS VDD VSS VSS nfet_06v0 L=2U W=18U AS=7.92P AD=7.92P PS=36.88U
+ PD=36.88U
M$1283 \$2795 \$2795 VSS VSS nfet_06v0 L=1U W=1U AS=0.44P AD=0.44P PS=2.88U
+ PD=2.88U
M$1284 \$2840 \$2780 VSS VSS nfet_06v0 L=1U W=5U AS=2.2P AD=1.25P PS=10.88U
+ PD=5.5U
M$1285 \$2780 \$2795 \$2840 VSS nfet_06v0 L=1U W=5U AS=1.25P AD=2.2P PS=5.5U
+ PD=10.88U
M$1286 \$2822 \$3483 VSS VSS nfet_06v0 L=1U W=1U AS=0.44P AD=0.25P PS=2.88U
+ PD=1.5U
M$1287 \$3404 \$3483 \$2822 VSS nfet_06v0 L=1U W=1U AS=0.25P AD=0.44P PS=1.5U
+ PD=2.88U
M$1288 \$2823 \$3483 VSS VSS nfet_06v0 L=1U W=1U AS=0.44P AD=0.25P PS=2.88U
+ PD=1.5U
M$1289 \$3483 \$3483 \$2823 VSS nfet_06v0 L=1U W=1U AS=0.25P AD=0.44P PS=1.5U
+ PD=2.88U
M$1290 \$2841 \$2780 VSS VSS nfet_06v0 L=1U W=5U AS=2.2P AD=1.25P PS=10.88U
+ PD=5.5U
M$1291 \$2796 \$2795 \$2841 VSS nfet_06v0 L=1U W=5U AS=1.25P AD=1.65P PS=5.5U
+ PD=5.66U
M$1292 \$2842 \$2795 \$2796 VSS nfet_06v0 L=1U W=5U AS=1.65P AD=1.25P PS=5.66U
+ PD=5.5U
M$1293 VSS \$2780 \$2842 VSS nfet_06v0 L=1U W=5U AS=1.25P AD=2.2P PS=5.5U
+ PD=10.88U
M$1294 \$2797 \$21 \$2796 VSS nfet_06v0 L=1U W=5U AS=2.2P AD=1.3P PS=10.88U
+ PD=5.52U
M$1295 \$2796 \$21 \$2797 VSS nfet_06v0 L=1U W=5U AS=1.3P AD=2.2P PS=5.52U
+ PD=10.88U
M$1296 \$2798 \$43 \$2796 VSS nfet_06v0 L=1U W=5U AS=2.2P AD=1.3P PS=10.88U
+ PD=5.52U
M$1297 \$2796 \$43 \$2798 VSS nfet_06v0 L=1U W=5U AS=1.3P AD=2.2P PS=5.52U
+ PD=10.88U
M$1298 \$2800 \$2795 \$2799 VSS nfet_06v0 L=1U W=2.5U AS=1.1P AD=0.65P PS=5.88U
+ PD=3.02U
M$1299 \$2799 \$2795 \$2800 VSS nfet_06v0 L=1U W=2.5U AS=0.65P AD=1.1P PS=3.02U
+ PD=5.88U
M$1300 \$2802 \$2795 \$2801 VSS nfet_06v0 L=1U W=2.5U AS=1.1P AD=0.65P PS=5.88U
+ PD=3.02U
M$1301 \$2801 \$2795 \$2802 VSS nfet_06v0 L=1U W=2.5U AS=0.65P AD=1.1P PS=3.02U
+ PD=5.88U
M$1302 \$2799 \$2800 VSS VSS nfet_06v0 L=1U W=2.5U AS=1.1P AD=0.65P PS=5.88U
+ PD=3.02U
M$1303 VSS \$2800 \$2799 VSS nfet_06v0 L=1U W=2.5U AS=0.65P AD=0.65P PS=3.02U
+ PD=3.02U
M$1304 \$2799 \$2800 VSS VSS nfet_06v0 L=1U W=2.5U AS=0.65P AD=0.65P PS=3.02U
+ PD=3.02U
M$1305 VSS \$2800 \$2799 VSS nfet_06v0 L=1U W=2.5U AS=0.65P AD=1.1P PS=3.02U
+ PD=5.88U
M$1306 \$2801 \$2800 VSS VSS nfet_06v0 L=1U W=2.5U AS=1.1P AD=0.65P PS=5.88U
+ PD=3.02U
M$1307 VSS \$2800 \$2801 VSS nfet_06v0 L=1U W=2.5U AS=0.65P AD=0.65P PS=3.02U
+ PD=3.02U
M$1308 \$2801 \$2800 VSS VSS nfet_06v0 L=1U W=2.5U AS=0.65P AD=0.65P PS=3.02U
+ PD=3.02U
M$1309 VSS \$2800 \$2801 VSS nfet_06v0 L=1U W=2.5U AS=0.65P AD=1.1P PS=3.02U
+ PD=5.88U
M$1310 \$2949 \$2828 \$2800 VSS nfet_06v0 L=1U W=2.5U AS=1.1P AD=1.1P PS=5.88U
+ PD=5.88U
M$1311 \$2781 \$2828 \$2802 VSS nfet_06v0 L=1U W=2.5U AS=1.1P AD=1.1P PS=5.88U
+ PD=5.88U
M$1312 \$2843 \$2780 VSS VSS nfet_06v0 L=1U W=5U AS=2.2P AD=1.25P PS=10.88U
+ PD=5.5U
M$1313 \$2782 \$2795 \$2843 VSS nfet_06v0 L=1U W=5U AS=1.25P AD=2.2P PS=5.5U
+ PD=10.88U
M$1314 \$2844 \$2783 VSS VSS nfet_06v0 L=1U W=5U AS=2.2P AD=1.25P PS=10.88U
+ PD=5.5U
M$1315 \$2783 \$2795 \$2844 VSS nfet_06v0 L=1U W=5U AS=1.25P AD=1.65P PS=5.5U
+ PD=5.66U
M$1316 \$2828 \$2828 \$2783 VSS nfet_06v0 L=1U W=5U AS=1.65P AD=2.2P PS=5.66U
+ PD=10.88U
M$1317 \$2803 \$2802 VSS VSS nfet_06v0 L=1U W=5U AS=2.2P AD=1.3P PS=10.88U
+ PD=5.52U
M$1318 VSS \$2802 \$2803 VSS nfet_06v0 L=1U W=5U AS=1.3P AD=1.3P PS=5.52U
+ PD=5.52U
M$1319 \$2803 \$2802 VSS VSS nfet_06v0 L=1U W=5U AS=1.3P AD=2.2P PS=5.52U
+ PD=10.88U
M$1320 VSS VDD VSS VSS nfet_06v0 L=2U W=18U AS=7.92P AD=7.92P PS=36.88U
+ PD=36.88U
M$1321 VSS VDD VSS VSS nfet_06v0 L=2U W=18U AS=7.92P AD=7.92P PS=36.88U
+ PD=36.88U
M$1322 \$2804 \$2804 VSS VSS nfet_06v0 L=1U W=1U AS=0.44P AD=0.44P PS=2.88U
+ PD=2.88U
M$1323 \$2845 \$2785 VSS VSS nfet_06v0 L=1U W=5U AS=2.2P AD=1.25P PS=10.88U
+ PD=5.5U
M$1324 \$2785 \$2804 \$2845 VSS nfet_06v0 L=1U W=5U AS=1.25P AD=2.2P PS=5.5U
+ PD=10.88U
M$1325 \$2826 \$3485 VSS VSS nfet_06v0 L=1U W=1U AS=0.44P AD=0.25P PS=2.88U
+ PD=1.5U
M$1326 \$3405 \$3485 \$2826 VSS nfet_06v0 L=1U W=1U AS=0.25P AD=0.44P PS=1.5U
+ PD=2.88U
M$1327 \$2827 \$3485 VSS VSS nfet_06v0 L=1U W=1U AS=0.44P AD=0.25P PS=2.88U
+ PD=1.5U
M$1328 \$3485 \$3485 \$2827 VSS nfet_06v0 L=1U W=1U AS=0.25P AD=0.44P PS=1.5U
+ PD=2.88U
M$1329 \$2846 \$2785 VSS VSS nfet_06v0 L=1U W=5U AS=2.2P AD=1.25P PS=10.88U
+ PD=5.5U
M$1330 \$2805 \$2804 \$2846 VSS nfet_06v0 L=1U W=5U AS=1.25P AD=1.65P PS=5.5U
+ PD=5.66U
M$1331 \$2847 \$2804 \$2805 VSS nfet_06v0 L=1U W=5U AS=1.65P AD=1.25P PS=5.66U
+ PD=5.5U
M$1332 VSS \$2785 \$2847 VSS nfet_06v0 L=1U W=5U AS=1.25P AD=2.2P PS=5.5U
+ PD=10.88U
M$1333 \$2806 \$32 \$2805 VSS nfet_06v0 L=1U W=5U AS=2.2P AD=1.3P PS=10.88U
+ PD=5.52U
M$1334 \$2805 \$32 \$2806 VSS nfet_06v0 L=1U W=5U AS=1.3P AD=2.2P PS=5.52U
+ PD=10.88U
M$1335 \$2807 \$43 \$2805 VSS nfet_06v0 L=1U W=5U AS=2.2P AD=1.3P PS=10.88U
+ PD=5.52U
M$1336 \$2805 \$43 \$2807 VSS nfet_06v0 L=1U W=5U AS=1.3P AD=2.2P PS=5.52U
+ PD=10.88U
M$1337 \$2809 \$2804 \$2808 VSS nfet_06v0 L=1U W=2.5U AS=1.1P AD=0.65P PS=5.88U
+ PD=3.02U
M$1338 \$2808 \$2804 \$2809 VSS nfet_06v0 L=1U W=2.5U AS=0.65P AD=1.1P PS=3.02U
+ PD=5.88U
M$1339 \$2811 \$2804 \$2810 VSS nfet_06v0 L=1U W=2.5U AS=1.1P AD=0.65P PS=5.88U
+ PD=3.02U
M$1340 \$2810 \$2804 \$2811 VSS nfet_06v0 L=1U W=2.5U AS=0.65P AD=1.1P PS=3.02U
+ PD=5.88U
M$1341 \$2808 \$2809 VSS VSS nfet_06v0 L=1U W=2.5U AS=1.1P AD=0.65P PS=5.88U
+ PD=3.02U
M$1342 VSS \$2809 \$2808 VSS nfet_06v0 L=1U W=2.5U AS=0.65P AD=0.65P PS=3.02U
+ PD=3.02U
M$1343 \$2808 \$2809 VSS VSS nfet_06v0 L=1U W=2.5U AS=0.65P AD=0.65P PS=3.02U
+ PD=3.02U
M$1344 VSS \$2809 \$2808 VSS nfet_06v0 L=1U W=2.5U AS=0.65P AD=1.1P PS=3.02U
+ PD=5.88U
M$1345 \$2810 \$2809 VSS VSS nfet_06v0 L=1U W=2.5U AS=1.1P AD=0.65P PS=5.88U
+ PD=3.02U
M$1346 VSS \$2809 \$2810 VSS nfet_06v0 L=1U W=2.5U AS=0.65P AD=0.65P PS=3.02U
+ PD=3.02U
M$1347 \$2810 \$2809 VSS VSS nfet_06v0 L=1U W=2.5U AS=0.65P AD=0.65P PS=3.02U
+ PD=3.02U
M$1348 VSS \$2809 \$2810 VSS nfet_06v0 L=1U W=2.5U AS=0.65P AD=1.1P PS=3.02U
+ PD=5.88U
M$1349 \$2950 \$2829 \$2809 VSS nfet_06v0 L=1U W=2.5U AS=1.1P AD=1.1P PS=5.88U
+ PD=5.88U
M$1350 \$2786 \$2829 \$2811 VSS nfet_06v0 L=1U W=2.5U AS=1.1P AD=1.1P PS=5.88U
+ PD=5.88U
M$1351 \$2848 \$2785 VSS VSS nfet_06v0 L=1U W=5U AS=2.2P AD=1.25P PS=10.88U
+ PD=5.5U
M$1352 \$2787 \$2804 \$2848 VSS nfet_06v0 L=1U W=5U AS=1.25P AD=2.2P PS=5.5U
+ PD=10.88U
M$1353 VSS VDD VSS VSS nfet_06v0 L=2U W=18U AS=7.92P AD=7.92P PS=36.88U
+ PD=36.88U
M$1354 \$2850 \$2788 VSS VSS nfet_06v0 L=1U W=5U AS=2.2P AD=1.25P PS=10.88U
+ PD=5.5U
M$1355 \$2788 \$2804 \$2850 VSS nfet_06v0 L=1U W=5U AS=1.25P AD=1.65P PS=5.5U
+ PD=5.66U
M$1356 \$2829 \$2829 \$2788 VSS nfet_06v0 L=1U W=5U AS=1.65P AD=2.2P PS=5.66U
+ PD=10.88U
M$1357 VSS VDD VSS VSS nfet_06v0 L=2U W=18U AS=7.92P AD=7.92P PS=36.88U
+ PD=36.88U
M$1358 \$2812 \$2811 VSS VSS nfet_06v0 L=1U W=5U AS=2.2P AD=1.3P PS=10.88U
+ PD=5.52U
M$1359 VSS \$2811 \$2812 VSS nfet_06v0 L=1U W=5U AS=1.3P AD=1.3P PS=5.52U
+ PD=5.52U
M$1360 \$2812 \$2811 VSS VSS nfet_06v0 L=1U W=5U AS=1.3P AD=2.2P PS=5.52U
+ PD=10.88U
M$1361 \$2813 \$2813 VSS VSS nfet_06v0 L=1U W=1U AS=0.44P AD=0.44P PS=2.88U
+ PD=2.88U
M$1362 \$2852 \$2789 VSS VSS nfet_06v0 L=1U W=5U AS=2.2P AD=1.25P PS=10.88U
+ PD=5.5U
M$1363 \$2789 \$2813 \$2852 VSS nfet_06v0 L=1U W=5U AS=1.25P AD=2.2P PS=5.5U
+ PD=10.88U
M$1364 \$2825 \$3487 VSS VSS nfet_06v0 L=1U W=1U AS=0.44P AD=0.25P PS=2.88U
+ PD=1.5U
M$1365 \$3406 \$3487 \$2825 VSS nfet_06v0 L=1U W=1U AS=0.25P AD=0.44P PS=1.5U
+ PD=2.88U
M$1366 \$2824 \$3487 VSS VSS nfet_06v0 L=1U W=1U AS=0.44P AD=0.25P PS=2.88U
+ PD=1.5U
M$1367 \$3487 \$3487 \$2824 VSS nfet_06v0 L=1U W=1U AS=0.25P AD=0.44P PS=1.5U
+ PD=2.88U
M$1368 \$2853 \$2789 VSS VSS nfet_06v0 L=1U W=5U AS=2.2P AD=1.25P PS=10.88U
+ PD=5.5U
M$1369 \$2814 \$2813 \$2853 VSS nfet_06v0 L=1U W=5U AS=1.25P AD=1.65P PS=5.5U
+ PD=5.66U
M$1370 \$2854 \$2813 \$2814 VSS nfet_06v0 L=1U W=5U AS=1.65P AD=1.25P PS=5.66U
+ PD=5.5U
M$1371 VSS \$2789 \$2854 VSS nfet_06v0 L=1U W=5U AS=1.25P AD=2.2P PS=5.5U
+ PD=10.88U
M$1372 \$2815 \$32 \$2814 VSS nfet_06v0 L=1U W=5U AS=2.2P AD=1.3P PS=10.88U
+ PD=5.52U
M$1373 \$2814 \$32 \$2815 VSS nfet_06v0 L=1U W=5U AS=1.3P AD=2.2P PS=5.52U
+ PD=10.88U
M$1374 \$2816 \$21 \$2814 VSS nfet_06v0 L=1U W=5U AS=2.2P AD=1.3P PS=10.88U
+ PD=5.52U
M$1375 \$2814 \$21 \$2816 VSS nfet_06v0 L=1U W=5U AS=1.3P AD=2.2P PS=5.52U
+ PD=10.88U
M$1376 \$2818 \$2813 \$2817 VSS nfet_06v0 L=1U W=2.5U AS=1.1P AD=0.65P PS=5.88U
+ PD=3.02U
M$1377 \$2817 \$2813 \$2818 VSS nfet_06v0 L=1U W=2.5U AS=0.65P AD=1.1P PS=3.02U
+ PD=5.88U
M$1378 \$2820 \$2813 \$2819 VSS nfet_06v0 L=1U W=2.5U AS=1.1P AD=0.65P PS=5.88U
+ PD=3.02U
M$1379 \$2819 \$2813 \$2820 VSS nfet_06v0 L=1U W=2.5U AS=0.65P AD=1.1P PS=3.02U
+ PD=5.88U
M$1380 \$2817 \$2818 VSS VSS nfet_06v0 L=1U W=2.5U AS=1.1P AD=0.65P PS=5.88U
+ PD=3.02U
M$1381 VSS \$2818 \$2817 VSS nfet_06v0 L=1U W=2.5U AS=0.65P AD=0.65P PS=3.02U
+ PD=3.02U
M$1382 \$2817 \$2818 VSS VSS nfet_06v0 L=1U W=2.5U AS=0.65P AD=0.65P PS=3.02U
+ PD=3.02U
M$1383 VSS \$2818 \$2817 VSS nfet_06v0 L=1U W=2.5U AS=0.65P AD=1.1P PS=3.02U
+ PD=5.88U
M$1384 \$2819 \$2818 VSS VSS nfet_06v0 L=1U W=2.5U AS=1.1P AD=0.65P PS=5.88U
+ PD=3.02U
M$1385 VSS \$2818 \$2819 VSS nfet_06v0 L=1U W=2.5U AS=0.65P AD=0.65P PS=3.02U
+ PD=3.02U
M$1386 \$2819 \$2818 VSS VSS nfet_06v0 L=1U W=2.5U AS=0.65P AD=0.65P PS=3.02U
+ PD=3.02U
M$1387 VSS \$2818 \$2819 VSS nfet_06v0 L=1U W=2.5U AS=0.65P AD=1.1P PS=3.02U
+ PD=5.88U
M$1388 VSS VDD VSS VSS nfet_06v0 L=2U W=18U AS=7.92P AD=7.92P PS=36.88U
+ PD=36.88U
M$1389 \$2951 \$2830 \$2818 VSS nfet_06v0 L=1U W=2.5U AS=1.1P AD=1.1P PS=5.88U
+ PD=5.88U
M$1390 VSS VDD VSS VSS nfet_06v0 L=2U W=18U AS=7.92P AD=7.92P PS=36.88U
+ PD=36.88U
M$1391 \$2790 \$2830 \$2820 VSS nfet_06v0 L=1U W=2.5U AS=1.1P AD=1.1P PS=5.88U
+ PD=5.88U
M$1392 \$2851 \$2789 VSS VSS nfet_06v0 L=1U W=5U AS=2.2P AD=1.25P PS=10.88U
+ PD=5.5U
M$1393 \$2791 \$2813 \$2851 VSS nfet_06v0 L=1U W=5U AS=1.25P AD=2.2P PS=5.5U
+ PD=10.88U
M$1394 \$2849 \$2792 VSS VSS nfet_06v0 L=1U W=5U AS=2.2P AD=1.25P PS=10.88U
+ PD=5.5U
M$1395 \$2792 \$2813 \$2849 VSS nfet_06v0 L=1U W=5U AS=1.25P AD=1.65P PS=5.5U
+ PD=5.66U
M$1396 \$2830 \$2830 \$2792 VSS nfet_06v0 L=1U W=5U AS=1.65P AD=2.2P PS=5.66U
+ PD=10.88U
M$1397 \$2821 \$2820 VSS VSS nfet_06v0 L=1U W=5U AS=2.2P AD=1.3P PS=10.88U
+ PD=5.52U
M$1398 VSS \$2820 \$2821 VSS nfet_06v0 L=1U W=5U AS=1.3P AD=1.3P PS=5.52U
+ PD=5.52U
M$1399 \$2821 \$2820 VSS VSS nfet_06v0 L=1U W=5U AS=1.3P AD=2.2P PS=5.52U
+ PD=10.88U
M$1400 VSS VDD VSS VSS nfet_06v0 L=2U W=18U AS=7.92P AD=7.92P PS=36.88U
+ PD=36.88U
M$1401 VSS VDD VSS VSS nfet_06v0 L=2U W=9.75U AS=4.29P AD=4.29P PS=20.38U
+ PD=20.38U
M$1402 \$4617 \$4617 VSS VSS nfet_06v0 L=1U W=1U AS=0.44P AD=0.44P PS=2.88U
+ PD=2.88U
M$1403 \$4629 \$4571 VSS VSS nfet_06v0 L=1U W=5U AS=2.2P AD=1.25P PS=10.88U
+ PD=5.5U
M$1404 \$4571 \$4617 \$4629 VSS nfet_06v0 L=1U W=5U AS=1.25P AD=2.2P PS=5.5U
+ PD=10.88U
M$1405 \$4611 \$5123 VSS VSS nfet_06v0 L=1U W=1U AS=0.44P AD=0.25P PS=2.88U
+ PD=1.5U
M$1406 \$5122 \$5123 \$4611 VSS nfet_06v0 L=1U W=1U AS=0.25P AD=0.44P PS=1.5U
+ PD=2.88U
M$1407 \$4612 \$5123 VSS VSS nfet_06v0 L=1U W=1U AS=0.44P AD=0.25P PS=2.88U
+ PD=1.5U
M$1408 \$5123 \$5123 \$4612 VSS nfet_06v0 L=1U W=1U AS=0.25P AD=0.44P PS=1.5U
+ PD=2.88U
M$1409 \$4630 \$4571 VSS VSS nfet_06v0 L=1U W=5U AS=2.2P AD=1.25P PS=10.88U
+ PD=5.5U
M$1410 \$4587 \$4617 \$4630 VSS nfet_06v0 L=1U W=5U AS=1.25P AD=1.65P PS=5.5U
+ PD=5.66U
M$1411 \$4631 \$4617 \$4587 VSS nfet_06v0 L=1U W=5U AS=1.65P AD=1.25P PS=5.66U
+ PD=5.5U
M$1412 VSS \$4571 \$4631 VSS nfet_06v0 L=1U W=5U AS=1.25P AD=2.2P PS=5.5U
+ PD=10.88U
M$1413 \$4588 \$54 \$4587 VSS nfet_06v0 L=1U W=5U AS=2.2P AD=1.3P PS=10.88U
+ PD=5.52U
M$1414 \$4587 \$54 \$4588 VSS nfet_06v0 L=1U W=5U AS=1.3P AD=2.2P PS=5.52U
+ PD=10.88U
M$1415 \$4589 \$955 \$4587 VSS nfet_06v0 L=1U W=5U AS=2.2P AD=1.3P PS=10.88U
+ PD=5.52U
M$1416 \$4587 \$955 \$4589 VSS nfet_06v0 L=1U W=5U AS=1.3P AD=2.2P PS=5.52U
+ PD=10.88U
M$1417 \$4591 \$4617 \$4590 VSS nfet_06v0 L=1U W=2.5U AS=1.1P AD=0.65P PS=5.88U
+ PD=3.02U
M$1418 \$4590 \$4617 \$4591 VSS nfet_06v0 L=1U W=2.5U AS=0.65P AD=1.1P PS=3.02U
+ PD=5.88U
M$1419 \$4593 \$4617 \$4592 VSS nfet_06v0 L=1U W=2.5U AS=1.1P AD=0.65P PS=5.88U
+ PD=3.02U
M$1420 \$4592 \$4617 \$4593 VSS nfet_06v0 L=1U W=2.5U AS=0.65P AD=1.1P PS=3.02U
+ PD=5.88U
M$1421 \$4590 \$4591 VSS VSS nfet_06v0 L=1U W=2.5U AS=1.1P AD=0.65P PS=5.88U
+ PD=3.02U
M$1422 VSS \$4591 \$4590 VSS nfet_06v0 L=1U W=2.5U AS=0.65P AD=0.65P PS=3.02U
+ PD=3.02U
M$1423 \$4590 \$4591 VSS VSS nfet_06v0 L=1U W=2.5U AS=0.65P AD=0.65P PS=3.02U
+ PD=3.02U
M$1424 VSS \$4591 \$4590 VSS nfet_06v0 L=1U W=2.5U AS=0.65P AD=1.1P PS=3.02U
+ PD=5.88U
M$1425 \$4592 \$4591 VSS VSS nfet_06v0 L=1U W=2.5U AS=1.1P AD=0.65P PS=5.88U
+ PD=3.02U
M$1426 VSS \$4591 \$4592 VSS nfet_06v0 L=1U W=2.5U AS=0.65P AD=0.65P PS=3.02U
+ PD=3.02U
M$1427 \$4592 \$4591 VSS VSS nfet_06v0 L=1U W=2.5U AS=0.65P AD=0.65P PS=3.02U
+ PD=3.02U
M$1428 VSS \$4591 \$4592 VSS nfet_06v0 L=1U W=2.5U AS=0.65P AD=1.1P PS=3.02U
+ PD=5.88U
M$1429 \$4740 \$4622 \$4591 VSS nfet_06v0 L=1U W=2.5U AS=1.1P AD=1.1P PS=5.88U
+ PD=5.88U
M$1430 \$4572 \$4622 \$4593 VSS nfet_06v0 L=1U W=2.5U AS=1.1P AD=1.1P PS=5.88U
+ PD=5.88U
M$1431 \$4635 \$4571 VSS VSS nfet_06v0 L=1U W=5U AS=2.2P AD=1.25P PS=10.88U
+ PD=5.5U
M$1432 \$4573 \$4617 \$4635 VSS nfet_06v0 L=1U W=5U AS=1.25P AD=2.2P PS=5.5U
+ PD=10.88U
M$1433 \$4636 \$4574 VSS VSS nfet_06v0 L=1U W=5U AS=2.2P AD=1.25P PS=10.88U
+ PD=5.5U
M$1434 \$4574 \$4617 \$4636 VSS nfet_06v0 L=1U W=5U AS=1.25P AD=1.65P PS=5.5U
+ PD=5.66U
M$1435 \$4622 \$4622 \$4574 VSS nfet_06v0 L=1U W=5U AS=1.65P AD=2.2P PS=5.66U
+ PD=10.88U
M$1436 \$4594 \$4593 VSS VSS nfet_06v0 L=1U W=5U AS=2.2P AD=1.3P PS=10.88U
+ PD=5.52U
M$1437 VSS \$4593 \$4594 VSS nfet_06v0 L=1U W=5U AS=1.3P AD=1.3P PS=5.52U
+ PD=5.52U
M$1438 \$4594 \$4593 VSS VSS nfet_06v0 L=1U W=5U AS=1.3P AD=2.2P PS=5.52U
+ PD=10.88U
M$1439 VSS VDD VSS VSS nfet_06v0 L=2U W=9.75U AS=4.29P AD=4.29P PS=20.38U
+ PD=20.38U
M$1440 VSS VDD VSS VSS nfet_06v0 L=2U W=9.75U AS=4.29P AD=4.29P PS=20.38U
+ PD=20.38U
M$1441 \$4618 \$4618 VSS VSS nfet_06v0 L=1U W=1U AS=0.44P AD=0.44P PS=2.88U
+ PD=2.88U
M$1442 \$4637 \$4575 VSS VSS nfet_06v0 L=1U W=5U AS=2.2P AD=1.25P PS=10.88U
+ PD=5.5U
M$1443 \$4575 \$4618 \$4637 VSS nfet_06v0 L=1U W=5U AS=1.25P AD=2.2P PS=5.5U
+ PD=10.88U
M$1444 \$4616 \$5126 VSS VSS nfet_06v0 L=1U W=1U AS=0.44P AD=0.25P PS=2.88U
+ PD=1.5U
M$1445 \$5125 \$5126 \$4616 VSS nfet_06v0 L=1U W=1U AS=0.25P AD=0.44P PS=1.5U
+ PD=2.88U
M$1446 \$4615 \$5126 VSS VSS nfet_06v0 L=1U W=1U AS=0.44P AD=0.25P PS=2.88U
+ PD=1.5U
M$1447 \$5126 \$5126 \$4615 VSS nfet_06v0 L=1U W=1U AS=0.25P AD=0.44P PS=1.5U
+ PD=2.88U
M$1448 \$4638 \$4575 VSS VSS nfet_06v0 L=1U W=5U AS=2.2P AD=1.25P PS=10.88U
+ PD=5.5U
M$1449 \$4595 \$4618 \$4638 VSS nfet_06v0 L=1U W=5U AS=1.25P AD=1.65P PS=5.5U
+ PD=5.66U
M$1450 \$4639 \$4618 \$4595 VSS nfet_06v0 L=1U W=5U AS=1.65P AD=1.25P PS=5.66U
+ PD=5.5U
M$1451 VSS \$4575 \$4639 VSS nfet_06v0 L=1U W=5U AS=1.25P AD=2.2P PS=5.5U
+ PD=10.88U
M$1452 \$4596 \$944 \$4595 VSS nfet_06v0 L=1U W=5U AS=2.2P AD=1.3P PS=10.88U
+ PD=5.52U
M$1453 \$4595 \$944 \$4596 VSS nfet_06v0 L=1U W=5U AS=1.3P AD=2.2P PS=5.52U
+ PD=10.88U
M$1454 \$4597 \$955 \$4595 VSS nfet_06v0 L=1U W=5U AS=2.2P AD=1.3P PS=10.88U
+ PD=5.52U
M$1455 \$4595 \$955 \$4597 VSS nfet_06v0 L=1U W=5U AS=1.3P AD=2.2P PS=5.52U
+ PD=10.88U
M$1456 \$4599 \$4618 \$4598 VSS nfet_06v0 L=1U W=2.5U AS=1.1P AD=0.65P PS=5.88U
+ PD=3.02U
M$1457 \$4598 \$4618 \$4599 VSS nfet_06v0 L=1U W=2.5U AS=0.65P AD=1.1P PS=3.02U
+ PD=5.88U
M$1458 \$4601 \$4618 \$4600 VSS nfet_06v0 L=1U W=2.5U AS=1.1P AD=0.65P PS=5.88U
+ PD=3.02U
M$1459 \$4600 \$4618 \$4601 VSS nfet_06v0 L=1U W=2.5U AS=0.65P AD=1.1P PS=3.02U
+ PD=5.88U
M$1460 \$4598 \$4599 VSS VSS nfet_06v0 L=1U W=2.5U AS=1.1P AD=0.65P PS=5.88U
+ PD=3.02U
M$1461 VSS \$4599 \$4598 VSS nfet_06v0 L=1U W=2.5U AS=0.65P AD=0.65P PS=3.02U
+ PD=3.02U
M$1462 \$4598 \$4599 VSS VSS nfet_06v0 L=1U W=2.5U AS=0.65P AD=0.65P PS=3.02U
+ PD=3.02U
M$1463 VSS \$4599 \$4598 VSS nfet_06v0 L=1U W=2.5U AS=0.65P AD=1.1P PS=3.02U
+ PD=5.88U
M$1464 \$4600 \$4599 VSS VSS nfet_06v0 L=1U W=2.5U AS=1.1P AD=0.65P PS=5.88U
+ PD=3.02U
M$1465 VSS \$4599 \$4600 VSS nfet_06v0 L=1U W=2.5U AS=0.65P AD=0.65P PS=3.02U
+ PD=3.02U
M$1466 \$4600 \$4599 VSS VSS nfet_06v0 L=1U W=2.5U AS=0.65P AD=0.65P PS=3.02U
+ PD=3.02U
M$1467 VSS \$4599 \$4600 VSS nfet_06v0 L=1U W=2.5U AS=0.65P AD=1.1P PS=3.02U
+ PD=5.88U
M$1468 \$4742 \$4625 \$4599 VSS nfet_06v0 L=1U W=2.5U AS=1.1P AD=1.1P PS=5.88U
+ PD=5.88U
M$1469 \$4576 \$4625 \$4601 VSS nfet_06v0 L=1U W=2.5U AS=1.1P AD=1.1P PS=5.88U
+ PD=5.88U
M$1470 \$4641 \$4575 VSS VSS nfet_06v0 L=1U W=5U AS=2.2P AD=1.25P PS=10.88U
+ PD=5.5U
M$1471 \$4577 \$4618 \$4641 VSS nfet_06v0 L=1U W=5U AS=1.25P AD=2.2P PS=5.5U
+ PD=10.88U
M$1472 \$4642 \$4578 VSS VSS nfet_06v0 L=1U W=5U AS=2.2P AD=1.25P PS=10.88U
+ PD=5.5U
M$1473 \$4578 \$4618 \$4642 VSS nfet_06v0 L=1U W=5U AS=1.25P AD=1.65P PS=5.5U
+ PD=5.66U
M$1474 \$4625 \$4625 \$4578 VSS nfet_06v0 L=1U W=5U AS=1.65P AD=2.2P PS=5.66U
+ PD=10.88U
M$1475 \$4602 \$4601 VSS VSS nfet_06v0 L=1U W=5U AS=2.2P AD=1.3P PS=10.88U
+ PD=5.52U
M$1476 VSS \$4601 \$4602 VSS nfet_06v0 L=1U W=5U AS=1.3P AD=1.3P PS=5.52U
+ PD=5.52U
M$1477 \$4602 \$4601 VSS VSS nfet_06v0 L=1U W=5U AS=1.3P AD=2.2P PS=5.52U
+ PD=10.88U
M$1478 VSS VDD VSS VSS nfet_06v0 L=2U W=9.75U AS=4.29P AD=4.29P PS=20.38U
+ PD=20.38U
M$1479 VSS VDD VSS VSS nfet_06v0 L=2U W=9.75U AS=4.29P AD=4.29P PS=20.38U
+ PD=20.38U
M$1480 \$4619 \$4619 VSS VSS nfet_06v0 L=1U W=1U AS=0.44P AD=0.44P PS=2.88U
+ PD=2.88U
M$1481 \$4644 \$4580 VSS VSS nfet_06v0 L=1U W=5U AS=2.2P AD=1.25P PS=10.88U
+ PD=5.5U
M$1482 \$4580 \$4619 \$4644 VSS nfet_06v0 L=1U W=5U AS=1.25P AD=2.2P PS=5.5U
+ PD=10.88U
M$1483 \$4614 \$5129 VSS VSS nfet_06v0 L=1U W=1U AS=0.44P AD=0.25P PS=2.88U
+ PD=1.5U
M$1484 \$5128 \$5129 \$4614 VSS nfet_06v0 L=1U W=1U AS=0.25P AD=0.44P PS=1.5U
+ PD=2.88U
M$1485 \$4613 \$5129 VSS VSS nfet_06v0 L=1U W=1U AS=0.44P AD=0.25P PS=2.88U
+ PD=1.5U
M$1486 \$5129 \$5129 \$4613 VSS nfet_06v0 L=1U W=1U AS=0.25P AD=0.44P PS=1.5U
+ PD=2.88U
M$1487 \$4645 \$4580 VSS VSS nfet_06v0 L=1U W=5U AS=2.2P AD=1.25P PS=10.88U
+ PD=5.5U
M$1488 \$4603 \$4619 \$4645 VSS nfet_06v0 L=1U W=5U AS=1.25P AD=1.65P PS=5.5U
+ PD=5.66U
M$1489 \$4646 \$4619 \$4603 VSS nfet_06v0 L=1U W=5U AS=1.65P AD=1.25P PS=5.66U
+ PD=5.5U
M$1490 VSS \$4580 \$4646 VSS nfet_06v0 L=1U W=5U AS=1.25P AD=2.2P PS=5.5U
+ PD=10.88U
M$1491 \$4604 \$944 \$4603 VSS nfet_06v0 L=1U W=5U AS=2.2P AD=1.3P PS=10.88U
+ PD=5.52U
M$1492 \$4603 \$944 \$4604 VSS nfet_06v0 L=1U W=5U AS=1.3P AD=2.2P PS=5.52U
+ PD=10.88U
M$1493 \$4605 \$54 \$4603 VSS nfet_06v0 L=1U W=5U AS=2.2P AD=1.3P PS=10.88U
+ PD=5.52U
M$1494 \$4603 \$54 \$4605 VSS nfet_06v0 L=1U W=5U AS=1.3P AD=2.2P PS=5.52U
+ PD=10.88U
M$1495 \$4607 \$4619 \$4606 VSS nfet_06v0 L=1U W=2.5U AS=1.1P AD=0.65P PS=5.88U
+ PD=3.02U
M$1496 \$4606 \$4619 \$4607 VSS nfet_06v0 L=1U W=2.5U AS=0.65P AD=1.1P PS=3.02U
+ PD=5.88U
M$1497 \$4609 \$4619 \$4608 VSS nfet_06v0 L=1U W=2.5U AS=1.1P AD=0.65P PS=5.88U
+ PD=3.02U
M$1498 \$4608 \$4619 \$4609 VSS nfet_06v0 L=1U W=2.5U AS=0.65P AD=1.1P PS=3.02U
+ PD=5.88U
M$1499 \$4606 \$4607 VSS VSS nfet_06v0 L=1U W=2.5U AS=1.1P AD=0.65P PS=5.88U
+ PD=3.02U
M$1500 VSS \$4607 \$4606 VSS nfet_06v0 L=1U W=2.5U AS=0.65P AD=0.65P PS=3.02U
+ PD=3.02U
M$1501 \$4606 \$4607 VSS VSS nfet_06v0 L=1U W=2.5U AS=0.65P AD=0.65P PS=3.02U
+ PD=3.02U
M$1502 VSS \$4607 \$4606 VSS nfet_06v0 L=1U W=2.5U AS=0.65P AD=1.1P PS=3.02U
+ PD=5.88U
M$1503 \$4608 \$4607 VSS VSS nfet_06v0 L=1U W=2.5U AS=1.1P AD=0.65P PS=5.88U
+ PD=3.02U
M$1504 VSS \$4607 \$4608 VSS nfet_06v0 L=1U W=2.5U AS=0.65P AD=0.65P PS=3.02U
+ PD=3.02U
M$1505 \$4608 \$4607 VSS VSS nfet_06v0 L=1U W=2.5U AS=0.65P AD=0.65P PS=3.02U
+ PD=3.02U
M$1506 VSS \$4607 \$4608 VSS nfet_06v0 L=1U W=2.5U AS=0.65P AD=1.1P PS=3.02U
+ PD=5.88U
M$1507 \$4744 \$4628 \$4607 VSS nfet_06v0 L=1U W=2.5U AS=1.1P AD=1.1P PS=5.88U
+ PD=5.88U
M$1508 \$4581 \$4628 \$4609 VSS nfet_06v0 L=1U W=2.5U AS=1.1P AD=1.1P PS=5.88U
+ PD=5.88U
M$1509 \$4643 \$4580 VSS VSS nfet_06v0 L=1U W=5U AS=2.2P AD=1.25P PS=10.88U
+ PD=5.5U
M$1510 \$4582 \$4619 \$4643 VSS nfet_06v0 L=1U W=5U AS=1.25P AD=2.2P PS=5.5U
+ PD=10.88U
M$1511 \$4640 \$4583 VSS VSS nfet_06v0 L=1U W=5U AS=2.2P AD=1.25P PS=10.88U
+ PD=5.5U
M$1512 \$4583 \$4619 \$4640 VSS nfet_06v0 L=1U W=5U AS=1.25P AD=1.65P PS=5.5U
+ PD=5.66U
M$1513 \$4628 \$4628 \$4583 VSS nfet_06v0 L=1U W=5U AS=1.65P AD=2.2P PS=5.66U
+ PD=10.88U
M$1514 \$4610 \$4609 VSS VSS nfet_06v0 L=1U W=5U AS=2.2P AD=1.3P PS=10.88U
+ PD=5.52U
M$1515 VSS \$4609 \$4610 VSS nfet_06v0 L=1U W=5U AS=1.3P AD=1.3P PS=5.52U
+ PD=5.52U
M$1516 \$4610 \$4609 VSS VSS nfet_06v0 L=1U W=5U AS=1.3P AD=2.2P PS=5.52U
+ PD=10.88U
M$1517 VSS VDD VSS VSS nfet_06v0 L=2U W=9.75U AS=4.29P AD=4.29P PS=20.38U
+ PD=20.38U
M$1518 VSS VDD VSS VSS nfet_06v0 L=2U W=9.75U AS=4.29P AD=4.29P PS=20.38U
+ PD=20.38U
M$1519 X \$2855 \$2866 VSS nfet_06v0 L=1U W=2.48U AS=1.0912P AD=0.6448P
+ PS=5.84U PD=3U
M$1520 \$2866 \$2855 X VSS nfet_06v0 L=1U W=2.48U AS=0.6448P AD=1.0912P PS=3U
+ PD=5.84U
M$1521 X \$2784 \$2778 VSS nfet_06v0 L=1U W=2.48U AS=1.0912P AD=0.6448P
+ PS=5.84U PD=3U
M$1522 \$2778 \$2784 X VSS nfet_06v0 L=1U W=2.48U AS=0.6448P AD=1.0912P PS=3U
+ PD=5.84U
M$1523 X \$2856 \$2868 VSS nfet_06v0 L=1U W=2.48U AS=1.0912P AD=0.6448P
+ PS=5.84U PD=3U
M$1524 \$2868 \$2856 X VSS nfet_06v0 L=1U W=2.48U AS=0.6448P AD=1.0912P PS=3U
+ PD=5.84U
M$1525 \$2778 \$2793 VSS VSS nfet_06v0 L=1U W=1.24U AS=0.5456P AD=0.5456P
+ PS=3.36U PD=3.36U
M$1526 \$2866 \$2793 VSS VSS nfet_06v0 L=1U W=1.24U AS=0.5456P AD=0.5456P
+ PS=3.36U PD=3.36U
M$1527 \$2868 \$2793 VSS VSS nfet_06v0 L=1U W=1.24U AS=0.5456P AD=0.5456P
+ PS=3.36U PD=3.36U
M$1528 \$2833 \$2793 VSS VSS nfet_06v0 L=1U W=0.7U AS=0.308P AD=0.175P PS=2.28U
+ PD=1.2U
M$1529 \$2832 \$2793 \$2833 VSS nfet_06v0 L=1U W=0.7U AS=0.175P AD=0.175P
+ PS=1.2U PD=1.2U
M$1530 \$2831 \$2793 \$2832 VSS nfet_06v0 L=1U W=0.7U AS=0.175P AD=0.175P
+ PS=1.2U PD=1.2U
M$1531 \$2793 \$2793 \$2831 VSS nfet_06v0 L=1U W=0.7U AS=0.175P AD=0.308P
+ PS=1.2U PD=2.28U
M$1532 X X \$2869 VSS nfet_06v0 L=1U W=2U AS=0.88P AD=0.52P PS=4.88U PD=2.52U
M$1533 \$2869 X X VSS nfet_06v0 L=1U W=2U AS=0.52P AD=0.88P PS=2.52U PD=4.88U
M$1534 \$2952 X VSS VSS nfet_06v0 L=1U W=2U AS=0.88P AD=0.5P PS=4.88U PD=2.5U
M$1535 \$2869 X \$2952 VSS nfet_06v0 L=1U W=2U AS=0.5P AD=0.88P PS=2.5U PD=4.88U
M$1536 X \$3328 \$2870 VSS nfet_06v0 L=1U W=2.48U AS=1.0912P AD=0.6448P
+ PS=5.84U PD=3U
M$1537 \$2870 \$3328 X VSS nfet_06v0 L=1U W=2.48U AS=0.6448P AD=1.0912P PS=3U
+ PD=5.84U
M$1538 \$2870 \$2793 VSS VSS nfet_06v0 L=1U W=1.24U AS=0.5456P AD=0.5456P
+ PS=3.36U PD=3.36U
M$1539 VSS VDD VSS VSS nfet_06v0 L=2U W=9.75U AS=4.29P AD=4.29P PS=20.38U
+ PD=20.38U
M$1540 \$6407 \$6407 VSS VSS nfet_06v0 L=1U W=1U AS=0.44P AD=0.44P PS=2.88U
+ PD=2.88U
M$1541 \$6419 \$6362 VSS VSS nfet_06v0 L=1U W=5U AS=2.2P AD=1.25P PS=10.88U
+ PD=5.5U
M$1542 \$6362 \$6407 \$6419 VSS nfet_06v0 L=1U W=5U AS=1.25P AD=2.2P PS=5.5U
+ PD=10.88U
M$1543 \$6401 \$6989 VSS VSS nfet_06v0 L=1U W=1U AS=0.44P AD=0.25P PS=2.88U
+ PD=1.5U
M$1544 \$6835 \$6989 \$6401 VSS nfet_06v0 L=1U W=1U AS=0.25P AD=0.44P PS=1.5U
+ PD=2.88U
M$1545 \$6402 \$6989 VSS VSS nfet_06v0 L=1U W=1U AS=0.44P AD=0.25P PS=2.88U
+ PD=1.5U
M$1546 \$6989 \$6989 \$6402 VSS nfet_06v0 L=1U W=1U AS=0.25P AD=0.44P PS=1.5U
+ PD=2.88U
M$1547 \$6420 \$6362 VSS VSS nfet_06v0 L=1U W=5U AS=2.2P AD=1.25P PS=10.88U
+ PD=5.5U
M$1548 \$6377 \$6407 \$6420 VSS nfet_06v0 L=1U W=5U AS=1.25P AD=1.65P PS=5.5U
+ PD=5.66U
M$1549 \$6421 \$6407 \$6377 VSS nfet_06v0 L=1U W=5U AS=1.65P AD=1.25P PS=5.66U
+ PD=5.5U
M$1550 VSS \$6362 \$6421 VSS nfet_06v0 L=1U W=5U AS=1.25P AD=2.2P PS=5.5U
+ PD=10.88U
M$1551 \$6378 \$966 \$6377 VSS nfet_06v0 L=1U W=5U AS=2.2P AD=1.3P PS=10.88U
+ PD=5.52U
M$1552 \$6377 \$966 \$6378 VSS nfet_06v0 L=1U W=5U AS=1.3P AD=2.2P PS=5.52U
+ PD=10.88U
M$1553 \$6379 \$1866 \$6377 VSS nfet_06v0 L=1U W=5U AS=2.2P AD=1.3P PS=10.88U
+ PD=5.52U
M$1554 \$6377 \$1866 \$6379 VSS nfet_06v0 L=1U W=5U AS=1.3P AD=2.2P PS=5.52U
+ PD=10.88U
M$1555 \$6381 \$6407 \$6380 VSS nfet_06v0 L=1U W=2.5U AS=1.1P AD=0.65P PS=5.88U
+ PD=3.02U
M$1556 \$6380 \$6407 \$6381 VSS nfet_06v0 L=1U W=2.5U AS=0.65P AD=1.1P PS=3.02U
+ PD=5.88U
M$1557 \$6383 \$6407 \$6382 VSS nfet_06v0 L=1U W=2.5U AS=1.1P AD=0.65P PS=5.88U
+ PD=3.02U
M$1558 \$6382 \$6407 \$6383 VSS nfet_06v0 L=1U W=2.5U AS=0.65P AD=1.1P PS=3.02U
+ PD=5.88U
M$1559 \$6380 \$6381 VSS VSS nfet_06v0 L=1U W=2.5U AS=1.1P AD=0.65P PS=5.88U
+ PD=3.02U
M$1560 VSS \$6381 \$6380 VSS nfet_06v0 L=1U W=2.5U AS=0.65P AD=0.65P PS=3.02U
+ PD=3.02U
M$1561 \$6380 \$6381 VSS VSS nfet_06v0 L=1U W=2.5U AS=0.65P AD=0.65P PS=3.02U
+ PD=3.02U
M$1562 VSS \$6381 \$6380 VSS nfet_06v0 L=1U W=2.5U AS=0.65P AD=1.1P PS=3.02U
+ PD=5.88U
M$1563 \$6382 \$6381 VSS VSS nfet_06v0 L=1U W=2.5U AS=1.1P AD=0.65P PS=5.88U
+ PD=3.02U
M$1564 VSS \$6381 \$6382 VSS nfet_06v0 L=1U W=2.5U AS=0.65P AD=0.65P PS=3.02U
+ PD=3.02U
M$1565 \$6382 \$6381 VSS VSS nfet_06v0 L=1U W=2.5U AS=0.65P AD=0.65P PS=3.02U
+ PD=3.02U
M$1566 VSS \$6381 \$6382 VSS nfet_06v0 L=1U W=2.5U AS=0.65P AD=1.1P PS=3.02U
+ PD=5.88U
M$1567 \$6531 \$6412 \$6381 VSS nfet_06v0 L=1U W=2.5U AS=1.1P AD=1.1P PS=5.88U
+ PD=5.88U
M$1568 \$6363 \$6412 \$6383 VSS nfet_06v0 L=1U W=2.5U AS=1.1P AD=1.1P PS=5.88U
+ PD=5.88U
M$1569 \$6425 \$6362 VSS VSS nfet_06v0 L=1U W=5U AS=2.2P AD=1.25P PS=10.88U
+ PD=5.5U
M$1570 \$6364 \$6407 \$6425 VSS nfet_06v0 L=1U W=5U AS=1.25P AD=2.2P PS=5.5U
+ PD=10.88U
M$1571 \$6426 \$6365 VSS VSS nfet_06v0 L=1U W=5U AS=2.2P AD=1.25P PS=10.88U
+ PD=5.5U
M$1572 \$6365 \$6407 \$6426 VSS nfet_06v0 L=1U W=5U AS=1.25P AD=1.65P PS=5.5U
+ PD=5.66U
M$1573 \$6412 \$6412 \$6365 VSS nfet_06v0 L=1U W=5U AS=1.65P AD=2.2P PS=5.66U
+ PD=10.88U
M$1574 \$6384 \$6383 VSS VSS nfet_06v0 L=1U W=5U AS=2.2P AD=1.3P PS=10.88U
+ PD=5.52U
M$1575 VSS \$6383 \$6384 VSS nfet_06v0 L=1U W=5U AS=1.3P AD=1.3P PS=5.52U
+ PD=5.52U
M$1576 \$6384 \$6383 VSS VSS nfet_06v0 L=1U W=5U AS=1.3P AD=2.2P PS=5.52U
+ PD=10.88U
M$1577 VSS VDD VSS VSS nfet_06v0 L=2U W=9.75U AS=4.29P AD=4.29P PS=20.38U
+ PD=20.38U
M$1578 VSS VDD VSS VSS nfet_06v0 L=2U W=9.75U AS=4.29P AD=4.29P PS=20.38U
+ PD=20.38U
M$1579 \$6408 \$6408 VSS VSS nfet_06v0 L=1U W=1U AS=0.44P AD=0.44P PS=2.88U
+ PD=2.88U
M$1580 \$6427 \$6366 VSS VSS nfet_06v0 L=1U W=5U AS=2.2P AD=1.25P PS=10.88U
+ PD=5.5U
M$1581 \$6366 \$6408 \$6427 VSS nfet_06v0 L=1U W=5U AS=1.25P AD=2.2P PS=5.5U
+ PD=10.88U
M$1582 \$6405 \$6991 VSS VSS nfet_06v0 L=1U W=1U AS=0.44P AD=0.25P PS=2.88U
+ PD=1.5U
M$1583 \$6836 \$6991 \$6405 VSS nfet_06v0 L=1U W=1U AS=0.25P AD=0.44P PS=1.5U
+ PD=2.88U
M$1584 \$6406 \$6991 VSS VSS nfet_06v0 L=1U W=1U AS=0.44P AD=0.25P PS=2.88U
+ PD=1.5U
M$1585 \$6991 \$6991 \$6406 VSS nfet_06v0 L=1U W=1U AS=0.25P AD=0.44P PS=1.5U
+ PD=2.88U
M$1586 \$6428 \$6366 VSS VSS nfet_06v0 L=1U W=5U AS=2.2P AD=1.25P PS=10.88U
+ PD=5.5U
M$1587 \$6385 \$6408 \$6428 VSS nfet_06v0 L=1U W=5U AS=1.25P AD=1.65P PS=5.5U
+ PD=5.66U
M$1588 \$6429 \$6408 \$6385 VSS nfet_06v0 L=1U W=5U AS=1.65P AD=1.25P PS=5.66U
+ PD=5.5U
M$1589 VSS \$6366 \$6429 VSS nfet_06v0 L=1U W=5U AS=1.25P AD=2.2P PS=5.5U
+ PD=10.88U
M$1590 \$6386 \$977 \$6385 VSS nfet_06v0 L=1U W=5U AS=2.2P AD=1.3P PS=10.88U
+ PD=5.52U
M$1591 \$6385 \$977 \$6386 VSS nfet_06v0 L=1U W=5U AS=1.3P AD=2.2P PS=5.52U
+ PD=10.88U
M$1592 \$6387 \$1866 \$6385 VSS nfet_06v0 L=1U W=5U AS=2.2P AD=1.3P PS=10.88U
+ PD=5.52U
M$1593 \$6385 \$1866 \$6387 VSS nfet_06v0 L=1U W=5U AS=1.3P AD=2.2P PS=5.52U
+ PD=10.88U
M$1594 \$6389 \$6408 \$6388 VSS nfet_06v0 L=1U W=2.5U AS=1.1P AD=0.65P PS=5.88U
+ PD=3.02U
M$1595 \$6388 \$6408 \$6389 VSS nfet_06v0 L=1U W=2.5U AS=0.65P AD=1.1P PS=3.02U
+ PD=5.88U
M$1596 \$6391 \$6408 \$6390 VSS nfet_06v0 L=1U W=2.5U AS=1.1P AD=0.65P PS=5.88U
+ PD=3.02U
M$1597 \$6390 \$6408 \$6391 VSS nfet_06v0 L=1U W=2.5U AS=0.65P AD=1.1P PS=3.02U
+ PD=5.88U
M$1598 \$6388 \$6389 VSS VSS nfet_06v0 L=1U W=2.5U AS=1.1P AD=0.65P PS=5.88U
+ PD=3.02U
M$1599 VSS \$6389 \$6388 VSS nfet_06v0 L=1U W=2.5U AS=0.65P AD=0.65P PS=3.02U
+ PD=3.02U
M$1600 \$6388 \$6389 VSS VSS nfet_06v0 L=1U W=2.5U AS=0.65P AD=0.65P PS=3.02U
+ PD=3.02U
M$1601 VSS \$6389 \$6388 VSS nfet_06v0 L=1U W=2.5U AS=0.65P AD=1.1P PS=3.02U
+ PD=5.88U
M$1602 \$6390 \$6389 VSS VSS nfet_06v0 L=1U W=2.5U AS=1.1P AD=0.65P PS=5.88U
+ PD=3.02U
M$1603 VSS \$6389 \$6390 VSS nfet_06v0 L=1U W=2.5U AS=0.65P AD=0.65P PS=3.02U
+ PD=3.02U
M$1604 \$6390 \$6389 VSS VSS nfet_06v0 L=1U W=2.5U AS=0.65P AD=0.65P PS=3.02U
+ PD=3.02U
M$1605 VSS \$6389 \$6390 VSS nfet_06v0 L=1U W=2.5U AS=0.65P AD=1.1P PS=3.02U
+ PD=5.88U
M$1606 \$6532 \$6415 \$6389 VSS nfet_06v0 L=1U W=2.5U AS=1.1P AD=1.1P PS=5.88U
+ PD=5.88U
M$1607 \$6367 \$6415 \$6391 VSS nfet_06v0 L=1U W=2.5U AS=1.1P AD=1.1P PS=5.88U
+ PD=5.88U
M$1608 \$6430 \$6366 VSS VSS nfet_06v0 L=1U W=5U AS=2.2P AD=1.25P PS=10.88U
+ PD=5.5U
M$1609 \$6368 \$6408 \$6430 VSS nfet_06v0 L=1U W=5U AS=1.25P AD=2.2P PS=5.5U
+ PD=10.88U
M$1610 \$6431 \$6369 VSS VSS nfet_06v0 L=1U W=5U AS=2.2P AD=1.25P PS=10.88U
+ PD=5.5U
M$1611 \$6369 \$6408 \$6431 VSS nfet_06v0 L=1U W=5U AS=1.25P AD=1.65P PS=5.5U
+ PD=5.66U
M$1612 \$6415 \$6415 \$6369 VSS nfet_06v0 L=1U W=5U AS=1.65P AD=2.2P PS=5.66U
+ PD=10.88U
M$1613 \$6392 \$6391 VSS VSS nfet_06v0 L=1U W=5U AS=2.2P AD=1.3P PS=10.88U
+ PD=5.52U
M$1614 VSS \$6391 \$6392 VSS nfet_06v0 L=1U W=5U AS=1.3P AD=1.3P PS=5.52U
+ PD=5.52U
M$1615 \$6392 \$6391 VSS VSS nfet_06v0 L=1U W=5U AS=1.3P AD=2.2P PS=5.52U
+ PD=10.88U
M$1616 VSS VDD VSS VSS nfet_06v0 L=2U W=9.75U AS=4.29P AD=4.29P PS=20.38U
+ PD=20.38U
M$1617 VSS VDD VSS VSS nfet_06v0 L=2U W=9.75U AS=4.29P AD=4.29P PS=20.38U
+ PD=20.38U
M$1618 \$6409 \$6409 VSS VSS nfet_06v0 L=1U W=1U AS=0.44P AD=0.44P PS=2.88U
+ PD=2.88U
M$1619 \$6432 \$6371 VSS VSS nfet_06v0 L=1U W=5U AS=2.2P AD=1.25P PS=10.88U
+ PD=5.5U
M$1620 \$6371 \$6409 \$6432 VSS nfet_06v0 L=1U W=5U AS=1.25P AD=2.2P PS=5.5U
+ PD=10.88U
M$1621 \$6404 \$6993 VSS VSS nfet_06v0 L=1U W=1U AS=0.44P AD=0.25P PS=2.88U
+ PD=1.5U
M$1622 \$6837 \$6993 \$6404 VSS nfet_06v0 L=1U W=1U AS=0.25P AD=0.44P PS=1.5U
+ PD=2.88U
M$1623 \$6403 \$6993 VSS VSS nfet_06v0 L=1U W=1U AS=0.44P AD=0.25P PS=2.88U
+ PD=1.5U
M$1624 \$6993 \$6993 \$6403 VSS nfet_06v0 L=1U W=1U AS=0.25P AD=0.44P PS=1.5U
+ PD=2.88U
M$1625 \$6434 \$6371 VSS VSS nfet_06v0 L=1U W=5U AS=2.2P AD=1.25P PS=10.88U
+ PD=5.5U
M$1626 \$6393 \$6409 \$6434 VSS nfet_06v0 L=1U W=5U AS=1.25P AD=1.65P PS=5.5U
+ PD=5.66U
M$1627 \$6435 \$6409 \$6393 VSS nfet_06v0 L=1U W=5U AS=1.65P AD=1.25P PS=5.66U
+ PD=5.5U
M$1628 VSS \$6371 \$6435 VSS nfet_06v0 L=1U W=5U AS=1.25P AD=2.2P PS=5.5U
+ PD=10.88U
M$1629 \$6394 \$977 \$6393 VSS nfet_06v0 L=1U W=5U AS=2.2P AD=1.3P PS=10.88U
+ PD=5.52U
M$1630 \$6393 \$977 \$6394 VSS nfet_06v0 L=1U W=5U AS=1.3P AD=2.2P PS=5.52U
+ PD=10.88U
M$1631 \$6395 \$966 \$6393 VSS nfet_06v0 L=1U W=5U AS=2.2P AD=1.3P PS=10.88U
+ PD=5.52U
M$1632 \$6393 \$966 \$6395 VSS nfet_06v0 L=1U W=5U AS=1.3P AD=2.2P PS=5.52U
+ PD=10.88U
M$1633 \$6397 \$6409 \$6396 VSS nfet_06v0 L=1U W=2.5U AS=1.1P AD=0.65P PS=5.88U
+ PD=3.02U
M$1634 \$6396 \$6409 \$6397 VSS nfet_06v0 L=1U W=2.5U AS=0.65P AD=1.1P PS=3.02U
+ PD=5.88U
M$1635 \$6399 \$6409 \$6398 VSS nfet_06v0 L=1U W=2.5U AS=1.1P AD=0.65P PS=5.88U
+ PD=3.02U
M$1636 \$6398 \$6409 \$6399 VSS nfet_06v0 L=1U W=2.5U AS=0.65P AD=1.1P PS=3.02U
+ PD=5.88U
M$1637 \$6396 \$6397 VSS VSS nfet_06v0 L=1U W=2.5U AS=1.1P AD=0.65P PS=5.88U
+ PD=3.02U
M$1638 VSS \$6397 \$6396 VSS nfet_06v0 L=1U W=2.5U AS=0.65P AD=0.65P PS=3.02U
+ PD=3.02U
M$1639 \$6396 \$6397 VSS VSS nfet_06v0 L=1U W=2.5U AS=0.65P AD=0.65P PS=3.02U
+ PD=3.02U
M$1640 VSS \$6397 \$6396 VSS nfet_06v0 L=1U W=2.5U AS=0.65P AD=1.1P PS=3.02U
+ PD=5.88U
M$1641 \$6398 \$6397 VSS VSS nfet_06v0 L=1U W=2.5U AS=1.1P AD=0.65P PS=5.88U
+ PD=3.02U
M$1642 VSS \$6397 \$6398 VSS nfet_06v0 L=1U W=2.5U AS=0.65P AD=0.65P PS=3.02U
+ PD=3.02U
M$1643 \$6398 \$6397 VSS VSS nfet_06v0 L=1U W=2.5U AS=0.65P AD=0.65P PS=3.02U
+ PD=3.02U
M$1644 VSS \$6397 \$6398 VSS nfet_06v0 L=1U W=2.5U AS=0.65P AD=1.1P PS=3.02U
+ PD=5.88U
M$1645 \$6533 \$6418 \$6397 VSS nfet_06v0 L=1U W=2.5U AS=1.1P AD=1.1P PS=5.88U
+ PD=5.88U
M$1646 \$6372 \$6418 \$6399 VSS nfet_06v0 L=1U W=2.5U AS=1.1P AD=1.1P PS=5.88U
+ PD=5.88U
M$1647 \$6436 \$6371 VSS VSS nfet_06v0 L=1U W=5U AS=2.2P AD=1.25P PS=10.88U
+ PD=5.5U
M$1648 \$6373 \$6409 \$6436 VSS nfet_06v0 L=1U W=5U AS=1.25P AD=2.2P PS=5.5U
+ PD=10.88U
M$1649 \$6433 \$6374 VSS VSS nfet_06v0 L=1U W=5U AS=2.2P AD=1.25P PS=10.88U
+ PD=5.5U
M$1650 \$6374 \$6409 \$6433 VSS nfet_06v0 L=1U W=5U AS=1.25P AD=1.65P PS=5.5U
+ PD=5.66U
M$1651 \$6418 \$6418 \$6374 VSS nfet_06v0 L=1U W=5U AS=1.65P AD=2.2P PS=5.66U
+ PD=10.88U
M$1652 \$6400 \$6399 VSS VSS nfet_06v0 L=1U W=5U AS=2.2P AD=1.3P PS=10.88U
+ PD=5.52U
M$1653 VSS \$6399 \$6400 VSS nfet_06v0 L=1U W=5U AS=1.3P AD=1.3P PS=5.52U
+ PD=5.52U
M$1654 \$6400 \$6399 VSS VSS nfet_06v0 L=1U W=5U AS=1.3P AD=2.2P PS=5.52U
+ PD=10.88U
M$1655 VSS VDD VSS VSS nfet_06v0 L=2U W=9.75U AS=4.29P AD=4.29P PS=20.38U
+ PD=20.38U
M$1656 VSS VDD VSS VSS nfet_06v0 L=2U W=9.75U AS=4.29P AD=4.29P PS=20.38U
+ PD=20.38U
M$1657 Y \$4654 \$4653 VSS nfet_06v0 L=1U W=2.48U AS=1.0912P AD=0.6448P
+ PS=5.84U PD=3U
M$1658 \$4653 \$4654 Y VSS nfet_06v0 L=1U W=2.48U AS=0.6448P AD=1.0912P PS=3U
+ PD=5.84U
M$1659 Y \$4579 \$4569 VSS nfet_06v0 L=1U W=2.48U AS=1.0912P AD=0.6448P
+ PS=5.84U PD=3U
M$1660 \$4569 \$4579 Y VSS nfet_06v0 L=1U W=2.48U AS=0.6448P AD=1.0912P PS=3U
+ PD=5.84U
M$1661 Y \$4656 \$4655 VSS nfet_06v0 L=1U W=2.48U AS=1.0912P AD=0.6448P
+ PS=5.84U PD=3U
M$1662 \$4655 \$4656 Y VSS nfet_06v0 L=1U W=2.48U AS=0.6448P AD=1.0912P PS=3U
+ PD=5.84U
M$1663 \$4569 \$4584 VSS VSS nfet_06v0 L=1U W=1.24U AS=0.5456P AD=0.5456P
+ PS=3.36U PD=3.36U
M$1664 \$4653 \$4584 VSS VSS nfet_06v0 L=1U W=1.24U AS=0.5456P AD=0.5456P
+ PS=3.36U PD=3.36U
M$1665 \$4655 \$4584 VSS VSS nfet_06v0 L=1U W=1.24U AS=0.5456P AD=0.5456P
+ PS=3.36U PD=3.36U
M$1666 \$4634 \$4584 VSS VSS nfet_06v0 L=1U W=0.7U AS=0.308P AD=0.175P PS=2.28U
+ PD=1.2U
M$1667 \$4633 \$4584 \$4634 VSS nfet_06v0 L=1U W=0.7U AS=0.175P AD=0.175P
+ PS=1.2U PD=1.2U
M$1668 \$4632 \$4584 \$4633 VSS nfet_06v0 L=1U W=0.7U AS=0.175P AD=0.175P
+ PS=1.2U PD=1.2U
M$1669 \$4584 \$4584 \$4632 VSS nfet_06v0 L=1U W=0.7U AS=0.175P AD=0.308P
+ PS=1.2U PD=2.28U
M$1670 Y Y \$4657 VSS nfet_06v0 L=1U W=2U AS=0.88P AD=0.52P PS=4.88U PD=2.52U
M$1671 \$4657 Y Y VSS nfet_06v0 L=1U W=2U AS=0.52P AD=0.88P PS=2.52U PD=4.88U
M$1672 \$4745 Y VSS VSS nfet_06v0 L=1U W=2U AS=0.88P AD=0.5P PS=4.88U PD=2.5U
M$1673 \$4657 Y \$4745 VSS nfet_06v0 L=1U W=2U AS=0.5P AD=0.88P PS=2.5U PD=4.88U
M$1674 Y \$4659 \$4658 VSS nfet_06v0 L=1U W=2.48U AS=1.0912P AD=0.6448P
+ PS=5.84U PD=3U
M$1675 \$4658 \$4659 Y VSS nfet_06v0 L=1U W=2.48U AS=0.6448P AD=1.0912P PS=3U
+ PD=5.84U
M$1676 \$4658 \$4584 VSS VSS nfet_06v0 L=1U W=1.24U AS=0.5456P AD=0.5456P
+ PS=3.36U PD=3.36U
M$1677 VSS VDD VSS VSS nfet_06v0 L=2U W=9.75U AS=4.29P AD=4.29P PS=20.38U
+ PD=20.38U
M$1678 \$8164 \$8164 VSS VSS nfet_06v0 L=1U W=1U AS=0.44P AD=0.44P PS=2.88U
+ PD=2.88U
M$1679 \$8210 \$8151 VSS VSS nfet_06v0 L=1U W=5U AS=2.2P AD=1.25P PS=10.88U
+ PD=5.5U
M$1680 \$8151 \$8164 \$8210 VSS nfet_06v0 L=1U W=5U AS=1.25P AD=2.2P PS=5.5U
+ PD=10.88U
M$1681 \$8194 \$8695 VSS VSS nfet_06v0 L=1U W=1U AS=0.44P AD=0.25P PS=2.88U
+ PD=1.5U
M$1682 \$8694 \$8695 \$8194 VSS nfet_06v0 L=1U W=1U AS=0.25P AD=0.44P PS=1.5U
+ PD=2.88U
M$1683 \$8195 \$8695 VSS VSS nfet_06v0 L=1U W=1U AS=0.44P AD=0.25P PS=2.88U
+ PD=1.5U
M$1684 \$8695 \$8695 \$8195 VSS nfet_06v0 L=1U W=1U AS=0.25P AD=0.44P PS=1.5U
+ PD=2.88U
M$1685 \$8211 \$8151 VSS VSS nfet_06v0 L=1U W=5U AS=2.2P AD=1.25P PS=10.88U
+ PD=5.5U
M$1686 \$8165 \$8164 \$8211 VSS nfet_06v0 L=1U W=5U AS=1.25P AD=1.65P PS=5.5U
+ PD=5.66U
M$1687 \$8212 \$8164 \$8165 VSS nfet_06v0 L=1U W=5U AS=1.65P AD=1.25P PS=5.66U
+ PD=5.5U
M$1688 VSS \$8151 \$8212 VSS nfet_06v0 L=1U W=5U AS=1.25P AD=2.2P PS=5.5U
+ PD=10.88U
M$1689 \$8166 \$1876 \$8165 VSS nfet_06v0 L=1U W=5U AS=2.2P AD=1.3P PS=10.88U
+ PD=5.52U
M$1690 \$8165 \$1876 \$8166 VSS nfet_06v0 L=1U W=5U AS=1.3P AD=2.2P PS=5.52U
+ PD=10.88U
M$1691 \$8167 \$1896 \$8165 VSS nfet_06v0 L=1U W=5U AS=2.2P AD=1.3P PS=10.88U
+ PD=5.52U
M$1692 \$8165 \$1896 \$8167 VSS nfet_06v0 L=1U W=5U AS=1.3P AD=2.2P PS=5.52U
+ PD=10.88U
M$1693 \$8169 \$8164 \$8168 VSS nfet_06v0 L=1U W=2.5U AS=1.1P AD=0.65P PS=5.88U
+ PD=3.02U
M$1694 \$8168 \$8164 \$8169 VSS nfet_06v0 L=1U W=2.5U AS=0.65P AD=1.1P PS=3.02U
+ PD=5.88U
M$1695 \$8171 \$8164 \$8170 VSS nfet_06v0 L=1U W=2.5U AS=1.1P AD=0.65P PS=5.88U
+ PD=3.02U
M$1696 \$8170 \$8164 \$8171 VSS nfet_06v0 L=1U W=2.5U AS=0.65P AD=1.1P PS=3.02U
+ PD=5.88U
M$1697 \$8168 \$8169 VSS VSS nfet_06v0 L=1U W=2.5U AS=1.1P AD=0.65P PS=5.88U
+ PD=3.02U
M$1698 VSS \$8169 \$8168 VSS nfet_06v0 L=1U W=2.5U AS=0.65P AD=0.65P PS=3.02U
+ PD=3.02U
M$1699 \$8168 \$8169 VSS VSS nfet_06v0 L=1U W=2.5U AS=0.65P AD=0.65P PS=3.02U
+ PD=3.02U
M$1700 VSS \$8169 \$8168 VSS nfet_06v0 L=1U W=2.5U AS=0.65P AD=1.1P PS=3.02U
+ PD=5.88U
M$1701 \$8170 \$8169 VSS VSS nfet_06v0 L=1U W=2.5U AS=1.1P AD=0.65P PS=5.88U
+ PD=3.02U
M$1702 VSS \$8169 \$8170 VSS nfet_06v0 L=1U W=2.5U AS=0.65P AD=0.65P PS=3.02U
+ PD=3.02U
M$1703 \$8170 \$8169 VSS VSS nfet_06v0 L=1U W=2.5U AS=0.65P AD=0.65P PS=3.02U
+ PD=3.02U
M$1704 VSS \$8169 \$8170 VSS nfet_06v0 L=1U W=2.5U AS=0.65P AD=1.1P PS=3.02U
+ PD=5.88U
M$1705 \$8312 \$8201 \$8169 VSS nfet_06v0 L=1U W=2.5U AS=1.1P AD=1.1P PS=5.88U
+ PD=5.88U
M$1706 \$8152 \$8201 \$8171 VSS nfet_06v0 L=1U W=2.5U AS=1.1P AD=1.1P PS=5.88U
+ PD=5.88U
M$1707 \$8213 \$8151 VSS VSS nfet_06v0 L=1U W=5U AS=2.2P AD=1.25P PS=10.88U
+ PD=5.5U
M$1708 \$8153 \$8164 \$8213 VSS nfet_06v0 L=1U W=5U AS=1.25P AD=2.2P PS=5.5U
+ PD=10.88U
M$1709 \$8214 \$8154 VSS VSS nfet_06v0 L=1U W=5U AS=2.2P AD=1.25P PS=10.88U
+ PD=5.5U
M$1710 \$8154 \$8164 \$8214 VSS nfet_06v0 L=1U W=5U AS=1.25P AD=1.65P PS=5.5U
+ PD=5.66U
M$1711 \$8201 \$8201 \$8154 VSS nfet_06v0 L=1U W=5U AS=1.65P AD=2.2P PS=5.66U
+ PD=10.88U
M$1712 \$8172 \$8171 VSS VSS nfet_06v0 L=1U W=5U AS=2.2P AD=1.3P PS=10.88U
+ PD=5.52U
M$1713 VSS \$8171 \$8172 VSS nfet_06v0 L=1U W=5U AS=1.3P AD=1.3P PS=5.52U
+ PD=5.52U
M$1714 \$8172 \$8171 VSS VSS nfet_06v0 L=1U W=5U AS=1.3P AD=2.2P PS=5.52U
+ PD=10.88U
M$1715 VSS VDD VSS VSS nfet_06v0 L=2U W=9.75U AS=4.29P AD=4.29P PS=20.38U
+ PD=20.38U
M$1716 VSS VDD VSS VSS nfet_06v0 L=2U W=9.75U AS=4.29P AD=4.29P PS=20.38U
+ PD=20.38U
M$1717 \$8173 \$8173 VSS VSS nfet_06v0 L=1U W=1U AS=0.44P AD=0.44P PS=2.88U
+ PD=2.88U
M$1718 \$8215 \$8155 VSS VSS nfet_06v0 L=1U W=5U AS=2.2P AD=1.25P PS=10.88U
+ PD=5.5U
M$1719 \$8155 \$8173 \$8215 VSS nfet_06v0 L=1U W=5U AS=1.25P AD=2.2P PS=5.5U
+ PD=10.88U
M$1720 \$8199 \$8698 VSS VSS nfet_06v0 L=1U W=1U AS=0.44P AD=0.25P PS=2.88U
+ PD=1.5U
M$1721 \$8697 \$8698 \$8199 VSS nfet_06v0 L=1U W=1U AS=0.25P AD=0.44P PS=1.5U
+ PD=2.88U
M$1722 \$8200 \$8698 VSS VSS nfet_06v0 L=1U W=1U AS=0.44P AD=0.25P PS=2.88U
+ PD=1.5U
M$1723 \$8698 \$8698 \$8200 VSS nfet_06v0 L=1U W=1U AS=0.25P AD=0.44P PS=1.5U
+ PD=2.88U
M$1724 \$8216 \$8155 VSS VSS nfet_06v0 L=1U W=5U AS=2.2P AD=1.25P PS=10.88U
+ PD=5.5U
M$1725 \$8174 \$8173 \$8216 VSS nfet_06v0 L=1U W=5U AS=1.25P AD=1.65P PS=5.5U
+ PD=5.66U
M$1726 \$8217 \$8173 \$8174 VSS nfet_06v0 L=1U W=5U AS=1.65P AD=1.25P PS=5.66U
+ PD=5.5U
M$1727 VSS \$8155 \$8217 VSS nfet_06v0 L=1U W=5U AS=1.25P AD=2.2P PS=5.5U
+ PD=10.88U
M$1728 \$8175 \$1886 \$8174 VSS nfet_06v0 L=1U W=5U AS=2.2P AD=1.3P PS=10.88U
+ PD=5.52U
M$1729 \$8174 \$1886 \$8175 VSS nfet_06v0 L=1U W=5U AS=1.3P AD=2.2P PS=5.52U
+ PD=10.88U
M$1730 \$8176 \$1896 \$8174 VSS nfet_06v0 L=1U W=5U AS=2.2P AD=1.3P PS=10.88U
+ PD=5.52U
M$1731 \$8174 \$1896 \$8176 VSS nfet_06v0 L=1U W=5U AS=1.3P AD=2.2P PS=5.52U
+ PD=10.88U
M$1732 \$8178 \$8173 \$8177 VSS nfet_06v0 L=1U W=2.5U AS=1.1P AD=0.65P PS=5.88U
+ PD=3.02U
M$1733 \$8177 \$8173 \$8178 VSS nfet_06v0 L=1U W=2.5U AS=0.65P AD=1.1P PS=3.02U
+ PD=5.88U
M$1734 \$8180 \$8173 \$8179 VSS nfet_06v0 L=1U W=2.5U AS=1.1P AD=0.65P PS=5.88U
+ PD=3.02U
M$1735 \$8179 \$8173 \$8180 VSS nfet_06v0 L=1U W=2.5U AS=0.65P AD=1.1P PS=3.02U
+ PD=5.88U
M$1736 \$8177 \$8178 VSS VSS nfet_06v0 L=1U W=2.5U AS=1.1P AD=0.65P PS=5.88U
+ PD=3.02U
M$1737 VSS \$8178 \$8177 VSS nfet_06v0 L=1U W=2.5U AS=0.65P AD=0.65P PS=3.02U
+ PD=3.02U
M$1738 \$8177 \$8178 VSS VSS nfet_06v0 L=1U W=2.5U AS=0.65P AD=0.65P PS=3.02U
+ PD=3.02U
M$1739 VSS \$8178 \$8177 VSS nfet_06v0 L=1U W=2.5U AS=0.65P AD=1.1P PS=3.02U
+ PD=5.88U
M$1740 \$8179 \$8178 VSS VSS nfet_06v0 L=1U W=2.5U AS=1.1P AD=0.65P PS=5.88U
+ PD=3.02U
M$1741 VSS \$8178 \$8179 VSS nfet_06v0 L=1U W=2.5U AS=0.65P AD=0.65P PS=3.02U
+ PD=3.02U
M$1742 \$8179 \$8178 VSS VSS nfet_06v0 L=1U W=2.5U AS=0.65P AD=0.65P PS=3.02U
+ PD=3.02U
M$1743 VSS \$8178 \$8179 VSS nfet_06v0 L=1U W=2.5U AS=0.65P AD=1.1P PS=3.02U
+ PD=5.88U
M$1744 \$8314 \$8202 \$8178 VSS nfet_06v0 L=1U W=2.5U AS=1.1P AD=1.1P PS=5.88U
+ PD=5.88U
M$1745 \$8156 \$8202 \$8180 VSS nfet_06v0 L=1U W=2.5U AS=1.1P AD=1.1P PS=5.88U
+ PD=5.88U
M$1746 \$8218 \$8155 VSS VSS nfet_06v0 L=1U W=5U AS=2.2P AD=1.25P PS=10.88U
+ PD=5.5U
M$1747 \$8157 \$8173 \$8218 VSS nfet_06v0 L=1U W=5U AS=1.25P AD=2.2P PS=5.5U
+ PD=10.88U
M$1748 \$8219 \$8158 VSS VSS nfet_06v0 L=1U W=5U AS=2.2P AD=1.25P PS=10.88U
+ PD=5.5U
M$1749 \$8158 \$8173 \$8219 VSS nfet_06v0 L=1U W=5U AS=1.25P AD=1.65P PS=5.5U
+ PD=5.66U
M$1750 \$8202 \$8202 \$8158 VSS nfet_06v0 L=1U W=5U AS=1.65P AD=2.2P PS=5.66U
+ PD=10.88U
M$1751 \$8181 \$8180 VSS VSS nfet_06v0 L=1U W=5U AS=2.2P AD=1.3P PS=10.88U
+ PD=5.52U
M$1752 VSS \$8180 \$8181 VSS nfet_06v0 L=1U W=5U AS=1.3P AD=1.3P PS=5.52U
+ PD=5.52U
M$1753 \$8181 \$8180 VSS VSS nfet_06v0 L=1U W=5U AS=1.3P AD=2.2P PS=5.52U
+ PD=10.88U
M$1754 VSS VDD VSS VSS nfet_06v0 L=2U W=9.75U AS=4.29P AD=4.29P PS=20.38U
+ PD=20.38U
M$1755 VSS VDD VSS VSS nfet_06v0 L=2U W=9.75U AS=4.29P AD=4.29P PS=20.38U
+ PD=20.38U
M$1756 \$8182 \$8182 VSS VSS nfet_06v0 L=1U W=1U AS=0.44P AD=0.44P PS=2.88U
+ PD=2.88U
M$1757 \$8221 \$8159 VSS VSS nfet_06v0 L=1U W=5U AS=2.2P AD=1.25P PS=10.88U
+ PD=5.5U
M$1758 \$8159 \$8182 \$8221 VSS nfet_06v0 L=1U W=5U AS=1.25P AD=2.2P PS=5.5U
+ PD=10.88U
M$1759 \$8198 \$8701 VSS VSS nfet_06v0 L=1U W=1U AS=0.44P AD=0.25P PS=2.88U
+ PD=1.5U
M$1760 \$8700 \$8701 \$8198 VSS nfet_06v0 L=1U W=1U AS=0.25P AD=0.44P PS=1.5U
+ PD=2.88U
M$1761 \$8197 \$8701 VSS VSS nfet_06v0 L=1U W=1U AS=0.44P AD=0.25P PS=2.88U
+ PD=1.5U
M$1762 \$8701 \$8701 \$8197 VSS nfet_06v0 L=1U W=1U AS=0.25P AD=0.44P PS=1.5U
+ PD=2.88U
M$1763 \$8223 \$8159 VSS VSS nfet_06v0 L=1U W=5U AS=2.2P AD=1.25P PS=10.88U
+ PD=5.5U
M$1764 \$8183 \$8182 \$8223 VSS nfet_06v0 L=1U W=5U AS=1.25P AD=1.65P PS=5.5U
+ PD=5.66U
M$1765 \$8224 \$8182 \$8183 VSS nfet_06v0 L=1U W=5U AS=1.65P AD=1.25P PS=5.66U
+ PD=5.5U
M$1766 VSS \$8159 \$8224 VSS nfet_06v0 L=1U W=5U AS=1.25P AD=2.2P PS=5.5U
+ PD=10.88U
M$1767 \$8184 \$1886 \$8183 VSS nfet_06v0 L=1U W=5U AS=2.2P AD=1.3P PS=10.88U
+ PD=5.52U
M$1768 \$8183 \$1886 \$8184 VSS nfet_06v0 L=1U W=5U AS=1.3P AD=2.2P PS=5.52U
+ PD=10.88U
M$1769 \$8185 \$1876 \$8183 VSS nfet_06v0 L=1U W=5U AS=2.2P AD=1.3P PS=10.88U
+ PD=5.52U
M$1770 \$8183 \$1876 \$8185 VSS nfet_06v0 L=1U W=5U AS=1.3P AD=2.2P PS=5.52U
+ PD=10.88U
M$1771 \$8187 \$8182 \$8186 VSS nfet_06v0 L=1U W=2.5U AS=1.1P AD=0.65P PS=5.88U
+ PD=3.02U
M$1772 \$8186 \$8182 \$8187 VSS nfet_06v0 L=1U W=2.5U AS=0.65P AD=1.1P PS=3.02U
+ PD=5.88U
M$1773 \$8189 \$8182 \$8188 VSS nfet_06v0 L=1U W=2.5U AS=1.1P AD=0.65P PS=5.88U
+ PD=3.02U
M$1774 \$8188 \$8182 \$8189 VSS nfet_06v0 L=1U W=2.5U AS=0.65P AD=1.1P PS=3.02U
+ PD=5.88U
M$1775 \$8186 \$8187 VSS VSS nfet_06v0 L=1U W=2.5U AS=1.1P AD=0.65P PS=5.88U
+ PD=3.02U
M$1776 VSS \$8187 \$8186 VSS nfet_06v0 L=1U W=2.5U AS=0.65P AD=0.65P PS=3.02U
+ PD=3.02U
M$1777 \$8186 \$8187 VSS VSS nfet_06v0 L=1U W=2.5U AS=0.65P AD=0.65P PS=3.02U
+ PD=3.02U
M$1778 VSS \$8187 \$8186 VSS nfet_06v0 L=1U W=2.5U AS=0.65P AD=1.1P PS=3.02U
+ PD=5.88U
M$1779 \$8188 \$8187 VSS VSS nfet_06v0 L=1U W=2.5U AS=1.1P AD=0.65P PS=5.88U
+ PD=3.02U
M$1780 VSS \$8187 \$8188 VSS nfet_06v0 L=1U W=2.5U AS=0.65P AD=0.65P PS=3.02U
+ PD=3.02U
M$1781 \$8188 \$8187 VSS VSS nfet_06v0 L=1U W=2.5U AS=0.65P AD=0.65P PS=3.02U
+ PD=3.02U
M$1782 VSS \$8187 \$8188 VSS nfet_06v0 L=1U W=2.5U AS=0.65P AD=1.1P PS=3.02U
+ PD=5.88U
M$1783 \$8316 \$8203 \$8187 VSS nfet_06v0 L=1U W=2.5U AS=1.1P AD=1.1P PS=5.88U
+ PD=5.88U
M$1784 \$8160 \$8203 \$8189 VSS nfet_06v0 L=1U W=2.5U AS=1.1P AD=1.1P PS=5.88U
+ PD=5.88U
M$1785 \$8222 \$8159 VSS VSS nfet_06v0 L=1U W=5U AS=2.2P AD=1.25P PS=10.88U
+ PD=5.5U
M$1786 \$8161 \$8182 \$8222 VSS nfet_06v0 L=1U W=5U AS=1.25P AD=2.2P PS=5.5U
+ PD=10.88U
M$1787 \$8220 \$8162 VSS VSS nfet_06v0 L=1U W=5U AS=2.2P AD=1.25P PS=10.88U
+ PD=5.5U
M$1788 \$8162 \$8182 \$8220 VSS nfet_06v0 L=1U W=5U AS=1.25P AD=1.65P PS=5.5U
+ PD=5.66U
M$1789 \$8203 \$8203 \$8162 VSS nfet_06v0 L=1U W=5U AS=1.65P AD=2.2P PS=5.66U
+ PD=10.88U
M$1790 \$8190 \$8189 VSS VSS nfet_06v0 L=1U W=5U AS=2.2P AD=1.3P PS=10.88U
+ PD=5.52U
M$1791 VSS \$8189 \$8190 VSS nfet_06v0 L=1U W=5U AS=1.3P AD=1.3P PS=5.52U
+ PD=5.52U
M$1792 \$8190 \$8189 VSS VSS nfet_06v0 L=1U W=5U AS=1.3P AD=2.2P PS=5.52U
+ PD=10.88U
M$1793 VSS VDD VSS VSS nfet_06v0 L=2U W=9.75U AS=4.29P AD=4.29P PS=20.38U
+ PD=20.38U
M$1794 VSS VDD VSS VSS nfet_06v0 L=2U W=9.75U AS=4.29P AD=4.29P PS=20.38U
+ PD=20.38U
M$1795 \$6684 \$2821 VSS VSS nfet_06v0 L=1U W=1U AS=0.44P AD=0.33P PS=2.88U
+ PD=1.66U
M$1796 VSS \$2812 \$6684 VSS nfet_06v0 L=1U W=1U AS=0.33P AD=0.44P PS=1.66U
+ PD=2.88U
M$1797 Z \$6370 \$6360 VSS nfet_06v0 L=1U W=2.48U AS=1.0912P AD=0.6448P
+ PS=5.84U PD=3U
M$1798 \$6360 \$6370 Z VSS nfet_06v0 L=1U W=2.48U AS=0.6448P AD=1.0912P PS=3U
+ PD=5.84U
M$1799 Z \$6447 \$6446 VSS nfet_06v0 L=1U W=2.48U AS=1.0912P AD=0.6448P
+ PS=5.84U PD=3U
M$1800 \$6446 \$6447 Z VSS nfet_06v0 L=1U W=2.48U AS=0.6448P AD=1.0912P PS=3U
+ PD=5.84U
M$1801 VSS \$2803 \$8163 VSS nfet_06v0 L=1U W=1U AS=0.44P AD=0.44P PS=2.88U
+ PD=2.88U
M$1802 Z \$6995 \$6448 VSS nfet_06v0 L=1U W=2.48U AS=1.0912P AD=0.6448P
+ PS=5.84U PD=3U
M$1803 \$6448 \$6995 Z VSS nfet_06v0 L=1U W=2.48U AS=0.6448P AD=1.0912P PS=3U
+ PD=5.84U
M$1804 \$6360 \$6375 VSS VSS nfet_06v0 L=1U W=1.24U AS=0.5456P AD=0.5456P
+ PS=3.36U PD=3.36U
M$1805 VSS \$8191 \$4659 VSS nfet_06v0 L=1U W=1U AS=0.44P AD=0.44P PS=2.88U
+ PD=2.88U
M$1806 \$6446 \$6375 VSS VSS nfet_06v0 L=1U W=1.24U AS=0.5456P AD=0.5456P
+ PS=3.36U PD=3.36U
M$1807 \$6448 \$6375 VSS VSS nfet_06v0 L=1U W=1.24U AS=0.5456P AD=0.5456P
+ PS=3.36U PD=3.36U
M$1808 \$8196 \$8163 \$8191 VSS nfet_06v0 L=1U W=1U AS=0.44P AD=0.25P PS=2.88U
+ PD=1.5U
M$1809 VSS \$2821 \$8196 VSS nfet_06v0 L=1U W=1U AS=0.25P AD=0.44P PS=1.5U
+ PD=2.88U
M$1810 \$6423 \$6375 VSS VSS nfet_06v0 L=1U W=0.7U AS=0.308P AD=0.175P PS=2.28U
+ PD=1.2U
M$1811 \$6422 \$6375 \$6423 VSS nfet_06v0 L=1U W=0.7U AS=0.175P AD=0.175P
+ PS=1.2U PD=1.2U
M$1812 \$6424 \$6375 \$6422 VSS nfet_06v0 L=1U W=0.7U AS=0.175P AD=0.175P
+ PS=1.2U PD=1.2U
M$1813 \$6375 \$6375 \$6424 VSS nfet_06v0 L=1U W=0.7U AS=0.175P AD=0.308P
+ PS=1.2U PD=2.28U
M$1814 Z Z \$6449 VSS nfet_06v0 L=1U W=2U AS=0.88P AD=0.52P PS=4.88U PD=2.52U
M$1815 \$6449 Z Z VSS nfet_06v0 L=1U W=2U AS=0.52P AD=0.88P PS=2.52U PD=4.88U
M$1816 VSS \$8192 \$3328 VSS nfet_06v0 L=1U W=1U AS=0.44P AD=0.44P PS=2.88U
+ PD=2.88U
M$1817 \$6455 Z VSS VSS nfet_06v0 L=1U W=2U AS=0.88P AD=0.5P PS=4.88U PD=2.5U
M$1818 \$6449 Z \$6455 VSS nfet_06v0 L=1U W=2U AS=0.5P AD=0.88P PS=2.5U PD=4.88U
M$1819 \$8193 \$2812 \$8192 VSS nfet_06v0 L=1U W=1U AS=0.44P AD=0.25P PS=2.88U
+ PD=1.5U
M$1820 VSS \$2803 \$8193 VSS nfet_06v0 L=1U W=1U AS=0.25P AD=0.44P PS=1.5U
+ PD=2.88U
M$1821 Z \$6684 \$6450 VSS nfet_06v0 L=1U W=2.48U AS=1.0912P AD=0.6448P
+ PS=5.84U PD=3U
M$1822 \$6450 \$6684 Z VSS nfet_06v0 L=1U W=2.48U AS=0.6448P AD=1.0912P PS=3U
+ PD=5.84U
M$1823 \$6450 \$6375 VSS VSS nfet_06v0 L=1U W=1.24U AS=0.5456P AD=0.5456P
+ PS=3.36U PD=3.36U
M$1824 VSS VDD VSS VSS nfet_06v0 L=2U W=1.5U AS=0.66P AD=0.66P PS=3.88U PD=3.88U
M$1825 VSS VDD VSS VSS nfet_06v0 L=2U W=9.75U AS=4.29P AD=4.29P PS=20.38U
+ PD=20.38U
M$1826 \$6995 \$4610 VSS VSS nfet_06v0 L=1U W=1U AS=0.44P AD=0.33P PS=2.88U
+ PD=1.66U
M$1827 VSS \$4602 \$6995 VSS nfet_06v0 L=1U W=1U AS=0.33P AD=0.44P PS=1.66U
+ PD=2.88U
M$1828 VSS \$4594 \$9931 VSS nfet_06v0 L=1U W=1U AS=0.44P AD=0.44P PS=2.88U
+ PD=2.88U
M$1829 VSS \$9932 \$4656 VSS nfet_06v0 L=1U W=1U AS=0.44P AD=0.44P PS=2.88U
+ PD=2.88U
M$1830 \$9940 \$9931 \$9932 VSS nfet_06v0 L=1U W=1U AS=0.44P AD=0.25P PS=2.88U
+ PD=1.5U
M$1831 VSS \$4610 \$9940 VSS nfet_06v0 L=1U W=1U AS=0.25P AD=0.44P PS=1.5U
+ PD=2.88U
M$1832 VSS \$9933 \$2856 VSS nfet_06v0 L=1U W=1U AS=0.44P AD=0.44P PS=2.88U
+ PD=2.88U
M$1833 \$9941 \$4602 \$9933 VSS nfet_06v0 L=1U W=1U AS=0.44P AD=0.25P PS=2.88U
+ PD=1.5U
M$1834 VSS \$4594 \$9941 VSS nfet_06v0 L=1U W=1U AS=0.25P AD=0.44P PS=1.5U
+ PD=2.88U
M$1835 VSS VDD VSS VSS nfet_06v0 L=2U W=1.5U AS=0.66P AD=0.66P PS=3.88U PD=3.88U
M$1836 VSS VDD VSS VSS nfet_06v0 L=2U W=1.5U AS=0.66P AD=0.66P PS=3.88U PD=3.88U
M$1837 \$6370 \$6400 VSS VSS nfet_06v0 L=1U W=1U AS=0.44P AD=0.33P PS=2.88U
+ PD=1.66U
M$1838 VSS \$6392 \$6370 VSS nfet_06v0 L=1U W=1U AS=0.33P AD=0.44P PS=1.66U
+ PD=2.88U
M$1839 VSS \$6384 \$9934 VSS nfet_06v0 L=1U W=1U AS=0.44P AD=0.44P PS=2.88U
+ PD=2.88U
M$1840 VSS \$9935 \$4579 VSS nfet_06v0 L=1U W=1U AS=0.44P AD=0.44P PS=2.88U
+ PD=2.88U
M$1841 \$9942 \$9934 \$9935 VSS nfet_06v0 L=1U W=1U AS=0.44P AD=0.25P PS=2.88U
+ PD=1.5U
M$1842 VSS \$6400 \$9942 VSS nfet_06v0 L=1U W=1U AS=0.25P AD=0.44P PS=1.5U
+ PD=2.88U
M$1843 VSS \$9936 \$2784 VSS nfet_06v0 L=1U W=1U AS=0.44P AD=0.44P PS=2.88U
+ PD=2.88U
M$1844 \$9944 \$6392 \$9936 VSS nfet_06v0 L=1U W=1U AS=0.44P AD=0.25P PS=2.88U
+ PD=1.5U
M$1845 VSS \$6384 \$9944 VSS nfet_06v0 L=1U W=1U AS=0.25P AD=0.44P PS=1.5U
+ PD=2.88U
M$1846 VSS VDD VSS VSS nfet_06v0 L=2U W=1.5U AS=0.66P AD=0.66P PS=3.88U PD=3.88U
M$1847 VSS VDD VSS VSS nfet_06v0 L=2U W=1.5U AS=0.66P AD=0.66P PS=3.88U PD=3.88U
M$1848 \$6447 \$8190 VSS VSS nfet_06v0 L=1U W=1U AS=0.44P AD=0.33P PS=2.88U
+ PD=1.66U
M$1849 VSS \$8181 \$6447 VSS nfet_06v0 L=1U W=1U AS=0.33P AD=0.44P PS=1.66U
+ PD=2.88U
M$1850 VSS VDD VSS VSS nfet_06v0 L=2U W=9.75U AS=4.29P AD=4.29P PS=20.38U
+ PD=20.38U
M$1851 VSS \$8172 \$9937 VSS nfet_06v0 L=1U W=1U AS=0.44P AD=0.44P PS=2.88U
+ PD=2.88U
M$1852 VSS VDD VSS VSS nfet_06v0 L=2U W=9.75U AS=4.29P AD=4.29P PS=20.38U
+ PD=20.38U
M$1853 VSS \$9938 \$4654 VSS nfet_06v0 L=1U W=1U AS=0.44P AD=0.44P PS=2.88U
+ PD=2.88U
M$1854 \$9945 \$9937 \$9938 VSS nfet_06v0 L=1U W=1U AS=0.44P AD=0.25P PS=2.88U
+ PD=1.5U
M$1855 VSS \$8190 \$9945 VSS nfet_06v0 L=1U W=1U AS=0.25P AD=0.44P PS=1.5U
+ PD=2.88U
M$1856 VSS \$9939 \$2855 VSS nfet_06v0 L=1U W=1U AS=0.44P AD=0.44P PS=2.88U
+ PD=2.88U
M$1857 \$9943 \$8181 \$9939 VSS nfet_06v0 L=1U W=1U AS=0.44P AD=0.25P PS=2.88U
+ PD=1.5U
M$1858 VSS \$8172 \$9943 VSS nfet_06v0 L=1U W=1U AS=0.25P AD=0.44P PS=1.5U
+ PD=2.88U
M$1859 VSS VDD VSS VSS nfet_06v0 L=2U W=1.5U AS=0.66P AD=0.66P PS=3.88U PD=3.88U
M$1860 VSS VDD VSS VSS nfet_06v0 L=2U W=1.5U AS=0.66P AD=0.66P PS=3.88U PD=3.88U
M$1861 VSS VDD VSS VSS nfet_06v0 L=2U W=1.5U AS=0.66P AD=0.66P PS=3.88U PD=3.88U
M$1862 VSS VDD VSS VSS nfet_06v0 L=2U W=1.5U AS=0.66P AD=0.66P PS=3.88U PD=3.88U
M$1863 VSS VDD VSS VSS nfet_06v0 L=2U W=1.5U AS=0.66P AD=0.66P PS=3.88U PD=3.88U
M$1864 VSS VDD VSS VSS nfet_06v0 L=2U W=1.5U AS=0.66P AD=0.66P PS=3.88U PD=3.88U
M$1865 VSS VDD VSS VSS nfet_06v0 L=2U W=1.5U AS=0.66P AD=0.66P PS=3.88U PD=3.88U
M$1866 VSS VDD VSS VSS nfet_06v0 L=2U W=1.5U AS=0.66P AD=0.66P PS=3.88U PD=3.88U
M$1867 VSS VDD VSS VSS nfet_06v0 L=2U W=1.5U AS=0.66P AD=0.66P PS=3.88U PD=3.88U
M$1868 VSS VDD VSS VSS nfet_06v0 L=2U W=1.5U AS=0.66P AD=0.66P PS=3.88U PD=3.88U
M$1869 VSS VDD VSS VSS nfet_06v0 L=2U W=1.5U AS=0.66P AD=0.66P PS=3.88U PD=3.88U
M$1870 VSS VDD VSS VSS nfet_06v0 L=2U W=1.5U AS=0.66P AD=0.66P PS=3.88U PD=3.88U
M$1871 VSS VDD VSS VSS nfet_06v0 L=2U W=1.5U AS=0.66P AD=0.66P PS=3.88U PD=3.88U
M$1872 VSS VDD VSS VSS nfet_06v0 L=2U W=1.5U AS=0.66P AD=0.66P PS=3.88U PD=3.88U
M$1873 VSS VDD VSS VSS nfet_06v0 L=2U W=1.5U AS=0.66P AD=0.66P PS=3.88U PD=3.88U
M$1874 VSS VDD VSS VSS nfet_06v0 L=2U W=1.5U AS=0.66P AD=0.66P PS=3.88U PD=3.88U
M$1875 VSS VDD VSS VSS nfet_06v0 L=2U W=1.5U AS=0.66P AD=0.66P PS=3.88U PD=3.88U
M$1876 VSS VDD VSS VSS nfet_06v0 L=2U W=9.75U AS=4.29P AD=4.29P PS=20.38U
+ PD=20.38U
M$1877 VSS VDD VSS VSS nfet_06v0 L=2U W=1.5U AS=0.66P AD=0.66P PS=3.88U PD=3.88U
M$1878 VSS VDD VSS VSS nfet_06v0 L=2U W=9.75U AS=4.29P AD=4.29P PS=20.38U
+ PD=20.38U
M$1879 VSS VDD VSS VSS nfet_06v0 L=2U W=1.5U AS=0.66P AD=0.66P PS=3.88U PD=3.88U
M$1880 VSS VDD VSS VSS nfet_06v0 L=2U W=1.5U AS=0.66P AD=0.66P PS=3.88U PD=3.88U
M$1881 VSS VDD VSS VSS nfet_06v0 L=2U W=1.5U AS=0.66P AD=0.66P PS=3.88U PD=3.88U
M$1882 VSS VDD VSS VSS nfet_06v0 L=2U W=1.5U AS=0.66P AD=0.66P PS=3.88U PD=3.88U
M$1883 VSS VDD VSS VSS nfet_06v0 L=2U W=1.5U AS=0.66P AD=0.66P PS=3.88U PD=3.88U
M$1884 VSS VDD VSS VSS nfet_06v0 L=2U W=1.5U AS=0.66P AD=0.66P PS=3.88U PD=3.88U
M$1885 VSS VDD VSS VSS nfet_06v0 L=2U W=1.5U AS=0.66P AD=0.66P PS=3.88U PD=3.88U
M$1886 VSS VDD VSS VSS nfet_06v0 L=2U W=1.5U AS=0.66P AD=0.66P PS=3.88U PD=3.88U
M$1887 VSS VDD VSS VSS nfet_06v0 L=2U W=1.5U AS=0.66P AD=0.66P PS=3.88U PD=3.88U
M$1888 VSS VDD VSS VSS nfet_06v0 L=2U W=1.5U AS=0.66P AD=0.66P PS=3.88U PD=3.88U
M$1889 VSS VDD VSS VSS nfet_06v0 L=2U W=1.5U AS=0.66P AD=0.66P PS=3.88U PD=3.88U
M$1890 VSS VDD VSS VSS nfet_06v0 L=2U W=1.5U AS=0.66P AD=0.66P PS=3.88U PD=3.88U
M$1891 VSS VDD VSS VSS nfet_06v0 L=2U W=1.5U AS=0.66P AD=0.66P PS=3.88U PD=3.88U
M$1892 VSS VDD VSS VSS nfet_06v0 L=2U W=1.5U AS=0.66P AD=0.66P PS=3.88U PD=3.88U
M$1893 VSS VDD VSS VSS nfet_06v0 L=2U W=1.5U AS=0.66P AD=0.66P PS=3.88U PD=3.88U
M$1894 VSS VDD VSS VSS nfet_06v0 L=2U W=1.5U AS=0.66P AD=0.66P PS=3.88U PD=3.88U
M$1895 VSS VDD VSS VSS nfet_06v0 L=2U W=1.5U AS=0.66P AD=0.66P PS=3.88U PD=3.88U
M$1896 VSS VDD VSS VSS nfet_06v0 L=2U W=1.5U AS=0.66P AD=0.66P PS=3.88U PD=3.88U
M$1897 VSS VDD VSS VSS nfet_06v0 L=2U W=1.5U AS=0.66P AD=0.66P PS=3.88U PD=3.88U
M$1898 VSS VDD VSS VSS nfet_06v0 L=2U W=1.5U AS=0.66P AD=0.66P PS=3.88U PD=3.88U
M$1899 VSS VDD VSS VSS nfet_06v0 L=2U W=1.5U AS=0.66P AD=0.66P PS=3.88U PD=3.88U
M$1900 VSS VDD VSS VSS nfet_06v0 L=2U W=1.5U AS=0.66P AD=0.66P PS=3.88U PD=3.88U
M$1901 VSS VDD VSS VSS nfet_06v0 L=2U W=9.75U AS=4.29P AD=4.29P PS=20.38U
+ PD=20.38U
M$1902 VSS VDD VSS VSS nfet_06v0 L=2U W=1.5U AS=0.66P AD=0.66P PS=3.88U PD=3.88U
M$1903 VSS VDD VSS VSS nfet_06v0 L=2U W=9.75U AS=4.29P AD=4.29P PS=20.38U
+ PD=20.38U
M$1904 VSS VDD VSS VSS nfet_06v0 L=2U W=1.5U AS=0.66P AD=0.66P PS=3.88U PD=3.88U
M$1905 VSS VDD VSS VSS nfet_06v0 L=2U W=1.5U AS=0.66P AD=0.66P PS=3.88U PD=3.88U
M$1906 VSS VDD VSS VSS nfet_06v0 L=2U W=1.5U AS=0.66P AD=0.66P PS=3.88U PD=3.88U
M$1907 VSS VDD VSS VSS nfet_06v0 L=2U W=1.5U AS=0.66P AD=0.66P PS=3.88U PD=3.88U
M$1908 VSS VDD VSS VSS nfet_06v0 L=2U W=1.5U AS=0.66P AD=0.66P PS=3.88U PD=3.88U
M$1909 VSS VDD VSS VSS nfet_06v0 L=2U W=1.5U AS=0.66P AD=0.66P PS=3.88U PD=3.88U
M$1910 VSS VDD VSS VSS nfet_06v0 L=2U W=1.5U AS=0.66P AD=0.66P PS=3.88U PD=3.88U
M$1911 VSS VDD VSS VSS nfet_06v0 L=2U W=1.5U AS=0.66P AD=0.66P PS=3.88U PD=3.88U
M$1912 VSS VDD VSS VSS nfet_06v0 L=2U W=1.5U AS=0.66P AD=0.66P PS=3.88U PD=3.88U
M$1913 VSS VDD VSS VSS nfet_06v0 L=2U W=1.5U AS=0.66P AD=0.66P PS=3.88U PD=3.88U
M$1914 VSS VDD VSS VSS nfet_06v0 L=2U W=1.5U AS=0.66P AD=0.66P PS=3.88U PD=3.88U
M$1915 VSS VDD VSS VSS nfet_06v0 L=2U W=1.5U AS=0.66P AD=0.66P PS=3.88U PD=3.88U
M$1916 VSS VDD VSS VSS nfet_06v0 L=2U W=1.5U AS=0.66P AD=0.66P PS=3.88U PD=3.88U
M$1917 VSS VDD VSS VSS nfet_06v0 L=2U W=1.5U AS=0.66P AD=0.66P PS=3.88U PD=3.88U
M$1918 VSS VDD VSS VSS nfet_06v0 L=2U W=1.5U AS=0.66P AD=0.66P PS=3.88U PD=3.88U
M$1919 VSS VDD VSS VSS nfet_06v0 L=2U W=1.5U AS=0.66P AD=0.66P PS=3.88U PD=3.88U
R$1920 \$382 \$891 VSS 76450 ppolyf_u_1k L=76.45U W=1U
R$1921 \$382 \$383 VSS 76450 ppolyf_u_1k L=76.45U W=1U
R$1922 \$890 \$21 VSS 76450 ppolyf_u_1k L=76.45U W=1U
R$1923 \$890 \$891 VSS 76450 ppolyf_u_1k L=76.45U W=1U
R$1924 \$18 \$383 VSS 76450 ppolyf_u_1k L=76.45U W=1U
R$1925 \$892 \$893 VSS 76450 ppolyf_u_1k L=76.45U W=1U
R$1926 \$385 \$386 VSS 76450 ppolyf_u_1k L=76.45U W=1U
R$1927 \$29 \$386 VSS 76450 ppolyf_u_1k L=76.45U W=1U
R$1928 \$892 \$32 VSS 76450 ppolyf_u_1k L=76.45U W=1U
R$1929 \$385 \$893 VSS 76450 ppolyf_u_1k L=76.45U W=1U
R$1930 \$388 \$389 VSS 76450 ppolyf_u_1k L=76.45U W=1U
R$1931 \$388 \$895 VSS 76450 ppolyf_u_1k L=76.45U W=1U
R$1932 \$894 \$43 VSS 76450 ppolyf_u_1k L=76.45U W=1U
R$1933 \$894 \$895 VSS 76450 ppolyf_u_1k L=76.45U W=1U
R$1934 \$40 \$389 VSS 76450 ppolyf_u_1k L=76.45U W=1U
R$1935 \$391 \$392 VSS 76450 ppolyf_u_1k L=76.45U W=1U
R$1936 \$51 \$392 VSS 76450 ppolyf_u_1k L=76.45U W=1U
R$1937 \$896 \$897 VSS 76450 ppolyf_u_1k L=76.45U W=1U
R$1938 \$391 \$897 VSS 76450 ppolyf_u_1k L=76.45U W=1U
R$1939 \$896 \$54 VSS 76450 ppolyf_u_1k L=76.45U W=1U
R$1940 \$1305 \$1814 VSS 76450 ppolyf_u_1k L=76.45U W=1U
R$1941 \$1305 \$1306 VSS 76450 ppolyf_u_1k L=76.45U W=1U
R$1942 \$941 \$1306 VSS 76450 ppolyf_u_1k L=76.45U W=1U
R$1943 \$1813 \$944 VSS 76450 ppolyf_u_1k L=76.45U W=1U
R$1944 \$1813 \$1814 VSS 76450 ppolyf_u_1k L=76.45U W=1U
R$1945 \$1308 \$1816 VSS 76450 ppolyf_u_1k L=76.45U W=1U
R$1946 \$1815 \$955 VSS 76450 ppolyf_u_1k L=76.45U W=1U
R$1947 \$952 \$1309 VSS 76450 ppolyf_u_1k L=76.45U W=1U
R$1948 \$1308 \$1309 VSS 76450 ppolyf_u_1k L=76.45U W=1U
R$1949 \$1815 \$1816 VSS 76450 ppolyf_u_1k L=76.45U W=1U
R$1950 \$1311 \$1818 VSS 76450 ppolyf_u_1k L=76.45U W=1U
R$1951 \$1817 \$966 VSS 76450 ppolyf_u_1k L=76.45U W=1U
R$1952 \$963 \$1312 VSS 76450 ppolyf_u_1k L=76.45U W=1U
R$1953 \$1311 \$1312 VSS 76450 ppolyf_u_1k L=76.45U W=1U
R$1954 \$1817 \$1818 VSS 76450 ppolyf_u_1k L=76.45U W=1U
R$1955 \$1819 \$977 VSS 76450 ppolyf_u_1k L=76.45U W=1U
R$1956 \$1314 \$1820 VSS 76450 ppolyf_u_1k L=76.45U W=1U
R$1957 \$1819 \$1820 VSS 76450 ppolyf_u_1k L=76.45U W=1U
R$1958 \$974 \$1315 VSS 76450 ppolyf_u_1k L=76.45U W=1U
R$1959 \$1314 \$1315 VSS 76450 ppolyf_u_1k L=76.45U W=1U
R$1960 \$2734 \$2735 VSS 76450 ppolyf_u_1k L=76.45U W=1U
R$1961 \$2734 \$1866 VSS 76450 ppolyf_u_1k L=76.45U W=1U
R$1962 \$2226 \$2735 VSS 76450 ppolyf_u_1k L=76.45U W=1U
R$1963 \$2226 \$2227 VSS 76450 ppolyf_u_1k L=76.45U W=1U
R$1964 \$1962 \$2227 VSS 76450 ppolyf_u_1k L=76.45U W=1U
R$1965 \$2229 \$2737 VSS 76450 ppolyf_u_1k L=76.45U W=1U
R$1966 \$2229 \$2230 VSS 76450 ppolyf_u_1k L=76.45U W=1U
R$1967 \$2736 \$2737 VSS 76450 ppolyf_u_1k L=76.45U W=1U
R$1968 \$1964 \$2230 VSS 76450 ppolyf_u_1k L=76.45U W=1U
R$1969 \$2736 \$1876 VSS 76450 ppolyf_u_1k L=76.45U W=1U
R$1970 \$2232 \$2739 VSS 76450 ppolyf_u_1k L=76.45U W=1U
R$1971 \$1966 \$2233 VSS 76450 ppolyf_u_1k L=76.45U W=1U
R$1972 \$2738 \$1886 VSS 76450 ppolyf_u_1k L=76.45U W=1U
R$1973 \$2232 \$2233 VSS 76450 ppolyf_u_1k L=76.45U W=1U
R$1974 \$2738 \$2739 VSS 76450 ppolyf_u_1k L=76.45U W=1U
R$1975 \$2235 \$2236 VSS 76450 ppolyf_u_1k L=76.45U W=1U
R$1976 \$1968 \$2236 VSS 76450 ppolyf_u_1k L=76.45U W=1U
R$1977 \$2235 \$2741 VSS 76450 ppolyf_u_1k L=76.45U W=1U
R$1978 \$2740 \$2741 VSS 76450 ppolyf_u_1k L=76.45U W=1U
R$1979 \$2740 \$1896 VSS 76450 ppolyf_u_1k L=76.45U W=1U
C$1980 \$8175 \$8181 4e-13 cap_mim_2f0fF A=200P P=60U
C$1981 \$8184 \$8190 4e-13 cap_mim_2f0fF A=200P P=60U
C$1982 \$8166 \$8172 4e-13 cap_mim_2f0fF A=200P P=60U
C$1983 \$8190 \$8188 4e-13 cap_mim_2f0fF A=200P P=60U
C$1984 \$8172 \$8170 4e-13 cap_mim_2f0fF A=200P P=60U
C$1985 \$6394 \$6400 4e-13 cap_mim_2f0fF A=200P P=60U
C$1986 \$6392 \$6390 4e-13 cap_mim_2f0fF A=200P P=60U
C$1987 \$6384 \$6382 4e-13 cap_mim_2f0fF A=200P P=60U
C$1988 \$4604 \$4610 4e-13 cap_mim_2f0fF A=200P P=60U
C$1989 \$4596 \$4602 4e-13 cap_mim_2f0fF A=200P P=60U
C$1990 \$4588 \$4594 4e-13 cap_mim_2f0fF A=200P P=60U
C$1991 \$4610 \$4608 4e-13 cap_mim_2f0fF A=200P P=60U
C$1992 \$4602 \$4600 4e-13 cap_mim_2f0fF A=200P P=60U
C$1993 \$4594 \$4592 4e-13 cap_mim_2f0fF A=200P P=60U
C$1994 \$977 \$1032 2e-13 cap_mim_2f0fF A=100P P=58U
C$1995 \$955 \$1029 2e-13 cap_mim_2f0fF A=100P P=58U
C$1996 \$2815 \$2821 4e-13 cap_mim_2f0fF A=200P P=60U
C$1997 \$957 \$966 2e-13 cap_mim_2f0fF A=100P P=58U
C$1998 \$1858 \$1866 2e-13 cap_mim_2f0fF A=100P P=58U
C$1999 \$1878 \$1886 2e-13 cap_mim_2f0fF A=100P P=58U
C$2000 \$2821 \$2819 4e-13 cap_mim_2f0fF A=200P P=60U
C$2001 \$944 \$1020 2e-13 cap_mim_2f0fF A=100P P=58U
C$2002 \$45 \$54 2e-13 cap_mim_2f0fF A=100P P=58U
C$2003 \$23 \$32 2e-13 cap_mim_2f0fF A=100P P=58U
C$2004 \$6378 \$6384 4e-13 cap_mim_2f0fF A=200P P=60U
C$2005 \$32 \$98 2e-13 cap_mim_2f0fF A=100P P=58U
C$2006 \$54 \$109 2e-13 cap_mim_2f0fF A=100P P=58U
C$2007 \$1876 \$1943 2e-13 cap_mim_2f0fF A=100P P=58U
C$2008 \$935 \$944 2e-13 cap_mim_2f0fF A=100P P=58U
C$2009 \$34 \$43 2e-13 cap_mim_2f0fF A=100P P=58U
C$2010 \$966 \$1023 2e-13 cap_mim_2f0fF A=100P P=58U
C$2011 \$21 \$104 2e-13 cap_mim_2f0fF A=100P P=58U
C$2012 \$2806 \$2812 4e-13 cap_mim_2f0fF A=200P P=60U
C$2013 \$1886 \$1945 2e-13 cap_mim_2f0fF A=100P P=58U
C$2014 \$43 \$107 2e-13 cap_mim_2f0fF A=100P P=58U
C$2015 \$1866 \$1937 2e-13 cap_mim_2f0fF A=100P P=58U
C$2016 \$6400 \$6398 4e-13 cap_mim_2f0fF A=200P P=60U
C$2017 \$946 \$955 2e-13 cap_mim_2f0fF A=100P P=58U
C$2018 \$2797 \$2803 4e-13 cap_mim_2f0fF A=200P P=60U
C$2019 \$1868 \$1876 2e-13 cap_mim_2f0fF A=100P P=58U
C$2020 \$12 \$21 2e-13 cap_mim_2f0fF A=100P P=58U
C$2021 \$968 \$977 2e-13 cap_mim_2f0fF A=100P P=58U
C$2022 \$1888 \$1896 2e-13 cap_mim_2f0fF A=100P P=58U
C$2023 \$2803 \$2801 4e-13 cap_mim_2f0fF A=200P P=60U
C$2024 \$8181 \$8179 4e-13 cap_mim_2f0fF A=200P P=60U
C$2025 \$6386 \$6392 4e-13 cap_mim_2f0fF A=200P P=60U
C$2026 \$1896 \$1949 2e-13 cap_mim_2f0fF A=100P P=58U
C$2027 \$2812 \$2810 4e-13 cap_mim_2f0fF A=200P P=60U
.ENDS GRADIENT_NAV2
