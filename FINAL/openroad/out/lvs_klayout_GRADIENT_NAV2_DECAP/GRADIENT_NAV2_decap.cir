* Extracted by KLayout with GF180MCU LVS runset on : 29/08/2026 18:57

.SUBCKT GRADIENT_NAV2 S4P S4N S2P S1P S1N S2N S3N S3P VDD XN XP X YN YP Y ZN ZP
+ Z VSS
M$1 \$7247 X VDD VDD pfet_05v0 L=0.5U W=1.83U AS=0.8052P AD=0.8052P PS=4.54U
+ PD=4.54U
M$2 XN \$7247 VDD VDD pfet_05v0 L=0.5U W=1.83U AS=0.8052P AD=0.8052P PS=4.54U
+ PD=4.54U
M$3 XP XN VDD VDD pfet_05v0 L=0.5U W=1.83U AS=0.8052P AD=0.8052P PS=4.54U
+ PD=4.54U
M$4 \$9049 Y VDD VDD pfet_05v0 L=0.5U W=1.83U AS=0.8052P AD=0.8052P PS=4.54U
+ PD=4.54U
M$5 YN \$9049 VDD VDD pfet_05v0 L=0.5U W=1.83U AS=0.8052P AD=0.8052P PS=4.54U
+ PD=4.54U
M$6 YP YN VDD VDD pfet_05v0 L=0.5U W=1.83U AS=0.8052P AD=0.8052P PS=4.54U
+ PD=4.54U
M$7 \$10850 Z VDD VDD pfet_05v0 L=0.5U W=1.83U AS=0.8052P AD=0.8052P PS=4.54U
+ PD=4.54U
M$8 ZN \$10850 VDD VDD pfet_05v0 L=0.5U W=1.83U AS=0.8052P AD=0.8052P PS=4.54U
+ PD=4.54U
M$9 ZP ZN VDD VDD pfet_05v0 L=0.5U W=1.83U AS=0.8052P AD=0.8052P PS=4.54U
+ PD=4.54U
M$10 VDD VSS VDD VDD pfet_06v0 L=2U W=18U AS=7.92P AD=7.92P PS=36.88U PD=36.88U
M$11 VDD VSS VDD VDD pfet_06v0 L=2U W=18U AS=7.92P AD=7.92P PS=36.88U PD=36.88U
M$12 VDD VSS VDD VDD pfet_06v0 L=2U W=18U AS=7.92P AD=7.92P PS=36.88U PD=36.88U
M$13 VDD VSS VDD VDD pfet_06v0 L=2U W=18U AS=7.92P AD=7.92P PS=36.88U PD=36.88U
M$14 VDD VSS VDD VDD pfet_06v0 L=2U W=18U AS=7.92P AD=7.92P PS=36.88U PD=36.88U
M$15 VDD VSS VDD VDD pfet_06v0 L=2U W=18U AS=7.92P AD=7.92P PS=36.88U PD=36.88U
M$16 VDD VSS VDD VDD pfet_06v0 L=2U W=18U AS=7.92P AD=7.92P PS=36.88U PD=36.88U
M$17 VDD VSS VDD VDD pfet_06v0 L=2U W=18U AS=7.92P AD=7.92P PS=36.88U PD=36.88U
M$18 VDD VSS VDD VDD pfet_06v0 L=2U W=18U AS=7.92P AD=7.92P PS=36.88U PD=36.88U
M$19 \$2392 \$87 VDD VDD pfet_06v0 L=1U W=10U AS=4.4P AD=2.5P PS=20.88U PD=10.5U
M$20 \$126 \$109 \$2392 VDD pfet_06v0 L=1U W=10U AS=2.5P AD=4.4P PS=10.5U
+ PD=20.88U
M$21 \$2394 \$87 VDD VDD pfet_06v0 L=1U W=10U AS=4.4P AD=2.5P PS=20.88U PD=10.5U
M$22 \$126 \$109 \$2394 VDD pfet_06v0 L=1U W=10U AS=2.5P AD=4.4P PS=10.5U
+ PD=20.88U
M$23 \$127 \$109 \$13 VDD pfet_06v0 L=1U W=10U AS=4.4P AD=4.4P PS=20.88U
+ PD=20.88U
M$24 \$110 \$109 \$12 VDD pfet_06v0 L=1U W=10U AS=4.4P AD=4.4P PS=20.88U
+ PD=20.88U
M$25 \$2397 \$95 VDD VDD pfet_06v0 L=1U W=10U AS=4.4P AD=2.5P PS=20.88U PD=10.5U
M$26 \$95 \$109 \$2397 VDD pfet_06v0 L=1U W=10U AS=2.5P AD=3.3P PS=10.5U
+ PD=10.66U
M$27 \$16 \$16 \$95 VDD pfet_06v0 L=1U W=10U AS=3.3P AD=4.4P PS=10.66U PD=20.88U
M$28 \$2398 \$87 VDD VDD pfet_06v0 L=1U W=10U AS=4.4P AD=2.5P PS=20.88U PD=10.5U
M$29 \$52 \$109 \$2398 VDD pfet_06v0 L=1U W=10U AS=2.5P AD=4.4P PS=10.5U
+ PD=20.88U
M$30 \$2400 \$87 VDD VDD pfet_06v0 L=1U W=10U AS=4.4P AD=2.5P PS=20.88U PD=10.5U
M$31 \$83 \$109 \$2400 VDD pfet_06v0 L=1U W=10U AS=2.5P AD=4.4P PS=10.5U
+ PD=20.88U
M$32 \$2402 \$87 VDD VDD pfet_06v0 L=1U W=10U AS=4.4P AD=2.5P PS=20.88U PD=10.5U
M$33 \$79 \$109 \$2402 VDD pfet_06v0 L=1U W=10U AS=2.5P AD=4.4P PS=10.5U
+ PD=20.88U
M$34 \$2403 \$87 VDD VDD pfet_06v0 L=1U W=10U AS=4.4P AD=2.5P PS=20.88U PD=10.5U
M$35 \$87 \$109 \$2403 VDD pfet_06v0 L=1U W=10U AS=2.5P AD=4.4P PS=10.5U
+ PD=20.88U
M$36 \$2404 \$88 VDD VDD pfet_06v0 L=1U W=10U AS=4.4P AD=2.5P PS=20.88U PD=10.5U
M$37 \$128 \$112 \$2404 VDD pfet_06v0 L=1U W=10U AS=2.5P AD=4.4P PS=10.5U
+ PD=20.88U
M$38 \$2405 \$88 VDD VDD pfet_06v0 L=1U W=10U AS=4.4P AD=2.5P PS=20.88U PD=10.5U
M$39 \$128 \$112 \$2405 VDD pfet_06v0 L=1U W=10U AS=2.5P AD=4.4P PS=10.5U
+ PD=20.88U
M$40 \$129 \$112 \$21 VDD pfet_06v0 L=1U W=10U AS=4.4P AD=4.4P PS=20.88U
+ PD=20.88U
M$41 \$113 \$112 \$20 VDD pfet_06v0 L=1U W=10U AS=4.4P AD=4.4P PS=20.88U
+ PD=20.88U
M$42 \$2407 \$100 VDD VDD pfet_06v0 L=1U W=10U AS=4.4P AD=2.5P PS=20.88U
+ PD=10.5U
M$43 \$100 \$112 \$2407 VDD pfet_06v0 L=1U W=10U AS=2.5P AD=3.3P PS=10.5U
+ PD=10.66U
M$44 \$24 \$24 \$100 VDD pfet_06v0 L=1U W=10U AS=3.3P AD=4.4P PS=10.66U
+ PD=20.88U
M$45 \$2409 \$88 VDD VDD pfet_06v0 L=1U W=10U AS=4.4P AD=2.5P PS=20.88U PD=10.5U
M$46 \$54 \$112 \$2409 VDD pfet_06v0 L=1U W=10U AS=2.5P AD=4.4P PS=10.5U
+ PD=20.88U
M$47 \$2412 \$88 VDD VDD pfet_06v0 L=1U W=10U AS=4.4P AD=2.5P PS=20.88U PD=10.5U
M$48 \$84 \$112 \$2412 VDD pfet_06v0 L=1U W=10U AS=2.5P AD=4.4P PS=10.5U
+ PD=20.88U
M$49 \$2413 \$88 VDD VDD pfet_06v0 L=1U W=10U AS=4.4P AD=2.5P PS=20.88U PD=10.5U
M$50 \$80 \$112 \$2413 VDD pfet_06v0 L=1U W=10U AS=2.5P AD=4.4P PS=10.5U
+ PD=20.88U
M$51 \$2415 \$88 VDD VDD pfet_06v0 L=1U W=10U AS=4.4P AD=2.5P PS=20.88U PD=10.5U
M$52 \$88 \$112 \$2415 VDD pfet_06v0 L=1U W=10U AS=2.5P AD=4.4P PS=10.5U
+ PD=20.88U
M$53 \$2416 \$89 VDD VDD pfet_06v0 L=1U W=10U AS=4.4P AD=2.5P PS=20.88U PD=10.5U
M$54 \$130 \$114 \$2416 VDD pfet_06v0 L=1U W=10U AS=2.5P AD=4.4P PS=10.5U
+ PD=20.88U
M$55 \$2417 \$89 VDD VDD pfet_06v0 L=1U W=10U AS=4.4P AD=2.5P PS=20.88U PD=10.5U
M$56 \$130 \$114 \$2417 VDD pfet_06v0 L=1U W=10U AS=2.5P AD=4.4P PS=10.5U
+ PD=20.88U
M$57 \$131 \$114 \$29 VDD pfet_06v0 L=1U W=10U AS=4.4P AD=4.4P PS=20.88U
+ PD=20.88U
M$58 \$115 \$114 \$28 VDD pfet_06v0 L=1U W=10U AS=4.4P AD=4.4P PS=20.88U
+ PD=20.88U
M$59 \$2419 \$104 VDD VDD pfet_06v0 L=1U W=10U AS=4.4P AD=2.5P PS=20.88U
+ PD=10.5U
M$60 \$104 \$114 \$2419 VDD pfet_06v0 L=1U W=10U AS=2.5P AD=3.3P PS=10.5U
+ PD=10.66U
M$61 \$32 \$32 \$104 VDD pfet_06v0 L=1U W=10U AS=3.3P AD=4.4P PS=10.66U
+ PD=20.88U
M$62 \$2418 \$89 VDD VDD pfet_06v0 L=1U W=10U AS=4.4P AD=2.5P PS=20.88U PD=10.5U
M$63 \$56 \$114 \$2418 VDD pfet_06v0 L=1U W=10U AS=2.5P AD=4.4P PS=10.5U
+ PD=20.88U
M$64 \$2414 \$89 VDD VDD pfet_06v0 L=1U W=10U AS=4.4P AD=2.5P PS=20.88U PD=10.5U
M$65 \$85 \$114 \$2414 VDD pfet_06v0 L=1U W=10U AS=2.5P AD=4.4P PS=10.5U
+ PD=20.88U
M$66 \$2411 \$89 VDD VDD pfet_06v0 L=1U W=10U AS=4.4P AD=2.5P PS=20.88U PD=10.5U
M$67 \$81 \$114 \$2411 VDD pfet_06v0 L=1U W=10U AS=2.5P AD=4.4P PS=10.5U
+ PD=20.88U
M$68 \$2410 \$89 VDD VDD pfet_06v0 L=1U W=10U AS=4.4P AD=2.5P PS=20.88U PD=10.5U
M$69 \$89 \$114 \$2410 VDD pfet_06v0 L=1U W=10U AS=2.5P AD=4.4P PS=10.5U
+ PD=20.88U
M$70 \$2408 \$90 VDD VDD pfet_06v0 L=1U W=10U AS=4.4P AD=2.5P PS=20.88U PD=10.5U
M$71 \$132 \$116 \$2408 VDD pfet_06v0 L=1U W=10U AS=2.5P AD=4.4P PS=10.5U
+ PD=20.88U
M$72 \$2406 \$90 VDD VDD pfet_06v0 L=1U W=10U AS=4.4P AD=2.5P PS=20.88U PD=10.5U
M$73 \$132 \$116 \$2406 VDD pfet_06v0 L=1U W=10U AS=2.5P AD=4.4P PS=10.5U
+ PD=20.88U
M$74 \$133 \$116 \$37 VDD pfet_06v0 L=1U W=10U AS=4.4P AD=4.4P PS=20.88U
+ PD=20.88U
M$75 \$117 \$116 \$36 VDD pfet_06v0 L=1U W=10U AS=4.4P AD=4.4P PS=20.88U
+ PD=20.88U
M$76 \$2401 \$108 VDD VDD pfet_06v0 L=1U W=10U AS=4.4P AD=2.5P PS=20.88U
+ PD=10.5U
M$77 \$108 \$116 \$2401 VDD pfet_06v0 L=1U W=10U AS=2.5P AD=3.3P PS=10.5U
+ PD=10.66U
M$78 \$40 \$40 \$108 VDD pfet_06v0 L=1U W=10U AS=3.3P AD=4.4P PS=10.66U
+ PD=20.88U
M$79 \$2399 \$90 VDD VDD pfet_06v0 L=1U W=10U AS=4.4P AD=2.5P PS=20.88U PD=10.5U
M$80 \$58 \$116 \$2399 VDD pfet_06v0 L=1U W=10U AS=2.5P AD=4.4P PS=10.5U
+ PD=20.88U
M$81 \$2396 \$90 VDD VDD pfet_06v0 L=1U W=10U AS=4.4P AD=2.5P PS=20.88U PD=10.5U
M$82 \$86 \$116 \$2396 VDD pfet_06v0 L=1U W=10U AS=2.5P AD=4.4P PS=10.5U
+ PD=20.88U
M$83 \$2395 \$90 VDD VDD pfet_06v0 L=1U W=10U AS=4.4P AD=2.5P PS=20.88U PD=10.5U
M$84 \$82 \$116 \$2395 VDD pfet_06v0 L=1U W=10U AS=2.5P AD=4.4P PS=10.5U
+ PD=20.88U
M$85 \$2393 \$90 VDD VDD pfet_06v0 L=1U W=10U AS=4.4P AD=2.5P PS=20.88U PD=10.5U
M$86 \$90 \$116 \$2393 VDD pfet_06v0 L=1U W=10U AS=2.5P AD=4.4P PS=10.5U
+ PD=20.88U
M$87 VDD VSS VDD VDD pfet_06v0 L=2U W=18U AS=7.92P AD=7.92P PS=36.88U PD=36.88U
M$88 \$4803 \$2496 VDD VDD pfet_06v0 L=1U W=10U AS=4.4P AD=2.5P PS=20.88U
+ PD=10.5U
M$89 \$2536 \$2520 \$4803 VDD pfet_06v0 L=1U W=10U AS=2.5P AD=4.4P PS=10.5U
+ PD=20.88U
M$90 \$4805 \$2496 VDD VDD pfet_06v0 L=1U W=10U AS=4.4P AD=2.5P PS=20.88U
+ PD=10.5U
M$91 \$2536 \$2520 \$4805 VDD pfet_06v0 L=1U W=10U AS=2.5P AD=4.4P PS=10.5U
+ PD=20.88U
M$92 \$91 S2P \$126 VDD pfet_06v0 L=1U W=0.55U AS=0.242P AD=0.242P PS=1.98U
+ PD=1.98U
M$93 \$14 S2N \$126 VDD pfet_06v0 L=1U W=0.5U AS=0.22P AD=0.22P PS=1.88U
+ PD=1.88U
M$94 \$2537 \$2520 \$2426 VDD pfet_06v0 L=1U W=10U AS=4.4P AD=4.4P PS=20.88U
+ PD=20.88U
M$95 \$2526 \$2520 \$2425 VDD pfet_06v0 L=1U W=10U AS=4.4P AD=4.4P PS=20.88U
+ PD=20.88U
M$96 \$13 \$127 VDD VDD pfet_06v0 L=1U W=5U AS=2.2P AD=2.2P PS=10.88U PD=10.88U
M$97 \$12 \$127 VDD VDD pfet_06v0 L=1U W=5U AS=2.2P AD=2.2P PS=10.88U PD=10.88U
M$98 \$51 \$16 \$127 VDD pfet_06v0 L=1U W=4U AS=1.76P AD=1.76P PS=8.88U PD=8.88U
M$99 \$15 \$16 \$110 VDD pfet_06v0 L=1U W=4U AS=1.76P AD=1.76P PS=8.88U PD=8.88U
M$100 \$4808 \$2511 VDD VDD pfet_06v0 L=1U W=10U AS=4.4P AD=2.5P PS=20.88U
+ PD=10.5U
M$101 \$2511 \$2520 \$4808 VDD pfet_06v0 L=1U W=10U AS=2.5P AD=3.3P PS=10.5U
+ PD=10.66U
M$102 \$2429 \$2429 \$2511 VDD pfet_06v0 L=1U W=10U AS=3.3P AD=4.4P PS=10.66U
+ PD=20.88U
M$103 \$4809 \$2496 VDD VDD pfet_06v0 L=1U W=10U AS=4.4P AD=2.5P PS=20.88U
+ PD=10.5U
M$104 \$2464 \$2520 \$4809 VDD pfet_06v0 L=1U W=10U AS=2.5P AD=4.4P PS=10.5U
+ PD=20.88U
M$105 \$18 \$110 VDD VDD pfet_06v0 L=1U W=1U AS=0.44P AD=0.44P PS=2.88U PD=2.88U
M$106 \$18 \$110 VDD VDD pfet_06v0 L=1U W=1U AS=0.44P AD=0.44P PS=2.88U PD=2.88U
M$107 \$18 \$110 VDD VDD pfet_06v0 L=1U W=1U AS=0.44P AD=0.44P PS=2.88U PD=2.88U
M$108 \$18 \$110 VDD VDD pfet_06v0 L=1U W=1U AS=0.44P AD=0.44P PS=2.88U PD=2.88U
M$109 \$4811 \$2496 VDD VDD pfet_06v0 L=1U W=10U AS=4.4P AD=2.5P PS=20.88U
+ PD=10.5U
M$110 \$2469 \$2520 \$4811 VDD pfet_06v0 L=1U W=10U AS=2.5P AD=4.4P PS=10.5U
+ PD=20.88U
M$111 \$4813 \$2496 VDD VDD pfet_06v0 L=1U W=10U AS=4.4P AD=2.5P PS=20.88U
+ PD=10.5U
M$112 \$2468 \$2520 \$4813 VDD pfet_06v0 L=1U W=10U AS=2.5P AD=4.4P PS=10.5U
+ PD=20.88U
M$113 \$109 \$109 VDD VDD pfet_06v0 L=1U W=2U AS=0.88P AD=0.88P PS=4.88U
+ PD=4.88U
M$114 \$4814 \$2496 VDD VDD pfet_06v0 L=1U W=10U AS=4.4P AD=2.5P PS=20.88U
+ PD=10.5U
M$115 \$2496 \$2520 \$4814 VDD pfet_06v0 L=1U W=10U AS=2.5P AD=4.4P PS=10.5U
+ PD=20.88U
M$116 VDD VSS VDD VDD pfet_06v0 L=2U W=18U AS=7.92P AD=7.92P PS=36.88U PD=36.88U
M$117 VDD VSS VDD VDD pfet_06v0 L=2U W=18U AS=7.92P AD=7.92P PS=36.88U PD=36.88U
M$118 \$4815 \$2500 VDD VDD pfet_06v0 L=1U W=10U AS=4.4P AD=2.5P PS=20.88U
+ PD=10.5U
M$119 \$2538 \$2521 \$4815 VDD pfet_06v0 L=1U W=10U AS=2.5P AD=4.4P PS=10.5U
+ PD=20.88U
M$120 \$4816 \$2500 VDD VDD pfet_06v0 L=1U W=10U AS=4.4P AD=2.5P PS=20.88U
+ PD=10.5U
M$121 \$2538 \$2521 \$4816 VDD pfet_06v0 L=1U W=10U AS=2.5P AD=4.4P PS=10.5U
+ PD=20.88U
M$122 \$96 S3P \$128 VDD pfet_06v0 L=1U W=0.55U AS=0.242P AD=0.242P PS=1.98U
+ PD=1.98U
M$123 \$22 S3N \$128 VDD pfet_06v0 L=1U W=0.5U AS=0.22P AD=0.22P PS=1.88U
+ PD=1.88U
M$124 \$2540 \$2521 \$2434 VDD pfet_06v0 L=1U W=10U AS=4.4P AD=4.4P PS=20.88U
+ PD=20.88U
M$125 \$2529 \$2521 \$2433 VDD pfet_06v0 L=1U W=10U AS=4.4P AD=4.4P PS=20.88U
+ PD=20.88U
M$126 \$21 \$129 VDD VDD pfet_06v0 L=1U W=5U AS=2.2P AD=2.2P PS=10.88U PD=10.88U
M$127 \$20 \$129 VDD VDD pfet_06v0 L=1U W=5U AS=2.2P AD=2.2P PS=10.88U PD=10.88U
M$128 \$53 \$24 \$129 VDD pfet_06v0 L=1U W=4U AS=1.76P AD=1.76P PS=8.88U
+ PD=8.88U
M$129 \$23 \$24 \$113 VDD pfet_06v0 L=1U W=4U AS=1.76P AD=1.76P PS=8.88U
+ PD=8.88U
M$130 \$4818 \$2513 VDD VDD pfet_06v0 L=1U W=10U AS=4.4P AD=2.5P PS=20.88U
+ PD=10.5U
M$131 \$2513 \$2521 \$4818 VDD pfet_06v0 L=1U W=10U AS=2.5P AD=3.3P PS=10.5U
+ PD=10.66U
M$132 \$2437 \$2437 \$2513 VDD pfet_06v0 L=1U W=10U AS=3.3P AD=4.4P PS=10.66U
+ PD=20.88U
M$133 \$4820 \$2500 VDD VDD pfet_06v0 L=1U W=10U AS=4.4P AD=2.5P PS=20.88U
+ PD=10.5U
M$134 \$2465 \$2521 \$4820 VDD pfet_06v0 L=1U W=10U AS=2.5P AD=4.4P PS=10.5U
+ PD=20.88U
M$135 \$26 \$113 VDD VDD pfet_06v0 L=1U W=1U AS=0.44P AD=0.44P PS=2.88U PD=2.88U
M$136 \$26 \$113 VDD VDD pfet_06v0 L=1U W=1U AS=0.44P AD=0.44P PS=2.88U PD=2.88U
M$137 \$26 \$113 VDD VDD pfet_06v0 L=1U W=1U AS=0.44P AD=0.44P PS=2.88U PD=2.88U
M$138 \$26 \$113 VDD VDD pfet_06v0 L=1U W=1U AS=0.44P AD=0.44P PS=2.88U PD=2.88U
M$139 \$4823 \$2500 VDD VDD pfet_06v0 L=1U W=10U AS=4.4P AD=2.5P PS=20.88U
+ PD=10.5U
M$140 \$2471 \$2521 \$4823 VDD pfet_06v0 L=1U W=10U AS=2.5P AD=4.4P PS=10.5U
+ PD=20.88U
M$141 \$4824 \$2500 VDD VDD pfet_06v0 L=1U W=10U AS=4.4P AD=2.5P PS=20.88U
+ PD=10.5U
M$142 \$2470 \$2521 \$4824 VDD pfet_06v0 L=1U W=10U AS=2.5P AD=4.4P PS=10.5U
+ PD=20.88U
M$143 \$112 \$112 VDD VDD pfet_06v0 L=1U W=2U AS=0.88P AD=0.88P PS=4.88U
+ PD=4.88U
M$144 \$4826 \$2500 VDD VDD pfet_06v0 L=1U W=10U AS=4.4P AD=2.5P PS=20.88U
+ PD=10.5U
M$145 \$2500 \$2521 \$4826 VDD pfet_06v0 L=1U W=10U AS=2.5P AD=4.4P PS=10.5U
+ PD=20.88U
M$146 VDD VSS VDD VDD pfet_06v0 L=2U W=18U AS=7.92P AD=7.92P PS=36.88U PD=36.88U
M$147 VDD VSS VDD VDD pfet_06v0 L=2U W=18U AS=7.92P AD=7.92P PS=36.88U PD=36.88U
M$148 \$4827 \$2504 VDD VDD pfet_06v0 L=1U W=10U AS=4.4P AD=2.5P PS=20.88U
+ PD=10.5U
M$149 \$2541 \$2522 \$4827 VDD pfet_06v0 L=1U W=10U AS=2.5P AD=4.4P PS=10.5U
+ PD=20.88U
M$150 \$4828 \$2504 VDD VDD pfet_06v0 L=1U W=10U AS=4.4P AD=2.5P PS=20.88U
+ PD=10.5U
M$151 \$2541 \$2522 \$4828 VDD pfet_06v0 L=1U W=10U AS=2.5P AD=4.4P PS=10.5U
+ PD=20.88U
M$152 \$102 S1P \$130 VDD pfet_06v0 L=1U W=0.55U AS=0.242P AD=0.242P PS=1.98U
+ PD=1.98U
M$153 \$30 S1N \$130 VDD pfet_06v0 L=1U W=0.5U AS=0.22P AD=0.22P PS=1.88U
+ PD=1.88U
M$154 \$2542 \$2522 \$2442 VDD pfet_06v0 L=1U W=10U AS=4.4P AD=4.4P PS=20.88U
+ PD=20.88U
M$155 \$2532 \$2522 \$2441 VDD pfet_06v0 L=1U W=10U AS=4.4P AD=4.4P PS=20.88U
+ PD=20.88U
M$156 \$29 \$131 VDD VDD pfet_06v0 L=1U W=5U AS=2.2P AD=2.2P PS=10.88U PD=10.88U
M$157 \$28 \$131 VDD VDD pfet_06v0 L=1U W=5U AS=2.2P AD=2.2P PS=10.88U PD=10.88U
M$158 \$55 \$32 \$131 VDD pfet_06v0 L=1U W=4U AS=1.76P AD=1.76P PS=8.88U
+ PD=8.88U
M$159 \$31 \$32 \$115 VDD pfet_06v0 L=1U W=4U AS=1.76P AD=1.76P PS=8.88U
+ PD=8.88U
M$160 \$4830 \$2516 VDD VDD pfet_06v0 L=1U W=10U AS=4.4P AD=2.5P PS=20.88U
+ PD=10.5U
M$161 \$2516 \$2522 \$4830 VDD pfet_06v0 L=1U W=10U AS=2.5P AD=3.3P PS=10.5U
+ PD=10.66U
M$162 \$2445 \$2445 \$2516 VDD pfet_06v0 L=1U W=10U AS=3.3P AD=4.4P PS=10.66U
+ PD=20.88U
M$163 \$4829 \$2504 VDD VDD pfet_06v0 L=1U W=10U AS=4.4P AD=2.5P PS=20.88U
+ PD=10.5U
M$164 \$2466 \$2522 \$4829 VDD pfet_06v0 L=1U W=10U AS=2.5P AD=4.4P PS=10.5U
+ PD=20.88U
M$165 \$34 \$115 VDD VDD pfet_06v0 L=1U W=1U AS=0.44P AD=0.44P PS=2.88U PD=2.88U
M$166 \$34 \$115 VDD VDD pfet_06v0 L=1U W=1U AS=0.44P AD=0.44P PS=2.88U PD=2.88U
M$167 \$34 \$115 VDD VDD pfet_06v0 L=1U W=1U AS=0.44P AD=0.44P PS=2.88U PD=2.88U
M$168 \$34 \$115 VDD VDD pfet_06v0 L=1U W=1U AS=0.44P AD=0.44P PS=2.88U PD=2.88U
M$169 \$4825 \$2504 VDD VDD pfet_06v0 L=1U W=10U AS=4.4P AD=2.5P PS=20.88U
+ PD=10.5U
M$170 \$2473 \$2522 \$4825 VDD pfet_06v0 L=1U W=10U AS=2.5P AD=4.4P PS=10.5U
+ PD=20.88U
M$171 \$4822 \$2504 VDD VDD pfet_06v0 L=1U W=10U AS=4.4P AD=2.5P PS=20.88U
+ PD=10.5U
M$172 \$2472 \$2522 \$4822 VDD pfet_06v0 L=1U W=10U AS=2.5P AD=4.4P PS=10.5U
+ PD=20.88U
M$173 \$114 \$114 VDD VDD pfet_06v0 L=1U W=2U AS=0.88P AD=0.88P PS=4.88U
+ PD=4.88U
M$174 \$4821 \$2504 VDD VDD pfet_06v0 L=1U W=10U AS=4.4P AD=2.5P PS=20.88U
+ PD=10.5U
M$175 \$2504 \$2522 \$4821 VDD pfet_06v0 L=1U W=10U AS=2.5P AD=4.4P PS=10.5U
+ PD=20.88U
M$176 VDD VSS VDD VDD pfet_06v0 L=2U W=18U AS=7.92P AD=7.92P PS=36.88U PD=36.88U
M$177 VDD VSS VDD VDD pfet_06v0 L=2U W=18U AS=7.92P AD=7.92P PS=36.88U PD=36.88U
M$178 \$4819 \$2507 VDD VDD pfet_06v0 L=1U W=10U AS=4.4P AD=2.5P PS=20.88U
+ PD=10.5U
M$179 \$2543 \$2523 \$4819 VDD pfet_06v0 L=1U W=10U AS=2.5P AD=4.4P PS=10.5U
+ PD=20.88U
M$180 \$4817 \$2507 VDD VDD pfet_06v0 L=1U W=10U AS=4.4P AD=2.5P PS=20.88U
+ PD=10.5U
M$181 \$2543 \$2523 \$4817 VDD pfet_06v0 L=1U W=10U AS=2.5P AD=4.4P PS=10.5U
+ PD=20.88U
M$182 \$107 S1P \$132 VDD pfet_06v0 L=1U W=0.55U AS=0.242P AD=0.242P PS=1.98U
+ PD=1.98U
M$183 \$38 S1N \$132 VDD pfet_06v0 L=1U W=0.5U AS=0.22P AD=0.22P PS=1.88U
+ PD=1.88U
M$184 \$2544 \$2523 \$2450 VDD pfet_06v0 L=1U W=10U AS=4.4P AD=4.4P PS=20.88U
+ PD=20.88U
M$185 \$2535 \$2523 \$2449 VDD pfet_06v0 L=1U W=10U AS=4.4P AD=4.4P PS=20.88U
+ PD=20.88U
M$186 \$37 \$133 VDD VDD pfet_06v0 L=1U W=5U AS=2.2P AD=2.2P PS=10.88U PD=10.88U
M$187 \$36 \$133 VDD VDD pfet_06v0 L=1U W=5U AS=2.2P AD=2.2P PS=10.88U PD=10.88U
M$188 \$57 \$40 \$133 VDD pfet_06v0 L=1U W=4U AS=1.76P AD=1.76P PS=8.88U
+ PD=8.88U
M$189 \$39 \$40 \$117 VDD pfet_06v0 L=1U W=4U AS=1.76P AD=1.76P PS=8.88U
+ PD=8.88U
M$190 \$4812 \$2519 VDD VDD pfet_06v0 L=1U W=10U AS=4.4P AD=2.5P PS=20.88U
+ PD=10.5U
M$191 \$2519 \$2523 \$4812 VDD pfet_06v0 L=1U W=10U AS=2.5P AD=3.3P PS=10.5U
+ PD=10.66U
M$192 \$2453 \$2453 \$2519 VDD pfet_06v0 L=1U W=10U AS=3.3P AD=4.4P PS=10.66U
+ PD=20.88U
M$193 \$4810 \$2507 VDD VDD pfet_06v0 L=1U W=10U AS=4.4P AD=2.5P PS=20.88U
+ PD=10.5U
M$194 \$2467 \$2523 \$4810 VDD pfet_06v0 L=1U W=10U AS=2.5P AD=4.4P PS=10.5U
+ PD=20.88U
M$195 \$42 \$117 VDD VDD pfet_06v0 L=1U W=1U AS=0.44P AD=0.44P PS=2.88U PD=2.88U
M$196 \$42 \$117 VDD VDD pfet_06v0 L=1U W=1U AS=0.44P AD=0.44P PS=2.88U PD=2.88U
M$197 \$42 \$117 VDD VDD pfet_06v0 L=1U W=1U AS=0.44P AD=0.44P PS=2.88U PD=2.88U
M$198 \$42 \$117 VDD VDD pfet_06v0 L=1U W=1U AS=0.44P AD=0.44P PS=2.88U PD=2.88U
M$199 \$4807 \$2507 VDD VDD pfet_06v0 L=1U W=10U AS=4.4P AD=2.5P PS=20.88U
+ PD=10.5U
M$200 \$2475 \$2523 \$4807 VDD pfet_06v0 L=1U W=10U AS=2.5P AD=4.4P PS=10.5U
+ PD=20.88U
M$201 \$4806 \$2507 VDD VDD pfet_06v0 L=1U W=10U AS=4.4P AD=2.5P PS=20.88U
+ PD=10.5U
M$202 \$2474 \$2523 \$4806 VDD pfet_06v0 L=1U W=10U AS=2.5P AD=4.4P PS=10.5U
+ PD=20.88U
M$203 \$116 \$116 VDD VDD pfet_06v0 L=1U W=2U AS=0.88P AD=0.88P PS=4.88U
+ PD=4.88U
M$204 \$4804 \$2507 VDD VDD pfet_06v0 L=1U W=10U AS=4.4P AD=2.5P PS=20.88U
+ PD=10.5U
M$205 \$2507 \$2523 \$4804 VDD pfet_06v0 L=1U W=10U AS=2.5P AD=4.4P PS=10.5U
+ PD=20.88U
M$206 VDD VSS VDD VDD pfet_06v0 L=2U W=18U AS=7.92P AD=7.92P PS=36.88U PD=36.88U
M$207 VDD VSS VDD VDD pfet_06v0 L=2U W=18U AS=7.92P AD=7.92P PS=36.88U PD=36.88U
M$208 VDD VSS VDD VDD pfet_06v0 L=2U W=18U AS=7.92P AD=7.92P PS=36.88U PD=36.88U
M$209 \$7212 \$4911 VDD VDD pfet_06v0 L=1U W=10U AS=4.4P AD=2.5P PS=20.88U
+ PD=10.5U
M$210 \$4947 \$4931 \$7212 VDD pfet_06v0 L=1U W=10U AS=2.5P AD=4.4P PS=10.5U
+ PD=20.88U
M$211 \$7214 \$4911 VDD VDD pfet_06v0 L=1U W=10U AS=4.4P AD=2.5P PS=20.88U
+ PD=10.5U
M$212 \$4947 \$4931 \$7214 VDD pfet_06v0 L=1U W=10U AS=2.5P AD=4.4P PS=10.5U
+ PD=20.88U
M$213 \$2499 S2P \$2536 VDD pfet_06v0 L=1U W=0.55U AS=0.242P AD=0.242P PS=1.98U
+ PD=1.98U
M$214 \$2427 S2N \$2536 VDD pfet_06v0 L=1U W=0.5U AS=0.22P AD=0.22P PS=1.88U
+ PD=1.88U
M$215 \$4948 \$4931 \$4837 VDD pfet_06v0 L=1U W=10U AS=4.4P AD=4.4P PS=20.88U
+ PD=20.88U
M$216 \$4934 \$4931 \$4836 VDD pfet_06v0 L=1U W=10U AS=4.4P AD=4.4P PS=20.88U
+ PD=20.88U
M$217 \$2426 \$2537 VDD VDD pfet_06v0 L=1U W=5U AS=2.2P AD=2.2P PS=10.88U
+ PD=10.88U
M$218 \$2425 \$2537 VDD VDD pfet_06v0 L=1U W=5U AS=2.2P AD=2.2P PS=10.88U
+ PD=10.88U
M$219 \$2510 \$2429 \$2537 VDD pfet_06v0 L=1U W=4U AS=1.76P AD=1.76P PS=8.88U
+ PD=8.88U
M$220 \$2428 \$2429 \$2526 VDD pfet_06v0 L=1U W=4U AS=1.76P AD=1.76P PS=8.88U
+ PD=8.88U
M$221 \$7217 \$4918 VDD VDD pfet_06v0 L=1U W=10U AS=4.4P AD=2.5P PS=20.88U
+ PD=10.5U
M$222 \$4918 \$4931 \$7217 VDD pfet_06v0 L=1U W=10U AS=2.5P AD=3.3P PS=10.5U
+ PD=10.66U
M$223 \$4840 \$4840 \$4918 VDD pfet_06v0 L=1U W=10U AS=3.3P AD=4.4P PS=10.66U
+ PD=20.88U
M$224 \$7218 \$4911 VDD VDD pfet_06v0 L=1U W=10U AS=4.4P AD=2.5P PS=20.88U
+ PD=10.5U
M$225 \$4876 \$4931 \$7218 VDD pfet_06v0 L=1U W=10U AS=2.5P AD=4.4P PS=10.5U
+ PD=20.88U
M$226 \$2431 \$2526 VDD VDD pfet_06v0 L=1U W=1U AS=0.44P AD=0.44P PS=2.88U
+ PD=2.88U
M$227 \$2431 \$2526 VDD VDD pfet_06v0 L=1U W=1U AS=0.44P AD=0.44P PS=2.88U
+ PD=2.88U
M$228 \$2431 \$2526 VDD VDD pfet_06v0 L=1U W=1U AS=0.44P AD=0.44P PS=2.88U
+ PD=2.88U
M$229 \$2431 \$2526 VDD VDD pfet_06v0 L=1U W=1U AS=0.44P AD=0.44P PS=2.88U
+ PD=2.88U
M$230 \$7220 \$4911 VDD VDD pfet_06v0 L=1U W=10U AS=4.4P AD=2.5P PS=20.88U
+ PD=10.5U
M$231 \$4884 \$4931 \$7220 VDD pfet_06v0 L=1U W=10U AS=2.5P AD=4.4P PS=10.5U
+ PD=20.88U
M$232 \$7222 \$4911 VDD VDD pfet_06v0 L=1U W=10U AS=4.4P AD=2.5P PS=20.88U
+ PD=10.5U
M$233 \$4883 \$4931 \$7222 VDD pfet_06v0 L=1U W=10U AS=2.5P AD=4.4P PS=10.5U
+ PD=20.88U
M$234 \$2520 \$2520 VDD VDD pfet_06v0 L=1U W=2U AS=0.88P AD=0.88P PS=4.88U
+ PD=4.88U
M$235 \$7223 \$4911 VDD VDD pfet_06v0 L=1U W=10U AS=4.4P AD=2.5P PS=20.88U
+ PD=10.5U
M$236 \$4911 \$4931 \$7223 VDD pfet_06v0 L=1U W=10U AS=2.5P AD=4.4P PS=10.5U
+ PD=20.88U
M$237 VDD VSS VDD VDD pfet_06v0 L=2U W=18U AS=7.92P AD=7.92P PS=36.88U PD=36.88U
M$238 VDD VSS VDD VDD pfet_06v0 L=2U W=18U AS=7.92P AD=7.92P PS=36.88U PD=36.88U
M$239 \$7224 \$4912 VDD VDD pfet_06v0 L=1U W=10U AS=4.4P AD=2.5P PS=20.88U
+ PD=10.5U
M$240 \$4949 \$4935 \$7224 VDD pfet_06v0 L=1U W=10U AS=2.5P AD=4.4P PS=10.5U
+ PD=20.88U
M$241 \$7225 \$4912 VDD VDD pfet_06v0 L=1U W=10U AS=4.4P AD=2.5P PS=20.88U
+ PD=10.5U
M$242 \$4949 \$4935 \$7225 VDD pfet_06v0 L=1U W=10U AS=2.5P AD=4.4P PS=10.5U
+ PD=20.88U
M$243 \$2501 \$2539 \$2538 VDD pfet_06v0 L=1U W=0.55U AS=0.242P AD=0.242P
+ PS=1.98U PD=1.98U
M$244 \$2435 S4N \$2538 VDD pfet_06v0 L=1U W=0.5U AS=0.22P AD=0.22P PS=1.88U
+ PD=1.88U
M$245 \$4950 \$4935 \$4845 VDD pfet_06v0 L=1U W=10U AS=4.4P AD=4.4P PS=20.88U
+ PD=20.88U
M$246 \$4938 \$4935 \$4844 VDD pfet_06v0 L=1U W=10U AS=4.4P AD=4.4P PS=20.88U
+ PD=20.88U
M$247 \$2434 \$2540 VDD VDD pfet_06v0 L=1U W=5U AS=2.2P AD=2.2P PS=10.88U
+ PD=10.88U
M$248 \$2433 \$2540 VDD VDD pfet_06v0 L=1U W=5U AS=2.2P AD=2.2P PS=10.88U
+ PD=10.88U
M$249 \$2512 \$2437 \$2540 VDD pfet_06v0 L=1U W=4U AS=1.76P AD=1.76P PS=8.88U
+ PD=8.88U
M$250 \$2436 \$2437 \$2529 VDD pfet_06v0 L=1U W=4U AS=1.76P AD=1.76P PS=8.88U
+ PD=8.88U
M$251 \$7227 \$4922 VDD VDD pfet_06v0 L=1U W=10U AS=4.4P AD=2.5P PS=20.88U
+ PD=10.5U
M$252 \$4922 \$4935 \$7227 VDD pfet_06v0 L=1U W=10U AS=2.5P AD=3.3P PS=10.5U
+ PD=10.66U
M$253 \$4848 \$4848 \$4922 VDD pfet_06v0 L=1U W=10U AS=3.3P AD=4.4P PS=10.66U
+ PD=20.88U
M$254 \$7228 \$4912 VDD VDD pfet_06v0 L=1U W=10U AS=4.4P AD=2.5P PS=20.88U
+ PD=10.5U
M$255 \$4878 \$4935 \$7228 VDD pfet_06v0 L=1U W=10U AS=2.5P AD=4.4P PS=10.5U
+ PD=20.88U
M$256 \$2439 \$2529 VDD VDD pfet_06v0 L=1U W=1U AS=0.44P AD=0.44P PS=2.88U
+ PD=2.88U
M$257 \$2439 \$2529 VDD VDD pfet_06v0 L=1U W=1U AS=0.44P AD=0.44P PS=2.88U
+ PD=2.88U
M$258 \$2439 \$2529 VDD VDD pfet_06v0 L=1U W=1U AS=0.44P AD=0.44P PS=2.88U
+ PD=2.88U
M$259 \$2439 \$2529 VDD VDD pfet_06v0 L=1U W=1U AS=0.44P AD=0.44P PS=2.88U
+ PD=2.88U
M$260 \$7231 \$4912 VDD VDD pfet_06v0 L=1U W=10U AS=4.4P AD=2.5P PS=20.88U
+ PD=10.5U
M$261 \$4886 \$4935 \$7231 VDD pfet_06v0 L=1U W=10U AS=2.5P AD=4.4P PS=10.5U
+ PD=20.88U
M$262 \$7233 \$4912 VDD VDD pfet_06v0 L=1U W=10U AS=4.4P AD=2.5P PS=20.88U
+ PD=10.5U
M$263 \$4885 \$4935 \$7233 VDD pfet_06v0 L=1U W=10U AS=2.5P AD=4.4P PS=10.5U
+ PD=20.88U
M$264 \$2521 \$2521 VDD VDD pfet_06v0 L=1U W=2U AS=0.88P AD=0.88P PS=4.88U
+ PD=4.88U
M$265 \$7235 \$4912 VDD VDD pfet_06v0 L=1U W=10U AS=4.4P AD=2.5P PS=20.88U
+ PD=10.5U
M$266 \$4912 \$4935 \$7235 VDD pfet_06v0 L=1U W=10U AS=2.5P AD=4.4P PS=10.5U
+ PD=20.88U
M$267 VDD VSS VDD VDD pfet_06v0 L=2U W=18U AS=7.92P AD=7.92P PS=36.88U PD=36.88U
M$268 VDD VSS VDD VDD pfet_06v0 L=2U W=18U AS=7.92P AD=7.92P PS=36.88U PD=36.88U
M$269 \$7236 \$4913 VDD VDD pfet_06v0 L=1U W=10U AS=4.4P AD=2.5P PS=20.88U
+ PD=10.5U
M$270 \$4951 \$4939 \$7236 VDD pfet_06v0 L=1U W=10U AS=2.5P AD=4.4P PS=10.5U
+ PD=20.88U
M$271 \$7237 \$4913 VDD VDD pfet_06v0 L=1U W=10U AS=4.4P AD=2.5P PS=20.88U
+ PD=10.5U
M$272 \$4951 \$4939 \$7237 VDD pfet_06v0 L=1U W=10U AS=2.5P AD=4.4P PS=10.5U
+ PD=20.88U
M$273 \$2514 S4P \$2541 VDD pfet_06v0 L=1U W=0.55U AS=0.242P AD=0.242P PS=1.98U
+ PD=1.98U
M$274 \$2443 S4N \$2541 VDD pfet_06v0 L=1U W=0.5U AS=0.22P AD=0.22P PS=1.88U
+ PD=1.88U
M$275 \$4952 \$4939 \$4853 VDD pfet_06v0 L=1U W=10U AS=4.4P AD=4.4P PS=20.88U
+ PD=20.88U
M$276 \$4942 \$4939 \$4852 VDD pfet_06v0 L=1U W=10U AS=4.4P AD=4.4P PS=20.88U
+ PD=20.88U
M$277 \$2442 \$2542 VDD VDD pfet_06v0 L=1U W=5U AS=2.2P AD=2.2P PS=10.88U
+ PD=10.88U
M$278 \$2441 \$2542 VDD VDD pfet_06v0 L=1U W=5U AS=2.2P AD=2.2P PS=10.88U
+ PD=10.88U
M$279 \$2515 \$2445 \$2542 VDD pfet_06v0 L=1U W=4U AS=1.76P AD=1.76P PS=8.88U
+ PD=8.88U
M$280 \$2444 \$2445 \$2532 VDD pfet_06v0 L=1U W=4U AS=1.76P AD=1.76P PS=8.88U
+ PD=8.88U
M$281 \$7239 \$4926 VDD VDD pfet_06v0 L=1U W=10U AS=4.4P AD=2.5P PS=20.88U
+ PD=10.5U
M$282 \$4926 \$4939 \$7239 VDD pfet_06v0 L=1U W=10U AS=2.5P AD=3.3P PS=10.5U
+ PD=10.66U
M$283 \$4856 \$4856 \$4926 VDD pfet_06v0 L=1U W=10U AS=3.3P AD=4.4P PS=10.66U
+ PD=20.88U
M$284 \$7238 \$4913 VDD VDD pfet_06v0 L=1U W=10U AS=4.4P AD=2.5P PS=20.88U
+ PD=10.5U
M$285 \$4880 \$4939 \$7238 VDD pfet_06v0 L=1U W=10U AS=2.5P AD=4.4P PS=10.5U
+ PD=20.88U
M$286 \$2447 \$2532 VDD VDD pfet_06v0 L=1U W=1U AS=0.44P AD=0.44P PS=2.88U
+ PD=2.88U
M$287 \$2447 \$2532 VDD VDD pfet_06v0 L=1U W=1U AS=0.44P AD=0.44P PS=2.88U
+ PD=2.88U
M$288 \$2447 \$2532 VDD VDD pfet_06v0 L=1U W=1U AS=0.44P AD=0.44P PS=2.88U
+ PD=2.88U
M$289 \$2447 \$2532 VDD VDD pfet_06v0 L=1U W=1U AS=0.44P AD=0.44P PS=2.88U
+ PD=2.88U
M$290 \$7234 \$4913 VDD VDD pfet_06v0 L=1U W=10U AS=4.4P AD=2.5P PS=20.88U
+ PD=10.5U
M$291 \$4888 \$4939 \$7234 VDD pfet_06v0 L=1U W=10U AS=2.5P AD=4.4P PS=10.5U
+ PD=20.88U
M$292 \$7232 \$4913 VDD VDD pfet_06v0 L=1U W=10U AS=4.4P AD=2.5P PS=20.88U
+ PD=10.5U
M$293 \$4887 \$4939 \$7232 VDD pfet_06v0 L=1U W=10U AS=2.5P AD=4.4P PS=10.5U
+ PD=20.88U
M$294 \$2522 \$2522 VDD VDD pfet_06v0 L=1U W=2U AS=0.88P AD=0.88P PS=4.88U
+ PD=4.88U
M$295 \$7230 \$4913 VDD VDD pfet_06v0 L=1U W=10U AS=4.4P AD=2.5P PS=20.88U
+ PD=10.5U
M$296 \$4913 \$4939 \$7230 VDD pfet_06v0 L=1U W=10U AS=2.5P AD=4.4P PS=10.5U
+ PD=20.88U
M$297 VDD VSS VDD VDD pfet_06v0 L=2U W=18U AS=7.92P AD=7.92P PS=36.88U PD=36.88U
M$298 VDD VSS VDD VDD pfet_06v0 L=2U W=18U AS=7.92P AD=7.92P PS=36.88U PD=36.88U
M$299 \$7229 \$4914 VDD VDD pfet_06v0 L=1U W=10U AS=4.4P AD=2.5P PS=20.88U
+ PD=10.5U
M$300 \$4953 \$4943 \$7229 VDD pfet_06v0 L=1U W=10U AS=2.5P AD=4.4P PS=10.5U
+ PD=20.88U
M$301 \$7226 \$4914 VDD VDD pfet_06v0 L=1U W=10U AS=4.4P AD=2.5P PS=20.88U
+ PD=10.5U
M$302 \$4953 \$4943 \$7226 VDD pfet_06v0 L=1U W=10U AS=2.5P AD=4.4P PS=10.5U
+ PD=20.88U
M$303 \$2517 S1P \$2543 VDD pfet_06v0 L=1U W=0.55U AS=0.242P AD=0.242P PS=1.98U
+ PD=1.98U
M$304 \$2451 S1N \$2543 VDD pfet_06v0 L=1U W=0.5U AS=0.22P AD=0.22P PS=1.88U
+ PD=1.88U
M$305 \$4954 \$4943 \$4861 VDD pfet_06v0 L=1U W=10U AS=4.4P AD=4.4P PS=20.88U
+ PD=20.88U
M$306 \$4946 \$4943 \$4860 VDD pfet_06v0 L=1U W=10U AS=4.4P AD=4.4P PS=20.88U
+ PD=20.88U
M$307 \$2450 \$2544 VDD VDD pfet_06v0 L=1U W=5U AS=2.2P AD=2.2P PS=10.88U
+ PD=10.88U
M$308 \$2449 \$2544 VDD VDD pfet_06v0 L=1U W=5U AS=2.2P AD=2.2P PS=10.88U
+ PD=10.88U
M$309 \$2518 \$2453 \$2544 VDD pfet_06v0 L=1U W=4U AS=1.76P AD=1.76P PS=8.88U
+ PD=8.88U
M$310 \$2452 \$2453 \$2535 VDD pfet_06v0 L=1U W=4U AS=1.76P AD=1.76P PS=8.88U
+ PD=8.88U
M$311 \$7221 \$4930 VDD VDD pfet_06v0 L=1U W=10U AS=4.4P AD=2.5P PS=20.88U
+ PD=10.5U
M$312 \$4930 \$4943 \$7221 VDD pfet_06v0 L=1U W=10U AS=2.5P AD=3.3P PS=10.5U
+ PD=10.66U
M$313 \$4864 \$4864 \$4930 VDD pfet_06v0 L=1U W=10U AS=3.3P AD=4.4P PS=10.66U
+ PD=20.88U
M$314 \$7219 \$4914 VDD VDD pfet_06v0 L=1U W=10U AS=4.4P AD=2.5P PS=20.88U
+ PD=10.5U
M$315 \$4882 \$4943 \$7219 VDD pfet_06v0 L=1U W=10U AS=2.5P AD=4.4P PS=10.5U
+ PD=20.88U
M$316 \$2455 \$2535 VDD VDD pfet_06v0 L=1U W=1U AS=0.44P AD=0.44P PS=2.88U
+ PD=2.88U
M$317 \$2455 \$2535 VDD VDD pfet_06v0 L=1U W=1U AS=0.44P AD=0.44P PS=2.88U
+ PD=2.88U
M$318 \$2455 \$2535 VDD VDD pfet_06v0 L=1U W=1U AS=0.44P AD=0.44P PS=2.88U
+ PD=2.88U
M$319 \$2455 \$2535 VDD VDD pfet_06v0 L=1U W=1U AS=0.44P AD=0.44P PS=2.88U
+ PD=2.88U
M$320 \$7216 \$4914 VDD VDD pfet_06v0 L=1U W=10U AS=4.4P AD=2.5P PS=20.88U
+ PD=10.5U
M$321 \$4890 \$4943 \$7216 VDD pfet_06v0 L=1U W=10U AS=2.5P AD=4.4P PS=10.5U
+ PD=20.88U
M$322 \$7215 \$4914 VDD VDD pfet_06v0 L=1U W=10U AS=4.4P AD=2.5P PS=20.88U
+ PD=10.5U
M$323 \$4889 \$4943 \$7215 VDD pfet_06v0 L=1U W=10U AS=2.5P AD=4.4P PS=10.5U
+ PD=20.88U
M$324 \$2523 \$2523 VDD VDD pfet_06v0 L=1U W=2U AS=0.88P AD=0.88P PS=4.88U
+ PD=4.88U
M$325 \$7213 \$4914 VDD VDD pfet_06v0 L=1U W=10U AS=4.4P AD=2.5P PS=20.88U
+ PD=10.5U
M$326 \$4914 \$4943 \$7213 VDD pfet_06v0 L=1U W=10U AS=2.5P AD=4.4P PS=10.5U
+ PD=20.88U
M$327 VDD VSS VDD VDD pfet_06v0 L=2U W=18U AS=7.92P AD=7.92P PS=36.88U PD=36.88U
M$328 VDD VSS VDD VDD pfet_06v0 L=2U W=18U AS=7.92P AD=7.92P PS=36.88U PD=36.88U
M$329 VDD VSS VDD VDD pfet_06v0 L=2U W=9.75U AS=4.29P AD=4.29P PS=20.38U
+ PD=20.38U
M$330 \$4916 S3P \$4947 VDD pfet_06v0 L=1U W=0.55U AS=0.242P AD=0.242P PS=1.98U
+ PD=1.98U
M$331 \$4838 S3N \$4947 VDD pfet_06v0 L=1U W=0.5U AS=0.22P AD=0.22P PS=1.88U
+ PD=1.88U
M$332 \$4837 \$4948 VDD VDD pfet_06v0 L=1U W=5U AS=2.2P AD=2.2P PS=10.88U
+ PD=10.88U
M$333 \$7270 \$18 \$7350 VDD pfet_06v0 L=1U W=10U AS=4.4P AD=2.6P PS=20.88U
+ PD=10.52U
M$334 \$7350 \$18 \$7270 VDD pfet_06v0 L=1U W=10U AS=2.6P AD=4.4P PS=10.52U
+ PD=20.88U
M$335 \$4836 \$4948 VDD VDD pfet_06v0 L=1U W=5U AS=2.2P AD=2.2P PS=10.88U
+ PD=10.88U
M$336 \$7268 \$34 \$7350 VDD pfet_06v0 L=1U W=10U AS=4.4P AD=2.6P PS=20.88U
+ PD=10.52U
M$337 \$7350 \$34 \$7268 VDD pfet_06v0 L=1U W=10U AS=2.6P AD=4.4P PS=10.52U
+ PD=20.88U
M$338 \$4875 \$4840 \$4948 VDD pfet_06v0 L=1U W=4U AS=1.76P AD=1.76P PS=8.88U
+ PD=8.88U
M$339 \$4839 \$4840 \$4934 VDD pfet_06v0 L=1U W=4U AS=1.76P AD=1.76P PS=8.88U
+ PD=8.88U
M$340 \$4842 \$4934 VDD VDD pfet_06v0 L=1U W=1U AS=0.44P AD=0.44P PS=2.88U
+ PD=2.88U
M$341 \$4842 \$4934 VDD VDD pfet_06v0 L=1U W=1U AS=0.44P AD=0.44P PS=2.88U
+ PD=2.88U
M$342 \$4842 \$4934 VDD VDD pfet_06v0 L=1U W=1U AS=0.44P AD=0.44P PS=2.88U
+ PD=2.88U
M$343 \$4842 \$4934 VDD VDD pfet_06v0 L=1U W=1U AS=0.44P AD=0.44P PS=2.88U
+ PD=2.88U
M$344 \$4931 \$4931 VDD VDD pfet_06v0 L=1U W=2U AS=0.88P AD=0.88P PS=4.88U
+ PD=4.88U
M$345 \$7272 \$7250 VDD VDD pfet_06v0 L=1U W=10U AS=4.4P AD=2.6P PS=20.88U
+ PD=10.52U
M$346 VDD \$7250 \$7272 VDD pfet_06v0 L=1U W=10U AS=2.6P AD=2.6P PS=10.52U
+ PD=10.52U
M$347 \$7272 \$7250 VDD VDD pfet_06v0 L=1U W=10U AS=2.6P AD=4.4P PS=10.52U
+ PD=20.88U
M$348 VDD VSS VDD VDD pfet_06v0 L=2U W=9.75U AS=4.29P AD=4.29P PS=20.38U
+ PD=20.38U
M$349 VDD VSS VDD VDD pfet_06v0 L=2U W=9.75U AS=4.29P AD=4.29P PS=20.38U
+ PD=20.38U
M$350 \$4919 S3P \$4949 VDD pfet_06v0 L=1U W=0.55U AS=0.242P AD=0.242P PS=1.98U
+ PD=1.98U
M$351 \$4846 S3N \$4949 VDD pfet_06v0 L=1U W=0.5U AS=0.22P AD=0.22P PS=1.88U
+ PD=1.88U
M$352 \$4845 \$4950 VDD VDD pfet_06v0 L=1U W=5U AS=2.2P AD=2.2P PS=10.88U
+ PD=10.88U
M$353 \$4844 \$4950 VDD VDD pfet_06v0 L=1U W=5U AS=2.2P AD=2.2P PS=10.88U
+ PD=10.88U
M$354 \$7279 \$26 \$7351 VDD pfet_06v0 L=1U W=10U AS=4.4P AD=2.6P PS=20.88U
+ PD=10.52U
M$355 \$7351 \$26 \$7279 VDD pfet_06v0 L=1U W=10U AS=2.6P AD=4.4P PS=10.52U
+ PD=20.88U
M$356 \$4877 \$4848 \$4950 VDD pfet_06v0 L=1U W=4U AS=1.76P AD=1.76P PS=8.88U
+ PD=8.88U
M$357 \$7277 \$34 \$7351 VDD pfet_06v0 L=1U W=10U AS=4.4P AD=2.6P PS=20.88U
+ PD=10.52U
M$358 \$7351 \$34 \$7277 VDD pfet_06v0 L=1U W=10U AS=2.6P AD=4.4P PS=10.52U
+ PD=20.88U
M$359 \$4847 \$4848 \$4938 VDD pfet_06v0 L=1U W=4U AS=1.76P AD=1.76P PS=8.88U
+ PD=8.88U
M$360 \$4850 \$4938 VDD VDD pfet_06v0 L=1U W=1U AS=0.44P AD=0.44P PS=2.88U
+ PD=2.88U
M$361 \$4850 \$4938 VDD VDD pfet_06v0 L=1U W=1U AS=0.44P AD=0.44P PS=2.88U
+ PD=2.88U
M$362 \$4850 \$4938 VDD VDD pfet_06v0 L=1U W=1U AS=0.44P AD=0.44P PS=2.88U
+ PD=2.88U
M$363 \$4850 \$4938 VDD VDD pfet_06v0 L=1U W=1U AS=0.44P AD=0.44P PS=2.88U
+ PD=2.88U
M$364 \$4935 \$4935 VDD VDD pfet_06v0 L=1U W=2U AS=0.88P AD=0.88P PS=4.88U
+ PD=4.88U
M$365 \$7292 \$7254 VDD VDD pfet_06v0 L=1U W=10U AS=4.4P AD=2.6P PS=20.88U
+ PD=10.52U
M$366 VDD \$7254 \$7292 VDD pfet_06v0 L=1U W=10U AS=2.6P AD=2.6P PS=10.52U
+ PD=10.52U
M$367 \$7292 \$7254 VDD VDD pfet_06v0 L=1U W=10U AS=2.6P AD=4.4P PS=10.52U
+ PD=20.88U
M$368 VDD VSS VDD VDD pfet_06v0 L=2U W=9.75U AS=4.29P AD=4.29P PS=20.38U
+ PD=20.38U
M$369 VDD VSS VDD VDD pfet_06v0 L=2U W=9.75U AS=4.29P AD=4.29P PS=20.38U
+ PD=20.38U
M$370 \$4923 S4P \$4951 VDD pfet_06v0 L=1U W=0.55U AS=0.242P AD=0.242P PS=1.98U
+ PD=1.98U
M$371 \$4854 S4N \$4951 VDD pfet_06v0 L=1U W=0.5U AS=0.22P AD=0.22P PS=1.88U
+ PD=1.88U
M$372 \$4853 \$4952 VDD VDD pfet_06v0 L=1U W=5U AS=2.2P AD=2.2P PS=10.88U
+ PD=10.88U
M$373 \$4852 \$4952 VDD VDD pfet_06v0 L=1U W=5U AS=2.2P AD=2.2P PS=10.88U
+ PD=10.88U
M$374 \$4879 \$4856 \$4952 VDD pfet_06v0 L=1U W=4U AS=1.76P AD=1.76P PS=8.88U
+ PD=8.88U
M$375 \$7287 \$26 \$7352 VDD pfet_06v0 L=1U W=10U AS=4.4P AD=2.6P PS=20.88U
+ PD=10.52U
M$376 \$7352 \$26 \$7287 VDD pfet_06v0 L=1U W=10U AS=2.6P AD=4.4P PS=10.52U
+ PD=20.88U
M$377 \$4855 \$4856 \$4942 VDD pfet_06v0 L=1U W=4U AS=1.76P AD=1.76P PS=8.88U
+ PD=8.88U
M$378 \$7285 \$18 \$7352 VDD pfet_06v0 L=1U W=10U AS=4.4P AD=2.6P PS=20.88U
+ PD=10.52U
M$379 \$7352 \$18 \$7285 VDD pfet_06v0 L=1U W=10U AS=2.6P AD=4.4P PS=10.52U
+ PD=20.88U
M$380 \$4858 \$4942 VDD VDD pfet_06v0 L=1U W=1U AS=0.44P AD=0.44P PS=2.88U
+ PD=2.88U
M$381 \$4858 \$4942 VDD VDD pfet_06v0 L=1U W=1U AS=0.44P AD=0.44P PS=2.88U
+ PD=2.88U
M$382 \$4858 \$4942 VDD VDD pfet_06v0 L=1U W=1U AS=0.44P AD=0.44P PS=2.88U
+ PD=2.88U
M$383 \$4858 \$4942 VDD VDD pfet_06v0 L=1U W=1U AS=0.44P AD=0.44P PS=2.88U
+ PD=2.88U
M$384 \$4939 \$4939 VDD VDD pfet_06v0 L=1U W=2U AS=0.88P AD=0.88P PS=4.88U
+ PD=4.88U
M$385 \$7289 \$7258 VDD VDD pfet_06v0 L=1U W=10U AS=4.4P AD=2.6P PS=20.88U
+ PD=10.52U
M$386 VDD \$7258 \$7289 VDD pfet_06v0 L=1U W=10U AS=2.6P AD=2.6P PS=10.52U
+ PD=10.52U
M$387 \$7289 \$7258 VDD VDD pfet_06v0 L=1U W=10U AS=2.6P AD=4.4P PS=10.52U
+ PD=20.88U
M$388 VDD VSS VDD VDD pfet_06v0 L=2U W=9.75U AS=4.29P AD=4.29P PS=20.38U
+ PD=20.38U
M$389 VDD VSS VDD VDD pfet_06v0 L=2U W=9.75U AS=4.29P AD=4.29P PS=20.38U
+ PD=20.38U
M$390 \$4927 S2P \$4953 VDD pfet_06v0 L=1U W=0.55U AS=0.242P AD=0.242P PS=1.98U
+ PD=1.98U
M$391 \$4862 S2N \$4953 VDD pfet_06v0 L=1U W=0.5U AS=0.22P AD=0.22P PS=1.88U
+ PD=1.88U
M$392 \$4861 \$4954 VDD VDD pfet_06v0 L=1U W=5U AS=2.2P AD=2.2P PS=10.88U
+ PD=10.88U
M$393 \$4860 \$4954 VDD VDD pfet_06v0 L=1U W=5U AS=2.2P AD=2.2P PS=10.88U
+ PD=10.88U
M$394 \$4881 \$4864 \$4954 VDD pfet_06v0 L=1U W=4U AS=1.76P AD=1.76P PS=8.88U
+ PD=8.88U
M$395 \$4863 \$4864 \$4946 VDD pfet_06v0 L=1U W=4U AS=1.76P AD=1.76P PS=8.88U
+ PD=8.88U
M$396 \$4866 \$4946 VDD VDD pfet_06v0 L=1U W=1U AS=0.44P AD=0.44P PS=2.88U
+ PD=2.88U
M$397 VDD VSS VDD VDD pfet_06v0 L=2U W=1U AS=0.44P AD=0.44P PS=2.88U PD=2.88U
M$398 \$4866 \$4946 VDD VDD pfet_06v0 L=1U W=1U AS=0.44P AD=0.44P PS=2.88U
+ PD=2.88U
M$399 VDD VSS VDD VDD pfet_06v0 L=2U W=1U AS=0.44P AD=0.44P PS=2.88U PD=2.88U
M$400 \$4866 \$4946 VDD VDD pfet_06v0 L=1U W=1U AS=0.44P AD=0.44P PS=2.88U
+ PD=2.88U
M$401 \$4866 \$4946 VDD VDD pfet_06v0 L=1U W=1U AS=0.44P AD=0.44P PS=2.88U
+ PD=2.88U
M$402 \$7262 \$7272 VDD VDD pfet_06v0 L=1U W=3U AS=1.32P AD=1.32P PS=6.88U
+ PD=6.88U
M$403 \$7308 \$7291 VDD VDD pfet_06v0 L=1U W=3U AS=1.32P AD=1.32P PS=6.88U
+ PD=6.88U
M$404 \$7291 \$7289 VDD VDD pfet_06v0 L=1U W=3U AS=1.32P AD=0.99P PS=6.88U
+ PD=3.66U
M$405 VDD \$7262 \$7291 VDD pfet_06v0 L=1U W=3U AS=0.99P AD=1.32P PS=3.66U
+ PD=6.88U
M$406 \$4943 \$4943 VDD VDD pfet_06v0 L=1U W=2U AS=0.88P AD=0.88P PS=4.88U
+ PD=4.88U
M$407 \$7353 \$7289 \$7290 VDD pfet_06v0 L=1U W=3U AS=1.32P AD=0.75P PS=6.88U
+ PD=3.5U
M$408 VDD \$7292 \$7353 VDD pfet_06v0 L=1U W=3U AS=0.75P AD=1.32P PS=3.5U
+ PD=6.88U
M$409 \$7263 \$7293 VDD VDD pfet_06v0 L=1U W=3U AS=1.32P AD=1.32P PS=6.88U
+ PD=6.88U
M$410 \$7293 \$7272 VDD VDD pfet_06v0 L=1U W=3U AS=1.32P AD=0.99P PS=6.88U
+ PD=3.66U
M$411 VDD \$7292 \$7293 VDD pfet_06v0 L=1U W=3U AS=0.99P AD=1.32P PS=3.66U
+ PD=6.88U
M$412 VDD VSS VDD VDD pfet_06v0 L=2U W=1U AS=0.44P AD=0.44P PS=2.88U PD=2.88U
M$413 \$9024 \$7883 VDD VDD pfet_06v0 L=1U W=10U AS=4.4P AD=2.5P PS=20.88U
+ PD=10.5U
M$414 \$7264 \$7962 \$9024 VDD pfet_06v0 L=1U W=10U AS=2.5P AD=4.4P PS=10.5U
+ PD=20.88U
M$415 \$9025 \$7883 VDD VDD pfet_06v0 L=1U W=10U AS=4.4P AD=2.5P PS=20.88U
+ PD=10.5U
M$416 \$7249 \$7962 \$9025 VDD pfet_06v0 L=1U W=10U AS=2.5P AD=4.4P PS=10.5U
+ PD=20.88U
M$417 \$9026 \$7883 VDD VDD pfet_06v0 L=1U W=10U AS=4.4P AD=2.5P PS=20.88U
+ PD=10.5U
M$418 \$7883 \$7962 \$9026 VDD pfet_06v0 L=1U W=10U AS=2.5P AD=4.4P PS=10.5U
+ PD=20.88U
M$419 \$9027 \$7883 VDD VDD pfet_06v0 L=1U W=10U AS=4.4P AD=2.5P PS=20.88U
+ PD=10.5U
M$420 \$7350 \$7962 \$9027 VDD pfet_06v0 L=1U W=10U AS=2.5P AD=3.3P PS=10.5U
+ PD=10.66U
M$421 \$9028 \$7962 \$7350 VDD pfet_06v0 L=1U W=10U AS=3.3P AD=2.5P PS=10.66U
+ PD=10.5U
M$422 VDD \$7883 \$9028 VDD pfet_06v0 L=1U W=10U AS=2.5P AD=4.4P PS=10.5U
+ PD=20.88U
M$423 \$9029 \$7338 VDD VDD pfet_06v0 L=1U W=10U AS=4.4P AD=2.5P PS=20.88U
+ PD=10.5U
M$424 \$7338 \$7962 \$9029 VDD pfet_06v0 L=1U W=10U AS=2.5P AD=3.3P PS=10.5U
+ PD=10.66U
M$425 \$7251 \$7251 \$7338 VDD pfet_06v0 L=1U W=10U AS=3.3P AD=4.4P PS=10.66U
+ PD=20.88U
M$426 \$9030 \$7883 VDD VDD pfet_06v0 L=1U W=10U AS=4.4P AD=2.5P PS=20.88U
+ PD=10.5U
M$427 \$7302 \$7962 \$9030 VDD pfet_06v0 L=1U W=10U AS=2.5P AD=4.4P PS=10.5U
+ PD=20.88U
M$428 \$9031 \$7884 VDD VDD pfet_06v0 L=1U W=10U AS=4.4P AD=2.5P PS=20.88U
+ PD=10.5U
M$429 \$7273 \$7964 \$9031 VDD pfet_06v0 L=1U W=10U AS=2.5P AD=4.4P PS=10.5U
+ PD=20.88U
M$430 \$9032 \$7884 VDD VDD pfet_06v0 L=1U W=10U AS=4.4P AD=2.5P PS=20.88U
+ PD=10.5U
M$431 \$7253 \$7964 \$9032 VDD pfet_06v0 L=1U W=10U AS=2.5P AD=4.4P PS=10.5U
+ PD=20.88U
M$432 \$9033 \$7884 VDD VDD pfet_06v0 L=1U W=10U AS=4.4P AD=2.5P PS=20.88U
+ PD=10.5U
M$433 \$7884 \$7964 \$9033 VDD pfet_06v0 L=1U W=10U AS=2.5P AD=4.4P PS=10.5U
+ PD=20.88U
M$434 \$9034 \$7884 VDD VDD pfet_06v0 L=1U W=10U AS=4.4P AD=2.5P PS=20.88U
+ PD=10.5U
M$435 \$7351 \$7964 \$9034 VDD pfet_06v0 L=1U W=10U AS=2.5P AD=3.3P PS=10.5U
+ PD=10.66U
M$436 \$9035 \$7964 \$7351 VDD pfet_06v0 L=1U W=10U AS=3.3P AD=2.5P PS=10.66U
+ PD=10.5U
M$437 VDD \$7884 \$9035 VDD pfet_06v0 L=1U W=10U AS=2.5P AD=4.4P PS=10.5U
+ PD=20.88U
M$438 \$9036 \$7341 VDD VDD pfet_06v0 L=1U W=10U AS=4.4P AD=2.5P PS=20.88U
+ PD=10.5U
M$439 \$7341 \$7964 \$9036 VDD pfet_06v0 L=1U W=10U AS=2.5P AD=3.3P PS=10.5U
+ PD=10.66U
M$440 \$7255 \$7255 \$7341 VDD pfet_06v0 L=1U W=10U AS=3.3P AD=4.4P PS=10.66U
+ PD=20.88U
M$441 \$9037 \$7884 VDD VDD pfet_06v0 L=1U W=10U AS=4.4P AD=2.5P PS=20.88U
+ PD=10.5U
M$442 \$7303 \$7964 \$9037 VDD pfet_06v0 L=1U W=10U AS=2.5P AD=4.4P PS=10.5U
+ PD=20.88U
M$443 \$9038 \$7885 VDD VDD pfet_06v0 L=1U W=10U AS=4.4P AD=2.5P PS=20.88U
+ PD=10.5U
M$444 \$7281 \$7966 \$9038 VDD pfet_06v0 L=1U W=10U AS=2.5P AD=4.4P PS=10.5U
+ PD=20.88U
M$445 \$9039 \$7885 VDD VDD pfet_06v0 L=1U W=10U AS=4.4P AD=2.5P PS=20.88U
+ PD=10.5U
M$446 \$7257 \$7966 \$9039 VDD pfet_06v0 L=1U W=10U AS=2.5P AD=4.4P PS=10.5U
+ PD=20.88U
M$447 \$9040 \$7885 VDD VDD pfet_06v0 L=1U W=10U AS=4.4P AD=2.5P PS=20.88U
+ PD=10.5U
M$448 \$7885 \$7966 \$9040 VDD pfet_06v0 L=1U W=10U AS=2.5P AD=4.4P PS=10.5U
+ PD=20.88U
M$449 \$9041 \$7885 VDD VDD pfet_06v0 L=1U W=10U AS=4.4P AD=2.5P PS=20.88U
+ PD=10.5U
M$450 \$7352 \$7966 \$9041 VDD pfet_06v0 L=1U W=10U AS=2.5P AD=3.3P PS=10.5U
+ PD=10.66U
M$451 \$9042 \$7966 \$7352 VDD pfet_06v0 L=1U W=10U AS=3.3P AD=2.5P PS=10.66U
+ PD=10.5U
M$452 VDD \$7885 \$9042 VDD pfet_06v0 L=1U W=10U AS=2.5P AD=4.4P PS=10.5U
+ PD=20.88U
M$453 \$9044 \$7344 VDD VDD pfet_06v0 L=1U W=10U AS=4.4P AD=2.5P PS=20.88U
+ PD=10.5U
M$454 \$7344 \$7966 \$9044 VDD pfet_06v0 L=1U W=10U AS=2.5P AD=3.3P PS=10.5U
+ PD=10.66U
M$455 \$7259 \$7259 \$7344 VDD pfet_06v0 L=1U W=10U AS=3.3P AD=4.4P PS=10.66U
+ PD=20.88U
M$456 \$9043 \$7885 VDD VDD pfet_06v0 L=1U W=10U AS=4.4P AD=2.5P PS=20.88U
+ PD=10.5U
M$457 \$7304 \$7966 \$9043 VDD pfet_06v0 L=1U W=10U AS=2.5P AD=4.4P PS=10.5U
+ PD=20.88U
M$458 VDD VSS VDD VDD pfet_06v0 L=2U W=9.75U AS=4.29P AD=4.29P PS=20.38U
+ PD=20.38U
M$459 \$7962 \$7962 VDD VDD pfet_06v0 L=1U W=2U AS=0.88P AD=0.88P PS=4.88U
+ PD=4.88U
M$460 \$7429 \$7962 \$7267 VDD pfet_06v0 L=1U W=5U AS=2.2P AD=1.3P PS=10.88U
+ PD=5.52U
M$461 \$7267 \$7962 \$7429 VDD pfet_06v0 L=1U W=5U AS=1.3P AD=2.2P PS=5.52U
+ PD=10.88U
M$462 \$7250 \$7962 \$7266 VDD pfet_06v0 L=1U W=5U AS=2.2P AD=1.3P PS=10.88U
+ PD=5.52U
M$463 \$7266 \$7962 \$7250 VDD pfet_06v0 L=1U W=5U AS=1.3P AD=2.2P PS=5.52U
+ PD=10.88U
M$464 \$7267 \$7429 VDD VDD pfet_06v0 L=1U W=5U AS=2.2P AD=1.3P PS=10.88U
+ PD=5.52U
M$465 VDD \$7429 \$7267 VDD pfet_06v0 L=1U W=5U AS=1.3P AD=1.3P PS=5.52U
+ PD=5.52U
M$466 \$7267 \$7429 VDD VDD pfet_06v0 L=1U W=5U AS=1.3P AD=1.3P PS=5.52U
+ PD=5.52U
M$467 VDD \$7429 \$7267 VDD pfet_06v0 L=1U W=5U AS=1.3P AD=2.2P PS=5.52U
+ PD=10.88U
M$468 \$7266 \$7429 VDD VDD pfet_06v0 L=1U W=5U AS=2.2P AD=1.3P PS=10.88U
+ PD=5.52U
M$469 VDD \$7429 \$7266 VDD pfet_06v0 L=1U W=5U AS=1.3P AD=1.3P PS=5.52U
+ PD=5.52U
M$470 \$7266 \$7429 VDD VDD pfet_06v0 L=1U W=5U AS=1.3P AD=1.3P PS=5.52U
+ PD=5.52U
M$471 VDD \$7429 \$7266 VDD pfet_06v0 L=1U W=5U AS=1.3P AD=2.2P PS=5.52U
+ PD=10.88U
M$472 \$7269 \$7251 \$7429 VDD pfet_06v0 L=1U W=5U AS=2.2P AD=2.2P PS=10.88U
+ PD=10.88U
M$473 \$7271 \$7251 \$7250 VDD pfet_06v0 L=1U W=5U AS=2.2P AD=2.2P PS=10.88U
+ PD=10.88U
M$474 VDD VSS VDD VDD pfet_06v0 L=2U W=9.75U AS=4.29P AD=4.29P PS=20.38U
+ PD=20.38U
M$475 VDD VSS VDD VDD pfet_06v0 L=2U W=9.75U AS=4.29P AD=4.29P PS=20.38U
+ PD=20.38U
M$476 \$7964 \$7964 VDD VDD pfet_06v0 L=1U W=2U AS=0.88P AD=0.88P PS=4.88U
+ PD=4.88U
M$477 \$7430 \$7964 \$7276 VDD pfet_06v0 L=1U W=5U AS=2.2P AD=1.3P PS=10.88U
+ PD=5.52U
M$478 \$7276 \$7964 \$7430 VDD pfet_06v0 L=1U W=5U AS=1.3P AD=2.2P PS=5.52U
+ PD=10.88U
M$479 \$7254 \$7964 \$7275 VDD pfet_06v0 L=1U W=5U AS=2.2P AD=1.3P PS=10.88U
+ PD=5.52U
M$480 \$7275 \$7964 \$7254 VDD pfet_06v0 L=1U W=5U AS=1.3P AD=2.2P PS=5.52U
+ PD=10.88U
M$481 \$7276 \$7430 VDD VDD pfet_06v0 L=1U W=5U AS=2.2P AD=1.3P PS=10.88U
+ PD=5.52U
M$482 VDD \$7430 \$7276 VDD pfet_06v0 L=1U W=5U AS=1.3P AD=1.3P PS=5.52U
+ PD=5.52U
M$483 \$7276 \$7430 VDD VDD pfet_06v0 L=1U W=5U AS=1.3P AD=1.3P PS=5.52U
+ PD=5.52U
M$484 VDD \$7430 \$7276 VDD pfet_06v0 L=1U W=5U AS=1.3P AD=2.2P PS=5.52U
+ PD=10.88U
M$485 \$7275 \$7430 VDD VDD pfet_06v0 L=1U W=5U AS=2.2P AD=1.3P PS=10.88U
+ PD=5.52U
M$486 VDD \$7430 \$7275 VDD pfet_06v0 L=1U W=5U AS=1.3P AD=1.3P PS=5.52U
+ PD=5.52U
M$487 \$7275 \$7430 VDD VDD pfet_06v0 L=1U W=5U AS=1.3P AD=1.3P PS=5.52U
+ PD=5.52U
M$488 VDD \$7430 \$7275 VDD pfet_06v0 L=1U W=5U AS=1.3P AD=2.2P PS=5.52U
+ PD=10.88U
M$489 \$7278 \$7255 \$7430 VDD pfet_06v0 L=1U W=5U AS=2.2P AD=2.2P PS=10.88U
+ PD=10.88U
M$490 \$7280 \$7255 \$7254 VDD pfet_06v0 L=1U W=5U AS=2.2P AD=2.2P PS=10.88U
+ PD=10.88U
M$491 VDD VSS VDD VDD pfet_06v0 L=2U W=9.75U AS=4.29P AD=4.29P PS=20.38U
+ PD=20.38U
M$492 VDD VSS VDD VDD pfet_06v0 L=2U W=9.75U AS=4.29P AD=4.29P PS=20.38U
+ PD=20.38U
M$493 \$7966 \$7966 VDD VDD pfet_06v0 L=1U W=2U AS=0.88P AD=0.88P PS=4.88U
+ PD=4.88U
M$494 \$7431 \$7966 \$7284 VDD pfet_06v0 L=1U W=5U AS=2.2P AD=1.3P PS=10.88U
+ PD=5.52U
M$495 \$7284 \$7966 \$7431 VDD pfet_06v0 L=1U W=5U AS=1.3P AD=2.2P PS=5.52U
+ PD=10.88U
M$496 \$7258 \$7966 \$7283 VDD pfet_06v0 L=1U W=5U AS=2.2P AD=1.3P PS=10.88U
+ PD=5.52U
M$497 \$7283 \$7966 \$7258 VDD pfet_06v0 L=1U W=5U AS=1.3P AD=2.2P PS=5.52U
+ PD=10.88U
M$498 \$7284 \$7431 VDD VDD pfet_06v0 L=1U W=5U AS=2.2P AD=1.3P PS=10.88U
+ PD=5.52U
M$499 VDD \$7431 \$7284 VDD pfet_06v0 L=1U W=5U AS=1.3P AD=1.3P PS=5.52U
+ PD=5.52U
M$500 \$7284 \$7431 VDD VDD pfet_06v0 L=1U W=5U AS=1.3P AD=1.3P PS=5.52U
+ PD=5.52U
M$501 VDD \$7431 \$7284 VDD pfet_06v0 L=1U W=5U AS=1.3P AD=2.2P PS=5.52U
+ PD=10.88U
M$502 \$7283 \$7431 VDD VDD pfet_06v0 L=1U W=5U AS=2.2P AD=1.3P PS=10.88U
+ PD=5.52U
M$503 VDD \$7431 \$7283 VDD pfet_06v0 L=1U W=5U AS=1.3P AD=1.3P PS=5.52U
+ PD=5.52U
M$504 \$7283 \$7431 VDD VDD pfet_06v0 L=1U W=5U AS=1.3P AD=1.3P PS=5.52U
+ PD=5.52U
M$505 VDD \$7431 \$7283 VDD pfet_06v0 L=1U W=5U AS=1.3P AD=2.2P PS=5.52U
+ PD=10.88U
M$506 \$7286 \$7259 \$7431 VDD pfet_06v0 L=1U W=5U AS=2.2P AD=2.2P PS=10.88U
+ PD=10.88U
M$507 \$7288 \$7259 \$7258 VDD pfet_06v0 L=1U W=5U AS=2.2P AD=2.2P PS=10.88U
+ PD=10.88U
M$508 VDD VSS VDD VDD pfet_06v0 L=2U W=9.75U AS=4.29P AD=4.29P PS=20.38U
+ PD=20.38U
M$509 VDD VSS VDD VDD pfet_06v0 L=2U W=9.75U AS=4.29P AD=4.29P PS=20.38U
+ PD=20.38U
M$510 X X VDD VDD pfet_06v0 L=1U W=2U AS=0.88P AD=0.52P PS=4.88U PD=2.52U
M$511 VDD X X VDD pfet_06v0 L=1U W=2U AS=0.52P AD=0.52P PS=2.52U PD=2.52U
M$512 X X VDD VDD pfet_06v0 L=1U W=2U AS=0.52P AD=0.52P PS=2.52U PD=2.52U
M$513 VDD X X VDD pfet_06v0 L=1U W=2U AS=0.52P AD=0.52P PS=2.52U PD=2.52U
M$514 X X VDD VDD pfet_06v0 L=1U W=2U AS=0.52P AD=0.52P PS=2.52U PD=2.52U
M$515 VDD X X VDD pfet_06v0 L=1U W=2U AS=0.52P AD=0.88P PS=2.52U PD=4.88U
M$516 \$7245 \$7245 VDD VDD pfet_06v0 L=1U W=2U AS=0.88P AD=0.88P PS=4.88U
+ PD=4.88U
M$517 VDD VSS VDD VDD pfet_06v0 L=2U W=1U AS=0.44P AD=0.44P PS=2.88U PD=2.88U
M$518 VDD VSS VDD VDD pfet_06v0 L=2U W=1U AS=0.44P AD=0.44P PS=2.88U PD=2.88U
M$519 \$9066 \$9075 VDD VDD pfet_06v0 L=1U W=3U AS=1.32P AD=1.32P PS=6.88U
+ PD=6.88U
M$520 \$9108 \$9094 VDD VDD pfet_06v0 L=1U W=3U AS=1.32P AD=1.32P PS=6.88U
+ PD=6.88U
M$521 \$9094 \$9092 VDD VDD pfet_06v0 L=1U W=3U AS=1.32P AD=0.99P PS=6.88U
+ PD=3.66U
M$522 VDD \$9066 \$9094 VDD pfet_06v0 L=1U W=3U AS=0.99P AD=1.32P PS=3.66U
+ PD=6.88U
M$523 \$9233 \$9092 \$9093 VDD pfet_06v0 L=1U W=3U AS=1.32P AD=0.75P PS=6.88U
+ PD=3.5U
M$524 VDD \$9095 \$9233 VDD pfet_06v0 L=1U W=3U AS=0.75P AD=1.32P PS=3.5U
+ PD=6.88U
M$525 \$7732 \$9096 VDD VDD pfet_06v0 L=1U W=3U AS=1.32P AD=1.32P PS=6.88U
+ PD=6.88U
M$526 \$9096 \$9075 VDD VDD pfet_06v0 L=1U W=3U AS=1.32P AD=0.99P PS=6.88U
+ PD=3.66U
M$527 VDD \$9095 \$9096 VDD pfet_06v0 L=1U W=3U AS=0.99P AD=1.32P PS=3.66U
+ PD=6.88U
M$528 VDD VSS VDD VDD pfet_06v0 L=2U W=1U AS=0.44P AD=0.44P PS=2.88U PD=2.88U
M$529 \$9073 \$42 \$9151 VDD pfet_06v0 L=1U W=10U AS=4.4P AD=2.6P PS=20.88U
+ PD=10.52U
M$530 \$9151 \$42 \$9073 VDD pfet_06v0 L=1U W=10U AS=2.6P AD=4.4P PS=10.52U
+ PD=20.88U
M$531 \$9071 \$2439 \$9151 VDD pfet_06v0 L=1U W=10U AS=4.4P AD=2.6P PS=20.88U
+ PD=10.52U
M$532 \$9151 \$2439 \$9071 VDD pfet_06v0 L=1U W=10U AS=2.6P AD=4.4P PS=10.52U
+ PD=20.88U
M$533 \$9075 \$9055 VDD VDD pfet_06v0 L=1U W=10U AS=4.4P AD=2.6P PS=20.88U
+ PD=10.52U
M$534 VDD \$9055 \$9075 VDD pfet_06v0 L=1U W=10U AS=2.6P AD=2.6P PS=10.52U
+ PD=10.52U
M$535 \$9075 \$9055 VDD VDD pfet_06v0 L=1U W=10U AS=2.6P AD=4.4P PS=10.52U
+ PD=20.88U
M$536 \$9082 \$2431 \$9152 VDD pfet_06v0 L=1U W=10U AS=4.4P AD=2.6P PS=20.88U
+ PD=10.52U
M$537 \$9152 \$2431 \$9082 VDD pfet_06v0 L=1U W=10U AS=2.6P AD=4.4P PS=10.52U
+ PD=20.88U
M$538 \$9080 \$2439 \$9152 VDD pfet_06v0 L=1U W=10U AS=4.4P AD=2.6P PS=20.88U
+ PD=10.52U
M$539 \$9152 \$2439 \$9080 VDD pfet_06v0 L=1U W=10U AS=2.6P AD=4.4P PS=10.52U
+ PD=20.88U
M$540 \$9095 \$9059 VDD VDD pfet_06v0 L=1U W=10U AS=4.4P AD=2.6P PS=20.88U
+ PD=10.52U
M$541 VDD \$9059 \$9095 VDD pfet_06v0 L=1U W=10U AS=2.6P AD=2.6P PS=10.52U
+ PD=10.52U
M$542 \$9095 \$9059 VDD VDD pfet_06v0 L=1U W=10U AS=2.6P AD=4.4P PS=10.52U
+ PD=20.88U
M$543 \$9090 \$2431 \$9153 VDD pfet_06v0 L=1U W=10U AS=4.4P AD=2.6P PS=20.88U
+ PD=10.52U
M$544 \$9153 \$2431 \$9090 VDD pfet_06v0 L=1U W=10U AS=2.6P AD=4.4P PS=10.52U
+ PD=20.88U
M$545 \$9088 \$42 \$9153 VDD pfet_06v0 L=1U W=10U AS=4.4P AD=2.6P PS=20.88U
+ PD=10.52U
M$546 \$9153 \$42 \$9088 VDD pfet_06v0 L=1U W=10U AS=2.6P AD=4.4P PS=10.52U
+ PD=20.88U
M$547 \$9092 \$9063 VDD VDD pfet_06v0 L=1U W=10U AS=4.4P AD=2.6P PS=20.88U
+ PD=10.52U
M$548 VDD \$9063 \$9092 VDD pfet_06v0 L=1U W=10U AS=2.6P AD=2.6P PS=10.52U
+ PD=10.52U
M$549 \$9092 \$9063 VDD VDD pfet_06v0 L=1U W=10U AS=2.6P AD=4.4P PS=10.52U
+ PD=20.88U
M$550 \$10823 \$9609 VDD VDD pfet_06v0 L=1U W=10U AS=4.4P AD=2.5P PS=20.88U
+ PD=10.5U
M$551 \$9067 \$9763 \$10823 VDD pfet_06v0 L=1U W=10U AS=2.5P AD=4.4P PS=10.5U
+ PD=20.88U
M$552 \$10824 \$9609 VDD VDD pfet_06v0 L=1U W=10U AS=4.4P AD=2.5P PS=20.88U
+ PD=10.5U
M$553 \$9054 \$9763 \$10824 VDD pfet_06v0 L=1U W=10U AS=2.5P AD=4.4P PS=10.5U
+ PD=20.88U
M$554 \$10825 \$9609 VDD VDD pfet_06v0 L=1U W=10U AS=4.4P AD=2.5P PS=20.88U
+ PD=10.5U
M$555 \$9609 \$9763 \$10825 VDD pfet_06v0 L=1U W=10U AS=2.5P AD=4.4P PS=10.5U
+ PD=20.88U
M$556 \$10826 \$9609 VDD VDD pfet_06v0 L=1U W=10U AS=4.4P AD=2.5P PS=20.88U
+ PD=10.5U
M$557 \$9151 \$9763 \$10826 VDD pfet_06v0 L=1U W=10U AS=2.5P AD=3.3P PS=10.5U
+ PD=10.66U
M$558 \$10827 \$9763 \$9151 VDD pfet_06v0 L=1U W=10U AS=3.3P AD=2.5P PS=10.66U
+ PD=10.5U
M$559 VDD \$9609 \$10827 VDD pfet_06v0 L=1U W=10U AS=2.5P AD=4.4P PS=10.5U
+ PD=20.88U
M$560 \$10830 \$9138 VDD VDD pfet_06v0 L=1U W=10U AS=4.4P AD=2.5P PS=20.88U
+ PD=10.5U
M$561 \$9138 \$9763 \$10830 VDD pfet_06v0 L=1U W=10U AS=2.5P AD=3.3P PS=10.5U
+ PD=10.66U
M$562 \$9056 \$9056 \$9138 VDD pfet_06v0 L=1U W=10U AS=3.3P AD=4.4P PS=10.66U
+ PD=20.88U
M$563 \$10831 \$9609 VDD VDD pfet_06v0 L=1U W=10U AS=4.4P AD=2.5P PS=20.88U
+ PD=10.5U
M$564 \$9105 \$9763 \$10831 VDD pfet_06v0 L=1U W=10U AS=2.5P AD=4.4P PS=10.5U
+ PD=20.88U
M$565 \$10832 \$9610 VDD VDD pfet_06v0 L=1U W=10U AS=4.4P AD=2.5P PS=20.88U
+ PD=10.5U
M$566 \$9076 \$9765 \$10832 VDD pfet_06v0 L=1U W=10U AS=2.5P AD=4.4P PS=10.5U
+ PD=20.88U
M$567 \$10833 \$9610 VDD VDD pfet_06v0 L=1U W=10U AS=4.4P AD=2.5P PS=20.88U
+ PD=10.5U
M$568 \$9058 \$9765 \$10833 VDD pfet_06v0 L=1U W=10U AS=2.5P AD=4.4P PS=10.5U
+ PD=20.88U
M$569 \$10834 \$9610 VDD VDD pfet_06v0 L=1U W=10U AS=4.4P AD=2.5P PS=20.88U
+ PD=10.5U
M$570 \$9610 \$9765 \$10834 VDD pfet_06v0 L=1U W=10U AS=2.5P AD=4.4P PS=10.5U
+ PD=20.88U
M$571 \$10835 \$9610 VDD VDD pfet_06v0 L=1U W=10U AS=4.4P AD=2.5P PS=20.88U
+ PD=10.5U
M$572 \$9152 \$9765 \$10835 VDD pfet_06v0 L=1U W=10U AS=2.5P AD=3.3P PS=10.5U
+ PD=10.66U
M$573 \$10836 \$9765 \$9152 VDD pfet_06v0 L=1U W=10U AS=3.3P AD=2.5P PS=10.66U
+ PD=10.5U
M$574 VDD \$9610 \$10836 VDD pfet_06v0 L=1U W=10U AS=2.5P AD=4.4P PS=10.5U
+ PD=20.88U
M$575 \$10838 \$9141 VDD VDD pfet_06v0 L=1U W=10U AS=4.4P AD=2.5P PS=20.88U
+ PD=10.5U
M$576 \$9141 \$9765 \$10838 VDD pfet_06v0 L=1U W=10U AS=2.5P AD=3.3P PS=10.5U
+ PD=10.66U
M$577 \$9060 \$9060 \$9141 VDD pfet_06v0 L=1U W=10U AS=3.3P AD=4.4P PS=10.66U
+ PD=20.88U
M$578 \$10840 \$9610 VDD VDD pfet_06v0 L=1U W=10U AS=4.4P AD=2.5P PS=20.88U
+ PD=10.5U
M$579 \$9106 \$9765 \$10840 VDD pfet_06v0 L=1U W=10U AS=2.5P AD=4.4P PS=10.5U
+ PD=20.88U
M$580 \$10842 \$9611 VDD VDD pfet_06v0 L=1U W=10U AS=4.4P AD=2.5P PS=20.88U
+ PD=10.5U
M$581 \$9084 \$9767 \$10842 VDD pfet_06v0 L=1U W=10U AS=2.5P AD=4.4P PS=10.5U
+ PD=20.88U
M$582 \$10843 \$9611 VDD VDD pfet_06v0 L=1U W=10U AS=4.4P AD=2.5P PS=20.88U
+ PD=10.5U
M$583 \$9062 \$9767 \$10843 VDD pfet_06v0 L=1U W=10U AS=2.5P AD=4.4P PS=10.5U
+ PD=20.88U
M$584 \$10841 \$9611 VDD VDD pfet_06v0 L=1U W=10U AS=4.4P AD=2.5P PS=20.88U
+ PD=10.5U
M$585 \$9611 \$9767 \$10841 VDD pfet_06v0 L=1U W=10U AS=2.5P AD=4.4P PS=10.5U
+ PD=20.88U
M$586 \$10839 \$9611 VDD VDD pfet_06v0 L=1U W=10U AS=4.4P AD=2.5P PS=20.88U
+ PD=10.5U
M$587 \$9153 \$9767 \$10839 VDD pfet_06v0 L=1U W=10U AS=2.5P AD=3.3P PS=10.5U
+ PD=10.66U
M$588 \$10837 \$9767 \$9153 VDD pfet_06v0 L=1U W=10U AS=3.3P AD=2.5P PS=10.66U
+ PD=10.5U
M$589 VDD \$9611 \$10837 VDD pfet_06v0 L=1U W=10U AS=2.5P AD=4.4P PS=10.5U
+ PD=20.88U
M$590 \$10829 \$9144 VDD VDD pfet_06v0 L=1U W=10U AS=4.4P AD=2.5P PS=20.88U
+ PD=10.5U
M$591 \$9144 \$9767 \$10829 VDD pfet_06v0 L=1U W=10U AS=2.5P AD=3.3P PS=10.5U
+ PD=10.66U
M$592 \$9064 \$9064 \$9144 VDD pfet_06v0 L=1U W=10U AS=3.3P AD=4.4P PS=10.66U
+ PD=20.88U
M$593 \$10828 \$9611 VDD VDD pfet_06v0 L=1U W=10U AS=4.4P AD=2.5P PS=20.88U
+ PD=10.5U
M$594 \$9107 \$9767 \$10828 VDD pfet_06v0 L=1U W=10U AS=2.5P AD=4.4P PS=10.5U
+ PD=20.88U
M$595 VDD VSS VDD VDD pfet_06v0 L=2U W=9.75U AS=4.29P AD=4.29P PS=20.38U
+ PD=20.38U
M$596 \$9763 \$9763 VDD VDD pfet_06v0 L=1U W=2U AS=0.88P AD=0.88P PS=4.88U
+ PD=4.88U
M$597 \$9230 \$9763 \$9070 VDD pfet_06v0 L=1U W=5U AS=2.2P AD=1.3P PS=10.88U
+ PD=5.52U
M$598 \$9070 \$9763 \$9230 VDD pfet_06v0 L=1U W=5U AS=1.3P AD=2.2P PS=5.52U
+ PD=10.88U
M$599 \$9055 \$9763 \$9069 VDD pfet_06v0 L=1U W=5U AS=2.2P AD=1.3P PS=10.88U
+ PD=5.52U
M$600 \$9069 \$9763 \$9055 VDD pfet_06v0 L=1U W=5U AS=1.3P AD=2.2P PS=5.52U
+ PD=10.88U
M$601 \$9070 \$9230 VDD VDD pfet_06v0 L=1U W=5U AS=2.2P AD=1.3P PS=10.88U
+ PD=5.52U
M$602 VDD \$9230 \$9070 VDD pfet_06v0 L=1U W=5U AS=1.3P AD=1.3P PS=5.52U
+ PD=5.52U
M$603 \$9070 \$9230 VDD VDD pfet_06v0 L=1U W=5U AS=1.3P AD=1.3P PS=5.52U
+ PD=5.52U
M$604 VDD \$9230 \$9070 VDD pfet_06v0 L=1U W=5U AS=1.3P AD=2.2P PS=5.52U
+ PD=10.88U
M$605 \$9069 \$9230 VDD VDD pfet_06v0 L=1U W=5U AS=2.2P AD=1.3P PS=10.88U
+ PD=5.52U
M$606 VDD \$9230 \$9069 VDD pfet_06v0 L=1U W=5U AS=1.3P AD=1.3P PS=5.52U
+ PD=5.52U
M$607 \$9069 \$9230 VDD VDD pfet_06v0 L=1U W=5U AS=1.3P AD=1.3P PS=5.52U
+ PD=5.52U
M$608 VDD \$9230 \$9069 VDD pfet_06v0 L=1U W=5U AS=1.3P AD=2.2P PS=5.52U
+ PD=10.88U
M$609 \$9072 \$9056 \$9230 VDD pfet_06v0 L=1U W=5U AS=2.2P AD=2.2P PS=10.88U
+ PD=10.88U
M$610 \$9074 \$9056 \$9055 VDD pfet_06v0 L=1U W=5U AS=2.2P AD=2.2P PS=10.88U
+ PD=10.88U
M$611 VDD VSS VDD VDD pfet_06v0 L=2U W=9.75U AS=4.29P AD=4.29P PS=20.38U
+ PD=20.38U
M$612 VDD VSS VDD VDD pfet_06v0 L=2U W=9.75U AS=4.29P AD=4.29P PS=20.38U
+ PD=20.38U
M$613 \$9765 \$9765 VDD VDD pfet_06v0 L=1U W=2U AS=0.88P AD=0.88P PS=4.88U
+ PD=4.88U
M$614 \$9231 \$9765 \$9079 VDD pfet_06v0 L=1U W=5U AS=2.2P AD=1.3P PS=10.88U
+ PD=5.52U
M$615 \$9079 \$9765 \$9231 VDD pfet_06v0 L=1U W=5U AS=1.3P AD=2.2P PS=5.52U
+ PD=10.88U
M$616 \$9059 \$9765 \$9078 VDD pfet_06v0 L=1U W=5U AS=2.2P AD=1.3P PS=10.88U
+ PD=5.52U
M$617 \$9078 \$9765 \$9059 VDD pfet_06v0 L=1U W=5U AS=1.3P AD=2.2P PS=5.52U
+ PD=10.88U
M$618 \$9079 \$9231 VDD VDD pfet_06v0 L=1U W=5U AS=2.2P AD=1.3P PS=10.88U
+ PD=5.52U
M$619 VDD \$9231 \$9079 VDD pfet_06v0 L=1U W=5U AS=1.3P AD=1.3P PS=5.52U
+ PD=5.52U
M$620 \$9079 \$9231 VDD VDD pfet_06v0 L=1U W=5U AS=1.3P AD=1.3P PS=5.52U
+ PD=5.52U
M$621 VDD \$9231 \$9079 VDD pfet_06v0 L=1U W=5U AS=1.3P AD=2.2P PS=5.52U
+ PD=10.88U
M$622 \$9078 \$9231 VDD VDD pfet_06v0 L=1U W=5U AS=2.2P AD=1.3P PS=10.88U
+ PD=5.52U
M$623 VDD \$9231 \$9078 VDD pfet_06v0 L=1U W=5U AS=1.3P AD=1.3P PS=5.52U
+ PD=5.52U
M$624 \$9078 \$9231 VDD VDD pfet_06v0 L=1U W=5U AS=1.3P AD=1.3P PS=5.52U
+ PD=5.52U
M$625 VDD \$9231 \$9078 VDD pfet_06v0 L=1U W=5U AS=1.3P AD=2.2P PS=5.52U
+ PD=10.88U
M$626 \$9081 \$9060 \$9231 VDD pfet_06v0 L=1U W=5U AS=2.2P AD=2.2P PS=10.88U
+ PD=10.88U
M$627 \$9083 \$9060 \$9059 VDD pfet_06v0 L=1U W=5U AS=2.2P AD=2.2P PS=10.88U
+ PD=10.88U
M$628 VDD VSS VDD VDD pfet_06v0 L=2U W=9.75U AS=4.29P AD=4.29P PS=20.38U
+ PD=20.38U
M$629 VDD VSS VDD VDD pfet_06v0 L=2U W=9.75U AS=4.29P AD=4.29P PS=20.38U
+ PD=20.38U
M$630 \$9767 \$9767 VDD VDD pfet_06v0 L=1U W=2U AS=0.88P AD=0.88P PS=4.88U
+ PD=4.88U
M$631 \$9232 \$9767 \$9087 VDD pfet_06v0 L=1U W=5U AS=2.2P AD=1.3P PS=10.88U
+ PD=5.52U
M$632 \$9087 \$9767 \$9232 VDD pfet_06v0 L=1U W=5U AS=1.3P AD=2.2P PS=5.52U
+ PD=10.88U
M$633 \$9063 \$9767 \$9086 VDD pfet_06v0 L=1U W=5U AS=2.2P AD=1.3P PS=10.88U
+ PD=5.52U
M$634 \$9086 \$9767 \$9063 VDD pfet_06v0 L=1U W=5U AS=1.3P AD=2.2P PS=5.52U
+ PD=10.88U
M$635 \$9087 \$9232 VDD VDD pfet_06v0 L=1U W=5U AS=2.2P AD=1.3P PS=10.88U
+ PD=5.52U
M$636 VDD \$9232 \$9087 VDD pfet_06v0 L=1U W=5U AS=1.3P AD=1.3P PS=5.52U
+ PD=5.52U
M$637 \$9087 \$9232 VDD VDD pfet_06v0 L=1U W=5U AS=1.3P AD=1.3P PS=5.52U
+ PD=5.52U
M$638 VDD \$9232 \$9087 VDD pfet_06v0 L=1U W=5U AS=1.3P AD=2.2P PS=5.52U
+ PD=10.88U
M$639 \$9086 \$9232 VDD VDD pfet_06v0 L=1U W=5U AS=2.2P AD=1.3P PS=10.88U
+ PD=5.52U
M$640 VDD \$9232 \$9086 VDD pfet_06v0 L=1U W=5U AS=1.3P AD=1.3P PS=5.52U
+ PD=5.52U
M$641 \$9086 \$9232 VDD VDD pfet_06v0 L=1U W=5U AS=1.3P AD=1.3P PS=5.52U
+ PD=5.52U
M$642 VDD \$9232 \$9086 VDD pfet_06v0 L=1U W=5U AS=1.3P AD=2.2P PS=5.52U
+ PD=10.88U
M$643 \$9089 \$9064 \$9232 VDD pfet_06v0 L=1U W=5U AS=2.2P AD=2.2P PS=10.88U
+ PD=10.88U
M$644 \$9091 \$9064 \$9063 VDD pfet_06v0 L=1U W=5U AS=2.2P AD=2.2P PS=10.88U
+ PD=10.88U
M$645 VDD VSS VDD VDD pfet_06v0 L=2U W=9.75U AS=4.29P AD=4.29P PS=20.38U
+ PD=20.38U
M$646 VDD VSS VDD VDD pfet_06v0 L=2U W=9.75U AS=4.29P AD=4.29P PS=20.38U
+ PD=20.38U
M$647 Y Y VDD VDD pfet_06v0 L=1U W=2U AS=0.88P AD=0.52P PS=4.88U PD=2.52U
M$648 VDD Y Y VDD pfet_06v0 L=1U W=2U AS=0.52P AD=0.52P PS=2.52U PD=2.52U
M$649 Y Y VDD VDD pfet_06v0 L=1U W=2U AS=0.52P AD=0.52P PS=2.52U PD=2.52U
M$650 VDD Y Y VDD pfet_06v0 L=1U W=2U AS=0.52P AD=0.52P PS=2.52U PD=2.52U
M$651 Y Y VDD VDD pfet_06v0 L=1U W=2U AS=0.52P AD=0.52P PS=2.52U PD=2.52U
M$652 VDD Y Y VDD pfet_06v0 L=1U W=2U AS=0.52P AD=0.88P PS=2.52U PD=4.88U
M$653 \$9050 \$9050 VDD VDD pfet_06v0 L=1U W=2U AS=0.88P AD=0.88P PS=4.88U
+ PD=4.88U
M$654 VDD VSS VDD VDD pfet_06v0 L=2U W=1U AS=0.44P AD=0.44P PS=2.88U PD=2.88U
M$655 VDD VSS VDD VDD pfet_06v0 L=2U W=1U AS=0.44P AD=0.44P PS=2.88U PD=2.88U
M$656 \$10866 \$10875 VDD VDD pfet_06v0 L=1U W=3U AS=1.32P AD=1.32P PS=6.88U
+ PD=6.88U
M$657 \$9150 \$10893 VDD VDD pfet_06v0 L=1U W=3U AS=1.32P AD=1.32P PS=6.88U
+ PD=6.88U
M$658 \$10893 \$10892 VDD VDD pfet_06v0 L=1U W=3U AS=1.32P AD=0.99P PS=6.88U
+ PD=3.66U
M$659 VDD \$10866 \$10893 VDD pfet_06v0 L=1U W=3U AS=0.99P AD=1.32P PS=3.66U
+ PD=6.88U
M$660 \$10999 \$10892 \$10907 VDD pfet_06v0 L=1U W=3U AS=1.32P AD=0.75P
+ PS=6.88U PD=3.5U
M$661 VDD \$10894 \$10999 VDD pfet_06v0 L=1U W=3U AS=0.75P AD=1.32P PS=3.5U
+ PD=6.88U
M$662 \$7331 \$10895 VDD VDD pfet_06v0 L=1U W=3U AS=1.32P AD=1.32P PS=6.88U
+ PD=6.88U
M$663 \$10895 \$10875 VDD VDD pfet_06v0 L=1U W=3U AS=1.32P AD=0.99P PS=6.88U
+ PD=3.66U
M$664 VDD \$10894 \$10895 VDD pfet_06v0 L=1U W=3U AS=0.99P AD=1.32P PS=3.66U
+ PD=6.88U
M$665 VDD VSS VDD VDD pfet_06v0 L=2U W=1U AS=0.44P AD=0.44P PS=2.88U PD=2.88U
M$666 \$10873 \$2447 \$10951 VDD pfet_06v0 L=1U W=10U AS=4.4P AD=2.6P PS=20.88U
+ PD=10.52U
M$667 \$10951 \$2447 \$10873 VDD pfet_06v0 L=1U W=10U AS=2.6P AD=4.4P PS=10.52U
+ PD=20.88U
M$668 \$10871 \$4842 \$10951 VDD pfet_06v0 L=1U W=10U AS=4.4P AD=2.6P PS=20.88U
+ PD=10.52U
M$669 \$10951 \$4842 \$10871 VDD pfet_06v0 L=1U W=10U AS=2.6P AD=4.4P PS=10.52U
+ PD=20.88U
M$670 \$10875 \$10854 VDD VDD pfet_06v0 L=1U W=10U AS=4.4P AD=2.6P PS=20.88U
+ PD=10.52U
M$671 VDD \$10854 \$10875 VDD pfet_06v0 L=1U W=10U AS=2.6P AD=2.6P PS=10.52U
+ PD=10.52U
M$672 \$10875 \$10854 VDD VDD pfet_06v0 L=1U W=10U AS=2.6P AD=4.4P PS=10.52U
+ PD=20.88U
M$673 \$10882 \$2455 \$10953 VDD pfet_06v0 L=1U W=10U AS=4.4P AD=2.6P PS=20.88U
+ PD=10.52U
M$674 \$10953 \$2455 \$10882 VDD pfet_06v0 L=1U W=10U AS=2.6P AD=4.4P PS=10.52U
+ PD=20.88U
M$675 \$10880 \$4842 \$10953 VDD pfet_06v0 L=1U W=10U AS=4.4P AD=2.6P PS=20.88U
+ PD=10.52U
M$676 \$10953 \$4842 \$10880 VDD pfet_06v0 L=1U W=10U AS=2.6P AD=4.4P PS=10.52U
+ PD=20.88U
M$677 \$10894 \$10858 VDD VDD pfet_06v0 L=1U W=10U AS=4.4P AD=2.6P PS=20.88U
+ PD=10.52U
M$678 VDD \$10858 \$10894 VDD pfet_06v0 L=1U W=10U AS=2.6P AD=2.6P PS=10.52U
+ PD=10.52U
M$679 \$10894 \$10858 VDD VDD pfet_06v0 L=1U W=10U AS=2.6P AD=4.4P PS=10.52U
+ PD=20.88U
M$680 \$10890 \$2455 \$10955 VDD pfet_06v0 L=1U W=10U AS=4.4P AD=2.6P PS=20.88U
+ PD=10.52U
M$681 \$10955 \$2455 \$10890 VDD pfet_06v0 L=1U W=10U AS=2.6P AD=4.4P PS=10.52U
+ PD=20.88U
M$682 \$10888 \$2447 \$10955 VDD pfet_06v0 L=1U W=10U AS=4.4P AD=2.6P PS=20.88U
+ PD=10.52U
M$683 \$10955 \$2447 \$10888 VDD pfet_06v0 L=1U W=10U AS=2.6P AD=4.4P PS=10.52U
+ PD=20.88U
M$684 \$10892 \$10862 VDD VDD pfet_06v0 L=1U W=10U AS=4.4P AD=2.6P PS=20.88U
+ PD=10.52U
M$685 VDD \$10862 \$10892 VDD pfet_06v0 L=1U W=10U AS=2.6P AD=2.6P PS=10.52U
+ PD=10.52U
M$686 \$10892 \$10862 VDD VDD pfet_06v0 L=1U W=10U AS=2.6P AD=4.4P PS=10.52U
+ PD=20.88U
M$687 \$12623 \$11409 VDD VDD pfet_06v0 L=1U W=10U AS=4.4P AD=2.5P PS=20.88U
+ PD=10.5U
M$688 \$10867 \$11410 \$12623 VDD pfet_06v0 L=1U W=10U AS=2.5P AD=4.4P PS=10.5U
+ PD=20.88U
M$689 \$12624 \$11409 VDD VDD pfet_06v0 L=1U W=10U AS=4.4P AD=2.5P PS=20.88U
+ PD=10.5U
M$690 \$10853 \$11410 \$12624 VDD pfet_06v0 L=1U W=10U AS=2.5P AD=4.4P PS=10.5U
+ PD=20.88U
M$691 \$12626 \$11409 VDD VDD pfet_06v0 L=1U W=10U AS=4.4P AD=2.5P PS=20.88U
+ PD=10.5U
M$692 \$11409 \$11410 \$12626 VDD pfet_06v0 L=1U W=10U AS=2.5P AD=4.4P PS=10.5U
+ PD=20.88U
M$693 \$12627 \$11409 VDD VDD pfet_06v0 L=1U W=10U AS=4.4P AD=2.5P PS=20.88U
+ PD=10.5U
M$694 \$10951 \$11410 \$12627 VDD pfet_06v0 L=1U W=10U AS=2.5P AD=3.3P PS=10.5U
+ PD=10.66U
M$695 \$12628 \$11410 \$10951 VDD pfet_06v0 L=1U W=10U AS=3.3P AD=2.5P
+ PS=10.66U PD=10.5U
M$696 VDD \$11409 \$12628 VDD pfet_06v0 L=1U W=10U AS=2.5P AD=4.4P PS=10.5U
+ PD=20.88U
M$697 \$12630 \$10939 VDD VDD pfet_06v0 L=1U W=10U AS=4.4P AD=2.5P PS=20.88U
+ PD=10.5U
M$698 \$10939 \$11410 \$12630 VDD pfet_06v0 L=1U W=10U AS=2.5P AD=3.3P PS=10.5U
+ PD=10.66U
M$699 \$10855 \$10855 \$10939 VDD pfet_06v0 L=1U W=10U AS=3.3P AD=4.4P
+ PS=10.66U PD=20.88U
M$700 \$12631 \$11409 VDD VDD pfet_06v0 L=1U W=10U AS=4.4P AD=2.5P PS=20.88U
+ PD=10.5U
M$701 \$10904 \$11410 \$12631 VDD pfet_06v0 L=1U W=10U AS=2.5P AD=4.4P PS=10.5U
+ PD=20.88U
M$702 \$12632 \$11412 VDD VDD pfet_06v0 L=1U W=10U AS=4.4P AD=2.5P PS=20.88U
+ PD=10.5U
M$703 \$10876 \$11413 \$12632 VDD pfet_06v0 L=1U W=10U AS=2.5P AD=4.4P PS=10.5U
+ PD=20.88U
M$704 \$12634 \$11412 VDD VDD pfet_06v0 L=1U W=10U AS=4.4P AD=2.5P PS=20.88U
+ PD=10.5U
M$705 \$10857 \$11413 \$12634 VDD pfet_06v0 L=1U W=10U AS=2.5P AD=4.4P PS=10.5U
+ PD=20.88U
M$706 \$12636 \$11412 VDD VDD pfet_06v0 L=1U W=10U AS=4.4P AD=2.5P PS=20.88U
+ PD=10.5U
M$707 \$11412 \$11413 \$12636 VDD pfet_06v0 L=1U W=10U AS=2.5P AD=4.4P PS=10.5U
+ PD=20.88U
M$708 \$12637 \$11412 VDD VDD pfet_06v0 L=1U W=10U AS=4.4P AD=2.5P PS=20.88U
+ PD=10.5U
M$709 \$10953 \$11413 \$12637 VDD pfet_06v0 L=1U W=10U AS=2.5P AD=3.3P PS=10.5U
+ PD=10.66U
M$710 \$12639 \$11413 \$10953 VDD pfet_06v0 L=1U W=10U AS=3.3P AD=2.5P
+ PS=10.66U PD=10.5U
M$711 VDD \$11412 \$12639 VDD pfet_06v0 L=1U W=10U AS=2.5P AD=4.4P PS=10.5U
+ PD=20.88U
M$712 \$12643 \$10942 VDD VDD pfet_06v0 L=1U W=10U AS=4.4P AD=2.5P PS=20.88U
+ PD=10.5U
M$713 \$10942 \$11413 \$12643 VDD pfet_06v0 L=1U W=10U AS=2.5P AD=3.3P PS=10.5U
+ PD=10.66U
M$714 \$10859 \$10859 \$10942 VDD pfet_06v0 L=1U W=10U AS=3.3P AD=4.4P
+ PS=10.66U PD=20.88U
M$715 \$12642 \$11412 VDD VDD pfet_06v0 L=1U W=10U AS=4.4P AD=2.5P PS=20.88U
+ PD=10.5U
M$716 \$10905 \$11413 \$12642 VDD pfet_06v0 L=1U W=10U AS=2.5P AD=4.4P PS=10.5U
+ PD=20.88U
M$717 \$12641 \$11415 VDD VDD pfet_06v0 L=1U W=10U AS=4.4P AD=2.5P PS=20.88U
+ PD=10.5U
M$718 \$10884 \$11416 \$12641 VDD pfet_06v0 L=1U W=10U AS=2.5P AD=4.4P PS=10.5U
+ PD=20.88U
M$719 \$12640 \$11415 VDD VDD pfet_06v0 L=1U W=10U AS=4.4P AD=2.5P PS=20.88U
+ PD=10.5U
M$720 \$10861 \$11416 \$12640 VDD pfet_06v0 L=1U W=10U AS=2.5P AD=4.4P PS=10.5U
+ PD=20.88U
M$721 \$12638 \$11415 VDD VDD pfet_06v0 L=1U W=10U AS=4.4P AD=2.5P PS=20.88U
+ PD=10.5U
M$722 \$11415 \$11416 \$12638 VDD pfet_06v0 L=1U W=10U AS=2.5P AD=4.4P PS=10.5U
+ PD=20.88U
M$723 \$12635 \$11415 VDD VDD pfet_06v0 L=1U W=10U AS=4.4P AD=2.5P PS=20.88U
+ PD=10.5U
M$724 \$10955 \$11416 \$12635 VDD pfet_06v0 L=1U W=10U AS=2.5P AD=3.3P PS=10.5U
+ PD=10.66U
M$725 \$12633 \$11416 \$10955 VDD pfet_06v0 L=1U W=10U AS=3.3P AD=2.5P
+ PS=10.66U PD=10.5U
M$726 VDD \$11415 \$12633 VDD pfet_06v0 L=1U W=10U AS=2.5P AD=4.4P PS=10.5U
+ PD=20.88U
M$727 \$12629 \$10945 VDD VDD pfet_06v0 L=1U W=10U AS=4.4P AD=2.5P PS=20.88U
+ PD=10.5U
M$728 \$10945 \$11416 \$12629 VDD pfet_06v0 L=1U W=10U AS=2.5P AD=3.3P PS=10.5U
+ PD=10.66U
M$729 \$10863 \$10863 \$10945 VDD pfet_06v0 L=1U W=10U AS=3.3P AD=4.4P
+ PS=10.66U PD=20.88U
M$730 \$12625 \$11415 VDD VDD pfet_06v0 L=1U W=10U AS=4.4P AD=2.5P PS=20.88U
+ PD=10.5U
M$731 \$10906 \$11416 \$12625 VDD pfet_06v0 L=1U W=10U AS=2.5P AD=4.4P PS=10.5U
+ PD=20.88U
M$732 \$11410 \$11410 VDD VDD pfet_06v0 L=1U W=2U AS=0.88P AD=0.88P PS=4.88U
+ PD=4.88U
M$733 \$10952 \$11410 \$10870 VDD pfet_06v0 L=1U W=5U AS=2.2P AD=1.3P PS=10.88U
+ PD=5.52U
M$734 \$10870 \$11410 \$10952 VDD pfet_06v0 L=1U W=5U AS=1.3P AD=2.2P PS=5.52U
+ PD=10.88U
M$735 \$10854 \$11410 \$10869 VDD pfet_06v0 L=1U W=5U AS=2.2P AD=1.3P PS=10.88U
+ PD=5.52U
M$736 \$10869 \$11410 \$10854 VDD pfet_06v0 L=1U W=5U AS=1.3P AD=2.2P PS=5.52U
+ PD=10.88U
M$737 \$10870 \$10952 VDD VDD pfet_06v0 L=1U W=5U AS=2.2P AD=1.3P PS=10.88U
+ PD=5.52U
M$738 VDD \$10952 \$10870 VDD pfet_06v0 L=1U W=5U AS=1.3P AD=1.3P PS=5.52U
+ PD=5.52U
M$739 \$10870 \$10952 VDD VDD pfet_06v0 L=1U W=5U AS=1.3P AD=1.3P PS=5.52U
+ PD=5.52U
M$740 VDD \$10952 \$10870 VDD pfet_06v0 L=1U W=5U AS=1.3P AD=2.2P PS=5.52U
+ PD=10.88U
M$741 \$10869 \$10952 VDD VDD pfet_06v0 L=1U W=5U AS=2.2P AD=1.3P PS=10.88U
+ PD=5.52U
M$742 VDD \$10952 \$10869 VDD pfet_06v0 L=1U W=5U AS=1.3P AD=1.3P PS=5.52U
+ PD=5.52U
M$743 \$10869 \$10952 VDD VDD pfet_06v0 L=1U W=5U AS=1.3P AD=1.3P PS=5.52U
+ PD=5.52U
M$744 VDD \$10952 \$10869 VDD pfet_06v0 L=1U W=5U AS=1.3P AD=2.2P PS=5.52U
+ PD=10.88U
M$745 \$10872 \$10855 \$10952 VDD pfet_06v0 L=1U W=5U AS=2.2P AD=2.2P PS=10.88U
+ PD=10.88U
M$746 \$10874 \$10855 \$10854 VDD pfet_06v0 L=1U W=5U AS=2.2P AD=2.2P PS=10.88U
+ PD=10.88U
M$747 \$11413 \$11413 VDD VDD pfet_06v0 L=1U W=2U AS=0.88P AD=0.88P PS=4.88U
+ PD=4.88U
M$748 \$10954 \$11413 \$10879 VDD pfet_06v0 L=1U W=5U AS=2.2P AD=1.3P PS=10.88U
+ PD=5.52U
M$749 \$10879 \$11413 \$10954 VDD pfet_06v0 L=1U W=5U AS=1.3P AD=2.2P PS=5.52U
+ PD=10.88U
M$750 \$10858 \$11413 \$10878 VDD pfet_06v0 L=1U W=5U AS=2.2P AD=1.3P PS=10.88U
+ PD=5.52U
M$751 \$10878 \$11413 \$10858 VDD pfet_06v0 L=1U W=5U AS=1.3P AD=2.2P PS=5.52U
+ PD=10.88U
M$752 \$10879 \$10954 VDD VDD pfet_06v0 L=1U W=5U AS=2.2P AD=1.3P PS=10.88U
+ PD=5.52U
M$753 VDD \$10954 \$10879 VDD pfet_06v0 L=1U W=5U AS=1.3P AD=1.3P PS=5.52U
+ PD=5.52U
M$754 \$10879 \$10954 VDD VDD pfet_06v0 L=1U W=5U AS=1.3P AD=1.3P PS=5.52U
+ PD=5.52U
M$755 VDD \$10954 \$10879 VDD pfet_06v0 L=1U W=5U AS=1.3P AD=2.2P PS=5.52U
+ PD=10.88U
M$756 \$10878 \$10954 VDD VDD pfet_06v0 L=1U W=5U AS=2.2P AD=1.3P PS=10.88U
+ PD=5.52U
M$757 VDD \$10954 \$10878 VDD pfet_06v0 L=1U W=5U AS=1.3P AD=1.3P PS=5.52U
+ PD=5.52U
M$758 \$10878 \$10954 VDD VDD pfet_06v0 L=1U W=5U AS=1.3P AD=1.3P PS=5.52U
+ PD=5.52U
M$759 VDD \$10954 \$10878 VDD pfet_06v0 L=1U W=5U AS=1.3P AD=2.2P PS=5.52U
+ PD=10.88U
M$760 \$10881 \$10859 \$10954 VDD pfet_06v0 L=1U W=5U AS=2.2P AD=2.2P PS=10.88U
+ PD=10.88U
M$761 \$10883 \$10859 \$10858 VDD pfet_06v0 L=1U W=5U AS=2.2P AD=2.2P PS=10.88U
+ PD=10.88U
M$762 \$11416 \$11416 VDD VDD pfet_06v0 L=1U W=2U AS=0.88P AD=0.88P PS=4.88U
+ PD=4.88U
M$763 \$10956 \$11416 \$10887 VDD pfet_06v0 L=1U W=5U AS=2.2P AD=1.3P PS=10.88U
+ PD=5.52U
M$764 \$10887 \$11416 \$10956 VDD pfet_06v0 L=1U W=5U AS=1.3P AD=2.2P PS=5.52U
+ PD=10.88U
M$765 \$10862 \$11416 \$10886 VDD pfet_06v0 L=1U W=5U AS=2.2P AD=1.3P PS=10.88U
+ PD=5.52U
M$766 \$10886 \$11416 \$10862 VDD pfet_06v0 L=1U W=5U AS=1.3P AD=2.2P PS=5.52U
+ PD=10.88U
M$767 \$10887 \$10956 VDD VDD pfet_06v0 L=1U W=5U AS=2.2P AD=1.3P PS=10.88U
+ PD=5.52U
M$768 VDD \$10956 \$10887 VDD pfet_06v0 L=1U W=5U AS=1.3P AD=1.3P PS=5.52U
+ PD=5.52U
M$769 \$10887 \$10956 VDD VDD pfet_06v0 L=1U W=5U AS=1.3P AD=1.3P PS=5.52U
+ PD=5.52U
M$770 VDD \$10956 \$10887 VDD pfet_06v0 L=1U W=5U AS=1.3P AD=2.2P PS=5.52U
+ PD=10.88U
M$771 \$10886 \$10956 VDD VDD pfet_06v0 L=1U W=5U AS=2.2P AD=1.3P PS=10.88U
+ PD=5.52U
M$772 VDD \$10956 \$10886 VDD pfet_06v0 L=1U W=5U AS=1.3P AD=1.3P PS=5.52U
+ PD=5.52U
M$773 \$10886 \$10956 VDD VDD pfet_06v0 L=1U W=5U AS=1.3P AD=1.3P PS=5.52U
+ PD=5.52U
M$774 VDD \$10956 \$10886 VDD pfet_06v0 L=1U W=5U AS=1.3P AD=2.2P PS=5.52U
+ PD=10.88U
M$775 \$10889 \$10863 \$10956 VDD pfet_06v0 L=1U W=5U AS=2.2P AD=2.2P PS=10.88U
+ PD=10.88U
M$776 \$10891 \$10863 \$10862 VDD pfet_06v0 L=1U W=5U AS=2.2P AD=2.2P PS=10.88U
+ PD=10.88U
M$777 \$12657 \$12666 VDD VDD pfet_06v0 L=1U W=3U AS=1.32P AD=1.32P PS=6.88U
+ PD=6.88U
M$778 Z Z VDD VDD pfet_06v0 L=1U W=2U AS=0.88P AD=0.52P PS=4.88U PD=2.52U
M$779 VDD Z Z VDD pfet_06v0 L=1U W=2U AS=0.52P AD=0.52P PS=2.52U PD=2.52U
M$780 Z Z VDD VDD pfet_06v0 L=1U W=2U AS=0.52P AD=0.52P PS=2.52U PD=2.52U
M$781 VDD Z Z VDD pfet_06v0 L=1U W=2U AS=0.52P AD=0.52P PS=2.52U PD=2.52U
M$782 Z Z VDD VDD pfet_06v0 L=1U W=2U AS=0.52P AD=0.52P PS=2.52U PD=2.52U
M$783 VDD Z Z VDD pfet_06v0 L=1U W=2U AS=0.52P AD=0.88P PS=2.52U PD=4.88U
M$784 \$9145 \$12685 VDD VDD pfet_06v0 L=1U W=3U AS=1.32P AD=1.32P PS=6.88U
+ PD=6.88U
M$785 \$12685 \$12684 VDD VDD pfet_06v0 L=1U W=3U AS=1.32P AD=0.99P PS=6.88U
+ PD=3.66U
M$786 VDD \$12657 \$12685 VDD pfet_06v0 L=1U W=3U AS=0.99P AD=1.32P PS=3.66U
+ PD=6.88U
M$787 \$12733 \$12684 \$10932 VDD pfet_06v0 L=1U W=3U AS=1.32P AD=0.75P
+ PS=6.88U PD=3.5U
M$788 VDD \$12675 \$12733 VDD pfet_06v0 L=1U W=3U AS=0.75P AD=1.32P PS=3.5U
+ PD=6.88U
M$789 \$10851 \$10851 VDD VDD pfet_06v0 L=1U W=2U AS=0.88P AD=0.88P PS=4.88U
+ PD=4.88U
M$790 \$7330 \$12686 VDD VDD pfet_06v0 L=1U W=3U AS=1.32P AD=1.32P PS=6.88U
+ PD=6.88U
M$791 \$12686 \$12666 VDD VDD pfet_06v0 L=1U W=3U AS=1.32P AD=0.99P PS=6.88U
+ PD=3.66U
M$792 VDD \$12675 \$12686 VDD pfet_06v0 L=1U W=3U AS=0.99P AD=1.32P PS=3.66U
+ PD=6.88U
M$793 VDD VSS VDD VDD pfet_06v0 L=2U W=1U AS=0.44P AD=0.44P PS=2.88U PD=2.88U
M$794 VDD VSS VDD VDD pfet_06v0 L=2U W=1U AS=0.44P AD=0.44P PS=2.88U PD=2.88U
M$795 VDD VSS VDD VDD pfet_06v0 L=2U W=1U AS=0.44P AD=0.44P PS=2.88U PD=2.88U
M$796 VDD VSS VDD VDD pfet_06v0 L=2U W=1U AS=0.44P AD=0.44P PS=2.88U PD=2.88U
M$797 VDD VSS VDD VDD pfet_06v0 L=2U W=1U AS=0.44P AD=0.44P PS=2.88U PD=2.88U
M$798 VDD VSS VDD VDD pfet_06v0 L=2U W=1U AS=0.44P AD=0.44P PS=2.88U PD=2.88U
M$799 VDD VSS VDD VDD pfet_06v0 L=2U W=1U AS=0.44P AD=0.44P PS=2.88U PD=2.88U
M$800 VDD VSS VDD VDD pfet_06v0 L=2U W=1U AS=0.44P AD=0.44P PS=2.88U PD=2.88U
M$801 VDD VSS VDD VDD pfet_06v0 L=2U W=1U AS=0.44P AD=0.44P PS=2.88U PD=2.88U
M$802 VDD VSS VDD VDD pfet_06v0 L=2U W=1U AS=0.44P AD=0.44P PS=2.88U PD=2.88U
M$803 VDD VSS VDD VDD pfet_06v0 L=2U W=1U AS=0.44P AD=0.44P PS=2.88U PD=2.88U
M$804 VDD VSS VDD VDD pfet_06v0 L=2U W=1U AS=0.44P AD=0.44P PS=2.88U PD=2.88U
M$805 VDD VSS VDD VDD pfet_06v0 L=2U W=9.75U AS=4.29P AD=4.29P PS=20.38U
+ PD=20.38U
M$806 \$12664 \$4850 \$12730 VDD pfet_06v0 L=1U W=10U AS=4.4P AD=2.6P PS=20.88U
+ PD=10.52U
M$807 \$12730 \$4850 \$12664 VDD pfet_06v0 L=1U W=10U AS=2.6P AD=4.4P PS=10.52U
+ PD=20.88U
M$808 \$12662 \$4866 \$12730 VDD pfet_06v0 L=1U W=10U AS=4.4P AD=2.6P PS=20.88U
+ PD=10.52U
M$809 \$12730 \$4866 \$12662 VDD pfet_06v0 L=1U W=10U AS=2.6P AD=4.4P PS=10.52U
+ PD=20.88U
M$810 \$12666 \$12646 VDD VDD pfet_06v0 L=1U W=10U AS=4.4P AD=2.6P PS=20.88U
+ PD=10.52U
M$811 VDD \$12646 \$12666 VDD pfet_06v0 L=1U W=10U AS=2.6P AD=2.6P PS=10.52U
+ PD=10.52U
M$812 \$12666 \$12646 VDD VDD pfet_06v0 L=1U W=10U AS=2.6P AD=4.4P PS=10.52U
+ PD=20.88U
M$813 VDD VSS VDD VDD pfet_06v0 L=2U W=9.75U AS=4.29P AD=4.29P PS=20.38U
+ PD=20.38U
M$814 VDD VSS VDD VDD pfet_06v0 L=2U W=9.75U AS=4.29P AD=4.29P PS=20.38U
+ PD=20.38U
M$815 \$12673 \$4858 \$12731 VDD pfet_06v0 L=1U W=10U AS=4.4P AD=2.6P PS=20.88U
+ PD=10.52U
M$816 \$12731 \$4858 \$12673 VDD pfet_06v0 L=1U W=10U AS=2.6P AD=4.4P PS=10.52U
+ PD=20.88U
M$817 \$12671 \$4866 \$12731 VDD pfet_06v0 L=1U W=10U AS=4.4P AD=2.6P PS=20.88U
+ PD=10.52U
M$818 \$12731 \$4866 \$12671 VDD pfet_06v0 L=1U W=10U AS=2.6P AD=4.4P PS=10.52U
+ PD=20.88U
M$819 \$12675 \$12650 VDD VDD pfet_06v0 L=1U W=10U AS=4.4P AD=2.6P PS=20.88U
+ PD=10.52U
M$820 VDD \$12650 \$12675 VDD pfet_06v0 L=1U W=10U AS=2.6P AD=2.6P PS=10.52U
+ PD=10.52U
M$821 \$12675 \$12650 VDD VDD pfet_06v0 L=1U W=10U AS=2.6P AD=4.4P PS=10.52U
+ PD=20.88U
M$822 VDD VSS VDD VDD pfet_06v0 L=2U W=9.75U AS=4.29P AD=4.29P PS=20.38U
+ PD=20.38U
M$823 VDD VSS VDD VDD pfet_06v0 L=2U W=9.75U AS=4.29P AD=4.29P PS=20.38U
+ PD=20.38U
M$824 \$12682 \$4858 \$12732 VDD pfet_06v0 L=1U W=10U AS=4.4P AD=2.6P PS=20.88U
+ PD=10.52U
M$825 \$12732 \$4858 \$12682 VDD pfet_06v0 L=1U W=10U AS=2.6P AD=4.4P PS=10.52U
+ PD=20.88U
M$826 \$12680 \$4850 \$12732 VDD pfet_06v0 L=1U W=10U AS=4.4P AD=2.6P PS=20.88U
+ PD=10.52U
M$827 \$12732 \$4850 \$12680 VDD pfet_06v0 L=1U W=10U AS=2.6P AD=4.4P PS=10.52U
+ PD=20.88U
M$828 \$12684 \$12654 VDD VDD pfet_06v0 L=1U W=10U AS=4.4P AD=2.6P PS=20.88U
+ PD=10.52U
M$829 VDD \$12654 \$12684 VDD pfet_06v0 L=1U W=10U AS=2.6P AD=2.6P PS=10.52U
+ PD=10.52U
M$830 \$12684 \$12654 VDD VDD pfet_06v0 L=1U W=10U AS=2.6P AD=4.4P PS=10.52U
+ PD=20.88U
M$831 VDD VSS VDD VDD pfet_06v0 L=2U W=9.75U AS=4.29P AD=4.29P PS=20.38U
+ PD=20.38U
M$832 VDD VSS VDD VDD pfet_06v0 L=2U W=9.75U AS=4.29P AD=4.29P PS=20.38U
+ PD=20.38U
M$833 \$14400 \$13262 VDD VDD pfet_06v0 L=1U W=10U AS=4.4P AD=2.5P PS=20.88U
+ PD=10.5U
M$834 \$12658 \$13266 \$14400 VDD pfet_06v0 L=1U W=10U AS=2.5P AD=4.4P PS=10.5U
+ PD=20.88U
M$835 \$14401 \$13262 VDD VDD pfet_06v0 L=1U W=10U AS=4.4P AD=2.5P PS=20.88U
+ PD=10.5U
M$836 \$12645 \$13266 \$14401 VDD pfet_06v0 L=1U W=10U AS=2.5P AD=4.4P PS=10.5U
+ PD=20.88U
M$837 \$14402 \$13262 VDD VDD pfet_06v0 L=1U W=10U AS=4.4P AD=2.5P PS=20.88U
+ PD=10.5U
M$838 \$13262 \$13266 \$14402 VDD pfet_06v0 L=1U W=10U AS=2.5P AD=4.4P PS=10.5U
+ PD=20.88U
M$839 \$14403 \$13262 VDD VDD pfet_06v0 L=1U W=10U AS=4.4P AD=2.5P PS=20.88U
+ PD=10.5U
M$840 \$12730 \$13266 \$14403 VDD pfet_06v0 L=1U W=10U AS=2.5P AD=3.3P PS=10.5U
+ PD=10.66U
M$841 \$14404 \$13266 \$12730 VDD pfet_06v0 L=1U W=10U AS=3.3P AD=2.5P
+ PS=10.66U PD=10.5U
M$842 VDD \$13262 \$14404 VDD pfet_06v0 L=1U W=10U AS=2.5P AD=4.4P PS=10.5U
+ PD=20.88U
M$843 \$14407 \$12723 VDD VDD pfet_06v0 L=1U W=10U AS=4.4P AD=2.5P PS=20.88U
+ PD=10.5U
M$844 \$12723 \$13266 \$14407 VDD pfet_06v0 L=1U W=10U AS=2.5P AD=3.3P PS=10.5U
+ PD=10.66U
M$845 \$12647 \$12647 \$12723 VDD pfet_06v0 L=1U W=10U AS=3.3P AD=4.4P
+ PS=10.66U PD=20.88U
M$846 \$14408 \$13262 VDD VDD pfet_06v0 L=1U W=10U AS=4.4P AD=2.5P PS=20.88U
+ PD=10.5U
M$847 \$12695 \$13266 \$14408 VDD pfet_06v0 L=1U W=10U AS=2.5P AD=4.4P PS=10.5U
+ PD=20.88U
M$848 \$14409 \$13263 VDD VDD pfet_06v0 L=1U W=10U AS=4.4P AD=2.5P PS=20.88U
+ PD=10.5U
M$849 \$12667 \$13268 \$14409 VDD pfet_06v0 L=1U W=10U AS=2.5P AD=4.4P PS=10.5U
+ PD=20.88U
M$850 \$14410 \$13263 VDD VDD pfet_06v0 L=1U W=10U AS=4.4P AD=2.5P PS=20.88U
+ PD=10.5U
M$851 \$12649 \$13268 \$14410 VDD pfet_06v0 L=1U W=10U AS=2.5P AD=4.4P PS=10.5U
+ PD=20.88U
M$852 \$14411 \$13263 VDD VDD pfet_06v0 L=1U W=10U AS=4.4P AD=2.5P PS=20.88U
+ PD=10.5U
M$853 \$13263 \$13268 \$14411 VDD pfet_06v0 L=1U W=10U AS=2.5P AD=4.4P PS=10.5U
+ PD=20.88U
M$854 \$14412 \$13263 VDD VDD pfet_06v0 L=1U W=10U AS=4.4P AD=2.5P PS=20.88U
+ PD=10.5U
M$855 \$12731 \$13268 \$14412 VDD pfet_06v0 L=1U W=10U AS=2.5P AD=3.3P PS=10.5U
+ PD=10.66U
M$856 \$14413 \$13268 \$12731 VDD pfet_06v0 L=1U W=10U AS=3.3P AD=2.5P
+ PS=10.66U PD=10.5U
M$857 VDD \$13263 \$14413 VDD pfet_06v0 L=1U W=10U AS=2.5P AD=4.4P PS=10.5U
+ PD=20.88U
M$858 \$14419 \$12726 VDD VDD pfet_06v0 L=1U W=10U AS=4.4P AD=2.5P PS=20.88U
+ PD=10.5U
M$859 \$12726 \$13268 \$14419 VDD pfet_06v0 L=1U W=10U AS=2.5P AD=3.3P PS=10.5U
+ PD=10.66U
M$860 \$12651 \$12651 \$12726 VDD pfet_06v0 L=1U W=10U AS=3.3P AD=4.4P
+ PS=10.66U PD=20.88U
M$861 \$14420 \$13263 VDD VDD pfet_06v0 L=1U W=10U AS=4.4P AD=2.5P PS=20.88U
+ PD=10.5U
M$862 \$12696 \$13268 \$14420 VDD pfet_06v0 L=1U W=10U AS=2.5P AD=4.4P PS=10.5U
+ PD=20.88U
M$863 \$14418 \$13264 VDD VDD pfet_06v0 L=1U W=10U AS=4.4P AD=2.5P PS=20.88U
+ PD=10.5U
M$864 \$12676 \$13270 \$14418 VDD pfet_06v0 L=1U W=10U AS=2.5P AD=4.4P PS=10.5U
+ PD=20.88U
M$865 \$14417 \$13264 VDD VDD pfet_06v0 L=1U W=10U AS=4.4P AD=2.5P PS=20.88U
+ PD=10.5U
M$866 \$12653 \$13270 \$14417 VDD pfet_06v0 L=1U W=10U AS=2.5P AD=4.4P PS=10.5U
+ PD=20.88U
M$867 \$14416 \$13264 VDD VDD pfet_06v0 L=1U W=10U AS=4.4P AD=2.5P PS=20.88U
+ PD=10.5U
M$868 \$13264 \$13270 \$14416 VDD pfet_06v0 L=1U W=10U AS=2.5P AD=4.4P PS=10.5U
+ PD=20.88U
M$869 \$14415 \$13264 VDD VDD pfet_06v0 L=1U W=10U AS=4.4P AD=2.5P PS=20.88U
+ PD=10.5U
M$870 \$12732 \$13270 \$14415 VDD pfet_06v0 L=1U W=10U AS=2.5P AD=3.3P PS=10.5U
+ PD=10.66U
M$871 \$14414 \$13270 \$12732 VDD pfet_06v0 L=1U W=10U AS=3.3P AD=2.5P
+ PS=10.66U PD=10.5U
M$872 VDD \$13264 \$14414 VDD pfet_06v0 L=1U W=10U AS=2.5P AD=4.4P PS=10.5U
+ PD=20.88U
M$873 \$14406 \$12729 VDD VDD pfet_06v0 L=1U W=10U AS=4.4P AD=2.5P PS=20.88U
+ PD=10.5U
M$874 \$12729 \$13270 \$14406 VDD pfet_06v0 L=1U W=10U AS=2.5P AD=3.3P PS=10.5U
+ PD=10.66U
M$875 \$12655 \$12655 \$12729 VDD pfet_06v0 L=1U W=10U AS=3.3P AD=4.4P
+ PS=10.66U PD=20.88U
M$876 \$14405 \$13264 VDD VDD pfet_06v0 L=1U W=10U AS=4.4P AD=2.5P PS=20.88U
+ PD=10.5U
M$877 \$12697 \$13270 \$14405 VDD pfet_06v0 L=1U W=10U AS=2.5P AD=4.4P PS=10.5U
+ PD=20.88U
M$878 \$13266 \$13266 VDD VDD pfet_06v0 L=1U W=2U AS=0.88P AD=0.88P PS=4.88U
+ PD=4.88U
M$879 \$12809 \$13266 \$12661 VDD pfet_06v0 L=1U W=5U AS=2.2P AD=1.3P PS=10.88U
+ PD=5.52U
M$880 \$12661 \$13266 \$12809 VDD pfet_06v0 L=1U W=5U AS=1.3P AD=2.2P PS=5.52U
+ PD=10.88U
M$881 \$12646 \$13266 \$12660 VDD pfet_06v0 L=1U W=5U AS=2.2P AD=1.3P PS=10.88U
+ PD=5.52U
M$882 \$12660 \$13266 \$12646 VDD pfet_06v0 L=1U W=5U AS=1.3P AD=2.2P PS=5.52U
+ PD=10.88U
M$883 \$12661 \$12809 VDD VDD pfet_06v0 L=1U W=5U AS=2.2P AD=1.3P PS=10.88U
+ PD=5.52U
M$884 VDD \$12809 \$12661 VDD pfet_06v0 L=1U W=5U AS=1.3P AD=1.3P PS=5.52U
+ PD=5.52U
M$885 \$12661 \$12809 VDD VDD pfet_06v0 L=1U W=5U AS=1.3P AD=1.3P PS=5.52U
+ PD=5.52U
M$886 VDD \$12809 \$12661 VDD pfet_06v0 L=1U W=5U AS=1.3P AD=2.2P PS=5.52U
+ PD=10.88U
M$887 \$12660 \$12809 VDD VDD pfet_06v0 L=1U W=5U AS=2.2P AD=1.3P PS=10.88U
+ PD=5.52U
M$888 VDD \$12809 \$12660 VDD pfet_06v0 L=1U W=5U AS=1.3P AD=1.3P PS=5.52U
+ PD=5.52U
M$889 \$12660 \$12809 VDD VDD pfet_06v0 L=1U W=5U AS=1.3P AD=1.3P PS=5.52U
+ PD=5.52U
M$890 VDD \$12809 \$12660 VDD pfet_06v0 L=1U W=5U AS=1.3P AD=2.2P PS=5.52U
+ PD=10.88U
M$891 \$12663 \$12647 \$12809 VDD pfet_06v0 L=1U W=5U AS=2.2P AD=2.2P PS=10.88U
+ PD=10.88U
M$892 \$12665 \$12647 \$12646 VDD pfet_06v0 L=1U W=5U AS=2.2P AD=2.2P PS=10.88U
+ PD=10.88U
M$893 \$13268 \$13268 VDD VDD pfet_06v0 L=1U W=2U AS=0.88P AD=0.88P PS=4.88U
+ PD=4.88U
M$894 \$12810 \$13268 \$12670 VDD pfet_06v0 L=1U W=5U AS=2.2P AD=1.3P PS=10.88U
+ PD=5.52U
M$895 \$12670 \$13268 \$12810 VDD pfet_06v0 L=1U W=5U AS=1.3P AD=2.2P PS=5.52U
+ PD=10.88U
M$896 \$12650 \$13268 \$12669 VDD pfet_06v0 L=1U W=5U AS=2.2P AD=1.3P PS=10.88U
+ PD=5.52U
M$897 \$12669 \$13268 \$12650 VDD pfet_06v0 L=1U W=5U AS=1.3P AD=2.2P PS=5.52U
+ PD=10.88U
M$898 \$12670 \$12810 VDD VDD pfet_06v0 L=1U W=5U AS=2.2P AD=1.3P PS=10.88U
+ PD=5.52U
M$899 VDD \$12810 \$12670 VDD pfet_06v0 L=1U W=5U AS=1.3P AD=1.3P PS=5.52U
+ PD=5.52U
M$900 \$12670 \$12810 VDD VDD pfet_06v0 L=1U W=5U AS=1.3P AD=1.3P PS=5.52U
+ PD=5.52U
M$901 VDD \$12810 \$12670 VDD pfet_06v0 L=1U W=5U AS=1.3P AD=2.2P PS=5.52U
+ PD=10.88U
M$902 \$12669 \$12810 VDD VDD pfet_06v0 L=1U W=5U AS=2.2P AD=1.3P PS=10.88U
+ PD=5.52U
M$903 VDD \$12810 \$12669 VDD pfet_06v0 L=1U W=5U AS=1.3P AD=1.3P PS=5.52U
+ PD=5.52U
M$904 \$12669 \$12810 VDD VDD pfet_06v0 L=1U W=5U AS=1.3P AD=1.3P PS=5.52U
+ PD=5.52U
M$905 VDD \$12810 \$12669 VDD pfet_06v0 L=1U W=5U AS=1.3P AD=2.2P PS=5.52U
+ PD=10.88U
M$906 \$12672 \$12651 \$12810 VDD pfet_06v0 L=1U W=5U AS=2.2P AD=2.2P PS=10.88U
+ PD=10.88U
M$907 \$12674 \$12651 \$12650 VDD pfet_06v0 L=1U W=5U AS=2.2P AD=2.2P PS=10.88U
+ PD=10.88U
M$908 \$13270 \$13270 VDD VDD pfet_06v0 L=1U W=2U AS=0.88P AD=0.88P PS=4.88U
+ PD=4.88U
M$909 \$12811 \$13270 \$12679 VDD pfet_06v0 L=1U W=5U AS=2.2P AD=1.3P PS=10.88U
+ PD=5.52U
M$910 \$12679 \$13270 \$12811 VDD pfet_06v0 L=1U W=5U AS=1.3P AD=2.2P PS=5.52U
+ PD=10.88U
M$911 \$12654 \$13270 \$12678 VDD pfet_06v0 L=1U W=5U AS=2.2P AD=1.3P PS=10.88U
+ PD=5.52U
M$912 \$12678 \$13270 \$12654 VDD pfet_06v0 L=1U W=5U AS=1.3P AD=2.2P PS=5.52U
+ PD=10.88U
M$913 \$12679 \$12811 VDD VDD pfet_06v0 L=1U W=5U AS=2.2P AD=1.3P PS=10.88U
+ PD=5.52U
M$914 VDD \$12811 \$12679 VDD pfet_06v0 L=1U W=5U AS=1.3P AD=1.3P PS=5.52U
+ PD=5.52U
M$915 \$12679 \$12811 VDD VDD pfet_06v0 L=1U W=5U AS=1.3P AD=1.3P PS=5.52U
+ PD=5.52U
M$916 VDD \$12811 \$12679 VDD pfet_06v0 L=1U W=5U AS=1.3P AD=2.2P PS=5.52U
+ PD=10.88U
M$917 \$12678 \$12811 VDD VDD pfet_06v0 L=1U W=5U AS=2.2P AD=1.3P PS=10.88U
+ PD=5.52U
M$918 VDD \$12811 \$12678 VDD pfet_06v0 L=1U W=5U AS=1.3P AD=1.3P PS=5.52U
+ PD=5.52U
M$919 \$12678 \$12811 VDD VDD pfet_06v0 L=1U W=5U AS=1.3P AD=1.3P PS=5.52U
+ PD=5.52U
M$920 VDD \$12811 \$12678 VDD pfet_06v0 L=1U W=5U AS=1.3P AD=2.2P PS=5.52U
+ PD=10.88U
M$921 \$12681 \$12655 \$12811 VDD pfet_06v0 L=1U W=5U AS=2.2P AD=2.2P PS=10.88U
+ PD=10.88U
M$922 \$12683 \$12655 \$12654 VDD pfet_06v0 L=1U W=5U AS=2.2P AD=2.2P PS=10.88U
+ PD=10.88U
M$923 \$7247 X VSS VSS nfet_05v0 L=0.6U W=1.32U AS=0.5808P AD=0.5808P PS=3.52U
+ PD=3.52U
M$924 XN \$7247 VSS VSS nfet_05v0 L=0.6U W=1.32U AS=0.5808P AD=0.5808P PS=3.52U
+ PD=3.52U
M$925 XP XN VSS VSS nfet_05v0 L=0.6U W=1.32U AS=0.5808P AD=0.5808P PS=3.52U
+ PD=3.52U
M$926 \$9049 Y VSS VSS nfet_05v0 L=0.6U W=1.32U AS=0.5808P AD=0.5808P PS=3.52U
+ PD=3.52U
M$927 YN \$9049 VSS VSS nfet_05v0 L=0.6U W=1.32U AS=0.5808P AD=0.5808P PS=3.52U
+ PD=3.52U
M$928 YP YN VSS VSS nfet_05v0 L=0.6U W=1.32U AS=0.5808P AD=0.5808P PS=3.52U
+ PD=3.52U
M$929 \$10850 Z VSS VSS nfet_05v0 L=0.6U W=1.32U AS=0.5808P AD=0.5808P PS=3.52U
+ PD=3.52U
M$930 ZN \$10850 VSS VSS nfet_05v0 L=0.6U W=1.32U AS=0.5808P AD=0.5808P
+ PS=3.52U PD=3.52U
M$931 ZP ZN VSS VSS nfet_05v0 L=0.6U W=1.32U AS=0.5808P AD=0.5808P PS=3.52U
+ PD=3.52U
M$932 \$59 \$79 VSS VSS nfet_06v0 L=1U W=5U AS=2.2P AD=1.25P PS=10.88U PD=5.5U
M$933 \$11 \$83 \$59 VSS nfet_06v0 L=1U W=5U AS=1.25P AD=2.2P PS=5.5U PD=10.88U
M$934 \$60 \$79 VSS VSS nfet_06v0 L=1U W=5U AS=2.2P AD=1.25P PS=10.88U PD=5.5U
M$935 \$11 \$83 \$60 VSS nfet_06v0 L=1U W=5U AS=1.25P AD=2.2P PS=5.5U PD=10.88U
M$936 \$12 S2P \$11 VSS nfet_06v0 L=1U W=7.5U AS=3.3P AD=3.3P PS=15.88U
+ PD=15.88U
M$937 \$13 S2N \$11 VSS nfet_06v0 L=1U W=8.5U AS=3.74P AD=3.74P PS=17.88U
+ PD=17.88U
M$938 \$14 \$51 VSS VSS nfet_06v0 L=1U W=2.5U AS=1.1P AD=0.825P PS=5.88U
+ PD=3.16U
M$939 \$51 \$83 \$14 VSS nfet_06v0 L=1U W=2.5U AS=0.825P AD=1.1P PS=3.16U
+ PD=5.88U
M$940 \$91 \$51 VSS VSS nfet_06v0 L=1U W=2.5U AS=1.1P AD=0.825P PS=5.88U
+ PD=3.16U
M$941 \$15 \$83 \$91 VSS nfet_06v0 L=1U W=2.5U AS=0.825P AD=1.1P PS=3.16U
+ PD=5.88U
M$942 \$127 \$52 \$51 VSS nfet_06v0 L=1U W=2U AS=0.88P AD=0.88P PS=4.88U
+ PD=4.88U
M$943 \$110 \$52 \$15 VSS nfet_06v0 L=1U W=2U AS=0.88P AD=0.88P PS=4.88U
+ PD=4.88U
M$944 \$62 \$79 VSS VSS nfet_06v0 L=1U W=5U AS=2.2P AD=1.25P PS=10.88U PD=5.5U
M$945 \$16 \$83 \$62 VSS nfet_06v0 L=1U W=5U AS=1.25P AD=2.2P PS=5.5U PD=10.88U
M$946 \$63 \$17 VSS VSS nfet_06v0 L=1U W=5U AS=2.2P AD=1.25P PS=10.88U PD=5.5U
M$947 \$17 \$83 \$63 VSS nfet_06v0 L=1U W=5U AS=1.25P AD=1.65P PS=5.5U PD=5.66U
M$948 \$52 \$52 \$17 VSS nfet_06v0 L=1U W=5U AS=1.65P AD=2.2P PS=5.66U PD=10.88U
M$949 \$18 \$15 VSS VSS nfet_06v0 L=1U W=1U AS=0.44P AD=0.44P PS=2.88U PD=2.88U
M$950 \$83 \$83 VSS VSS nfet_06v0 L=1U W=1U AS=0.44P AD=0.44P PS=2.88U PD=2.88U
M$951 \$64 \$79 VSS VSS nfet_06v0 L=1U W=5U AS=2.2P AD=1.25P PS=10.88U PD=5.5U
M$952 \$79 \$83 \$64 VSS nfet_06v0 L=1U W=5U AS=1.25P AD=2.2P PS=5.5U PD=10.88U
M$953 \$46 \$109 VSS VSS nfet_06v0 L=1U W=1U AS=0.44P AD=0.25P PS=2.88U PD=1.5U
M$954 \$87 \$109 \$46 VSS nfet_06v0 L=1U W=1U AS=0.25P AD=0.44P PS=1.5U PD=2.88U
M$955 \$47 \$109 VSS VSS nfet_06v0 L=1U W=1U AS=0.44P AD=0.25P PS=2.88U PD=1.5U
M$956 \$109 \$109 \$47 VSS nfet_06v0 L=1U W=1U AS=0.25P AD=0.44P PS=1.5U
+ PD=2.88U
M$957 \$67 \$80 VSS VSS nfet_06v0 L=1U W=5U AS=2.2P AD=1.25P PS=10.88U PD=5.5U
M$958 \$19 \$84 \$67 VSS nfet_06v0 L=1U W=5U AS=1.25P AD=2.2P PS=5.5U PD=10.88U
M$959 \$68 \$80 VSS VSS nfet_06v0 L=1U W=5U AS=2.2P AD=1.25P PS=10.88U PD=5.5U
M$960 \$19 \$84 \$68 VSS nfet_06v0 L=1U W=5U AS=1.25P AD=2.2P PS=5.5U PD=10.88U
M$961 \$20 S3P \$19 VSS nfet_06v0 L=1U W=7.5U AS=3.3P AD=3.3P PS=15.88U
+ PD=15.88U
M$962 \$21 S3N \$19 VSS nfet_06v0 L=1U W=8.5U AS=3.74P AD=3.74P PS=17.88U
+ PD=17.88U
M$963 \$22 \$53 VSS VSS nfet_06v0 L=1U W=2.5U AS=1.1P AD=0.825P PS=5.88U
+ PD=3.16U
M$964 \$53 \$84 \$22 VSS nfet_06v0 L=1U W=2.5U AS=0.825P AD=1.1P PS=3.16U
+ PD=5.88U
M$965 \$96 \$53 VSS VSS nfet_06v0 L=1U W=2.5U AS=1.1P AD=0.825P PS=5.88U
+ PD=3.16U
M$966 \$23 \$84 \$96 VSS nfet_06v0 L=1U W=2.5U AS=0.825P AD=1.1P PS=3.16U
+ PD=5.88U
M$967 \$129 \$54 \$53 VSS nfet_06v0 L=1U W=2U AS=0.88P AD=0.88P PS=4.88U
+ PD=4.88U
M$968 \$113 \$54 \$23 VSS nfet_06v0 L=1U W=2U AS=0.88P AD=0.88P PS=4.88U
+ PD=4.88U
M$969 \$69 \$80 VSS VSS nfet_06v0 L=1U W=5U AS=2.2P AD=1.25P PS=10.88U PD=5.5U
M$970 \$24 \$84 \$69 VSS nfet_06v0 L=1U W=5U AS=1.25P AD=2.2P PS=5.5U PD=10.88U
M$971 \$70 \$25 VSS VSS nfet_06v0 L=1U W=5U AS=2.2P AD=1.25P PS=10.88U PD=5.5U
M$972 \$25 \$84 \$70 VSS nfet_06v0 L=1U W=5U AS=1.25P AD=1.65P PS=5.5U PD=5.66U
M$973 \$54 \$54 \$25 VSS nfet_06v0 L=1U W=5U AS=1.65P AD=2.2P PS=5.66U PD=10.88U
M$974 \$26 \$23 VSS VSS nfet_06v0 L=1U W=1U AS=0.44P AD=0.44P PS=2.88U PD=2.88U
M$975 \$84 \$84 VSS VSS nfet_06v0 L=1U W=1U AS=0.44P AD=0.44P PS=2.88U PD=2.88U
M$976 \$71 \$80 VSS VSS nfet_06v0 L=1U W=5U AS=2.2P AD=1.25P PS=10.88U PD=5.5U
M$977 \$80 \$84 \$71 VSS nfet_06v0 L=1U W=5U AS=1.25P AD=2.2P PS=5.5U PD=10.88U
M$978 \$50 \$112 VSS VSS nfet_06v0 L=1U W=1U AS=0.44P AD=0.25P PS=2.88U PD=1.5U
M$979 \$88 \$112 \$50 VSS nfet_06v0 L=1U W=1U AS=0.25P AD=0.44P PS=1.5U PD=2.88U
M$980 \$49 \$112 VSS VSS nfet_06v0 L=1U W=1U AS=0.44P AD=0.25P PS=2.88U PD=1.5U
M$981 \$112 \$112 \$49 VSS nfet_06v0 L=1U W=1U AS=0.25P AD=0.44P PS=1.5U
+ PD=2.88U
M$982 \$72 \$81 VSS VSS nfet_06v0 L=1U W=5U AS=2.2P AD=1.25P PS=10.88U PD=5.5U
M$983 \$27 \$85 \$72 VSS nfet_06v0 L=1U W=5U AS=1.25P AD=2.2P PS=5.5U PD=10.88U
M$984 \$73 \$81 VSS VSS nfet_06v0 L=1U W=5U AS=2.2P AD=1.25P PS=10.88U PD=5.5U
M$985 \$27 \$85 \$73 VSS nfet_06v0 L=1U W=5U AS=1.25P AD=2.2P PS=5.5U PD=10.88U
M$986 \$28 S1P \$27 VSS nfet_06v0 L=1U W=7.5U AS=3.3P AD=3.3P PS=15.88U
+ PD=15.88U
M$987 \$29 S1N \$27 VSS nfet_06v0 L=1U W=8.5U AS=3.74P AD=3.74P PS=17.88U
+ PD=17.88U
M$988 \$30 \$55 VSS VSS nfet_06v0 L=1U W=2.5U AS=1.1P AD=0.825P PS=5.88U
+ PD=3.16U
M$989 \$55 \$85 \$30 VSS nfet_06v0 L=1U W=2.5U AS=0.825P AD=1.1P PS=3.16U
+ PD=5.88U
M$990 \$102 \$55 VSS VSS nfet_06v0 L=1U W=2.5U AS=1.1P AD=0.825P PS=5.88U
+ PD=3.16U
M$991 \$31 \$85 \$102 VSS nfet_06v0 L=1U W=2.5U AS=0.825P AD=1.1P PS=3.16U
+ PD=5.88U
M$992 \$131 \$56 \$55 VSS nfet_06v0 L=1U W=2U AS=0.88P AD=0.88P PS=4.88U
+ PD=4.88U
M$993 \$115 \$56 \$31 VSS nfet_06v0 L=1U W=2U AS=0.88P AD=0.88P PS=4.88U
+ PD=4.88U
M$994 \$76 \$81 VSS VSS nfet_06v0 L=1U W=5U AS=2.2P AD=1.25P PS=10.88U PD=5.5U
M$995 \$32 \$85 \$76 VSS nfet_06v0 L=1U W=5U AS=1.25P AD=2.2P PS=5.5U PD=10.88U
M$996 \$77 \$33 VSS VSS nfet_06v0 L=1U W=5U AS=2.2P AD=1.25P PS=10.88U PD=5.5U
M$997 \$33 \$85 \$77 VSS nfet_06v0 L=1U W=5U AS=1.25P AD=1.65P PS=5.5U PD=5.66U
M$998 \$56 \$56 \$33 VSS nfet_06v0 L=1U W=5U AS=1.65P AD=2.2P PS=5.66U PD=10.88U
M$999 \$34 \$31 VSS VSS nfet_06v0 L=1U W=1U AS=0.44P AD=0.44P PS=2.88U PD=2.88U
M$1000 \$85 \$85 VSS VSS nfet_06v0 L=1U W=1U AS=0.44P AD=0.44P PS=2.88U PD=2.88U
M$1001 \$78 \$81 VSS VSS nfet_06v0 L=1U W=5U AS=2.2P AD=1.25P PS=10.88U PD=5.5U
M$1002 \$81 \$85 \$78 VSS nfet_06v0 L=1U W=5U AS=1.25P AD=2.2P PS=5.5U PD=10.88U
M$1003 \$48 \$114 VSS VSS nfet_06v0 L=1U W=1U AS=0.44P AD=0.25P PS=2.88U PD=1.5U
M$1004 \$89 \$114 \$48 VSS nfet_06v0 L=1U W=1U AS=0.25P AD=0.44P PS=1.5U
+ PD=2.88U
M$1005 \$45 \$114 VSS VSS nfet_06v0 L=1U W=1U AS=0.44P AD=0.25P PS=2.88U PD=1.5U
M$1006 \$114 \$114 \$45 VSS nfet_06v0 L=1U W=1U AS=0.25P AD=0.44P PS=1.5U
+ PD=2.88U
M$1007 \$75 \$82 VSS VSS nfet_06v0 L=1U W=5U AS=2.2P AD=1.25P PS=10.88U PD=5.5U
M$1008 \$35 \$86 \$75 VSS nfet_06v0 L=1U W=5U AS=1.25P AD=2.2P PS=5.5U PD=10.88U
M$1009 \$74 \$82 VSS VSS nfet_06v0 L=1U W=5U AS=2.2P AD=1.25P PS=10.88U PD=5.5U
M$1010 \$35 \$86 \$74 VSS nfet_06v0 L=1U W=5U AS=1.25P AD=2.2P PS=5.5U PD=10.88U
M$1011 \$36 S1P \$35 VSS nfet_06v0 L=1U W=7.5U AS=3.3P AD=3.3P PS=15.88U
+ PD=15.88U
M$1012 \$37 S1N \$35 VSS nfet_06v0 L=1U W=8.5U AS=3.74P AD=3.74P PS=17.88U
+ PD=17.88U
M$1013 \$38 \$57 VSS VSS nfet_06v0 L=1U W=2.5U AS=1.1P AD=0.825P PS=5.88U
+ PD=3.16U
M$1014 \$57 \$86 \$38 VSS nfet_06v0 L=1U W=2.5U AS=0.825P AD=1.1P PS=3.16U
+ PD=5.88U
M$1015 \$107 \$57 VSS VSS nfet_06v0 L=1U W=2.5U AS=1.1P AD=0.825P PS=5.88U
+ PD=3.16U
M$1016 \$39 \$86 \$107 VSS nfet_06v0 L=1U W=2.5U AS=0.825P AD=1.1P PS=3.16U
+ PD=5.88U
M$1017 \$133 \$58 \$57 VSS nfet_06v0 L=1U W=2U AS=0.88P AD=0.88P PS=4.88U
+ PD=4.88U
M$1018 \$117 \$58 \$39 VSS nfet_06v0 L=1U W=2U AS=0.88P AD=0.88P PS=4.88U
+ PD=4.88U
M$1019 \$66 \$82 VSS VSS nfet_06v0 L=1U W=5U AS=2.2P AD=1.25P PS=10.88U PD=5.5U
M$1020 \$40 \$86 \$66 VSS nfet_06v0 L=1U W=5U AS=1.25P AD=2.2P PS=5.5U PD=10.88U
M$1021 \$65 \$41 VSS VSS nfet_06v0 L=1U W=5U AS=2.2P AD=1.25P PS=10.88U PD=5.5U
M$1022 \$41 \$86 \$65 VSS nfet_06v0 L=1U W=5U AS=1.25P AD=1.65P PS=5.5U PD=5.66U
M$1023 \$58 \$58 \$41 VSS nfet_06v0 L=1U W=5U AS=1.65P AD=2.2P PS=5.66U
+ PD=10.88U
M$1024 \$42 \$39 VSS VSS nfet_06v0 L=1U W=1U AS=0.44P AD=0.44P PS=2.88U PD=2.88U
M$1025 \$86 \$86 VSS VSS nfet_06v0 L=1U W=1U AS=0.44P AD=0.44P PS=2.88U PD=2.88U
M$1026 \$61 \$82 VSS VSS nfet_06v0 L=1U W=5U AS=2.2P AD=1.25P PS=10.88U PD=5.5U
M$1027 \$82 \$86 \$61 VSS nfet_06v0 L=1U W=5U AS=1.25P AD=2.2P PS=5.5U PD=10.88U
M$1028 \$44 \$116 VSS VSS nfet_06v0 L=1U W=1U AS=0.44P AD=0.25P PS=2.88U PD=1.5U
M$1029 \$90 \$116 \$44 VSS nfet_06v0 L=1U W=1U AS=0.25P AD=0.44P PS=1.5U
+ PD=2.88U
M$1030 \$43 \$116 VSS VSS nfet_06v0 L=1U W=1U AS=0.44P AD=0.25P PS=2.88U PD=1.5U
M$1031 \$116 \$116 \$43 VSS nfet_06v0 L=1U W=1U AS=0.25P AD=0.44P PS=1.5U
+ PD=2.88U
M$1032 VSS VDD VSS VSS nfet_06v0 L=2U W=18U AS=7.92P AD=7.92P PS=36.88U
+ PD=36.88U
M$1033 \$2476 \$2468 VSS VSS nfet_06v0 L=1U W=5U AS=2.2P AD=1.25P PS=10.88U
+ PD=5.5U
M$1034 \$2424 \$2469 \$2476 VSS nfet_06v0 L=1U W=5U AS=1.25P AD=2.2P PS=5.5U
+ PD=10.88U
M$1035 \$2477 \$2468 VSS VSS nfet_06v0 L=1U W=5U AS=2.2P AD=1.25P PS=10.88U
+ PD=5.5U
M$1036 \$2424 \$2469 \$2477 VSS nfet_06v0 L=1U W=5U AS=1.25P AD=2.2P PS=5.5U
+ PD=10.88U
M$1037 \$2425 S2P \$2424 VSS nfet_06v0 L=1U W=7.5U AS=3.3P AD=3.3P PS=15.88U
+ PD=15.88U
M$1038 \$2426 S2N \$2424 VSS nfet_06v0 L=1U W=8.5U AS=3.74P AD=3.74P PS=17.88U
+ PD=17.88U
M$1039 \$2427 \$2510 VSS VSS nfet_06v0 L=1U W=2.5U AS=1.1P AD=0.825P PS=5.88U
+ PD=3.16U
M$1040 \$2510 \$2469 \$2427 VSS nfet_06v0 L=1U W=2.5U AS=0.825P AD=1.1P
+ PS=3.16U PD=5.88U
M$1041 \$2499 \$2510 VSS VSS nfet_06v0 L=1U W=2.5U AS=1.1P AD=0.825P PS=5.88U
+ PD=3.16U
M$1042 \$2428 \$2469 \$2499 VSS nfet_06v0 L=1U W=2.5U AS=0.825P AD=1.1P
+ PS=3.16U PD=5.88U
M$1043 \$2537 \$2464 \$2510 VSS nfet_06v0 L=1U W=2U AS=0.88P AD=0.88P PS=4.88U
+ PD=4.88U
M$1044 \$2526 \$2464 \$2428 VSS nfet_06v0 L=1U W=2U AS=0.88P AD=0.88P PS=4.88U
+ PD=4.88U
M$1045 \$2478 \$2468 VSS VSS nfet_06v0 L=1U W=5U AS=2.2P AD=1.25P PS=10.88U
+ PD=5.5U
M$1046 \$2429 \$2469 \$2478 VSS nfet_06v0 L=1U W=5U AS=1.25P AD=2.2P PS=5.5U
+ PD=10.88U
M$1047 \$2479 \$2430 VSS VSS nfet_06v0 L=1U W=5U AS=2.2P AD=1.25P PS=10.88U
+ PD=5.5U
M$1048 \$2430 \$2469 \$2479 VSS nfet_06v0 L=1U W=5U AS=1.25P AD=1.65P PS=5.5U
+ PD=5.66U
M$1049 \$2464 \$2464 \$2430 VSS nfet_06v0 L=1U W=5U AS=1.65P AD=2.2P PS=5.66U
+ PD=10.88U
M$1050 \$2431 \$2428 VSS VSS nfet_06v0 L=1U W=1U AS=0.44P AD=0.44P PS=2.88U
+ PD=2.88U
M$1051 \$2469 \$2469 VSS VSS nfet_06v0 L=1U W=1U AS=0.44P AD=0.44P PS=2.88U
+ PD=2.88U
M$1052 \$2480 \$2468 VSS VSS nfet_06v0 L=1U W=5U AS=2.2P AD=1.25P PS=10.88U
+ PD=5.5U
M$1053 \$2468 \$2469 \$2480 VSS nfet_06v0 L=1U W=5U AS=1.25P AD=2.2P PS=5.5U
+ PD=10.88U
M$1054 \$2457 \$2520 VSS VSS nfet_06v0 L=1U W=1U AS=0.44P AD=0.25P PS=2.88U
+ PD=1.5U
M$1055 \$2496 \$2520 \$2457 VSS nfet_06v0 L=1U W=1U AS=0.25P AD=0.44P PS=1.5U
+ PD=2.88U
M$1056 \$2458 \$2520 VSS VSS nfet_06v0 L=1U W=1U AS=0.44P AD=0.25P PS=2.88U
+ PD=1.5U
M$1057 \$2520 \$2520 \$2458 VSS nfet_06v0 L=1U W=1U AS=0.25P AD=0.44P PS=1.5U
+ PD=2.88U
M$1058 VSS VDD VSS VSS nfet_06v0 L=2U W=18U AS=7.92P AD=7.92P PS=36.88U
+ PD=36.88U
M$1059 VSS VDD VSS VSS nfet_06v0 L=2U W=18U AS=7.92P AD=7.92P PS=36.88U
+ PD=36.88U
M$1060 \$2483 \$2470 VSS VSS nfet_06v0 L=1U W=5U AS=2.2P AD=1.25P PS=10.88U
+ PD=5.5U
M$1061 \$2432 \$2471 \$2483 VSS nfet_06v0 L=1U W=5U AS=1.25P AD=2.2P PS=5.5U
+ PD=10.88U
M$1062 \$2484 \$2470 VSS VSS nfet_06v0 L=1U W=5U AS=2.2P AD=1.25P PS=10.88U
+ PD=5.5U
M$1063 \$2432 \$2471 \$2484 VSS nfet_06v0 L=1U W=5U AS=1.25P AD=2.2P PS=5.5U
+ PD=10.88U
M$1064 \$2433 \$2539 \$2432 VSS nfet_06v0 L=1U W=7.5U AS=3.3P AD=3.3P PS=15.88U
+ PD=15.88U
M$1065 \$2434 S4N \$2432 VSS nfet_06v0 L=1U W=8.5U AS=3.74P AD=3.74P PS=17.88U
+ PD=17.88U
M$1066 \$2435 \$2512 VSS VSS nfet_06v0 L=1U W=2.5U AS=1.1P AD=0.825P PS=5.88U
+ PD=3.16U
M$1067 \$2512 \$2471 \$2435 VSS nfet_06v0 L=1U W=2.5U AS=0.825P AD=1.1P
+ PS=3.16U PD=5.88U
M$1068 \$2501 \$2512 VSS VSS nfet_06v0 L=1U W=2.5U AS=1.1P AD=0.825P PS=5.88U
+ PD=3.16U
M$1069 \$2436 \$2471 \$2501 VSS nfet_06v0 L=1U W=2.5U AS=0.825P AD=1.1P
+ PS=3.16U PD=5.88U
M$1070 \$2540 \$2465 \$2512 VSS nfet_06v0 L=1U W=2U AS=0.88P AD=0.88P PS=4.88U
+ PD=4.88U
M$1071 \$2529 \$2465 \$2436 VSS nfet_06v0 L=1U W=2U AS=0.88P AD=0.88P PS=4.88U
+ PD=4.88U
M$1072 \$2486 \$2470 VSS VSS nfet_06v0 L=1U W=5U AS=2.2P AD=1.25P PS=10.88U
+ PD=5.5U
M$1073 \$2437 \$2471 \$2486 VSS nfet_06v0 L=1U W=5U AS=1.25P AD=2.2P PS=5.5U
+ PD=10.88U
M$1074 \$2487 \$2438 VSS VSS nfet_06v0 L=1U W=5U AS=2.2P AD=1.25P PS=10.88U
+ PD=5.5U
M$1075 \$2438 \$2471 \$2487 VSS nfet_06v0 L=1U W=5U AS=1.25P AD=1.65P PS=5.5U
+ PD=5.66U
M$1076 \$2465 \$2465 \$2438 VSS nfet_06v0 L=1U W=5U AS=1.65P AD=2.2P PS=5.66U
+ PD=10.88U
M$1077 \$2439 \$2436 VSS VSS nfet_06v0 L=1U W=1U AS=0.44P AD=0.44P PS=2.88U
+ PD=2.88U
M$1078 \$2471 \$2471 VSS VSS nfet_06v0 L=1U W=1U AS=0.44P AD=0.44P PS=2.88U
+ PD=2.88U
M$1079 \$2488 \$2470 VSS VSS nfet_06v0 L=1U W=5U AS=2.2P AD=1.25P PS=10.88U
+ PD=5.5U
M$1080 \$2470 \$2471 \$2488 VSS nfet_06v0 L=1U W=5U AS=1.25P AD=2.2P PS=5.5U
+ PD=10.88U
M$1081 \$2460 \$2521 VSS VSS nfet_06v0 L=1U W=1U AS=0.44P AD=0.25P PS=2.88U
+ PD=1.5U
M$1082 \$2500 \$2521 \$2460 VSS nfet_06v0 L=1U W=1U AS=0.25P AD=0.44P PS=1.5U
+ PD=2.88U
M$1083 \$2461 \$2521 VSS VSS nfet_06v0 L=1U W=1U AS=0.44P AD=0.25P PS=2.88U
+ PD=1.5U
M$1084 \$2521 \$2521 \$2461 VSS nfet_06v0 L=1U W=1U AS=0.25P AD=0.44P PS=1.5U
+ PD=2.88U
M$1085 VSS VDD VSS VSS nfet_06v0 L=2U W=18U AS=7.92P AD=7.92P PS=36.88U
+ PD=36.88U
M$1086 VSS VDD VSS VSS nfet_06v0 L=2U W=18U AS=7.92P AD=7.92P PS=36.88U
+ PD=36.88U
M$1087 \$2490 \$2472 VSS VSS nfet_06v0 L=1U W=5U AS=2.2P AD=1.25P PS=10.88U
+ PD=5.5U
M$1088 \$2440 \$2473 \$2490 VSS nfet_06v0 L=1U W=5U AS=1.25P AD=2.2P PS=5.5U
+ PD=10.88U
M$1089 \$2492 \$2472 VSS VSS nfet_06v0 L=1U W=5U AS=2.2P AD=1.25P PS=10.88U
+ PD=5.5U
M$1090 \$2440 \$2473 \$2492 VSS nfet_06v0 L=1U W=5U AS=1.25P AD=2.2P PS=5.5U
+ PD=10.88U
M$1091 \$2441 S4P \$2440 VSS nfet_06v0 L=1U W=7.5U AS=3.3P AD=3.3P PS=15.88U
+ PD=15.88U
M$1092 \$2442 S4N \$2440 VSS nfet_06v0 L=1U W=8.5U AS=3.74P AD=3.74P PS=17.88U
+ PD=17.88U
M$1093 \$2443 \$2515 VSS VSS nfet_06v0 L=1U W=2.5U AS=1.1P AD=0.825P PS=5.88U
+ PD=3.16U
M$1094 \$2515 \$2473 \$2443 VSS nfet_06v0 L=1U W=2.5U AS=0.825P AD=1.1P
+ PS=3.16U PD=5.88U
M$1095 \$2514 \$2515 VSS VSS nfet_06v0 L=1U W=2.5U AS=1.1P AD=0.825P PS=5.88U
+ PD=3.16U
M$1096 \$2444 \$2473 \$2514 VSS nfet_06v0 L=1U W=2.5U AS=0.825P AD=1.1P
+ PS=3.16U PD=5.88U
M$1097 \$2542 \$2466 \$2515 VSS nfet_06v0 L=1U W=2U AS=0.88P AD=0.88P PS=4.88U
+ PD=4.88U
M$1098 \$2532 \$2466 \$2444 VSS nfet_06v0 L=1U W=2U AS=0.88P AD=0.88P PS=4.88U
+ PD=4.88U
M$1099 \$2493 \$2472 VSS VSS nfet_06v0 L=1U W=5U AS=2.2P AD=1.25P PS=10.88U
+ PD=5.5U
M$1100 \$2445 \$2473 \$2493 VSS nfet_06v0 L=1U W=5U AS=1.25P AD=2.2P PS=5.5U
+ PD=10.88U
M$1101 \$2494 \$2446 VSS VSS nfet_06v0 L=1U W=5U AS=2.2P AD=1.25P PS=10.88U
+ PD=5.5U
M$1102 \$2446 \$2473 \$2494 VSS nfet_06v0 L=1U W=5U AS=1.25P AD=1.65P PS=5.5U
+ PD=5.66U
M$1103 \$2466 \$2466 \$2446 VSS nfet_06v0 L=1U W=5U AS=1.65P AD=2.2P PS=5.66U
+ PD=10.88U
M$1104 \$2447 \$2444 VSS VSS nfet_06v0 L=1U W=1U AS=0.44P AD=0.44P PS=2.88U
+ PD=2.88U
M$1105 \$2473 \$2473 VSS VSS nfet_06v0 L=1U W=1U AS=0.44P AD=0.44P PS=2.88U
+ PD=2.88U
M$1106 \$2495 \$2472 VSS VSS nfet_06v0 L=1U W=5U AS=2.2P AD=1.25P PS=10.88U
+ PD=5.5U
M$1107 \$2472 \$2473 \$2495 VSS nfet_06v0 L=1U W=5U AS=1.25P AD=2.2P PS=5.5U
+ PD=10.88U
M$1108 \$2462 \$2522 VSS VSS nfet_06v0 L=1U W=1U AS=0.44P AD=0.25P PS=2.88U
+ PD=1.5U
M$1109 \$2504 \$2522 \$2462 VSS nfet_06v0 L=1U W=1U AS=0.25P AD=0.44P PS=1.5U
+ PD=2.88U
M$1110 \$2463 \$2522 VSS VSS nfet_06v0 L=1U W=1U AS=0.44P AD=0.25P PS=2.88U
+ PD=1.5U
M$1111 \$2522 \$2522 \$2463 VSS nfet_06v0 L=1U W=1U AS=0.25P AD=0.44P PS=1.5U
+ PD=2.88U
M$1112 VSS VDD VSS VSS nfet_06v0 L=2U W=18U AS=7.92P AD=7.92P PS=36.88U
+ PD=36.88U
M$1113 VSS VDD VSS VSS nfet_06v0 L=2U W=18U AS=7.92P AD=7.92P PS=36.88U
+ PD=36.88U
M$1114 \$2491 \$2474 VSS VSS nfet_06v0 L=1U W=5U AS=2.2P AD=1.25P PS=10.88U
+ PD=5.5U
M$1115 \$2448 \$2475 \$2491 VSS nfet_06v0 L=1U W=5U AS=1.25P AD=2.2P PS=5.5U
+ PD=10.88U
M$1116 \$2489 \$2474 VSS VSS nfet_06v0 L=1U W=5U AS=2.2P AD=1.25P PS=10.88U
+ PD=5.5U
M$1117 \$2448 \$2475 \$2489 VSS nfet_06v0 L=1U W=5U AS=1.25P AD=2.2P PS=5.5U
+ PD=10.88U
M$1118 \$2449 S1P \$2448 VSS nfet_06v0 L=1U W=7.5U AS=3.3P AD=3.3P PS=15.88U
+ PD=15.88U
M$1119 \$2450 S1N \$2448 VSS nfet_06v0 L=1U W=8.5U AS=3.74P AD=3.74P PS=17.88U
+ PD=17.88U
M$1120 \$2451 \$2518 VSS VSS nfet_06v0 L=1U W=2.5U AS=1.1P AD=0.825P PS=5.88U
+ PD=3.16U
M$1121 \$2518 \$2475 \$2451 VSS nfet_06v0 L=1U W=2.5U AS=0.825P AD=1.1P
+ PS=3.16U PD=5.88U
M$1122 \$2517 \$2518 VSS VSS nfet_06v0 L=1U W=2.5U AS=1.1P AD=0.825P PS=5.88U
+ PD=3.16U
M$1123 \$2452 \$2475 \$2517 VSS nfet_06v0 L=1U W=2.5U AS=0.825P AD=1.1P
+ PS=3.16U PD=5.88U
M$1124 \$2544 \$2467 \$2518 VSS nfet_06v0 L=1U W=2U AS=0.88P AD=0.88P PS=4.88U
+ PD=4.88U
M$1125 \$2535 \$2467 \$2452 VSS nfet_06v0 L=1U W=2U AS=0.88P AD=0.88P PS=4.88U
+ PD=4.88U
M$1126 \$2485 \$2474 VSS VSS nfet_06v0 L=1U W=5U AS=2.2P AD=1.25P PS=10.88U
+ PD=5.5U
M$1127 \$2453 \$2475 \$2485 VSS nfet_06v0 L=1U W=5U AS=1.25P AD=2.2P PS=5.5U
+ PD=10.88U
M$1128 \$2482 \$2454 VSS VSS nfet_06v0 L=1U W=5U AS=2.2P AD=1.25P PS=10.88U
+ PD=5.5U
M$1129 \$2454 \$2475 \$2482 VSS nfet_06v0 L=1U W=5U AS=1.25P AD=1.65P PS=5.5U
+ PD=5.66U
M$1130 \$2467 \$2467 \$2454 VSS nfet_06v0 L=1U W=5U AS=1.65P AD=2.2P PS=5.66U
+ PD=10.88U
M$1131 \$2455 \$2452 VSS VSS nfet_06v0 L=1U W=1U AS=0.44P AD=0.44P PS=2.88U
+ PD=2.88U
M$1132 \$2475 \$2475 VSS VSS nfet_06v0 L=1U W=1U AS=0.44P AD=0.44P PS=2.88U
+ PD=2.88U
M$1133 \$2481 \$2474 VSS VSS nfet_06v0 L=1U W=5U AS=2.2P AD=1.25P PS=10.88U
+ PD=5.5U
M$1134 \$2474 \$2475 \$2481 VSS nfet_06v0 L=1U W=5U AS=1.25P AD=2.2P PS=5.5U
+ PD=10.88U
M$1135 \$2459 \$2523 VSS VSS nfet_06v0 L=1U W=1U AS=0.44P AD=0.25P PS=2.88U
+ PD=1.5U
M$1136 \$2507 \$2523 \$2459 VSS nfet_06v0 L=1U W=1U AS=0.25P AD=0.44P PS=1.5U
+ PD=2.88U
M$1137 \$2456 \$2523 VSS VSS nfet_06v0 L=1U W=1U AS=0.44P AD=0.25P PS=2.88U
+ PD=1.5U
M$1138 \$2523 \$2523 \$2456 VSS nfet_06v0 L=1U W=1U AS=0.25P AD=0.44P PS=1.5U
+ PD=2.88U
M$1139 VSS VDD VSS VSS nfet_06v0 L=2U W=18U AS=7.92P AD=7.92P PS=36.88U
+ PD=36.88U
M$1140 VSS VDD VSS VSS nfet_06v0 L=2U W=18U AS=7.92P AD=7.92P PS=36.88U
+ PD=36.88U
M$1141 VSS VDD VSS VSS nfet_06v0 L=2U W=18U AS=7.92P AD=7.92P PS=36.88U
+ PD=36.88U
M$1142 VSS VDD VSS VSS nfet_06v0 L=2U W=18U AS=7.92P AD=7.92P PS=36.88U
+ PD=36.88U
M$1143 \$4891 \$4883 VSS VSS nfet_06v0 L=1U W=5U AS=2.2P AD=1.25P PS=10.88U
+ PD=5.5U
M$1144 \$4835 \$4884 \$4891 VSS nfet_06v0 L=1U W=5U AS=1.25P AD=2.2P PS=5.5U
+ PD=10.88U
M$1145 \$4892 \$4883 VSS VSS nfet_06v0 L=1U W=5U AS=2.2P AD=1.25P PS=10.88U
+ PD=5.5U
M$1146 \$4835 \$4884 \$4892 VSS nfet_06v0 L=1U W=5U AS=1.25P AD=2.2P PS=5.5U
+ PD=10.88U
M$1147 \$4836 S3P \$4835 VSS nfet_06v0 L=1U W=7.5U AS=3.3P AD=3.3P PS=15.88U
+ PD=15.88U
M$1148 \$4837 S3N \$4835 VSS nfet_06v0 L=1U W=8.5U AS=3.74P AD=3.74P PS=17.88U
+ PD=17.88U
M$1149 \$4838 \$4875 VSS VSS nfet_06v0 L=1U W=2.5U AS=1.1P AD=0.825P PS=5.88U
+ PD=3.16U
M$1150 \$4875 \$4884 \$4838 VSS nfet_06v0 L=1U W=2.5U AS=0.825P AD=1.1P
+ PS=3.16U PD=5.88U
M$1151 \$4916 \$4875 VSS VSS nfet_06v0 L=1U W=2.5U AS=1.1P AD=0.825P PS=5.88U
+ PD=3.16U
M$1152 \$4839 \$4884 \$4916 VSS nfet_06v0 L=1U W=2.5U AS=0.825P AD=1.1P
+ PS=3.16U PD=5.88U
M$1153 \$4948 \$4876 \$4875 VSS nfet_06v0 L=1U W=2U AS=0.88P AD=0.88P PS=4.88U
+ PD=4.88U
M$1154 \$4934 \$4876 \$4839 VSS nfet_06v0 L=1U W=2U AS=0.88P AD=0.88P PS=4.88U
+ PD=4.88U
M$1155 \$4893 \$4883 VSS VSS nfet_06v0 L=1U W=5U AS=2.2P AD=1.25P PS=10.88U
+ PD=5.5U
M$1156 \$4840 \$4884 \$4893 VSS nfet_06v0 L=1U W=5U AS=1.25P AD=2.2P PS=5.5U
+ PD=10.88U
M$1157 \$4894 \$4841 VSS VSS nfet_06v0 L=1U W=5U AS=2.2P AD=1.25P PS=10.88U
+ PD=5.5U
M$1158 \$4841 \$4884 \$4894 VSS nfet_06v0 L=1U W=5U AS=1.25P AD=1.65P PS=5.5U
+ PD=5.66U
M$1159 \$4876 \$4876 \$4841 VSS nfet_06v0 L=1U W=5U AS=1.65P AD=2.2P PS=5.66U
+ PD=10.88U
M$1160 \$4842 \$4839 VSS VSS nfet_06v0 L=1U W=1U AS=0.44P AD=0.44P PS=2.88U
+ PD=2.88U
M$1161 \$4884 \$4884 VSS VSS nfet_06v0 L=1U W=1U AS=0.44P AD=0.44P PS=2.88U
+ PD=2.88U
M$1162 \$4896 \$4883 VSS VSS nfet_06v0 L=1U W=5U AS=2.2P AD=1.25P PS=10.88U
+ PD=5.5U
M$1163 \$4883 \$4884 \$4896 VSS nfet_06v0 L=1U W=5U AS=1.25P AD=2.2P PS=5.5U
+ PD=10.88U
M$1164 \$4868 \$4931 VSS VSS nfet_06v0 L=1U W=1U AS=0.44P AD=0.25P PS=2.88U
+ PD=1.5U
M$1165 \$4911 \$4931 \$4868 VSS nfet_06v0 L=1U W=1U AS=0.25P AD=0.44P PS=1.5U
+ PD=2.88U
M$1166 \$4869 \$4931 VSS VSS nfet_06v0 L=1U W=1U AS=0.44P AD=0.25P PS=2.88U
+ PD=1.5U
M$1167 \$4931 \$4931 \$4869 VSS nfet_06v0 L=1U W=1U AS=0.25P AD=0.44P PS=1.5U
+ PD=2.88U
M$1168 VSS VDD VSS VSS nfet_06v0 L=2U W=18U AS=7.92P AD=7.92P PS=36.88U
+ PD=36.88U
M$1169 VSS VDD VSS VSS nfet_06v0 L=2U W=18U AS=7.92P AD=7.92P PS=36.88U
+ PD=36.88U
M$1170 \$4898 \$4885 VSS VSS nfet_06v0 L=1U W=5U AS=2.2P AD=1.25P PS=10.88U
+ PD=5.5U
M$1171 \$4843 \$4886 \$4898 VSS nfet_06v0 L=1U W=5U AS=1.25P AD=2.2P PS=5.5U
+ PD=10.88U
M$1172 \$4900 \$4885 VSS VSS nfet_06v0 L=1U W=5U AS=2.2P AD=1.25P PS=10.88U
+ PD=5.5U
M$1173 \$4843 \$4886 \$4900 VSS nfet_06v0 L=1U W=5U AS=1.25P AD=2.2P PS=5.5U
+ PD=10.88U
M$1174 \$4844 S3P \$4843 VSS nfet_06v0 L=1U W=7.5U AS=3.3P AD=3.3P PS=15.88U
+ PD=15.88U
M$1175 \$4845 S3N \$4843 VSS nfet_06v0 L=1U W=8.5U AS=3.74P AD=3.74P PS=17.88U
+ PD=17.88U
M$1176 \$4846 \$4877 VSS VSS nfet_06v0 L=1U W=2.5U AS=1.1P AD=0.825P PS=5.88U
+ PD=3.16U
M$1177 \$4877 \$4886 \$4846 VSS nfet_06v0 L=1U W=2.5U AS=0.825P AD=1.1P
+ PS=3.16U PD=5.88U
M$1178 \$4919 \$4877 VSS VSS nfet_06v0 L=1U W=2.5U AS=1.1P AD=0.825P PS=5.88U
+ PD=3.16U
M$1179 \$4847 \$4886 \$4919 VSS nfet_06v0 L=1U W=2.5U AS=0.825P AD=1.1P
+ PS=3.16U PD=5.88U
M$1180 \$4950 \$4878 \$4877 VSS nfet_06v0 L=1U W=2U AS=0.88P AD=0.88P PS=4.88U
+ PD=4.88U
M$1181 \$4938 \$4878 \$4847 VSS nfet_06v0 L=1U W=2U AS=0.88P AD=0.88P PS=4.88U
+ PD=4.88U
M$1182 \$4901 \$4885 VSS VSS nfet_06v0 L=1U W=5U AS=2.2P AD=1.25P PS=10.88U
+ PD=5.5U
M$1183 \$4848 \$4886 \$4901 VSS nfet_06v0 L=1U W=5U AS=1.25P AD=2.2P PS=5.5U
+ PD=10.88U
M$1184 \$4902 \$4849 VSS VSS nfet_06v0 L=1U W=5U AS=2.2P AD=1.25P PS=10.88U
+ PD=5.5U
M$1185 \$4849 \$4886 \$4902 VSS nfet_06v0 L=1U W=5U AS=1.25P AD=1.65P PS=5.5U
+ PD=5.66U
M$1186 \$4878 \$4878 \$4849 VSS nfet_06v0 L=1U W=5U AS=1.65P AD=2.2P PS=5.66U
+ PD=10.88U
M$1187 \$4850 \$4847 VSS VSS nfet_06v0 L=1U W=1U AS=0.44P AD=0.44P PS=2.88U
+ PD=2.88U
M$1188 \$4886 \$4886 VSS VSS nfet_06v0 L=1U W=1U AS=0.44P AD=0.44P PS=2.88U
+ PD=2.88U
M$1189 \$4903 \$4885 VSS VSS nfet_06v0 L=1U W=5U AS=2.2P AD=1.25P PS=10.88U
+ PD=5.5U
M$1190 \$4885 \$4886 \$4903 VSS nfet_06v0 L=1U W=5U AS=1.25P AD=2.2P PS=5.5U
+ PD=10.88U
M$1191 \$4871 \$4935 VSS VSS nfet_06v0 L=1U W=1U AS=0.44P AD=0.25P PS=2.88U
+ PD=1.5U
M$1192 \$4912 \$4935 \$4871 VSS nfet_06v0 L=1U W=1U AS=0.25P AD=0.44P PS=1.5U
+ PD=2.88U
M$1193 \$4872 \$4935 VSS VSS nfet_06v0 L=1U W=1U AS=0.44P AD=0.25P PS=2.88U
+ PD=1.5U
M$1194 \$4935 \$4935 \$4872 VSS nfet_06v0 L=1U W=1U AS=0.25P AD=0.44P PS=1.5U
+ PD=2.88U
M$1195 VSS VDD VSS VSS nfet_06v0 L=2U W=18U AS=7.92P AD=7.92P PS=36.88U
+ PD=36.88U
M$1196 VSS VDD VSS VSS nfet_06v0 L=2U W=18U AS=7.92P AD=7.92P PS=36.88U
+ PD=36.88U
M$1197 \$4906 \$4887 VSS VSS nfet_06v0 L=1U W=5U AS=2.2P AD=1.25P PS=10.88U
+ PD=5.5U
M$1198 \$4851 \$4888 \$4906 VSS nfet_06v0 L=1U W=5U AS=1.25P AD=2.2P PS=5.5U
+ PD=10.88U
M$1199 \$4907 \$4887 VSS VSS nfet_06v0 L=1U W=5U AS=2.2P AD=1.25P PS=10.88U
+ PD=5.5U
M$1200 \$4851 \$4888 \$4907 VSS nfet_06v0 L=1U W=5U AS=1.25P AD=2.2P PS=5.5U
+ PD=10.88U
M$1201 \$4852 S4P \$4851 VSS nfet_06v0 L=1U W=7.5U AS=3.3P AD=3.3P PS=15.88U
+ PD=15.88U
M$1202 \$4853 S4N \$4851 VSS nfet_06v0 L=1U W=8.5U AS=3.74P AD=3.74P PS=17.88U
+ PD=17.88U
M$1203 \$4854 \$4879 VSS VSS nfet_06v0 L=1U W=2.5U AS=1.1P AD=0.825P PS=5.88U
+ PD=3.16U
M$1204 \$4879 \$4888 \$4854 VSS nfet_06v0 L=1U W=2.5U AS=0.825P AD=1.1P
+ PS=3.16U PD=5.88U
M$1205 \$4923 \$4879 VSS VSS nfet_06v0 L=1U W=2.5U AS=1.1P AD=0.825P PS=5.88U
+ PD=3.16U
M$1206 \$4855 \$4888 \$4923 VSS nfet_06v0 L=1U W=2.5U AS=0.825P AD=1.1P
+ PS=3.16U PD=5.88U
M$1207 \$4952 \$4880 \$4879 VSS nfet_06v0 L=1U W=2U AS=0.88P AD=0.88P PS=4.88U
+ PD=4.88U
M$1208 \$4942 \$4880 \$4855 VSS nfet_06v0 L=1U W=2U AS=0.88P AD=0.88P PS=4.88U
+ PD=4.88U
M$1209 \$4908 \$4887 VSS VSS nfet_06v0 L=1U W=5U AS=2.2P AD=1.25P PS=10.88U
+ PD=5.5U
M$1210 \$4856 \$4888 \$4908 VSS nfet_06v0 L=1U W=5U AS=1.25P AD=2.2P PS=5.5U
+ PD=10.88U
M$1211 \$4909 \$4857 VSS VSS nfet_06v0 L=1U W=5U AS=2.2P AD=1.25P PS=10.88U
+ PD=5.5U
M$1212 \$4857 \$4888 \$4909 VSS nfet_06v0 L=1U W=5U AS=1.25P AD=1.65P PS=5.5U
+ PD=5.66U
M$1213 \$4880 \$4880 \$4857 VSS nfet_06v0 L=1U W=5U AS=1.65P AD=2.2P PS=5.66U
+ PD=10.88U
M$1214 \$4858 \$4855 VSS VSS nfet_06v0 L=1U W=1U AS=0.44P AD=0.44P PS=2.88U
+ PD=2.88U
M$1215 \$4888 \$4888 VSS VSS nfet_06v0 L=1U W=1U AS=0.44P AD=0.44P PS=2.88U
+ PD=2.88U
M$1216 \$4910 \$4887 VSS VSS nfet_06v0 L=1U W=5U AS=2.2P AD=1.25P PS=10.88U
+ PD=5.5U
M$1217 \$4887 \$4888 \$4910 VSS nfet_06v0 L=1U W=5U AS=1.25P AD=2.2P PS=5.5U
+ PD=10.88U
M$1218 \$4873 \$4939 VSS VSS nfet_06v0 L=1U W=1U AS=0.44P AD=0.25P PS=2.88U
+ PD=1.5U
M$1219 \$4913 \$4939 \$4873 VSS nfet_06v0 L=1U W=1U AS=0.25P AD=0.44P PS=1.5U
+ PD=2.88U
M$1220 \$4874 \$4939 VSS VSS nfet_06v0 L=1U W=1U AS=0.44P AD=0.25P PS=2.88U
+ PD=1.5U
M$1221 \$4939 \$4939 \$4874 VSS nfet_06v0 L=1U W=1U AS=0.25P AD=0.44P PS=1.5U
+ PD=2.88U
M$1222 VSS VDD VSS VSS nfet_06v0 L=2U W=18U AS=7.92P AD=7.92P PS=36.88U
+ PD=36.88U
M$1223 VSS VDD VSS VSS nfet_06v0 L=2U W=18U AS=7.92P AD=7.92P PS=36.88U
+ PD=36.88U
M$1224 \$4905 \$4889 VSS VSS nfet_06v0 L=1U W=5U AS=2.2P AD=1.25P PS=10.88U
+ PD=5.5U
M$1225 \$4859 \$4890 \$4905 VSS nfet_06v0 L=1U W=5U AS=1.25P AD=2.2P PS=5.5U
+ PD=10.88U
M$1226 \$4904 \$4889 VSS VSS nfet_06v0 L=1U W=5U AS=2.2P AD=1.25P PS=10.88U
+ PD=5.5U
M$1227 \$4859 \$4890 \$4904 VSS nfet_06v0 L=1U W=5U AS=1.25P AD=2.2P PS=5.5U
+ PD=10.88U
M$1228 \$4860 S2P \$4859 VSS nfet_06v0 L=1U W=7.5U AS=3.3P AD=3.3P PS=15.88U
+ PD=15.88U
M$1229 \$4861 S2N \$4859 VSS nfet_06v0 L=1U W=8.5U AS=3.74P AD=3.74P PS=17.88U
+ PD=17.88U
M$1230 \$4862 \$4881 VSS VSS nfet_06v0 L=1U W=2.5U AS=1.1P AD=0.825P PS=5.88U
+ PD=3.16U
M$1231 \$4881 \$4890 \$4862 VSS nfet_06v0 L=1U W=2.5U AS=0.825P AD=1.1P
+ PS=3.16U PD=5.88U
M$1232 \$4927 \$4881 VSS VSS nfet_06v0 L=1U W=2.5U AS=1.1P AD=0.825P PS=5.88U
+ PD=3.16U
M$1233 \$4863 \$4890 \$4927 VSS nfet_06v0 L=1U W=2.5U AS=0.825P AD=1.1P
+ PS=3.16U PD=5.88U
M$1234 \$4954 \$4882 \$4881 VSS nfet_06v0 L=1U W=2U AS=0.88P AD=0.88P PS=4.88U
+ PD=4.88U
M$1235 \$4946 \$4882 \$4863 VSS nfet_06v0 L=1U W=2U AS=0.88P AD=0.88P PS=4.88U
+ PD=4.88U
M$1236 \$4899 \$4889 VSS VSS nfet_06v0 L=1U W=5U AS=2.2P AD=1.25P PS=10.88U
+ PD=5.5U
M$1237 \$4864 \$4890 \$4899 VSS nfet_06v0 L=1U W=5U AS=1.25P AD=2.2P PS=5.5U
+ PD=10.88U
M$1238 \$4897 \$4865 VSS VSS nfet_06v0 L=1U W=5U AS=2.2P AD=1.25P PS=10.88U
+ PD=5.5U
M$1239 \$4865 \$4890 \$4897 VSS nfet_06v0 L=1U W=5U AS=1.25P AD=1.65P PS=5.5U
+ PD=5.66U
M$1240 \$4882 \$4882 \$4865 VSS nfet_06v0 L=1U W=5U AS=1.65P AD=2.2P PS=5.66U
+ PD=10.88U
M$1241 \$4866 \$4863 VSS VSS nfet_06v0 L=1U W=1U AS=0.44P AD=0.44P PS=2.88U
+ PD=2.88U
M$1242 \$4890 \$4890 VSS VSS nfet_06v0 L=1U W=1U AS=0.44P AD=0.44P PS=2.88U
+ PD=2.88U
M$1243 \$4895 \$4889 VSS VSS nfet_06v0 L=1U W=5U AS=2.2P AD=1.25P PS=10.88U
+ PD=5.5U
M$1244 \$4889 \$4890 \$4895 VSS nfet_06v0 L=1U W=5U AS=1.25P AD=2.2P PS=5.5U
+ PD=10.88U
M$1245 \$4870 \$4943 VSS VSS nfet_06v0 L=1U W=1U AS=0.44P AD=0.25P PS=2.88U
+ PD=1.5U
M$1246 \$4914 \$4943 \$4870 VSS nfet_06v0 L=1U W=1U AS=0.25P AD=0.44P PS=1.5U
+ PD=2.88U
M$1247 \$4867 \$4943 VSS VSS nfet_06v0 L=1U W=1U AS=0.44P AD=0.25P PS=2.88U
+ PD=1.5U
M$1248 \$4943 \$4943 \$4867 VSS nfet_06v0 L=1U W=1U AS=0.25P AD=0.44P PS=1.5U
+ PD=2.88U
M$1249 VSS VDD VSS VSS nfet_06v0 L=2U W=18U AS=7.92P AD=7.92P PS=36.88U
+ PD=36.88U
M$1250 VSS VDD VSS VSS nfet_06v0 L=2U W=18U AS=7.92P AD=7.92P PS=36.88U
+ PD=36.88U
M$1251 VSS VDD VSS VSS nfet_06v0 L=2U W=18U AS=7.92P AD=7.92P PS=36.88U
+ PD=36.88U
M$1252 VSS VDD VSS VSS nfet_06v0 L=2U W=18U AS=7.92P AD=7.92P PS=36.88U
+ PD=36.88U
M$1253 \$7264 \$7264 VSS VSS nfet_06v0 L=1U W=1U AS=0.44P AD=0.44P PS=2.88U
+ PD=2.88U
M$1254 \$7309 \$7249 VSS VSS nfet_06v0 L=1U W=5U AS=2.2P AD=1.25P PS=10.88U
+ PD=5.5U
M$1255 \$7249 \$7264 \$7309 VSS nfet_06v0 L=1U W=5U AS=1.25P AD=2.2P PS=5.5U
+ PD=10.88U
M$1256 \$7295 \$7962 VSS VSS nfet_06v0 L=1U W=1U AS=0.44P AD=0.25P PS=2.88U
+ PD=1.5U
M$1257 \$7883 \$7962 \$7295 VSS nfet_06v0 L=1U W=1U AS=0.25P AD=0.44P PS=1.5U
+ PD=2.88U
M$1258 \$7296 \$7962 VSS VSS nfet_06v0 L=1U W=1U AS=0.44P AD=0.25P PS=2.88U
+ PD=1.5U
M$1259 \$7962 \$7962 \$7296 VSS nfet_06v0 L=1U W=1U AS=0.25P AD=0.44P PS=1.5U
+ PD=2.88U
M$1260 \$7310 \$7249 VSS VSS nfet_06v0 L=1U W=5U AS=2.2P AD=1.25P PS=10.88U
+ PD=5.5U
M$1261 \$7265 \$7264 \$7310 VSS nfet_06v0 L=1U W=5U AS=1.25P AD=1.65P PS=5.5U
+ PD=5.66U
M$1262 \$7311 \$7264 \$7265 VSS nfet_06v0 L=1U W=5U AS=1.65P AD=1.25P PS=5.66U
+ PD=5.5U
M$1263 VSS \$7249 \$7311 VSS nfet_06v0 L=1U W=5U AS=1.25P AD=2.2P PS=5.5U
+ PD=10.88U
M$1264 \$7266 \$18 \$7265 VSS nfet_06v0 L=1U W=5U AS=2.2P AD=1.3P PS=10.88U
+ PD=5.52U
M$1265 \$7265 \$18 \$7266 VSS nfet_06v0 L=1U W=5U AS=1.3P AD=2.2P PS=5.52U
+ PD=10.88U
M$1266 \$7267 \$34 \$7265 VSS nfet_06v0 L=1U W=5U AS=2.2P AD=1.3P PS=10.88U
+ PD=5.52U
M$1267 \$7265 \$34 \$7267 VSS nfet_06v0 L=1U W=5U AS=1.3P AD=2.2P PS=5.52U
+ PD=10.88U
M$1268 \$7269 \$7264 \$7268 VSS nfet_06v0 L=1U W=2.5U AS=1.1P AD=0.65P PS=5.88U
+ PD=3.02U
M$1269 \$7268 \$7264 \$7269 VSS nfet_06v0 L=1U W=2.5U AS=0.65P AD=1.1P PS=3.02U
+ PD=5.88U
M$1270 \$7271 \$7264 \$7270 VSS nfet_06v0 L=1U W=2.5U AS=1.1P AD=0.65P PS=5.88U
+ PD=3.02U
M$1271 \$7270 \$7264 \$7271 VSS nfet_06v0 L=1U W=2.5U AS=0.65P AD=1.1P PS=3.02U
+ PD=5.88U
M$1272 \$7268 \$7269 VSS VSS nfet_06v0 L=1U W=2.5U AS=1.1P AD=0.65P PS=5.88U
+ PD=3.02U
M$1273 VSS \$7269 \$7268 VSS nfet_06v0 L=1U W=2.5U AS=0.65P AD=0.65P PS=3.02U
+ PD=3.02U
M$1274 \$7268 \$7269 VSS VSS nfet_06v0 L=1U W=2.5U AS=0.65P AD=0.65P PS=3.02U
+ PD=3.02U
M$1275 VSS \$7269 \$7268 VSS nfet_06v0 L=1U W=2.5U AS=0.65P AD=1.1P PS=3.02U
+ PD=5.88U
M$1276 \$7270 \$7269 VSS VSS nfet_06v0 L=1U W=2.5U AS=1.1P AD=0.65P PS=5.88U
+ PD=3.02U
M$1277 VSS \$7269 \$7270 VSS nfet_06v0 L=1U W=2.5U AS=0.65P AD=0.65P PS=3.02U
+ PD=3.02U
M$1278 \$7270 \$7269 VSS VSS nfet_06v0 L=1U W=2.5U AS=0.65P AD=0.65P PS=3.02U
+ PD=3.02U
M$1279 VSS \$7269 \$7270 VSS nfet_06v0 L=1U W=2.5U AS=0.65P AD=1.1P PS=3.02U
+ PD=5.88U
M$1280 \$7429 \$7302 \$7269 VSS nfet_06v0 L=1U W=2.5U AS=1.1P AD=1.1P PS=5.88U
+ PD=5.88U
M$1281 \$7250 \$7302 \$7271 VSS nfet_06v0 L=1U W=2.5U AS=1.1P AD=1.1P PS=5.88U
+ PD=5.88U
M$1282 \$7312 \$7249 VSS VSS nfet_06v0 L=1U W=5U AS=2.2P AD=1.25P PS=10.88U
+ PD=5.5U
M$1283 \$7251 \$7264 \$7312 VSS nfet_06v0 L=1U W=5U AS=1.25P AD=2.2P PS=5.5U
+ PD=10.88U
M$1284 \$7313 \$7252 VSS VSS nfet_06v0 L=1U W=5U AS=2.2P AD=1.25P PS=10.88U
+ PD=5.5U
M$1285 \$7252 \$7264 \$7313 VSS nfet_06v0 L=1U W=5U AS=1.25P AD=1.65P PS=5.5U
+ PD=5.66U
M$1286 \$7302 \$7302 \$7252 VSS nfet_06v0 L=1U W=5U AS=1.65P AD=2.2P PS=5.66U
+ PD=10.88U
M$1287 \$7272 \$7271 VSS VSS nfet_06v0 L=1U W=5U AS=2.2P AD=1.3P PS=10.88U
+ PD=5.52U
M$1288 VSS \$7271 \$7272 VSS nfet_06v0 L=1U W=5U AS=1.3P AD=1.3P PS=5.52U
+ PD=5.52U
M$1289 \$7272 \$7271 VSS VSS nfet_06v0 L=1U W=5U AS=1.3P AD=2.2P PS=5.52U
+ PD=10.88U
M$1290 VSS VDD VSS VSS nfet_06v0 L=2U W=18U AS=7.92P AD=7.92P PS=36.88U
+ PD=36.88U
M$1291 VSS VDD VSS VSS nfet_06v0 L=2U W=18U AS=7.92P AD=7.92P PS=36.88U
+ PD=36.88U
M$1292 \$7273 \$7273 VSS VSS nfet_06v0 L=1U W=1U AS=0.44P AD=0.44P PS=2.88U
+ PD=2.88U
M$1293 \$7314 \$7253 VSS VSS nfet_06v0 L=1U W=5U AS=2.2P AD=1.25P PS=10.88U
+ PD=5.5U
M$1294 \$7253 \$7273 \$7314 VSS nfet_06v0 L=1U W=5U AS=1.25P AD=2.2P PS=5.5U
+ PD=10.88U
M$1295 \$7299 \$7964 VSS VSS nfet_06v0 L=1U W=1U AS=0.44P AD=0.25P PS=2.88U
+ PD=1.5U
M$1296 \$7884 \$7964 \$7299 VSS nfet_06v0 L=1U W=1U AS=0.25P AD=0.44P PS=1.5U
+ PD=2.88U
M$1297 \$7301 \$7964 VSS VSS nfet_06v0 L=1U W=1U AS=0.44P AD=0.25P PS=2.88U
+ PD=1.5U
M$1298 \$7964 \$7964 \$7301 VSS nfet_06v0 L=1U W=1U AS=0.25P AD=0.44P PS=1.5U
+ PD=2.88U
M$1299 \$7315 \$7253 VSS VSS nfet_06v0 L=1U W=5U AS=2.2P AD=1.25P PS=10.88U
+ PD=5.5U
M$1300 \$7274 \$7273 \$7315 VSS nfet_06v0 L=1U W=5U AS=1.25P AD=1.65P PS=5.5U
+ PD=5.66U
M$1301 \$7316 \$7273 \$7274 VSS nfet_06v0 L=1U W=5U AS=1.65P AD=1.25P PS=5.66U
+ PD=5.5U
M$1302 VSS \$7253 \$7316 VSS nfet_06v0 L=1U W=5U AS=1.25P AD=2.2P PS=5.5U
+ PD=10.88U
M$1303 \$7275 \$26 \$7274 VSS nfet_06v0 L=1U W=5U AS=2.2P AD=1.3P PS=10.88U
+ PD=5.52U
M$1304 \$7274 \$26 \$7275 VSS nfet_06v0 L=1U W=5U AS=1.3P AD=2.2P PS=5.52U
+ PD=10.88U
M$1305 \$7276 \$34 \$7274 VSS nfet_06v0 L=1U W=5U AS=2.2P AD=1.3P PS=10.88U
+ PD=5.52U
M$1306 \$7274 \$34 \$7276 VSS nfet_06v0 L=1U W=5U AS=1.3P AD=2.2P PS=5.52U
+ PD=10.88U
M$1307 \$7278 \$7273 \$7277 VSS nfet_06v0 L=1U W=2.5U AS=1.1P AD=0.65P PS=5.88U
+ PD=3.02U
M$1308 \$7277 \$7273 \$7278 VSS nfet_06v0 L=1U W=2.5U AS=0.65P AD=1.1P PS=3.02U
+ PD=5.88U
M$1309 \$7280 \$7273 \$7279 VSS nfet_06v0 L=1U W=2.5U AS=1.1P AD=0.65P PS=5.88U
+ PD=3.02U
M$1310 \$7279 \$7273 \$7280 VSS nfet_06v0 L=1U W=2.5U AS=0.65P AD=1.1P PS=3.02U
+ PD=5.88U
M$1311 \$7277 \$7278 VSS VSS nfet_06v0 L=1U W=2.5U AS=1.1P AD=0.65P PS=5.88U
+ PD=3.02U
M$1312 VSS \$7278 \$7277 VSS nfet_06v0 L=1U W=2.5U AS=0.65P AD=0.65P PS=3.02U
+ PD=3.02U
M$1313 \$7277 \$7278 VSS VSS nfet_06v0 L=1U W=2.5U AS=0.65P AD=0.65P PS=3.02U
+ PD=3.02U
M$1314 VSS \$7278 \$7277 VSS nfet_06v0 L=1U W=2.5U AS=0.65P AD=1.1P PS=3.02U
+ PD=5.88U
M$1315 \$7279 \$7278 VSS VSS nfet_06v0 L=1U W=2.5U AS=1.1P AD=0.65P PS=5.88U
+ PD=3.02U
M$1316 VSS \$7278 \$7279 VSS nfet_06v0 L=1U W=2.5U AS=0.65P AD=0.65P PS=3.02U
+ PD=3.02U
M$1317 \$7279 \$7278 VSS VSS nfet_06v0 L=1U W=2.5U AS=0.65P AD=0.65P PS=3.02U
+ PD=3.02U
M$1318 VSS \$7278 \$7279 VSS nfet_06v0 L=1U W=2.5U AS=0.65P AD=1.1P PS=3.02U
+ PD=5.88U
M$1319 \$7430 \$7303 \$7278 VSS nfet_06v0 L=1U W=2.5U AS=1.1P AD=1.1P PS=5.88U
+ PD=5.88U
M$1320 \$7254 \$7303 \$7280 VSS nfet_06v0 L=1U W=2.5U AS=1.1P AD=1.1P PS=5.88U
+ PD=5.88U
M$1321 \$7319 \$7253 VSS VSS nfet_06v0 L=1U W=5U AS=2.2P AD=1.25P PS=10.88U
+ PD=5.5U
M$1322 \$7255 \$7273 \$7319 VSS nfet_06v0 L=1U W=5U AS=1.25P AD=2.2P PS=5.5U
+ PD=10.88U
M$1323 \$7320 \$7256 VSS VSS nfet_06v0 L=1U W=5U AS=2.2P AD=1.25P PS=10.88U
+ PD=5.5U
M$1324 \$7256 \$7273 \$7320 VSS nfet_06v0 L=1U W=5U AS=1.25P AD=1.65P PS=5.5U
+ PD=5.66U
M$1325 \$7303 \$7303 \$7256 VSS nfet_06v0 L=1U W=5U AS=1.65P AD=2.2P PS=5.66U
+ PD=10.88U
M$1326 \$7292 \$7280 VSS VSS nfet_06v0 L=1U W=5U AS=2.2P AD=1.3P PS=10.88U
+ PD=5.52U
M$1327 VSS \$7280 \$7292 VSS nfet_06v0 L=1U W=5U AS=1.3P AD=1.3P PS=5.52U
+ PD=5.52U
M$1328 \$7292 \$7280 VSS VSS nfet_06v0 L=1U W=5U AS=1.3P AD=2.2P PS=5.52U
+ PD=10.88U
M$1329 VSS VDD VSS VSS nfet_06v0 L=2U W=18U AS=7.92P AD=7.92P PS=36.88U
+ PD=36.88U
M$1330 VSS VDD VSS VSS nfet_06v0 L=2U W=18U AS=7.92P AD=7.92P PS=36.88U
+ PD=36.88U
M$1331 \$7281 \$7281 VSS VSS nfet_06v0 L=1U W=1U AS=0.44P AD=0.44P PS=2.88U
+ PD=2.88U
M$1332 \$7321 \$7257 VSS VSS nfet_06v0 L=1U W=5U AS=2.2P AD=1.25P PS=10.88U
+ PD=5.5U
M$1333 \$7257 \$7281 \$7321 VSS nfet_06v0 L=1U W=5U AS=1.25P AD=2.2P PS=5.5U
+ PD=10.88U
M$1334 \$7300 \$7966 VSS VSS nfet_06v0 L=1U W=1U AS=0.44P AD=0.25P PS=2.88U
+ PD=1.5U
M$1335 \$7885 \$7966 \$7300 VSS nfet_06v0 L=1U W=1U AS=0.25P AD=0.44P PS=1.5U
+ PD=2.88U
M$1336 \$7298 \$7966 VSS VSS nfet_06v0 L=1U W=1U AS=0.44P AD=0.25P PS=2.88U
+ PD=1.5U
M$1337 \$7966 \$7966 \$7298 VSS nfet_06v0 L=1U W=1U AS=0.25P AD=0.44P PS=1.5U
+ PD=2.88U
M$1338 \$7323 \$7257 VSS VSS nfet_06v0 L=1U W=5U AS=2.2P AD=1.25P PS=10.88U
+ PD=5.5U
M$1339 \$7282 \$7281 \$7323 VSS nfet_06v0 L=1U W=5U AS=1.25P AD=1.65P PS=5.5U
+ PD=5.66U
M$1340 \$7322 \$7281 \$7282 VSS nfet_06v0 L=1U W=5U AS=1.65P AD=1.25P PS=5.66U
+ PD=5.5U
M$1341 VSS \$7257 \$7322 VSS nfet_06v0 L=1U W=5U AS=1.25P AD=2.2P PS=5.5U
+ PD=10.88U
M$1342 \$7283 \$26 \$7282 VSS nfet_06v0 L=1U W=5U AS=2.2P AD=1.3P PS=10.88U
+ PD=5.52U
M$1343 \$7282 \$26 \$7283 VSS nfet_06v0 L=1U W=5U AS=1.3P AD=2.2P PS=5.52U
+ PD=10.88U
M$1344 \$7284 \$18 \$7282 VSS nfet_06v0 L=1U W=5U AS=2.2P AD=1.3P PS=10.88U
+ PD=5.52U
M$1345 \$7282 \$18 \$7284 VSS nfet_06v0 L=1U W=5U AS=1.3P AD=2.2P PS=5.52U
+ PD=10.88U
M$1346 \$7286 \$7281 \$7285 VSS nfet_06v0 L=1U W=2.5U AS=1.1P AD=0.65P PS=5.88U
+ PD=3.02U
M$1347 \$7285 \$7281 \$7286 VSS nfet_06v0 L=1U W=2.5U AS=0.65P AD=1.1P PS=3.02U
+ PD=5.88U
M$1348 \$7288 \$7281 \$7287 VSS nfet_06v0 L=1U W=2.5U AS=1.1P AD=0.65P PS=5.88U
+ PD=3.02U
M$1349 \$7287 \$7281 \$7288 VSS nfet_06v0 L=1U W=2.5U AS=0.65P AD=1.1P PS=3.02U
+ PD=5.88U
M$1350 \$7285 \$7286 VSS VSS nfet_06v0 L=1U W=2.5U AS=1.1P AD=0.65P PS=5.88U
+ PD=3.02U
M$1351 VSS \$7286 \$7285 VSS nfet_06v0 L=1U W=2.5U AS=0.65P AD=0.65P PS=3.02U
+ PD=3.02U
M$1352 \$7285 \$7286 VSS VSS nfet_06v0 L=1U W=2.5U AS=0.65P AD=0.65P PS=3.02U
+ PD=3.02U
M$1353 VSS \$7286 \$7285 VSS nfet_06v0 L=1U W=2.5U AS=0.65P AD=1.1P PS=3.02U
+ PD=5.88U
M$1354 \$7287 \$7286 VSS VSS nfet_06v0 L=1U W=2.5U AS=1.1P AD=0.65P PS=5.88U
+ PD=3.02U
M$1355 VSS \$7286 \$7287 VSS nfet_06v0 L=1U W=2.5U AS=0.65P AD=0.65P PS=3.02U
+ PD=3.02U
M$1356 \$7287 \$7286 VSS VSS nfet_06v0 L=1U W=2.5U AS=0.65P AD=0.65P PS=3.02U
+ PD=3.02U
M$1357 VSS \$7286 \$7287 VSS nfet_06v0 L=1U W=2.5U AS=0.65P AD=1.1P PS=3.02U
+ PD=5.88U
M$1358 \$7431 \$7304 \$7286 VSS nfet_06v0 L=1U W=2.5U AS=1.1P AD=1.1P PS=5.88U
+ PD=5.88U
M$1359 \$7258 \$7304 \$7288 VSS nfet_06v0 L=1U W=2.5U AS=1.1P AD=1.1P PS=5.88U
+ PD=5.88U
M$1360 \$7318 \$7257 VSS VSS nfet_06v0 L=1U W=5U AS=2.2P AD=1.25P PS=10.88U
+ PD=5.5U
M$1361 \$7259 \$7281 \$7318 VSS nfet_06v0 L=1U W=5U AS=1.25P AD=2.2P PS=5.5U
+ PD=10.88U
M$1362 \$7317 \$7260 VSS VSS nfet_06v0 L=1U W=5U AS=2.2P AD=1.25P PS=10.88U
+ PD=5.5U
M$1363 \$7260 \$7281 \$7317 VSS nfet_06v0 L=1U W=5U AS=1.25P AD=1.65P PS=5.5U
+ PD=5.66U
M$1364 \$7304 \$7304 \$7260 VSS nfet_06v0 L=1U W=5U AS=1.65P AD=2.2P PS=5.66U
+ PD=10.88U
M$1365 \$7289 \$7288 VSS VSS nfet_06v0 L=1U W=5U AS=2.2P AD=1.3P PS=10.88U
+ PD=5.52U
M$1366 VSS \$7288 \$7289 VSS nfet_06v0 L=1U W=5U AS=1.3P AD=1.3P PS=5.52U
+ PD=5.52U
M$1367 \$7289 \$7288 VSS VSS nfet_06v0 L=1U W=5U AS=1.3P AD=2.2P PS=5.52U
+ PD=10.88U
M$1368 VSS VDD VSS VSS nfet_06v0 L=2U W=18U AS=7.92P AD=7.92P PS=36.88U
+ PD=36.88U
M$1369 VSS VDD VSS VSS nfet_06v0 L=2U W=18U AS=7.92P AD=7.92P PS=36.88U
+ PD=36.88U
M$1370 VSS \$7272 \$7262 VSS nfet_06v0 L=1U W=1U AS=0.44P AD=0.44P PS=2.88U
+ PD=2.88U
M$1371 VSS \$7291 \$7308 VSS nfet_06v0 L=1U W=1U AS=0.44P AD=0.44P PS=2.88U
+ PD=2.88U
M$1372 \$7297 \$7262 \$7291 VSS nfet_06v0 L=1U W=1U AS=0.44P AD=0.25P PS=2.88U
+ PD=1.5U
M$1373 VSS \$7289 \$7297 VSS nfet_06v0 L=1U W=1U AS=0.25P AD=0.44P PS=1.5U
+ PD=2.88U
M$1374 \$7290 \$7289 VSS VSS nfet_06v0 L=1U W=1U AS=0.44P AD=0.33P PS=2.88U
+ PD=1.66U
M$1375 VSS \$7292 \$7290 VSS nfet_06v0 L=1U W=1U AS=0.33P AD=0.44P PS=1.66U
+ PD=2.88U
M$1376 VSS \$7293 \$7263 VSS nfet_06v0 L=1U W=1U AS=0.44P AD=0.44P PS=2.88U
+ PD=2.88U
M$1377 \$7294 \$7292 \$7293 VSS nfet_06v0 L=1U W=1U AS=0.44P AD=0.25P PS=2.88U
+ PD=1.5U
M$1378 VSS \$7272 \$7294 VSS nfet_06v0 L=1U W=1U AS=0.25P AD=0.44P PS=1.5U
+ PD=2.88U
M$1379 VSS VDD VSS VSS nfet_06v0 L=2U W=18U AS=7.92P AD=7.92P PS=36.88U
+ PD=36.88U
M$1380 VSS VDD VSS VSS nfet_06v0 L=2U W=18U AS=7.92P AD=7.92P PS=36.88U
+ PD=36.88U
M$1381 VSS VDD VSS VSS nfet_06v0 L=2U W=18U AS=7.92P AD=7.92P PS=36.88U
+ PD=36.88U
M$1382 VSS VDD VSS VSS nfet_06v0 L=2U W=9.75U AS=4.29P AD=4.29P PS=20.38U
+ PD=20.38U
M$1383 \$9067 \$9067 VSS VSS nfet_06v0 L=1U W=1U AS=0.44P AD=0.44P PS=2.88U
+ PD=2.88U
M$1384 \$9112 \$9054 VSS VSS nfet_06v0 L=1U W=5U AS=2.2P AD=1.25P PS=10.88U
+ PD=5.5U
M$1385 \$9054 \$9067 \$9112 VSS nfet_06v0 L=1U W=5U AS=1.25P AD=2.2P PS=5.5U
+ PD=10.88U
M$1386 \$9098 \$9763 VSS VSS nfet_06v0 L=1U W=1U AS=0.44P AD=0.25P PS=2.88U
+ PD=1.5U
M$1387 \$9609 \$9763 \$9098 VSS nfet_06v0 L=1U W=1U AS=0.25P AD=0.44P PS=1.5U
+ PD=2.88U
M$1388 \$9099 \$9763 VSS VSS nfet_06v0 L=1U W=1U AS=0.44P AD=0.25P PS=2.88U
+ PD=1.5U
M$1389 \$9763 \$9763 \$9099 VSS nfet_06v0 L=1U W=1U AS=0.25P AD=0.44P PS=1.5U
+ PD=2.88U
M$1390 \$9113 \$9054 VSS VSS nfet_06v0 L=1U W=5U AS=2.2P AD=1.25P PS=10.88U
+ PD=5.5U
M$1391 \$9068 \$9067 \$9113 VSS nfet_06v0 L=1U W=5U AS=1.25P AD=1.65P PS=5.5U
+ PD=5.66U
M$1392 \$9114 \$9067 \$9068 VSS nfet_06v0 L=1U W=5U AS=1.65P AD=1.25P PS=5.66U
+ PD=5.5U
M$1393 VSS \$9054 \$9114 VSS nfet_06v0 L=1U W=5U AS=1.25P AD=2.2P PS=5.5U
+ PD=10.88U
M$1394 \$9069 \$42 \$9068 VSS nfet_06v0 L=1U W=5U AS=2.2P AD=1.3P PS=10.88U
+ PD=5.52U
M$1395 \$9068 \$42 \$9069 VSS nfet_06v0 L=1U W=5U AS=1.3P AD=2.2P PS=5.52U
+ PD=10.88U
M$1396 \$9070 \$2439 \$9068 VSS nfet_06v0 L=1U W=5U AS=2.2P AD=1.3P PS=10.88U
+ PD=5.52U
M$1397 \$9068 \$2439 \$9070 VSS nfet_06v0 L=1U W=5U AS=1.3P AD=2.2P PS=5.52U
+ PD=10.88U
M$1398 \$9072 \$9067 \$9071 VSS nfet_06v0 L=1U W=2.5U AS=1.1P AD=0.65P PS=5.88U
+ PD=3.02U
M$1399 \$9071 \$9067 \$9072 VSS nfet_06v0 L=1U W=2.5U AS=0.65P AD=1.1P PS=3.02U
+ PD=5.88U
M$1400 \$9074 \$9067 \$9073 VSS nfet_06v0 L=1U W=2.5U AS=1.1P AD=0.65P PS=5.88U
+ PD=3.02U
M$1401 \$9073 \$9067 \$9074 VSS nfet_06v0 L=1U W=2.5U AS=0.65P AD=1.1P PS=3.02U
+ PD=5.88U
M$1402 \$9071 \$9072 VSS VSS nfet_06v0 L=1U W=2.5U AS=1.1P AD=0.65P PS=5.88U
+ PD=3.02U
M$1403 VSS \$9072 \$9071 VSS nfet_06v0 L=1U W=2.5U AS=0.65P AD=0.65P PS=3.02U
+ PD=3.02U
M$1404 \$9071 \$9072 VSS VSS nfet_06v0 L=1U W=2.5U AS=0.65P AD=0.65P PS=3.02U
+ PD=3.02U
M$1405 VSS \$9072 \$9071 VSS nfet_06v0 L=1U W=2.5U AS=0.65P AD=1.1P PS=3.02U
+ PD=5.88U
M$1406 \$9073 \$9072 VSS VSS nfet_06v0 L=1U W=2.5U AS=1.1P AD=0.65P PS=5.88U
+ PD=3.02U
M$1407 VSS \$9072 \$9073 VSS nfet_06v0 L=1U W=2.5U AS=0.65P AD=0.65P PS=3.02U
+ PD=3.02U
M$1408 \$9073 \$9072 VSS VSS nfet_06v0 L=1U W=2.5U AS=0.65P AD=0.65P PS=3.02U
+ PD=3.02U
M$1409 VSS \$9072 \$9073 VSS nfet_06v0 L=1U W=2.5U AS=0.65P AD=1.1P PS=3.02U
+ PD=5.88U
M$1410 \$9230 \$9105 \$9072 VSS nfet_06v0 L=1U W=2.5U AS=1.1P AD=1.1P PS=5.88U
+ PD=5.88U
M$1411 \$9055 \$9105 \$9074 VSS nfet_06v0 L=1U W=2.5U AS=1.1P AD=1.1P PS=5.88U
+ PD=5.88U
M$1412 \$9115 \$9054 VSS VSS nfet_06v0 L=1U W=5U AS=2.2P AD=1.25P PS=10.88U
+ PD=5.5U
M$1413 \$9056 \$9067 \$9115 VSS nfet_06v0 L=1U W=5U AS=1.25P AD=2.2P PS=5.5U
+ PD=10.88U
M$1414 \$9116 \$9057 VSS VSS nfet_06v0 L=1U W=5U AS=2.2P AD=1.25P PS=10.88U
+ PD=5.5U
M$1415 \$9057 \$9067 \$9116 VSS nfet_06v0 L=1U W=5U AS=1.25P AD=1.65P PS=5.5U
+ PD=5.66U
M$1416 \$9105 \$9105 \$9057 VSS nfet_06v0 L=1U W=5U AS=1.65P AD=2.2P PS=5.66U
+ PD=10.88U
M$1417 \$9075 \$9074 VSS VSS nfet_06v0 L=1U W=5U AS=2.2P AD=1.3P PS=10.88U
+ PD=5.52U
M$1418 VSS \$9074 \$9075 VSS nfet_06v0 L=1U W=5U AS=1.3P AD=1.3P PS=5.52U
+ PD=5.52U
M$1419 \$9075 \$9074 VSS VSS nfet_06v0 L=1U W=5U AS=1.3P AD=2.2P PS=5.52U
+ PD=10.88U
M$1420 VSS VDD VSS VSS nfet_06v0 L=2U W=9.75U AS=4.29P AD=4.29P PS=20.38U
+ PD=20.38U
M$1421 VSS VDD VSS VSS nfet_06v0 L=2U W=9.75U AS=4.29P AD=4.29P PS=20.38U
+ PD=20.38U
M$1422 \$9076 \$9076 VSS VSS nfet_06v0 L=1U W=1U AS=0.44P AD=0.44P PS=2.88U
+ PD=2.88U
M$1423 \$9117 \$9058 VSS VSS nfet_06v0 L=1U W=5U AS=2.2P AD=1.25P PS=10.88U
+ PD=5.5U
M$1424 \$9058 \$9076 \$9117 VSS nfet_06v0 L=1U W=5U AS=1.25P AD=2.2P PS=5.5U
+ PD=10.88U
M$1425 \$9101 \$9765 VSS VSS nfet_06v0 L=1U W=1U AS=0.44P AD=0.25P PS=2.88U
+ PD=1.5U
M$1426 \$9610 \$9765 \$9101 VSS nfet_06v0 L=1U W=1U AS=0.25P AD=0.44P PS=1.5U
+ PD=2.88U
M$1427 \$9102 \$9765 VSS VSS nfet_06v0 L=1U W=1U AS=0.44P AD=0.25P PS=2.88U
+ PD=1.5U
M$1428 \$9765 \$9765 \$9102 VSS nfet_06v0 L=1U W=1U AS=0.25P AD=0.44P PS=1.5U
+ PD=2.88U
M$1429 \$9118 \$9058 VSS VSS nfet_06v0 L=1U W=5U AS=2.2P AD=1.25P PS=10.88U
+ PD=5.5U
M$1430 \$9077 \$9076 \$9118 VSS nfet_06v0 L=1U W=5U AS=1.25P AD=1.65P PS=5.5U
+ PD=5.66U
M$1431 \$9119 \$9076 \$9077 VSS nfet_06v0 L=1U W=5U AS=1.65P AD=1.25P PS=5.66U
+ PD=5.5U
M$1432 VSS \$9058 \$9119 VSS nfet_06v0 L=1U W=5U AS=1.25P AD=2.2P PS=5.5U
+ PD=10.88U
M$1433 \$9078 \$2431 \$9077 VSS nfet_06v0 L=1U W=5U AS=2.2P AD=1.3P PS=10.88U
+ PD=5.52U
M$1434 \$9077 \$2431 \$9078 VSS nfet_06v0 L=1U W=5U AS=1.3P AD=2.2P PS=5.52U
+ PD=10.88U
M$1435 \$9079 \$2439 \$9077 VSS nfet_06v0 L=1U W=5U AS=2.2P AD=1.3P PS=10.88U
+ PD=5.52U
M$1436 \$9077 \$2439 \$9079 VSS nfet_06v0 L=1U W=5U AS=1.3P AD=2.2P PS=5.52U
+ PD=10.88U
M$1437 \$9081 \$9076 \$9080 VSS nfet_06v0 L=1U W=2.5U AS=1.1P AD=0.65P PS=5.88U
+ PD=3.02U
M$1438 \$9080 \$9076 \$9081 VSS nfet_06v0 L=1U W=2.5U AS=0.65P AD=1.1P PS=3.02U
+ PD=5.88U
M$1439 \$9083 \$9076 \$9082 VSS nfet_06v0 L=1U W=2.5U AS=1.1P AD=0.65P PS=5.88U
+ PD=3.02U
M$1440 \$9082 \$9076 \$9083 VSS nfet_06v0 L=1U W=2.5U AS=0.65P AD=1.1P PS=3.02U
+ PD=5.88U
M$1441 \$9080 \$9081 VSS VSS nfet_06v0 L=1U W=2.5U AS=1.1P AD=0.65P PS=5.88U
+ PD=3.02U
M$1442 VSS \$9081 \$9080 VSS nfet_06v0 L=1U W=2.5U AS=0.65P AD=0.65P PS=3.02U
+ PD=3.02U
M$1443 \$9080 \$9081 VSS VSS nfet_06v0 L=1U W=2.5U AS=0.65P AD=0.65P PS=3.02U
+ PD=3.02U
M$1444 VSS \$9081 \$9080 VSS nfet_06v0 L=1U W=2.5U AS=0.65P AD=1.1P PS=3.02U
+ PD=5.88U
M$1445 \$9082 \$9081 VSS VSS nfet_06v0 L=1U W=2.5U AS=1.1P AD=0.65P PS=5.88U
+ PD=3.02U
M$1446 VSS \$9081 \$9082 VSS nfet_06v0 L=1U W=2.5U AS=0.65P AD=0.65P PS=3.02U
+ PD=3.02U
M$1447 \$9082 \$9081 VSS VSS nfet_06v0 L=1U W=2.5U AS=0.65P AD=0.65P PS=3.02U
+ PD=3.02U
M$1448 VSS \$9081 \$9082 VSS nfet_06v0 L=1U W=2.5U AS=0.65P AD=1.1P PS=3.02U
+ PD=5.88U
M$1449 \$9231 \$9106 \$9081 VSS nfet_06v0 L=1U W=2.5U AS=1.1P AD=1.1P PS=5.88U
+ PD=5.88U
M$1450 \$9059 \$9106 \$9083 VSS nfet_06v0 L=1U W=2.5U AS=1.1P AD=1.1P PS=5.88U
+ PD=5.88U
M$1451 \$9122 \$9058 VSS VSS nfet_06v0 L=1U W=5U AS=2.2P AD=1.25P PS=10.88U
+ PD=5.5U
M$1452 \$9060 \$9076 \$9122 VSS nfet_06v0 L=1U W=5U AS=1.25P AD=2.2P PS=5.5U
+ PD=10.88U
M$1453 \$9123 \$9061 VSS VSS nfet_06v0 L=1U W=5U AS=2.2P AD=1.25P PS=10.88U
+ PD=5.5U
M$1454 \$9061 \$9076 \$9123 VSS nfet_06v0 L=1U W=5U AS=1.25P AD=1.65P PS=5.5U
+ PD=5.66U
M$1455 \$9106 \$9106 \$9061 VSS nfet_06v0 L=1U W=5U AS=1.65P AD=2.2P PS=5.66U
+ PD=10.88U
M$1456 \$9095 \$9083 VSS VSS nfet_06v0 L=1U W=5U AS=2.2P AD=1.3P PS=10.88U
+ PD=5.52U
M$1457 VSS \$9083 \$9095 VSS nfet_06v0 L=1U W=5U AS=1.3P AD=1.3P PS=5.52U
+ PD=5.52U
M$1458 \$9095 \$9083 VSS VSS nfet_06v0 L=1U W=5U AS=1.3P AD=2.2P PS=5.52U
+ PD=10.88U
M$1459 VSS VDD VSS VSS nfet_06v0 L=2U W=9.75U AS=4.29P AD=4.29P PS=20.38U
+ PD=20.38U
M$1460 VSS VDD VSS VSS nfet_06v0 L=2U W=9.75U AS=4.29P AD=4.29P PS=20.38U
+ PD=20.38U
M$1461 \$9084 \$9084 VSS VSS nfet_06v0 L=1U W=1U AS=0.44P AD=0.44P PS=2.88U
+ PD=2.88U
M$1462 \$9125 \$9062 VSS VSS nfet_06v0 L=1U W=5U AS=2.2P AD=1.25P PS=10.88U
+ PD=5.5U
M$1463 \$9062 \$9084 \$9125 VSS nfet_06v0 L=1U W=5U AS=1.25P AD=2.2P PS=5.5U
+ PD=10.88U
M$1464 \$9104 \$9767 VSS VSS nfet_06v0 L=1U W=1U AS=0.44P AD=0.25P PS=2.88U
+ PD=1.5U
M$1465 \$9611 \$9767 \$9104 VSS nfet_06v0 L=1U W=1U AS=0.25P AD=0.44P PS=1.5U
+ PD=2.88U
M$1466 \$9103 \$9767 VSS VSS nfet_06v0 L=1U W=1U AS=0.44P AD=0.25P PS=2.88U
+ PD=1.5U
M$1467 \$9767 \$9767 \$9103 VSS nfet_06v0 L=1U W=1U AS=0.25P AD=0.44P PS=1.5U
+ PD=2.88U
M$1468 \$9126 \$9062 VSS VSS nfet_06v0 L=1U W=5U AS=2.2P AD=1.25P PS=10.88U
+ PD=5.5U
M$1469 \$9085 \$9084 \$9126 VSS nfet_06v0 L=1U W=5U AS=1.25P AD=1.65P PS=5.5U
+ PD=5.66U
M$1470 \$9124 \$9084 \$9085 VSS nfet_06v0 L=1U W=5U AS=1.65P AD=1.25P PS=5.66U
+ PD=5.5U
M$1471 VSS \$9062 \$9124 VSS nfet_06v0 L=1U W=5U AS=1.25P AD=2.2P PS=5.5U
+ PD=10.88U
M$1472 \$9086 \$2431 \$9085 VSS nfet_06v0 L=1U W=5U AS=2.2P AD=1.3P PS=10.88U
+ PD=5.52U
M$1473 \$9085 \$2431 \$9086 VSS nfet_06v0 L=1U W=5U AS=1.3P AD=2.2P PS=5.52U
+ PD=10.88U
M$1474 \$9087 \$42 \$9085 VSS nfet_06v0 L=1U W=5U AS=2.2P AD=1.3P PS=10.88U
+ PD=5.52U
M$1475 \$9085 \$42 \$9087 VSS nfet_06v0 L=1U W=5U AS=1.3P AD=2.2P PS=5.52U
+ PD=10.88U
M$1476 \$9089 \$9084 \$9088 VSS nfet_06v0 L=1U W=2.5U AS=1.1P AD=0.65P PS=5.88U
+ PD=3.02U
M$1477 \$9088 \$9084 \$9089 VSS nfet_06v0 L=1U W=2.5U AS=0.65P AD=1.1P PS=3.02U
+ PD=5.88U
M$1478 \$9091 \$9084 \$9090 VSS nfet_06v0 L=1U W=2.5U AS=1.1P AD=0.65P PS=5.88U
+ PD=3.02U
M$1479 \$9090 \$9084 \$9091 VSS nfet_06v0 L=1U W=2.5U AS=0.65P AD=1.1P PS=3.02U
+ PD=5.88U
M$1480 \$9088 \$9089 VSS VSS nfet_06v0 L=1U W=2.5U AS=1.1P AD=0.65P PS=5.88U
+ PD=3.02U
M$1481 VSS \$9089 \$9088 VSS nfet_06v0 L=1U W=2.5U AS=0.65P AD=0.65P PS=3.02U
+ PD=3.02U
M$1482 \$9088 \$9089 VSS VSS nfet_06v0 L=1U W=2.5U AS=0.65P AD=0.65P PS=3.02U
+ PD=3.02U
M$1483 VSS \$9089 \$9088 VSS nfet_06v0 L=1U W=2.5U AS=0.65P AD=1.1P PS=3.02U
+ PD=5.88U
M$1484 \$9090 \$9089 VSS VSS nfet_06v0 L=1U W=2.5U AS=1.1P AD=0.65P PS=5.88U
+ PD=3.02U
M$1485 VSS \$9089 \$9090 VSS nfet_06v0 L=1U W=2.5U AS=0.65P AD=0.65P PS=3.02U
+ PD=3.02U
M$1486 \$9090 \$9089 VSS VSS nfet_06v0 L=1U W=2.5U AS=0.65P AD=0.65P PS=3.02U
+ PD=3.02U
M$1487 VSS \$9089 \$9090 VSS nfet_06v0 L=1U W=2.5U AS=0.65P AD=1.1P PS=3.02U
+ PD=5.88U
M$1488 \$9232 \$9107 \$9089 VSS nfet_06v0 L=1U W=2.5U AS=1.1P AD=1.1P PS=5.88U
+ PD=5.88U
M$1489 \$9063 \$9107 \$9091 VSS nfet_06v0 L=1U W=2.5U AS=1.1P AD=1.1P PS=5.88U
+ PD=5.88U
M$1490 \$9121 \$9062 VSS VSS nfet_06v0 L=1U W=5U AS=2.2P AD=1.25P PS=10.88U
+ PD=5.5U
M$1491 \$9064 \$9084 \$9121 VSS nfet_06v0 L=1U W=5U AS=1.25P AD=2.2P PS=5.5U
+ PD=10.88U
M$1492 \$9120 \$9065 VSS VSS nfet_06v0 L=1U W=5U AS=2.2P AD=1.25P PS=10.88U
+ PD=5.5U
M$1493 \$9065 \$9084 \$9120 VSS nfet_06v0 L=1U W=5U AS=1.25P AD=1.65P PS=5.5U
+ PD=5.66U
M$1494 \$9107 \$9107 \$9065 VSS nfet_06v0 L=1U W=5U AS=1.65P AD=2.2P PS=5.66U
+ PD=10.88U
M$1495 \$9092 \$9091 VSS VSS nfet_06v0 L=1U W=5U AS=2.2P AD=1.3P PS=10.88U
+ PD=5.52U
M$1496 VSS \$9091 \$9092 VSS nfet_06v0 L=1U W=5U AS=1.3P AD=1.3P PS=5.52U
+ PD=5.52U
M$1497 \$9092 \$9091 VSS VSS nfet_06v0 L=1U W=5U AS=1.3P AD=2.2P PS=5.52U
+ PD=10.88U
M$1498 VSS VDD VSS VSS nfet_06v0 L=2U W=9.75U AS=4.29P AD=4.29P PS=20.38U
+ PD=20.38U
M$1499 VSS VDD VSS VSS nfet_06v0 L=2U W=9.75U AS=4.29P AD=4.29P PS=20.38U
+ PD=20.38U
M$1500 \$7244 \$7245 VSS VSS nfet_06v0 L=1U W=1.24U AS=0.5456P AD=0.5456P
+ PS=3.36U PD=3.36U
M$1501 X \$7330 \$7261 VSS nfet_06v0 L=1U W=2.48U AS=1.0912P AD=0.6448P
+ PS=5.84U PD=3U
M$1502 \$7261 \$7330 X VSS nfet_06v0 L=1U W=2.48U AS=0.6448P AD=1.0912P PS=3U
+ PD=5.84U
M$1503 \$7261 \$7245 VSS VSS nfet_06v0 L=1U W=1.24U AS=0.5456P AD=0.5456P
+ PS=3.36U PD=3.36U
M$1504 X \$7732 \$7346 VSS nfet_06v0 L=1U W=2.48U AS=1.0912P AD=0.6448P
+ PS=5.84U PD=3U
M$1505 \$7346 \$7732 X VSS nfet_06v0 L=1U W=2.48U AS=0.6448P AD=1.0912P PS=3U
+ PD=5.84U
M$1506 \$7306 \$7245 VSS VSS nfet_06v0 L=1U W=0.7U AS=0.308P AD=0.175P PS=2.28U
+ PD=1.2U
M$1507 \$7307 \$7245 \$7306 VSS nfet_06v0 L=1U W=0.7U AS=0.175P AD=0.175P
+ PS=1.2U PD=1.2U
M$1508 \$7305 \$7245 \$7307 VSS nfet_06v0 L=1U W=0.7U AS=0.175P AD=0.175P
+ PS=1.2U PD=1.2U
M$1509 \$7245 \$7245 \$7305 VSS nfet_06v0 L=1U W=0.7U AS=0.175P AD=0.308P
+ PS=1.2U PD=2.28U
M$1510 \$7346 \$7245 VSS VSS nfet_06v0 L=1U W=1.24U AS=0.5456P AD=0.5456P
+ PS=3.36U PD=3.36U
M$1511 X X \$7347 VSS nfet_06v0 L=1U W=2U AS=0.88P AD=0.52P PS=4.88U PD=2.52U
M$1512 \$7347 X X VSS nfet_06v0 L=1U W=2U AS=0.52P AD=0.88P PS=2.52U PD=4.88U
M$1513 X VDD \$7246 VSS nfet_06v0 L=1U W=2.48U AS=1.0912P AD=0.6448P PS=5.84U
+ PD=3U
M$1514 \$7246 VDD X VSS nfet_06v0 L=1U W=2.48U AS=0.6448P AD=1.0912P PS=3U
+ PD=5.84U
M$1515 \$7349 X VSS VSS nfet_06v0 L=1U W=2U AS=0.88P AD=0.5P PS=4.88U PD=2.5U
M$1516 \$7347 X \$7349 VSS nfet_06v0 L=1U W=2U AS=0.5P AD=0.88P PS=2.5U PD=4.88U
M$1517 \$7246 \$7245 VSS VSS nfet_06v0 L=1U W=1.24U AS=0.5456P AD=0.5456P
+ PS=3.36U PD=3.36U
M$1518 X \$7263 \$7348 VSS nfet_06v0 L=1U W=2.48U AS=1.0912P AD=0.6448P
+ PS=5.84U PD=3U
M$1519 \$7348 \$7263 X VSS nfet_06v0 L=1U W=2.48U AS=0.6448P AD=1.0912P PS=3U
+ PD=5.84U
M$1520 \$7348 \$7245 VSS VSS nfet_06v0 L=1U W=1.24U AS=0.5456P AD=0.5456P
+ PS=3.36U PD=3.36U
M$1521 X \$7331 \$7244 VSS nfet_06v0 L=1U W=2.48U AS=1.0912P AD=0.6448P
+ PS=5.84U PD=3U
M$1522 \$7244 \$7331 X VSS nfet_06v0 L=1U W=2.48U AS=0.6448P AD=1.0912P PS=3U
+ PD=5.84U
M$1523 VSS VDD VSS VSS nfet_06v0 L=2U W=1U AS=0.44P AD=0.44P PS=2.88U PD=2.88U
M$1524 VSS VDD VSS VSS nfet_06v0 L=2U W=1U AS=0.44P AD=0.44P PS=2.88U PD=2.88U
M$1525 VSS \$9075 \$9066 VSS nfet_06v0 L=1U W=1U AS=0.44P AD=0.44P PS=2.88U
+ PD=2.88U
M$1526 VSS \$9094 \$9108 VSS nfet_06v0 L=1U W=1U AS=0.44P AD=0.44P PS=2.88U
+ PD=2.88U
M$1527 \$9100 \$9066 \$9094 VSS nfet_06v0 L=1U W=1U AS=0.44P AD=0.25P PS=2.88U
+ PD=1.5U
M$1528 VSS \$9092 \$9100 VSS nfet_06v0 L=1U W=1U AS=0.25P AD=0.44P PS=1.5U
+ PD=2.88U
M$1529 \$9093 \$9092 VSS VSS nfet_06v0 L=1U W=1U AS=0.44P AD=0.33P PS=2.88U
+ PD=1.66U
M$1530 VSS \$9095 \$9093 VSS nfet_06v0 L=1U W=1U AS=0.33P AD=0.44P PS=1.66U
+ PD=2.88U
M$1531 VSS \$9096 \$7732 VSS nfet_06v0 L=1U W=1U AS=0.44P AD=0.44P PS=2.88U
+ PD=2.88U
M$1532 \$9097 \$9095 \$9096 VSS nfet_06v0 L=1U W=1U AS=0.44P AD=0.25P PS=2.88U
+ PD=1.5U
M$1533 VSS \$9075 \$9097 VSS nfet_06v0 L=1U W=1U AS=0.25P AD=0.44P PS=1.5U
+ PD=2.88U
M$1534 VSS VDD VSS VSS nfet_06v0 L=2U W=1U AS=0.44P AD=0.44P PS=2.88U PD=2.88U
M$1535 VSS VDD VSS VSS nfet_06v0 L=2U W=9.75U AS=4.29P AD=4.29P PS=20.38U
+ PD=20.38U
M$1536 \$10867 \$10867 VSS VSS nfet_06v0 L=1U W=1U AS=0.44P AD=0.44P PS=2.88U
+ PD=2.88U
M$1537 \$10911 \$10853 VSS VSS nfet_06v0 L=1U W=5U AS=2.2P AD=1.25P PS=10.88U
+ PD=5.5U
M$1538 \$10853 \$10867 \$10911 VSS nfet_06v0 L=1U W=5U AS=1.25P AD=2.2P PS=5.5U
+ PD=10.88U
M$1539 \$10897 \$11410 VSS VSS nfet_06v0 L=1U W=1U AS=0.44P AD=0.25P PS=2.88U
+ PD=1.5U
M$1540 \$11409 \$11410 \$10897 VSS nfet_06v0 L=1U W=1U AS=0.25P AD=0.44P
+ PS=1.5U PD=2.88U
M$1541 \$10898 \$11410 VSS VSS nfet_06v0 L=1U W=1U AS=0.44P AD=0.25P PS=2.88U
+ PD=1.5U
M$1542 \$11410 \$11410 \$10898 VSS nfet_06v0 L=1U W=1U AS=0.25P AD=0.44P
+ PS=1.5U PD=2.88U
M$1543 \$10912 \$10853 VSS VSS nfet_06v0 L=1U W=5U AS=2.2P AD=1.25P PS=10.88U
+ PD=5.5U
M$1544 \$10868 \$10867 \$10912 VSS nfet_06v0 L=1U W=5U AS=1.25P AD=1.65P
+ PS=5.5U PD=5.66U
M$1545 \$10913 \$10867 \$10868 VSS nfet_06v0 L=1U W=5U AS=1.65P AD=1.25P
+ PS=5.66U PD=5.5U
M$1546 VSS \$10853 \$10913 VSS nfet_06v0 L=1U W=5U AS=1.25P AD=2.2P PS=5.5U
+ PD=10.88U
M$1547 \$10869 \$2447 \$10868 VSS nfet_06v0 L=1U W=5U AS=2.2P AD=1.3P PS=10.88U
+ PD=5.52U
M$1548 \$10868 \$2447 \$10869 VSS nfet_06v0 L=1U W=5U AS=1.3P AD=2.2P PS=5.52U
+ PD=10.88U
M$1549 \$10870 \$4842 \$10868 VSS nfet_06v0 L=1U W=5U AS=2.2P AD=1.3P PS=10.88U
+ PD=5.52U
M$1550 \$10868 \$4842 \$10870 VSS nfet_06v0 L=1U W=5U AS=1.3P AD=2.2P PS=5.52U
+ PD=10.88U
M$1551 \$10872 \$10867 \$10871 VSS nfet_06v0 L=1U W=2.5U AS=1.1P AD=0.65P
+ PS=5.88U PD=3.02U
M$1552 \$10871 \$10867 \$10872 VSS nfet_06v0 L=1U W=2.5U AS=0.65P AD=1.1P
+ PS=3.02U PD=5.88U
M$1553 \$10874 \$10867 \$10873 VSS nfet_06v0 L=1U W=2.5U AS=1.1P AD=0.65P
+ PS=5.88U PD=3.02U
M$1554 \$10873 \$10867 \$10874 VSS nfet_06v0 L=1U W=2.5U AS=0.65P AD=1.1P
+ PS=3.02U PD=5.88U
M$1555 \$10871 \$10872 VSS VSS nfet_06v0 L=1U W=2.5U AS=1.1P AD=0.65P PS=5.88U
+ PD=3.02U
M$1556 VSS \$10872 \$10871 VSS nfet_06v0 L=1U W=2.5U AS=0.65P AD=0.65P PS=3.02U
+ PD=3.02U
M$1557 \$10871 \$10872 VSS VSS nfet_06v0 L=1U W=2.5U AS=0.65P AD=0.65P PS=3.02U
+ PD=3.02U
M$1558 VSS \$10872 \$10871 VSS nfet_06v0 L=1U W=2.5U AS=0.65P AD=1.1P PS=3.02U
+ PD=5.88U
M$1559 \$10873 \$10872 VSS VSS nfet_06v0 L=1U W=2.5U AS=1.1P AD=0.65P PS=5.88U
+ PD=3.02U
M$1560 VSS \$10872 \$10873 VSS nfet_06v0 L=1U W=2.5U AS=0.65P AD=0.65P PS=3.02U
+ PD=3.02U
M$1561 \$10873 \$10872 VSS VSS nfet_06v0 L=1U W=2.5U AS=0.65P AD=0.65P PS=3.02U
+ PD=3.02U
M$1562 VSS \$10872 \$10873 VSS nfet_06v0 L=1U W=2.5U AS=0.65P AD=1.1P PS=3.02U
+ PD=5.88U
M$1563 \$10952 \$10904 \$10872 VSS nfet_06v0 L=1U W=2.5U AS=1.1P AD=1.1P
+ PS=5.88U PD=5.88U
M$1564 \$10854 \$10904 \$10874 VSS nfet_06v0 L=1U W=2.5U AS=1.1P AD=1.1P
+ PS=5.88U PD=5.88U
M$1565 \$10914 \$10853 VSS VSS nfet_06v0 L=1U W=5U AS=2.2P AD=1.25P PS=10.88U
+ PD=5.5U
M$1566 \$10855 \$10867 \$10914 VSS nfet_06v0 L=1U W=5U AS=1.25P AD=2.2P PS=5.5U
+ PD=10.88U
M$1567 \$10915 \$10856 VSS VSS nfet_06v0 L=1U W=5U AS=2.2P AD=1.25P PS=10.88U
+ PD=5.5U
M$1568 \$10856 \$10867 \$10915 VSS nfet_06v0 L=1U W=5U AS=1.25P AD=1.65P
+ PS=5.5U PD=5.66U
M$1569 \$10904 \$10904 \$10856 VSS nfet_06v0 L=1U W=5U AS=1.65P AD=2.2P
+ PS=5.66U PD=10.88U
M$1570 \$10875 \$10874 VSS VSS nfet_06v0 L=1U W=5U AS=2.2P AD=1.3P PS=10.88U
+ PD=5.52U
M$1571 VSS \$10874 \$10875 VSS nfet_06v0 L=1U W=5U AS=1.3P AD=1.3P PS=5.52U
+ PD=5.52U
M$1572 \$10875 \$10874 VSS VSS nfet_06v0 L=1U W=5U AS=1.3P AD=2.2P PS=5.52U
+ PD=10.88U
M$1573 VSS VDD VSS VSS nfet_06v0 L=2U W=9.75U AS=4.29P AD=4.29P PS=20.38U
+ PD=20.38U
M$1574 VSS VDD VSS VSS nfet_06v0 L=2U W=9.75U AS=4.29P AD=4.29P PS=20.38U
+ PD=20.38U
M$1575 \$10876 \$10876 VSS VSS nfet_06v0 L=1U W=1U AS=0.44P AD=0.44P PS=2.88U
+ PD=2.88U
M$1576 \$10916 \$10857 VSS VSS nfet_06v0 L=1U W=5U AS=2.2P AD=1.25P PS=10.88U
+ PD=5.5U
M$1577 \$10857 \$10876 \$10916 VSS nfet_06v0 L=1U W=5U AS=1.25P AD=2.2P PS=5.5U
+ PD=10.88U
M$1578 \$10901 \$11413 VSS VSS nfet_06v0 L=1U W=1U AS=0.44P AD=0.25P PS=2.88U
+ PD=1.5U
M$1579 \$11412 \$11413 \$10901 VSS nfet_06v0 L=1U W=1U AS=0.25P AD=0.44P
+ PS=1.5U PD=2.88U
M$1580 \$10903 \$11413 VSS VSS nfet_06v0 L=1U W=1U AS=0.44P AD=0.25P PS=2.88U
+ PD=1.5U
M$1581 \$11413 \$11413 \$10903 VSS nfet_06v0 L=1U W=1U AS=0.25P AD=0.44P
+ PS=1.5U PD=2.88U
M$1582 \$10917 \$10857 VSS VSS nfet_06v0 L=1U W=5U AS=2.2P AD=1.25P PS=10.88U
+ PD=5.5U
M$1583 \$10877 \$10876 \$10917 VSS nfet_06v0 L=1U W=5U AS=1.25P AD=1.65P
+ PS=5.5U PD=5.66U
M$1584 \$10918 \$10876 \$10877 VSS nfet_06v0 L=1U W=5U AS=1.65P AD=1.25P
+ PS=5.66U PD=5.5U
M$1585 VSS \$10857 \$10918 VSS nfet_06v0 L=1U W=5U AS=1.25P AD=2.2P PS=5.5U
+ PD=10.88U
M$1586 \$10878 \$2455 \$10877 VSS nfet_06v0 L=1U W=5U AS=2.2P AD=1.3P PS=10.88U
+ PD=5.52U
M$1587 \$10877 \$2455 \$10878 VSS nfet_06v0 L=1U W=5U AS=1.3P AD=2.2P PS=5.52U
+ PD=10.88U
M$1588 \$10879 \$4842 \$10877 VSS nfet_06v0 L=1U W=5U AS=2.2P AD=1.3P PS=10.88U
+ PD=5.52U
M$1589 \$10877 \$4842 \$10879 VSS nfet_06v0 L=1U W=5U AS=1.3P AD=2.2P PS=5.52U
+ PD=10.88U
M$1590 \$10881 \$10876 \$10880 VSS nfet_06v0 L=1U W=2.5U AS=1.1P AD=0.65P
+ PS=5.88U PD=3.02U
M$1591 \$10880 \$10876 \$10881 VSS nfet_06v0 L=1U W=2.5U AS=0.65P AD=1.1P
+ PS=3.02U PD=5.88U
M$1592 \$10883 \$10876 \$10882 VSS nfet_06v0 L=1U W=2.5U AS=1.1P AD=0.65P
+ PS=5.88U PD=3.02U
M$1593 \$10882 \$10876 \$10883 VSS nfet_06v0 L=1U W=2.5U AS=0.65P AD=1.1P
+ PS=3.02U PD=5.88U
M$1594 \$10880 \$10881 VSS VSS nfet_06v0 L=1U W=2.5U AS=1.1P AD=0.65P PS=5.88U
+ PD=3.02U
M$1595 VSS \$10881 \$10880 VSS nfet_06v0 L=1U W=2.5U AS=0.65P AD=0.65P PS=3.02U
+ PD=3.02U
M$1596 \$10880 \$10881 VSS VSS nfet_06v0 L=1U W=2.5U AS=0.65P AD=0.65P PS=3.02U
+ PD=3.02U
M$1597 VSS \$10881 \$10880 VSS nfet_06v0 L=1U W=2.5U AS=0.65P AD=1.1P PS=3.02U
+ PD=5.88U
M$1598 \$10882 \$10881 VSS VSS nfet_06v0 L=1U W=2.5U AS=1.1P AD=0.65P PS=5.88U
+ PD=3.02U
M$1599 VSS \$10881 \$10882 VSS nfet_06v0 L=1U W=2.5U AS=0.65P AD=0.65P PS=3.02U
+ PD=3.02U
M$1600 \$10882 \$10881 VSS VSS nfet_06v0 L=1U W=2.5U AS=0.65P AD=0.65P PS=3.02U
+ PD=3.02U
M$1601 VSS \$10881 \$10882 VSS nfet_06v0 L=1U W=2.5U AS=0.65P AD=1.1P PS=3.02U
+ PD=5.88U
M$1602 \$10954 \$10905 \$10881 VSS nfet_06v0 L=1U W=2.5U AS=1.1P AD=1.1P
+ PS=5.88U PD=5.88U
M$1603 \$10858 \$10905 \$10883 VSS nfet_06v0 L=1U W=2.5U AS=1.1P AD=1.1P
+ PS=5.88U PD=5.88U
M$1604 \$10921 \$10857 VSS VSS nfet_06v0 L=1U W=5U AS=2.2P AD=1.25P PS=10.88U
+ PD=5.5U
M$1605 \$10859 \$10876 \$10921 VSS nfet_06v0 L=1U W=5U AS=1.25P AD=2.2P PS=5.5U
+ PD=10.88U
M$1606 \$10924 \$10860 VSS VSS nfet_06v0 L=1U W=5U AS=2.2P AD=1.25P PS=10.88U
+ PD=5.5U
M$1607 \$10860 \$10876 \$10924 VSS nfet_06v0 L=1U W=5U AS=1.25P AD=1.65P
+ PS=5.5U PD=5.66U
M$1608 \$10905 \$10905 \$10860 VSS nfet_06v0 L=1U W=5U AS=1.65P AD=2.2P
+ PS=5.66U PD=10.88U
M$1609 \$10894 \$10883 VSS VSS nfet_06v0 L=1U W=5U AS=2.2P AD=1.3P PS=10.88U
+ PD=5.52U
M$1610 VSS \$10883 \$10894 VSS nfet_06v0 L=1U W=5U AS=1.3P AD=1.3P PS=5.52U
+ PD=5.52U
M$1611 \$10894 \$10883 VSS VSS nfet_06v0 L=1U W=5U AS=1.3P AD=2.2P PS=5.52U
+ PD=10.88U
M$1612 VSS VDD VSS VSS nfet_06v0 L=2U W=9.75U AS=4.29P AD=4.29P PS=20.38U
+ PD=20.38U
M$1613 VSS VDD VSS VSS nfet_06v0 L=2U W=9.75U AS=4.29P AD=4.29P PS=20.38U
+ PD=20.38U
M$1614 \$10884 \$10884 VSS VSS nfet_06v0 L=1U W=1U AS=0.44P AD=0.44P PS=2.88U
+ PD=2.88U
M$1615 \$10925 \$10861 VSS VSS nfet_06v0 L=1U W=5U AS=2.2P AD=1.25P PS=10.88U
+ PD=5.5U
M$1616 \$10861 \$10884 \$10925 VSS nfet_06v0 L=1U W=5U AS=1.25P AD=2.2P PS=5.5U
+ PD=10.88U
M$1617 \$10902 \$11416 VSS VSS nfet_06v0 L=1U W=1U AS=0.44P AD=0.25P PS=2.88U
+ PD=1.5U
M$1618 \$11415 \$11416 \$10902 VSS nfet_06v0 L=1U W=1U AS=0.25P AD=0.44P
+ PS=1.5U PD=2.88U
M$1619 \$10900 \$11416 VSS VSS nfet_06v0 L=1U W=1U AS=0.44P AD=0.25P PS=2.88U
+ PD=1.5U
M$1620 \$11416 \$11416 \$10900 VSS nfet_06v0 L=1U W=1U AS=0.25P AD=0.44P
+ PS=1.5U PD=2.88U
M$1621 \$10923 \$10861 VSS VSS nfet_06v0 L=1U W=5U AS=2.2P AD=1.25P PS=10.88U
+ PD=5.5U
M$1622 \$10885 \$10884 \$10923 VSS nfet_06v0 L=1U W=5U AS=1.25P AD=1.65P
+ PS=5.5U PD=5.66U
M$1623 \$10922 \$10884 \$10885 VSS nfet_06v0 L=1U W=5U AS=1.65P AD=1.25P
+ PS=5.66U PD=5.5U
M$1624 VSS \$10861 \$10922 VSS nfet_06v0 L=1U W=5U AS=1.25P AD=2.2P PS=5.5U
+ PD=10.88U
M$1625 \$10886 \$2455 \$10885 VSS nfet_06v0 L=1U W=5U AS=2.2P AD=1.3P PS=10.88U
+ PD=5.52U
M$1626 \$10885 \$2455 \$10886 VSS nfet_06v0 L=1U W=5U AS=1.3P AD=2.2P PS=5.52U
+ PD=10.88U
M$1627 \$10887 \$2447 \$10885 VSS nfet_06v0 L=1U W=5U AS=2.2P AD=1.3P PS=10.88U
+ PD=5.52U
M$1628 \$10885 \$2447 \$10887 VSS nfet_06v0 L=1U W=5U AS=1.3P AD=2.2P PS=5.52U
+ PD=10.88U
M$1629 \$10889 \$10884 \$10888 VSS nfet_06v0 L=1U W=2.5U AS=1.1P AD=0.65P
+ PS=5.88U PD=3.02U
M$1630 \$10888 \$10884 \$10889 VSS nfet_06v0 L=1U W=2.5U AS=0.65P AD=1.1P
+ PS=3.02U PD=5.88U
M$1631 \$10891 \$10884 \$10890 VSS nfet_06v0 L=1U W=2.5U AS=1.1P AD=0.65P
+ PS=5.88U PD=3.02U
M$1632 \$10890 \$10884 \$10891 VSS nfet_06v0 L=1U W=2.5U AS=0.65P AD=1.1P
+ PS=3.02U PD=5.88U
M$1633 \$10888 \$10889 VSS VSS nfet_06v0 L=1U W=2.5U AS=1.1P AD=0.65P PS=5.88U
+ PD=3.02U
M$1634 VSS \$10889 \$10888 VSS nfet_06v0 L=1U W=2.5U AS=0.65P AD=0.65P PS=3.02U
+ PD=3.02U
M$1635 \$10888 \$10889 VSS VSS nfet_06v0 L=1U W=2.5U AS=0.65P AD=0.65P PS=3.02U
+ PD=3.02U
M$1636 VSS \$10889 \$10888 VSS nfet_06v0 L=1U W=2.5U AS=0.65P AD=1.1P PS=3.02U
+ PD=5.88U
M$1637 \$10890 \$10889 VSS VSS nfet_06v0 L=1U W=2.5U AS=1.1P AD=0.65P PS=5.88U
+ PD=3.02U
M$1638 VSS \$10889 \$10890 VSS nfet_06v0 L=1U W=2.5U AS=0.65P AD=0.65P PS=3.02U
+ PD=3.02U
M$1639 \$10890 \$10889 VSS VSS nfet_06v0 L=1U W=2.5U AS=0.65P AD=0.65P PS=3.02U
+ PD=3.02U
M$1640 VSS \$10889 \$10890 VSS nfet_06v0 L=1U W=2.5U AS=0.65P AD=1.1P PS=3.02U
+ PD=5.88U
M$1641 \$10956 \$10906 \$10889 VSS nfet_06v0 L=1U W=2.5U AS=1.1P AD=1.1P
+ PS=5.88U PD=5.88U
M$1642 \$10862 \$10906 \$10891 VSS nfet_06v0 L=1U W=2.5U AS=1.1P AD=1.1P
+ PS=5.88U PD=5.88U
M$1643 \$10920 \$10861 VSS VSS nfet_06v0 L=1U W=5U AS=2.2P AD=1.25P PS=10.88U
+ PD=5.5U
M$1644 \$10863 \$10884 \$10920 VSS nfet_06v0 L=1U W=5U AS=1.25P AD=2.2P PS=5.5U
+ PD=10.88U
M$1645 \$10919 \$10864 VSS VSS nfet_06v0 L=1U W=5U AS=2.2P AD=1.25P PS=10.88U
+ PD=5.5U
M$1646 \$10864 \$10884 \$10919 VSS nfet_06v0 L=1U W=5U AS=1.25P AD=1.65P
+ PS=5.5U PD=5.66U
M$1647 \$10906 \$10906 \$10864 VSS nfet_06v0 L=1U W=5U AS=1.65P AD=2.2P
+ PS=5.66U PD=10.88U
M$1648 \$10892 \$10891 VSS VSS nfet_06v0 L=1U W=5U AS=2.2P AD=1.3P PS=10.88U
+ PD=5.52U
M$1649 VSS \$10891 \$10892 VSS nfet_06v0 L=1U W=5U AS=1.3P AD=1.3P PS=5.52U
+ PD=5.52U
M$1650 \$10892 \$10891 VSS VSS nfet_06v0 L=1U W=5U AS=1.3P AD=2.2P PS=5.52U
+ PD=10.88U
M$1651 VSS VDD VSS VSS nfet_06v0 L=2U W=9.75U AS=4.29P AD=4.29P PS=20.38U
+ PD=20.38U
M$1652 VSS VDD VSS VSS nfet_06v0 L=2U W=9.75U AS=4.29P AD=4.29P PS=20.38U
+ PD=20.38U
M$1653 \$9047 \$9050 VSS VSS nfet_06v0 L=1U W=1.24U AS=0.5456P AD=0.5456P
+ PS=3.36U PD=3.36U
M$1654 Y \$9145 \$9051 VSS nfet_06v0 L=1U W=2.48U AS=1.0912P AD=0.6448P
+ PS=5.84U PD=3U
M$1655 \$9051 \$9145 Y VSS nfet_06v0 L=1U W=2.48U AS=0.6448P AD=1.0912P PS=3U
+ PD=5.84U
M$1656 \$9051 \$9050 VSS VSS nfet_06v0 L=1U W=1.24U AS=0.5456P AD=0.5456P
+ PS=3.36U PD=3.36U
M$1657 Y \$9108 \$9147 VSS nfet_06v0 L=1U W=2.48U AS=1.0912P AD=0.6448P
+ PS=5.84U PD=3U
M$1658 \$9147 \$9108 Y VSS nfet_06v0 L=1U W=2.48U AS=0.6448P AD=1.0912P PS=3U
+ PD=5.84U
M$1659 \$9110 \$9050 VSS VSS nfet_06v0 L=1U W=0.7U AS=0.308P AD=0.175P PS=2.28U
+ PD=1.2U
M$1660 \$9109 \$9050 \$9110 VSS nfet_06v0 L=1U W=0.7U AS=0.175P AD=0.175P
+ PS=1.2U PD=1.2U
M$1661 \$9111 \$9050 \$9109 VSS nfet_06v0 L=1U W=0.7U AS=0.175P AD=0.175P
+ PS=1.2U PD=1.2U
M$1662 \$9050 \$9050 \$9111 VSS nfet_06v0 L=1U W=0.7U AS=0.175P AD=0.308P
+ PS=1.2U PD=2.28U
M$1663 \$9147 \$9050 VSS VSS nfet_06v0 L=1U W=1.24U AS=0.5456P AD=0.5456P
+ PS=3.36U PD=3.36U
M$1664 Y Y \$9148 VSS nfet_06v0 L=1U W=2U AS=0.88P AD=0.52P PS=4.88U PD=2.52U
M$1665 \$9148 Y Y VSS nfet_06v0 L=1U W=2U AS=0.52P AD=0.88P PS=2.52U PD=4.88U
M$1666 Y VDD \$9048 VSS nfet_06v0 L=1U W=2.48U AS=1.0912P AD=0.6448P PS=5.84U
+ PD=3U
M$1667 \$9048 VDD Y VSS nfet_06v0 L=1U W=2.48U AS=0.6448P AD=1.0912P PS=3U
+ PD=5.84U
M$1668 \$9179 Y VSS VSS nfet_06v0 L=1U W=2U AS=0.88P AD=0.5P PS=4.88U PD=2.5U
M$1669 \$9148 Y \$9179 VSS nfet_06v0 L=1U W=2U AS=0.5P AD=0.88P PS=2.5U PD=4.88U
M$1670 \$9048 \$9050 VSS VSS nfet_06v0 L=1U W=1.24U AS=0.5456P AD=0.5456P
+ PS=3.36U PD=3.36U
M$1671 Y \$7308 \$9149 VSS nfet_06v0 L=1U W=2.48U AS=1.0912P AD=0.6448P
+ PS=5.84U PD=3U
M$1672 \$9149 \$7308 Y VSS nfet_06v0 L=1U W=2.48U AS=0.6448P AD=1.0912P PS=3U
+ PD=5.84U
M$1673 \$9149 \$9050 VSS VSS nfet_06v0 L=1U W=1.24U AS=0.5456P AD=0.5456P
+ PS=3.36U PD=3.36U
M$1674 Y \$9150 \$9047 VSS nfet_06v0 L=1U W=2.48U AS=1.0912P AD=0.6448P
+ PS=5.84U PD=3U
M$1675 \$9047 \$9150 Y VSS nfet_06v0 L=1U W=2.48U AS=0.6448P AD=1.0912P PS=3U
+ PD=5.84U
M$1676 VSS VDD VSS VSS nfet_06v0 L=2U W=1U AS=0.44P AD=0.44P PS=2.88U PD=2.88U
M$1677 VSS VDD VSS VSS nfet_06v0 L=2U W=1U AS=0.44P AD=0.44P PS=2.88U PD=2.88U
M$1678 VSS \$10875 \$10866 VSS nfet_06v0 L=1U W=1U AS=0.44P AD=0.44P PS=2.88U
+ PD=2.88U
M$1679 VSS \$10893 \$9150 VSS nfet_06v0 L=1U W=1U AS=0.44P AD=0.44P PS=2.88U
+ PD=2.88U
M$1680 \$10899 \$10866 \$10893 VSS nfet_06v0 L=1U W=1U AS=0.44P AD=0.25P
+ PS=2.88U PD=1.5U
M$1681 VSS \$10892 \$10899 VSS nfet_06v0 L=1U W=1U AS=0.25P AD=0.44P PS=1.5U
+ PD=2.88U
M$1682 \$10907 \$10892 VSS VSS nfet_06v0 L=1U W=1U AS=0.44P AD=0.33P PS=2.88U
+ PD=1.66U
M$1683 VSS \$10894 \$10907 VSS nfet_06v0 L=1U W=1U AS=0.33P AD=0.44P PS=1.66U
+ PD=2.88U
M$1684 VSS \$10895 \$7331 VSS nfet_06v0 L=1U W=1U AS=0.44P AD=0.44P PS=2.88U
+ PD=2.88U
M$1685 \$10896 \$10894 \$10895 VSS nfet_06v0 L=1U W=1U AS=0.44P AD=0.25P
+ PS=2.88U PD=1.5U
M$1686 VSS \$10875 \$10896 VSS nfet_06v0 L=1U W=1U AS=0.25P AD=0.44P PS=1.5U
+ PD=2.88U
M$1687 VSS VDD VSS VSS nfet_06v0 L=2U W=1U AS=0.44P AD=0.44P PS=2.88U PD=2.88U
M$1688 VSS VDD VSS VSS nfet_06v0 L=2U W=9.75U AS=4.29P AD=4.29P PS=20.38U
+ PD=20.38U
M$1689 \$12658 \$12658 VSS VSS nfet_06v0 L=1U W=1U AS=0.44P AD=0.44P PS=2.88U
+ PD=2.88U
M$1690 \$12698 \$12645 VSS VSS nfet_06v0 L=1U W=5U AS=2.2P AD=1.25P PS=10.88U
+ PD=5.5U
M$1691 \$12645 \$12658 \$12698 VSS nfet_06v0 L=1U W=5U AS=1.25P AD=2.2P PS=5.5U
+ PD=10.88U
M$1692 \$12688 \$13266 VSS VSS nfet_06v0 L=1U W=1U AS=0.44P AD=0.25P PS=2.88U
+ PD=1.5U
M$1693 \$13262 \$13266 \$12688 VSS nfet_06v0 L=1U W=1U AS=0.25P AD=0.44P
+ PS=1.5U PD=2.88U
M$1694 \$12689 \$13266 VSS VSS nfet_06v0 L=1U W=1U AS=0.44P AD=0.25P PS=2.88U
+ PD=1.5U
M$1695 \$13266 \$13266 \$12689 VSS nfet_06v0 L=1U W=1U AS=0.25P AD=0.44P
+ PS=1.5U PD=2.88U
M$1696 \$12699 \$12645 VSS VSS nfet_06v0 L=1U W=5U AS=2.2P AD=1.25P PS=10.88U
+ PD=5.5U
M$1697 \$12659 \$12658 \$12699 VSS nfet_06v0 L=1U W=5U AS=1.25P AD=1.65P
+ PS=5.5U PD=5.66U
M$1698 \$12700 \$12658 \$12659 VSS nfet_06v0 L=1U W=5U AS=1.65P AD=1.25P
+ PS=5.66U PD=5.5U
M$1699 VSS \$12645 \$12700 VSS nfet_06v0 L=1U W=5U AS=1.25P AD=2.2P PS=5.5U
+ PD=10.88U
M$1700 \$12660 \$4850 \$12659 VSS nfet_06v0 L=1U W=5U AS=2.2P AD=1.3P PS=10.88U
+ PD=5.52U
M$1701 \$12659 \$4850 \$12660 VSS nfet_06v0 L=1U W=5U AS=1.3P AD=2.2P PS=5.52U
+ PD=10.88U
M$1702 \$12661 \$4866 \$12659 VSS nfet_06v0 L=1U W=5U AS=2.2P AD=1.3P PS=10.88U
+ PD=5.52U
M$1703 \$12659 \$4866 \$12661 VSS nfet_06v0 L=1U W=5U AS=1.3P AD=2.2P PS=5.52U
+ PD=10.88U
M$1704 \$12663 \$12658 \$12662 VSS nfet_06v0 L=1U W=2.5U AS=1.1P AD=0.65P
+ PS=5.88U PD=3.02U
M$1705 \$12662 \$12658 \$12663 VSS nfet_06v0 L=1U W=2.5U AS=0.65P AD=1.1P
+ PS=3.02U PD=5.88U
M$1706 \$12665 \$12658 \$12664 VSS nfet_06v0 L=1U W=2.5U AS=1.1P AD=0.65P
+ PS=5.88U PD=3.02U
M$1707 \$12664 \$12658 \$12665 VSS nfet_06v0 L=1U W=2.5U AS=0.65P AD=1.1P
+ PS=3.02U PD=5.88U
M$1708 \$12662 \$12663 VSS VSS nfet_06v0 L=1U W=2.5U AS=1.1P AD=0.65P PS=5.88U
+ PD=3.02U
M$1709 VSS \$12663 \$12662 VSS nfet_06v0 L=1U W=2.5U AS=0.65P AD=0.65P PS=3.02U
+ PD=3.02U
M$1710 \$12662 \$12663 VSS VSS nfet_06v0 L=1U W=2.5U AS=0.65P AD=0.65P PS=3.02U
+ PD=3.02U
M$1711 VSS \$12663 \$12662 VSS nfet_06v0 L=1U W=2.5U AS=0.65P AD=1.1P PS=3.02U
+ PD=5.88U
M$1712 \$12664 \$12663 VSS VSS nfet_06v0 L=1U W=2.5U AS=1.1P AD=0.65P PS=5.88U
+ PD=3.02U
M$1713 VSS \$12663 \$12664 VSS nfet_06v0 L=1U W=2.5U AS=0.65P AD=0.65P PS=3.02U
+ PD=3.02U
M$1714 \$12664 \$12663 VSS VSS nfet_06v0 L=1U W=2.5U AS=0.65P AD=0.65P PS=3.02U
+ PD=3.02U
M$1715 VSS \$12663 \$12664 VSS nfet_06v0 L=1U W=2.5U AS=0.65P AD=1.1P PS=3.02U
+ PD=5.88U
M$1716 \$12809 \$12695 \$12663 VSS nfet_06v0 L=1U W=2.5U AS=1.1P AD=1.1P
+ PS=5.88U PD=5.88U
M$1717 \$12646 \$12695 \$12665 VSS nfet_06v0 L=1U W=2.5U AS=1.1P AD=1.1P
+ PS=5.88U PD=5.88U
M$1718 \$12701 \$12645 VSS VSS nfet_06v0 L=1U W=5U AS=2.2P AD=1.25P PS=10.88U
+ PD=5.5U
M$1719 \$12647 \$12658 \$12701 VSS nfet_06v0 L=1U W=5U AS=1.25P AD=2.2P PS=5.5U
+ PD=10.88U
M$1720 \$12702 \$12648 VSS VSS nfet_06v0 L=1U W=5U AS=2.2P AD=1.25P PS=10.88U
+ PD=5.5U
M$1721 \$12648 \$12658 \$12702 VSS nfet_06v0 L=1U W=5U AS=1.25P AD=1.65P
+ PS=5.5U PD=5.66U
M$1722 \$12695 \$12695 \$12648 VSS nfet_06v0 L=1U W=5U AS=1.65P AD=2.2P
+ PS=5.66U PD=10.88U
M$1723 \$12666 \$12665 VSS VSS nfet_06v0 L=1U W=5U AS=2.2P AD=1.3P PS=10.88U
+ PD=5.52U
M$1724 VSS \$12665 \$12666 VSS nfet_06v0 L=1U W=5U AS=1.3P AD=1.3P PS=5.52U
+ PD=5.52U
M$1725 \$12666 \$12665 VSS VSS nfet_06v0 L=1U W=5U AS=1.3P AD=2.2P PS=5.52U
+ PD=10.88U
M$1726 VSS VDD VSS VSS nfet_06v0 L=2U W=9.75U AS=4.29P AD=4.29P PS=20.38U
+ PD=20.38U
M$1727 VSS VDD VSS VSS nfet_06v0 L=2U W=9.75U AS=4.29P AD=4.29P PS=20.38U
+ PD=20.38U
M$1728 \$12667 \$12667 VSS VSS nfet_06v0 L=1U W=1U AS=0.44P AD=0.44P PS=2.88U
+ PD=2.88U
M$1729 \$12703 \$12649 VSS VSS nfet_06v0 L=1U W=5U AS=2.2P AD=1.25P PS=10.88U
+ PD=5.5U
M$1730 \$12649 \$12667 \$12703 VSS nfet_06v0 L=1U W=5U AS=1.25P AD=2.2P PS=5.5U
+ PD=10.88U
M$1731 \$12691 \$13268 VSS VSS nfet_06v0 L=1U W=1U AS=0.44P AD=0.25P PS=2.88U
+ PD=1.5U
M$1732 \$13263 \$13268 \$12691 VSS nfet_06v0 L=1U W=1U AS=0.25P AD=0.44P
+ PS=1.5U PD=2.88U
M$1733 \$12693 \$13268 VSS VSS nfet_06v0 L=1U W=1U AS=0.44P AD=0.25P PS=2.88U
+ PD=1.5U
M$1734 \$13268 \$13268 \$12693 VSS nfet_06v0 L=1U W=1U AS=0.25P AD=0.44P
+ PS=1.5U PD=2.88U
M$1735 \$12704 \$12649 VSS VSS nfet_06v0 L=1U W=5U AS=2.2P AD=1.25P PS=10.88U
+ PD=5.5U
M$1736 \$12668 \$12667 \$12704 VSS nfet_06v0 L=1U W=5U AS=1.25P AD=1.65P
+ PS=5.5U PD=5.66U
M$1737 \$12705 \$12667 \$12668 VSS nfet_06v0 L=1U W=5U AS=1.65P AD=1.25P
+ PS=5.66U PD=5.5U
M$1738 VSS \$12649 \$12705 VSS nfet_06v0 L=1U W=5U AS=1.25P AD=2.2P PS=5.5U
+ PD=10.88U
M$1739 \$12669 \$4858 \$12668 VSS nfet_06v0 L=1U W=5U AS=2.2P AD=1.3P PS=10.88U
+ PD=5.52U
M$1740 \$12668 \$4858 \$12669 VSS nfet_06v0 L=1U W=5U AS=1.3P AD=2.2P PS=5.52U
+ PD=10.88U
M$1741 \$12670 \$4866 \$12668 VSS nfet_06v0 L=1U W=5U AS=2.2P AD=1.3P PS=10.88U
+ PD=5.52U
M$1742 \$12668 \$4866 \$12670 VSS nfet_06v0 L=1U W=5U AS=1.3P AD=2.2P PS=5.52U
+ PD=10.88U
M$1743 \$12672 \$12667 \$12671 VSS nfet_06v0 L=1U W=2.5U AS=1.1P AD=0.65P
+ PS=5.88U PD=3.02U
M$1744 \$12671 \$12667 \$12672 VSS nfet_06v0 L=1U W=2.5U AS=0.65P AD=1.1P
+ PS=3.02U PD=5.88U
M$1745 \$12674 \$12667 \$12673 VSS nfet_06v0 L=1U W=2.5U AS=1.1P AD=0.65P
+ PS=5.88U PD=3.02U
M$1746 \$12673 \$12667 \$12674 VSS nfet_06v0 L=1U W=2.5U AS=0.65P AD=1.1P
+ PS=3.02U PD=5.88U
M$1747 \$12671 \$12672 VSS VSS nfet_06v0 L=1U W=2.5U AS=1.1P AD=0.65P PS=5.88U
+ PD=3.02U
M$1748 VSS \$12672 \$12671 VSS nfet_06v0 L=1U W=2.5U AS=0.65P AD=0.65P PS=3.02U
+ PD=3.02U
M$1749 \$12671 \$12672 VSS VSS nfet_06v0 L=1U W=2.5U AS=0.65P AD=0.65P PS=3.02U
+ PD=3.02U
M$1750 VSS \$12672 \$12671 VSS nfet_06v0 L=1U W=2.5U AS=0.65P AD=1.1P PS=3.02U
+ PD=5.88U
M$1751 \$12673 \$12672 VSS VSS nfet_06v0 L=1U W=2.5U AS=1.1P AD=0.65P PS=5.88U
+ PD=3.02U
M$1752 VSS \$12672 \$12673 VSS nfet_06v0 L=1U W=2.5U AS=0.65P AD=0.65P PS=3.02U
+ PD=3.02U
M$1753 \$12673 \$12672 VSS VSS nfet_06v0 L=1U W=2.5U AS=0.65P AD=0.65P PS=3.02U
+ PD=3.02U
M$1754 VSS \$12672 \$12673 VSS nfet_06v0 L=1U W=2.5U AS=0.65P AD=1.1P PS=3.02U
+ PD=5.88U
M$1755 \$12810 \$12696 \$12672 VSS nfet_06v0 L=1U W=2.5U AS=1.1P AD=1.1P
+ PS=5.88U PD=5.88U
M$1756 \$12650 \$12696 \$12674 VSS nfet_06v0 L=1U W=2.5U AS=1.1P AD=1.1P
+ PS=5.88U PD=5.88U
M$1757 \$12706 \$12649 VSS VSS nfet_06v0 L=1U W=5U AS=2.2P AD=1.25P PS=10.88U
+ PD=5.5U
M$1758 \$12651 \$12667 \$12706 VSS nfet_06v0 L=1U W=5U AS=1.25P AD=2.2P PS=5.5U
+ PD=10.88U
M$1759 \$12707 \$12652 VSS VSS nfet_06v0 L=1U W=5U AS=2.2P AD=1.25P PS=10.88U
+ PD=5.5U
M$1760 \$12652 \$12667 \$12707 VSS nfet_06v0 L=1U W=5U AS=1.25P AD=1.65P
+ PS=5.5U PD=5.66U
M$1761 \$12696 \$12696 \$12652 VSS nfet_06v0 L=1U W=5U AS=1.65P AD=2.2P
+ PS=5.66U PD=10.88U
M$1762 \$12675 \$12674 VSS VSS nfet_06v0 L=1U W=5U AS=2.2P AD=1.3P PS=10.88U
+ PD=5.52U
M$1763 VSS \$12674 \$12675 VSS nfet_06v0 L=1U W=5U AS=1.3P AD=1.3P PS=5.52U
+ PD=5.52U
M$1764 \$12675 \$12674 VSS VSS nfet_06v0 L=1U W=5U AS=1.3P AD=2.2P PS=5.52U
+ PD=10.88U
M$1765 VSS VDD VSS VSS nfet_06v0 L=2U W=9.75U AS=4.29P AD=4.29P PS=20.38U
+ PD=20.38U
M$1766 VSS VDD VSS VSS nfet_06v0 L=2U W=9.75U AS=4.29P AD=4.29P PS=20.38U
+ PD=20.38U
M$1767 \$12676 \$12676 VSS VSS nfet_06v0 L=1U W=1U AS=0.44P AD=0.44P PS=2.88U
+ PD=2.88U
M$1768 \$12710 \$12653 VSS VSS nfet_06v0 L=1U W=5U AS=2.2P AD=1.25P PS=10.88U
+ PD=5.5U
M$1769 \$12653 \$12676 \$12710 VSS nfet_06v0 L=1U W=5U AS=1.25P AD=2.2P PS=5.5U
+ PD=10.88U
M$1770 \$12694 \$13270 VSS VSS nfet_06v0 L=1U W=1U AS=0.44P AD=0.25P PS=2.88U
+ PD=1.5U
M$1771 \$13264 \$13270 \$12694 VSS nfet_06v0 L=1U W=1U AS=0.25P AD=0.44P
+ PS=1.5U PD=2.88U
M$1772 \$12692 \$13270 VSS VSS nfet_06v0 L=1U W=1U AS=0.44P AD=0.25P PS=2.88U
+ PD=1.5U
M$1773 \$13270 \$13270 \$12692 VSS nfet_06v0 L=1U W=1U AS=0.25P AD=0.44P
+ PS=1.5U PD=2.88U
M$1774 \$12711 \$12653 VSS VSS nfet_06v0 L=1U W=5U AS=2.2P AD=1.25P PS=10.88U
+ PD=5.5U
M$1775 \$12677 \$12676 \$12711 VSS nfet_06v0 L=1U W=5U AS=1.25P AD=1.65P
+ PS=5.5U PD=5.66U
M$1776 \$12712 \$12676 \$12677 VSS nfet_06v0 L=1U W=5U AS=1.65P AD=1.25P
+ PS=5.66U PD=5.5U
M$1777 VSS \$12653 \$12712 VSS nfet_06v0 L=1U W=5U AS=1.25P AD=2.2P PS=5.5U
+ PD=10.88U
M$1778 \$12678 \$4858 \$12677 VSS nfet_06v0 L=1U W=5U AS=2.2P AD=1.3P PS=10.88U
+ PD=5.52U
M$1779 \$12677 \$4858 \$12678 VSS nfet_06v0 L=1U W=5U AS=1.3P AD=2.2P PS=5.52U
+ PD=10.88U
M$1780 \$12679 \$4850 \$12677 VSS nfet_06v0 L=1U W=5U AS=2.2P AD=1.3P PS=10.88U
+ PD=5.52U
M$1781 \$12677 \$4850 \$12679 VSS nfet_06v0 L=1U W=5U AS=1.3P AD=2.2P PS=5.52U
+ PD=10.88U
M$1782 \$12681 \$12676 \$12680 VSS nfet_06v0 L=1U W=2.5U AS=1.1P AD=0.65P
+ PS=5.88U PD=3.02U
M$1783 \$12680 \$12676 \$12681 VSS nfet_06v0 L=1U W=2.5U AS=0.65P AD=1.1P
+ PS=3.02U PD=5.88U
M$1784 \$12683 \$12676 \$12682 VSS nfet_06v0 L=1U W=2.5U AS=1.1P AD=0.65P
+ PS=5.88U PD=3.02U
M$1785 \$12682 \$12676 \$12683 VSS nfet_06v0 L=1U W=2.5U AS=0.65P AD=1.1P
+ PS=3.02U PD=5.88U
M$1786 \$12680 \$12681 VSS VSS nfet_06v0 L=1U W=2.5U AS=1.1P AD=0.65P PS=5.88U
+ PD=3.02U
M$1787 VSS \$12681 \$12680 VSS nfet_06v0 L=1U W=2.5U AS=0.65P AD=0.65P PS=3.02U
+ PD=3.02U
M$1788 \$12680 \$12681 VSS VSS nfet_06v0 L=1U W=2.5U AS=0.65P AD=0.65P PS=3.02U
+ PD=3.02U
M$1789 VSS \$12681 \$12680 VSS nfet_06v0 L=1U W=2.5U AS=0.65P AD=1.1P PS=3.02U
+ PD=5.88U
M$1790 \$12682 \$12681 VSS VSS nfet_06v0 L=1U W=2.5U AS=1.1P AD=0.65P PS=5.88U
+ PD=3.02U
M$1791 VSS \$12681 \$12682 VSS nfet_06v0 L=1U W=2.5U AS=0.65P AD=0.65P PS=3.02U
+ PD=3.02U
M$1792 \$12682 \$12681 VSS VSS nfet_06v0 L=1U W=2.5U AS=0.65P AD=0.65P PS=3.02U
+ PD=3.02U
M$1793 VSS \$12681 \$12682 VSS nfet_06v0 L=1U W=2.5U AS=0.65P AD=1.1P PS=3.02U
+ PD=5.88U
M$1794 \$12811 \$12697 \$12681 VSS nfet_06v0 L=1U W=2.5U AS=1.1P AD=1.1P
+ PS=5.88U PD=5.88U
M$1795 \$12654 \$12697 \$12683 VSS nfet_06v0 L=1U W=2.5U AS=1.1P AD=1.1P
+ PS=5.88U PD=5.88U
M$1796 \$12709 \$12653 VSS VSS nfet_06v0 L=1U W=5U AS=2.2P AD=1.25P PS=10.88U
+ PD=5.5U
M$1797 \$12655 \$12676 \$12709 VSS nfet_06v0 L=1U W=5U AS=1.25P AD=2.2P PS=5.5U
+ PD=10.88U
M$1798 \$12708 \$12656 VSS VSS nfet_06v0 L=1U W=5U AS=2.2P AD=1.25P PS=10.88U
+ PD=5.5U
M$1799 \$12656 \$12676 \$12708 VSS nfet_06v0 L=1U W=5U AS=1.25P AD=1.65P
+ PS=5.5U PD=5.66U
M$1800 \$12697 \$12697 \$12656 VSS nfet_06v0 L=1U W=5U AS=1.65P AD=2.2P
+ PS=5.66U PD=10.88U
M$1801 \$12684 \$12683 VSS VSS nfet_06v0 L=1U W=5U AS=2.2P AD=1.3P PS=10.88U
+ PD=5.52U
M$1802 VSS \$12683 \$12684 VSS nfet_06v0 L=1U W=5U AS=1.3P AD=1.3P PS=5.52U
+ PD=5.52U
M$1803 \$12684 \$12683 VSS VSS nfet_06v0 L=1U W=5U AS=1.3P AD=2.2P PS=5.52U
+ PD=10.88U
M$1804 VSS VDD VSS VSS nfet_06v0 L=2U W=9.75U AS=4.29P AD=4.29P PS=20.38U
+ PD=20.38U
M$1805 VSS VDD VSS VSS nfet_06v0 L=2U W=9.75U AS=4.29P AD=4.29P PS=20.38U
+ PD=20.38U
M$1806 VSS \$12666 \$12657 VSS nfet_06v0 L=1U W=1U AS=0.44P AD=0.44P PS=2.88U
+ PD=2.88U
M$1807 \$10848 \$10851 VSS VSS nfet_06v0 L=1U W=1.24U AS=0.5456P AD=0.5456P
+ PS=3.36U PD=3.36U
M$1808 Z \$10932 \$10865 VSS nfet_06v0 L=1U W=2.48U AS=1.0912P AD=0.6448P
+ PS=5.84U PD=3U
M$1809 \$10865 \$10932 Z VSS nfet_06v0 L=1U W=2.48U AS=0.6448P AD=1.0912P PS=3U
+ PD=5.84U
M$1810 VSS \$12685 \$9145 VSS nfet_06v0 L=1U W=1U AS=0.44P AD=0.44P PS=2.88U
+ PD=2.88U
M$1811 \$10865 \$10851 VSS VSS nfet_06v0 L=1U W=1.24U AS=0.5456P AD=0.5456P
+ PS=3.36U PD=3.36U
M$1812 \$12690 \$12657 \$12685 VSS nfet_06v0 L=1U W=1U AS=0.44P AD=0.25P
+ PS=2.88U PD=1.5U
M$1813 VSS \$12684 \$12690 VSS nfet_06v0 L=1U W=1U AS=0.25P AD=0.44P PS=1.5U
+ PD=2.88U
M$1814 Z \$9093 \$10947 VSS nfet_06v0 L=1U W=2.48U AS=1.0912P AD=0.6448P
+ PS=5.84U PD=3U
M$1815 \$10947 \$9093 Z VSS nfet_06v0 L=1U W=2.48U AS=0.6448P AD=1.0912P PS=3U
+ PD=5.84U
M$1816 \$10909 \$10851 VSS VSS nfet_06v0 L=1U W=0.7U AS=0.308P AD=0.175P
+ PS=2.28U PD=1.2U
M$1817 \$10908 \$10851 \$10909 VSS nfet_06v0 L=1U W=0.7U AS=0.175P AD=0.175P
+ PS=1.2U PD=1.2U
M$1818 \$10910 \$10851 \$10908 VSS nfet_06v0 L=1U W=0.7U AS=0.175P AD=0.175P
+ PS=1.2U PD=1.2U
M$1819 \$10851 \$10851 \$10910 VSS nfet_06v0 L=1U W=0.7U AS=0.175P AD=0.308P
+ PS=1.2U PD=2.28U
M$1820 \$10932 \$12684 VSS VSS nfet_06v0 L=1U W=1U AS=0.44P AD=0.33P PS=2.88U
+ PD=1.66U
M$1821 VSS \$12675 \$10932 VSS nfet_06v0 L=1U W=1U AS=0.33P AD=0.44P PS=1.66U
+ PD=2.88U
M$1822 \$10947 \$10851 VSS VSS nfet_06v0 L=1U W=1.24U AS=0.5456P AD=0.5456P
+ PS=3.36U PD=3.36U
M$1823 Z Z \$10948 VSS nfet_06v0 L=1U W=2U AS=0.88P AD=0.52P PS=4.88U PD=2.52U
M$1824 \$10948 Z Z VSS nfet_06v0 L=1U W=2U AS=0.52P AD=0.88P PS=2.52U PD=4.88U
M$1825 VSS \$12686 \$7330 VSS nfet_06v0 L=1U W=1U AS=0.44P AD=0.44P PS=2.88U
+ PD=2.88U
M$1826 Z VDD \$10849 VSS nfet_06v0 L=1U W=2.48U AS=1.0912P AD=0.6448P PS=5.84U
+ PD=3U
M$1827 \$10849 VDD Z VSS nfet_06v0 L=1U W=2.48U AS=0.6448P AD=1.0912P PS=3U
+ PD=5.84U
M$1828 \$12687 \$12675 \$12686 VSS nfet_06v0 L=1U W=1U AS=0.44P AD=0.25P
+ PS=2.88U PD=1.5U
M$1829 VSS \$12666 \$12687 VSS nfet_06v0 L=1U W=1U AS=0.25P AD=0.44P PS=1.5U
+ PD=2.88U
M$1830 \$10950 Z VSS VSS nfet_06v0 L=1U W=2U AS=0.88P AD=0.5P PS=4.88U PD=2.5U
M$1831 \$10948 Z \$10950 VSS nfet_06v0 L=1U W=2U AS=0.5P AD=0.88P PS=2.5U
+ PD=4.88U
M$1832 \$10849 \$10851 VSS VSS nfet_06v0 L=1U W=1.24U AS=0.5456P AD=0.5456P
+ PS=3.36U PD=3.36U
M$1833 Z \$7290 \$10949 VSS nfet_06v0 L=1U W=2.48U AS=1.0912P AD=0.6448P
+ PS=5.84U PD=3U
M$1834 \$10949 \$7290 Z VSS nfet_06v0 L=1U W=2.48U AS=0.6448P AD=1.0912P PS=3U
+ PD=5.84U
M$1835 \$10949 \$10851 VSS VSS nfet_06v0 L=1U W=1.24U AS=0.5456P AD=0.5456P
+ PS=3.36U PD=3.36U
M$1836 Z \$10907 \$10848 VSS nfet_06v0 L=1U W=2.48U AS=1.0912P AD=0.6448P
+ PS=5.84U PD=3U
M$1837 \$10848 \$10907 Z VSS nfet_06v0 L=1U W=2.48U AS=0.6448P AD=1.0912P PS=3U
+ PD=5.84U
M$1838 VSS VDD VSS VSS nfet_06v0 L=2U W=1U AS=0.44P AD=0.44P PS=2.88U PD=2.88U
M$1839 VSS VDD VSS VSS nfet_06v0 L=2U W=1U AS=0.44P AD=0.44P PS=2.88U PD=2.88U
M$1840 VSS VDD VSS VSS nfet_06v0 L=2U W=1U AS=0.44P AD=0.44P PS=2.88U PD=2.88U
M$1841 VSS VDD VSS VSS nfet_06v0 L=2U W=9.75U AS=4.29P AD=4.29P PS=20.38U
+ PD=20.38U
M$1842 VSS VDD VSS VSS nfet_06v0 L=2U W=9.75U AS=4.29P AD=4.29P PS=20.38U
+ PD=20.38U
M$1843 VSS VDD VSS VSS nfet_06v0 L=2U W=9.75U AS=4.29P AD=4.29P PS=20.38U
+ PD=20.38U
M$1844 VSS VDD VSS VSS nfet_06v0 L=2U W=9.75U AS=4.29P AD=4.29P PS=20.38U
+ PD=20.38U
M$1845 VSS VDD VSS VSS nfet_06v0 L=2U W=9.75U AS=4.29P AD=4.29P PS=20.38U
+ PD=20.38U
M$1846 VSS VDD VSS VSS nfet_06v0 L=2U W=9.75U AS=4.29P AD=4.29P PS=20.38U
+ PD=20.38U
M$1847 VSS VDD VSS VSS nfet_06v0 L=2U W=9.75U AS=4.29P AD=4.29P PS=20.38U
+ PD=20.38U
M$1848 VSS VDD VSS VSS nfet_06v0 L=2U W=1U AS=0.44P AD=0.44P PS=2.88U PD=2.88U
M$1849 VSS VDD VSS VSS nfet_06v0 L=2U W=1U AS=0.44P AD=0.44P PS=2.88U PD=2.88U
M$1850 VSS VDD VSS VSS nfet_06v0 L=2U W=1U AS=0.44P AD=0.44P PS=2.88U PD=2.88U
M$1851 VSS VDD VSS VSS nfet_06v0 L=2U W=1U AS=0.44P AD=0.44P PS=2.88U PD=2.88U
M$1852 VSS VDD VSS VSS nfet_06v0 L=2U W=1U AS=0.44P AD=0.44P PS=2.88U PD=2.88U
M$1853 VSS VDD VSS VSS nfet_06v0 L=2U W=1U AS=0.44P AD=0.44P PS=2.88U PD=2.88U
M$1854 VSS VDD VSS VSS nfet_06v0 L=2U W=1U AS=0.44P AD=0.44P PS=2.88U PD=2.88U
M$1855 VSS VDD VSS VSS nfet_06v0 L=2U W=1U AS=0.44P AD=0.44P PS=2.88U PD=2.88U
M$1856 VSS VDD VSS VSS nfet_06v0 L=2U W=1U AS=0.44P AD=0.44P PS=2.88U PD=2.88U
M$1857 VSS VDD VSS VSS nfet_06v0 L=2U W=1U AS=0.44P AD=0.44P PS=2.88U PD=2.88U
M$1858 VSS VDD VSS VSS nfet_06v0 L=2U W=1U AS=0.44P AD=0.44P PS=2.88U PD=2.88U
M$1859 VSS VDD VSS VSS nfet_06v0 L=2U W=1U AS=0.44P AD=0.44P PS=2.88U PD=2.88U
M$1860 VSS VDD VSS VSS nfet_06v0 L=2U W=1U AS=0.44P AD=0.44P PS=2.88U PD=2.88U
R$1861 \$2129 \$2131 VSS 76450 ppolyf_u_1k L=76.45U W=1U
R$1862 \$2129 \$18 VSS 76450 ppolyf_u_1k L=76.45U W=1U
R$1863 \$110 \$1127 VSS 76450 ppolyf_u_1k L=76.45U W=1U
R$1864 \$2130 \$2131 VSS 76450 ppolyf_u_1k L=76.45U W=1U
R$1865 \$2130 \$1127 VSS 76450 ppolyf_u_1k L=76.45U W=1U
R$1866 \$2134 \$26 VSS 76450 ppolyf_u_1k L=76.45U W=1U
R$1867 \$2134 \$2135 VSS 76450 ppolyf_u_1k L=76.45U W=1U
R$1868 \$2133 \$2135 VSS 76450 ppolyf_u_1k L=76.45U W=1U
R$1869 \$2133 \$1128 VSS 76450 ppolyf_u_1k L=76.45U W=1U
R$1870 \$113 \$1128 VSS 76450 ppolyf_u_1k L=76.45U W=1U
R$1871 \$2137 \$34 VSS 76450 ppolyf_u_1k L=76.45U W=1U
R$1872 \$115 \$1129 VSS 76450 ppolyf_u_1k L=76.45U W=1U
R$1873 \$2138 \$2139 VSS 76450 ppolyf_u_1k L=76.45U W=1U
R$1874 \$2137 \$2139 VSS 76450 ppolyf_u_1k L=76.45U W=1U
R$1875 \$2138 \$1129 VSS 76450 ppolyf_u_1k L=76.45U W=1U
R$1876 \$2141 \$42 VSS 76450 ppolyf_u_1k L=76.45U W=1U
R$1877 \$2141 \$2143 VSS 76450 ppolyf_u_1k L=76.45U W=1U
R$1878 \$2142 \$1130 VSS 76450 ppolyf_u_1k L=76.45U W=1U
R$1879 \$2142 \$2143 VSS 76450 ppolyf_u_1k L=76.45U W=1U
R$1880 \$117 \$1130 VSS 76450 ppolyf_u_1k L=76.45U W=1U
R$1881 \$4541 \$4542 VSS 76450 ppolyf_u_1k L=76.45U W=1U
R$1882 \$4541 \$2431 VSS 76450 ppolyf_u_1k L=76.45U W=1U
R$1883 \$2526 \$3538 VSS 76450 ppolyf_u_1k L=76.45U W=1U
R$1884 \$4540 \$4542 VSS 76450 ppolyf_u_1k L=76.45U W=1U
R$1885 \$4540 \$3538 VSS 76450 ppolyf_u_1k L=76.45U W=1U
R$1886 \$4545 \$4546 VSS 76450 ppolyf_u_1k L=76.45U W=1U
R$1887 \$4544 \$3539 VSS 76450 ppolyf_u_1k L=76.45U W=1U
R$1888 \$2529 \$3539 VSS 76450 ppolyf_u_1k L=76.45U W=1U
R$1889 \$4544 \$4546 VSS 76450 ppolyf_u_1k L=76.45U W=1U
R$1890 \$4545 \$2439 VSS 76450 ppolyf_u_1k L=76.45U W=1U
R$1891 \$4549 \$4550 VSS 76450 ppolyf_u_1k L=76.45U W=1U
R$1892 \$2532 \$3540 VSS 76450 ppolyf_u_1k L=76.45U W=1U
R$1893 \$4548 \$4550 VSS 76450 ppolyf_u_1k L=76.45U W=1U
R$1894 \$4548 \$3540 VSS 76450 ppolyf_u_1k L=76.45U W=1U
R$1895 \$4549 \$2447 VSS 76450 ppolyf_u_1k L=76.45U W=1U
R$1896 \$4553 \$4554 VSS 76450 ppolyf_u_1k L=76.45U W=1U
R$1897 \$4552 \$4554 VSS 76450 ppolyf_u_1k L=76.45U W=1U
R$1898 \$4552 \$2455 VSS 76450 ppolyf_u_1k L=76.45U W=1U
R$1899 \$4553 \$3541 VSS 76450 ppolyf_u_1k L=76.45U W=1U
R$1900 \$2535 \$3541 VSS 76450 ppolyf_u_1k L=76.45U W=1U
R$1901 \$6949 \$5947 VSS 76450 ppolyf_u_1k L=76.45U W=1U
R$1902 \$6949 \$6951 VSS 76450 ppolyf_u_1k L=76.45U W=1U
R$1903 \$4934 \$5947 VSS 76450 ppolyf_u_1k L=76.45U W=1U
R$1904 \$6950 \$6951 VSS 76450 ppolyf_u_1k L=76.45U W=1U
R$1905 \$6950 \$4842 VSS 76450 ppolyf_u_1k L=76.45U W=1U
R$1906 \$6954 \$4850 VSS 76450 ppolyf_u_1k L=76.45U W=1U
R$1907 \$6953 \$6955 VSS 76450 ppolyf_u_1k L=76.45U W=1U
R$1908 \$6953 \$5948 VSS 76450 ppolyf_u_1k L=76.45U W=1U
R$1909 \$4938 \$5948 VSS 76450 ppolyf_u_1k L=76.45U W=1U
R$1910 \$6954 \$6955 VSS 76450 ppolyf_u_1k L=76.45U W=1U
R$1911 \$4942 \$5949 VSS 76450 ppolyf_u_1k L=76.45U W=1U
R$1912 \$6957 \$5949 VSS 76450 ppolyf_u_1k L=76.45U W=1U
R$1913 \$6958 \$6959 VSS 76450 ppolyf_u_1k L=76.45U W=1U
R$1914 \$6957 \$6959 VSS 76450 ppolyf_u_1k L=76.45U W=1U
R$1915 \$6958 \$4858 VSS 76450 ppolyf_u_1k L=76.45U W=1U
R$1916 \$6961 \$4866 VSS 76450 ppolyf_u_1k L=76.45U W=1U
R$1917 \$6962 \$5950 VSS 76450 ppolyf_u_1k L=76.45U W=1U
R$1918 \$4946 \$5950 VSS 76450 ppolyf_u_1k L=76.45U W=1U
R$1919 \$6961 \$6963 VSS 76450 ppolyf_u_1k L=76.45U W=1U
R$1920 \$6962 \$6963 VSS 76450 ppolyf_u_1k L=76.45U W=1U
C$1921 \$12678 \$12684 4e-13 cap_mim_2f0fF A=200P P=60U
C$1922 \$12660 \$12666 4e-13 cap_mim_2f0fF A=200P P=60U
C$1923 \$12675 \$12673 4e-13 cap_mim_2f0fF A=200P P=60U
C$1924 \$12666 \$12664 4e-13 cap_mim_2f0fF A=200P P=60U
C$1925 \$10894 \$10882 4e-13 cap_mim_2f0fF A=200P P=60U
C$1926 \$10875 \$10873 4e-13 cap_mim_2f0fF A=200P P=60U
C$1927 \$9086 \$9092 4e-13 cap_mim_2f0fF A=200P P=60U
C$1928 \$9078 \$9095 4e-13 cap_mim_2f0fF A=200P P=60U
C$1929 \$9092 \$9090 4e-13 cap_mim_2f0fF A=200P P=60U
C$1930 \$9075 \$9073 4e-13 cap_mim_2f0fF A=200P P=60U
C$1931 \$10878 \$10894 4e-13 cap_mim_2f0fF A=200P P=60U
C$1932 \$7283 \$7289 4e-13 cap_mim_2f0fF A=200P P=60U
C$1933 \$10869 \$10875 4e-13 cap_mim_2f0fF A=200P P=60U
C$1934 \$9095 \$9082 4e-13 cap_mim_2f0fF A=200P P=60U
C$1935 \$2441 \$2447 4e-13 cap_mim_2f0fF A=200P P=66U
C$1936 \$20 \$26 4e-13 cap_mim_2f0fF A=200P P=66U
C$1937 \$42 \$107 4e-13 cap_mim_2f0fF A=200P P=66U
C$1938 \$4842 \$4916 4e-13 cap_mim_2f0fF A=200P P=66U
C$1939 \$36 \$42 4e-13 cap_mim_2f0fF A=200P P=66U
C$1940 \$34 \$102 4e-13 cap_mim_2f0fF A=200P P=66U
C$1941 \$10886 \$10892 4e-13 cap_mim_2f0fF A=200P P=60U
C$1942 \$7266 \$7272 4e-13 cap_mim_2f0fF A=200P P=60U
C$1943 \$28 \$34 4e-13 cap_mim_2f0fF A=200P P=66U
C$1944 \$10892 \$10890 4e-13 cap_mim_2f0fF A=200P P=60U
C$1945 \$2433 \$2439 4e-13 cap_mim_2f0fF A=200P P=66U
C$1946 \$2425 \$2431 4e-13 cap_mim_2f0fF A=200P P=66U
C$1947 \$12669 \$12675 4e-13 cap_mim_2f0fF A=200P P=60U
C$1948 \$2449 \$2455 4e-13 cap_mim_2f0fF A=200P P=66U
C$1949 \$26 \$96 4e-13 cap_mim_2f0fF A=200P P=66U
C$1950 \$2431 \$2499 4e-13 cap_mim_2f0fF A=200P P=66U
C$1951 \$12684 \$12682 4e-13 cap_mim_2f0fF A=200P P=60U
C$1952 \$12 \$18 4e-13 cap_mim_2f0fF A=200P P=66U
C$1953 \$7289 \$7287 4e-13 cap_mim_2f0fF A=200P P=60U
C$1954 \$4844 \$4850 4e-13 cap_mim_2f0fF A=200P P=66U
C$1955 \$2439 \$2501 4e-13 cap_mim_2f0fF A=200P P=66U
C$1956 \$4850 \$4919 4e-13 cap_mim_2f0fF A=200P P=66U
C$1957 \$2447 \$2514 4e-13 cap_mim_2f0fF A=200P P=66U
C$1958 \$4852 \$4858 4e-13 cap_mim_2f0fF A=200P P=66U
C$1959 \$4858 \$4923 4e-13 cap_mim_2f0fF A=200P P=66U
C$1960 \$4860 \$4866 4e-13 cap_mim_2f0fF A=200P P=66U
C$1961 \$18 \$91 4e-13 cap_mim_2f0fF A=200P P=66U
C$1962 \$2455 \$2517 4e-13 cap_mim_2f0fF A=200P P=66U
C$1963 \$4866 \$4927 4e-13 cap_mim_2f0fF A=200P P=66U
C$1964 \$7272 \$7270 4e-13 cap_mim_2f0fF A=200P P=60U
C$1965 \$9069 \$9075 4e-13 cap_mim_2f0fF A=200P P=60U
C$1966 \$4836 \$4842 4e-13 cap_mim_2f0fF A=200P P=66U
C$1967 \$7292 \$7279 4e-13 cap_mim_2f0fF A=200P P=60U
C$1968 \$7275 \$7292 4e-13 cap_mim_2f0fF A=200P P=60U
.ENDS GRADIENT_NAV2
