** sch_path: /foss/designs/sscs-2026-zotnetic/activities/opamp3AKAM/simulations_testbench/resistance.sch
**.subckt resistance
V1 VSS 0 0
V2 VDD 0 5
V3 VG1 0 2.5
V4 VG2 0 2.5
XM3 net1 VG2 VDD net1 nfet_06v0 L=1u W=4.275u nf=1 ad='int((nf+1)/2) * W/nf * 0.18u' as='int((nf+2)/2) * W/nf * 0.18u' pd='2*int((nf+1)/2) * (W/nf + 0.18u)'
+ ps='2*int((nf+2)/2) * (W/nf + 0.18u)' nrd='0.18u / W' nrs='0.18u / W' sa=0 sb=0 sd=0
XM4 VDD VG1 net1 VDD pfet_06v0 L=1.0u W=4.0u nf=1 ad='int((nf+1)/2) * W/nf * 0.18u' as='int((nf+2)/2) * W/nf * 0.18u' pd='2*int((nf+1)/2) * (W/nf + 0.18u)'
+ ps='2*int((nf+2)/2) * (W/nf + 0.18u)' nrd='0.18u / W' nrs='0.18u / W' sa=0 sb=0 sd=0
Vmeas net1 VSS 0
**** begin user architecture code

.include /foss/pdks/gf180mcuD/libs.tech/ngspice/design.ngspice
.lib /foss/pdks/gf180mcuD/libs.tech/ngspice/sm141064.ngspice typical

.control
op
echo "VG1 VG2 Resistance" > /foss/designs/sscs-2026-zotnetic/activities/opamp3AKAM/simulations_results/resistance.txt
let b1 = 0
let b2 = 0

while b1 <= 5
    alter v3 $&b1
    while b2 <=5
	alter v4 $&b2
	let b3 = v(VDD)/i(Vmeas)
	echo "$&b1 $&b2 $&b3" >> /foss/designs/sscs-2026-zotnetic/activities/opamp3AKAM/simulations_results/resistance.txt
	let b2 = b2 +0.5
    end
    let b2 = 0
    let b1 = b1 +0.5
end

.endc

**** end user architecture code
**.ends
.end
