v {xschem version=3.4.8RC file_version=1.3}
G {}
K {}
V {}
S {}
F {}
E {}
N -490 120 -490 150 {lab=0}
N -490 0 -490 60 {lab=VSS}
N -410 120 -410 150 {lab=0}
N -410 0 -410 60 {lab=VDD}
N -80 30 -80 70 {lab=VSS}
N -80 70 -80 80 {lab=VSS}
N -80 -100 -80 -70 {lab=VDD}
N -240 120 -240 150 {lab=0}
N -240 0 -240 60 {lab=A}
C {vsource.sym} -490 90 0 0 {name=V1 value=0 savecurrent=false}
C {gnd.sym} -490 150 0 0 {name=l1 lab=0}
C {lab_pin.sym} -490 10 0 0 {name=p2 sig_type=std_logic lab=VSS}
C {vsource.sym} -410 90 0 0 {name=V2 value=5 savecurrent=false}
C {gnd.sym} -410 150 0 0 {name=l2 lab=0}
C {lab_pin.sym} -410 10 0 0 {name=p4 sig_type=std_logic lab=VDD}
C {lab_pin.sym} -80 -100 0 0 {name=p1 sig_type=std_logic lab=VDD}
C {lab_pin.sym} -80 80 0 0 {name=p3 sig_type=std_logic lab=VSS}
C {vsource.sym} -240 90 0 0 {name=V4 value=PULSE(0,5,5n,0.1n,0.1n,10n,20n) savecurrent=false}
C {gnd.sym} -240 150 0 0 {name=l4 lab=0}
C {lab_pin.sym} -240 10 0 0 {name=p6 sig_type=std_logic lab=A}
C {lab_pin.sym} -140 -20 0 0 {name=p8 sig_type=std_logic lab=A}
C {code_shown.sym} -570 -200 0 0 {name=MODELS only_toplevel=false value=".include /foss/pdks/gf180mcuD/libs.tech/ngspice/design.ngspice
.lib /foss/pdks/gf180mcuD/libs.tech/ngspice/sm141064.ngspice typical"}
C {code_shown.sym} 180 -10 0 0 {name=NGSPICE
only_toplevel=false
value="

.control
tran .01n 20n
meas tran tpdr TRIG v(A) VAL='5/2' RISE=1 TARG v(output) VAL='5/2' FALL=1
meas tran tpdf TRIG v(A) VAL='5/2' FALL=1 TARG v(output) VAL='5/2' RISE=1

let tpd=(tpdr+tpdf)/2
print tpdr tpdf tpd
plot v(A) v(output)

.endc
"}
C {lab_pin.sym} 0 -20 2 0 {name=p9 sig_type=std_logic lab=output}
C {/foss/designs/sscs-2026-zotnetic/activities/opamp3AKAM/invertor.sym} -100 -10 0 0 {name=x1}
