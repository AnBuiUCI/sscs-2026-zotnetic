** sch_path: /foss/designs/sscs-2026-zotnetic/activities/opamp3An/N_PMOS9kresistor.sch
**.subckt N_PMOS9kresistor
XM3 net1 VG VDD net1 nfet_06v0 L=1u W=4.275u nf=1 ad='int((nf+1)/2) * W/nf * 0.18u' as='int((nf+2)/2) * W/nf * 0.18u' pd='2*int((nf+1)/2) * (W/nf + 0.18u)'
+ ps='2*int((nf+2)/2) * (W/nf + 0.18u)' nrd='0.18u / W' nrs='0.18u / W' sa=0 sb=0 sd=0
XM4 VDD VG net1 VDD pfet_06v0 L=1.0u W=4.0u nf=1 ad='int((nf+1)/2) * W/nf * 0.18u' as='int((nf+2)/2) * W/nf * 0.18u' pd='2*int((nf+1)/2) * (W/nf + 0.18u)'
+ ps='2*int((nf+2)/2) * (W/nf + 0.18u)' nrd='0.18u / W' nrs='0.18u / W' sa=0 sb=0 sd=0
V1 VSS 0 0
V2 VDD 0 5
VGATE VG 0 2.5
Vmeas net1 VSS 0
**** begin user architecture code

.control
op
dc VGATE 0 5 0.1
let resistance = v(VDD)/i(Vmeas)
print v(VG) resistance
plot v(VDD)/i(Vmeas)

.endc

.include /foss/pdks/gf180mcuD/libs.tech/ngspice/design.ngspice
.lib /foss/pdks/gf180mcuD/libs.tech/ngspice/sm141064.ngspice typical

**** end user architecture code
**.ends
.end
